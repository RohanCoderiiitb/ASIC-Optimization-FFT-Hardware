.meas tran vdout0_0ck40 FIND v(dout0_0) AT=25.025n

.meas tran vdout0_1ck40 FIND v(dout0_1) AT=25.025n

.meas tran vdout0_2ck40 FIND v(dout0_2) AT=25.025n

.meas tran vdout0_3ck40 FIND v(dout0_3) AT=25.025n

.meas tran vdout0_4ck40 FIND v(dout0_4) AT=25.025n

.meas tran vdout0_5ck40 FIND v(dout0_5) AT=25.025n

.meas tran vdout0_6ck40 FIND v(dout0_6) AT=25.025n

.meas tran vdout0_7ck40 FIND v(dout0_7) AT=25.025n

.meas tran vdout0_8ck40 FIND v(dout0_8) AT=25.025n

.meas tran vdout0_9ck40 FIND v(dout0_9) AT=25.025n

.meas tran vdout0_10ck40 FIND v(dout0_10) AT=25.025n

.meas tran vdout0_11ck40 FIND v(dout0_11) AT=25.025n

.meas tran vdout0_12ck40 FIND v(dout0_12) AT=25.025n

.meas tran vdout0_13ck40 FIND v(dout0_13) AT=25.025n

.meas tran vdout0_14ck40 FIND v(dout0_14) AT=25.025n

.meas tran vdout0_15ck40 FIND v(dout0_15) AT=25.025n

.meas tran vdout0_16ck40 FIND v(dout0_16) AT=25.025n

.meas tran vdout0_17ck40 FIND v(dout0_17) AT=25.025n

.meas tran vdout0_18ck40 FIND v(dout0_18) AT=25.025n

.meas tran vdout0_19ck40 FIND v(dout0_19) AT=25.025n

.meas tran vdout0_20ck40 FIND v(dout0_20) AT=25.025n

.meas tran vdout0_21ck40 FIND v(dout0_21) AT=25.025n

.meas tran vdout0_22ck40 FIND v(dout0_22) AT=25.025n

.meas tran vdout0_23ck40 FIND v(dout0_23) AT=25.025n

.meas tran vdout1_0ck40 FIND v(dout1_0) AT=25.025n

.meas tran vdout1_1ck40 FIND v(dout1_1) AT=25.025n

.meas tran vdout1_2ck40 FIND v(dout1_2) AT=25.025n

.meas tran vdout1_3ck40 FIND v(dout1_3) AT=25.025n

.meas tran vdout1_4ck40 FIND v(dout1_4) AT=25.025n

.meas tran vdout1_5ck40 FIND v(dout1_5) AT=25.025n

.meas tran vdout1_6ck40 FIND v(dout1_6) AT=25.025n

.meas tran vdout1_7ck40 FIND v(dout1_7) AT=25.025n

.meas tran vdout1_8ck40 FIND v(dout1_8) AT=25.025n

.meas tran vdout1_9ck40 FIND v(dout1_9) AT=25.025n

.meas tran vdout1_10ck40 FIND v(dout1_10) AT=25.025n

.meas tran vdout1_11ck40 FIND v(dout1_11) AT=25.025n

.meas tran vdout1_12ck40 FIND v(dout1_12) AT=25.025n

.meas tran vdout1_13ck40 FIND v(dout1_13) AT=25.025n

.meas tran vdout1_14ck40 FIND v(dout1_14) AT=25.025n

.meas tran vdout1_15ck40 FIND v(dout1_15) AT=25.025n

.meas tran vdout1_16ck40 FIND v(dout1_16) AT=25.025n

.meas tran vdout1_17ck40 FIND v(dout1_17) AT=25.025n

.meas tran vdout1_18ck40 FIND v(dout1_18) AT=25.025n

.meas tran vdout1_19ck40 FIND v(dout1_19) AT=25.025n

.meas tran vdout1_20ck40 FIND v(dout1_20) AT=25.025n

.meas tran vdout1_21ck40 FIND v(dout1_21) AT=25.025n

.meas tran vdout1_22ck40 FIND v(dout1_22) AT=25.025n

.meas tran vdout1_23ck40 FIND v(dout1_23) AT=25.025n

.meas tran vdout1_0ck50 FIND v(dout1_0) AT=30.025n

.meas tran vdout1_1ck50 FIND v(dout1_1) AT=30.025n

.meas tran vdout1_2ck50 FIND v(dout1_2) AT=30.025n

.meas tran vdout1_3ck50 FIND v(dout1_3) AT=30.025n

.meas tran vdout1_4ck50 FIND v(dout1_4) AT=30.025n

.meas tran vdout1_5ck50 FIND v(dout1_5) AT=30.025n

.meas tran vdout1_6ck50 FIND v(dout1_6) AT=30.025n

.meas tran vdout1_7ck50 FIND v(dout1_7) AT=30.025n

.meas tran vdout1_8ck50 FIND v(dout1_8) AT=30.025n

.meas tran vdout1_9ck50 FIND v(dout1_9) AT=30.025n

.meas tran vdout1_10ck50 FIND v(dout1_10) AT=30.025n

.meas tran vdout1_11ck50 FIND v(dout1_11) AT=30.025n

.meas tran vdout1_12ck50 FIND v(dout1_12) AT=30.025n

.meas tran vdout1_13ck50 FIND v(dout1_13) AT=30.025n

.meas tran vdout1_14ck50 FIND v(dout1_14) AT=30.025n

.meas tran vdout1_15ck50 FIND v(dout1_15) AT=30.025n

.meas tran vdout1_16ck50 FIND v(dout1_16) AT=30.025n

.meas tran vdout1_17ck50 FIND v(dout1_17) AT=30.025n

.meas tran vdout1_18ck50 FIND v(dout1_18) AT=30.025n

.meas tran vdout1_19ck50 FIND v(dout1_19) AT=30.025n

.meas tran vdout1_20ck50 FIND v(dout1_20) AT=30.025n

.meas tran vdout1_21ck50 FIND v(dout1_21) AT=30.025n

.meas tran vdout1_22ck50 FIND v(dout1_22) AT=30.025n

.meas tran vdout1_23ck50 FIND v(dout1_23) AT=30.025n

.meas tran vdout0_0ck60 FIND v(dout0_0) AT=35.025n

.meas tran vdout0_1ck60 FIND v(dout0_1) AT=35.025n

.meas tran vdout0_2ck60 FIND v(dout0_2) AT=35.025n

.meas tran vdout0_3ck60 FIND v(dout0_3) AT=35.025n

.meas tran vdout0_4ck60 FIND v(dout0_4) AT=35.025n

.meas tran vdout0_5ck60 FIND v(dout0_5) AT=35.025n

.meas tran vdout0_6ck60 FIND v(dout0_6) AT=35.025n

.meas tran vdout0_7ck60 FIND v(dout0_7) AT=35.025n

.meas tran vdout0_8ck60 FIND v(dout0_8) AT=35.025n

.meas tran vdout0_9ck60 FIND v(dout0_9) AT=35.025n

.meas tran vdout0_10ck60 FIND v(dout0_10) AT=35.025n

.meas tran vdout0_11ck60 FIND v(dout0_11) AT=35.025n

.meas tran vdout0_12ck60 FIND v(dout0_12) AT=35.025n

.meas tran vdout0_13ck60 FIND v(dout0_13) AT=35.025n

.meas tran vdout0_14ck60 FIND v(dout0_14) AT=35.025n

.meas tran vdout0_15ck60 FIND v(dout0_15) AT=35.025n

.meas tran vdout0_16ck60 FIND v(dout0_16) AT=35.025n

.meas tran vdout0_17ck60 FIND v(dout0_17) AT=35.025n

.meas tran vdout0_18ck60 FIND v(dout0_18) AT=35.025n

.meas tran vdout0_19ck60 FIND v(dout0_19) AT=35.025n

.meas tran vdout0_20ck60 FIND v(dout0_20) AT=35.025n

.meas tran vdout0_21ck60 FIND v(dout0_21) AT=35.025n

.meas tran vdout0_22ck60 FIND v(dout0_22) AT=35.025n

.meas tran vdout0_23ck60 FIND v(dout0_23) AT=35.025n

.meas tran vdout1_0ck60 FIND v(dout1_0) AT=35.025n

.meas tran vdout1_1ck60 FIND v(dout1_1) AT=35.025n

.meas tran vdout1_2ck60 FIND v(dout1_2) AT=35.025n

.meas tran vdout1_3ck60 FIND v(dout1_3) AT=35.025n

.meas tran vdout1_4ck60 FIND v(dout1_4) AT=35.025n

.meas tran vdout1_5ck60 FIND v(dout1_5) AT=35.025n

.meas tran vdout1_6ck60 FIND v(dout1_6) AT=35.025n

.meas tran vdout1_7ck60 FIND v(dout1_7) AT=35.025n

.meas tran vdout1_8ck60 FIND v(dout1_8) AT=35.025n

.meas tran vdout1_9ck60 FIND v(dout1_9) AT=35.025n

.meas tran vdout1_10ck60 FIND v(dout1_10) AT=35.025n

.meas tran vdout1_11ck60 FIND v(dout1_11) AT=35.025n

.meas tran vdout1_12ck60 FIND v(dout1_12) AT=35.025n

.meas tran vdout1_13ck60 FIND v(dout1_13) AT=35.025n

.meas tran vdout1_14ck60 FIND v(dout1_14) AT=35.025n

.meas tran vdout1_15ck60 FIND v(dout1_15) AT=35.025n

.meas tran vdout1_16ck60 FIND v(dout1_16) AT=35.025n

.meas tran vdout1_17ck60 FIND v(dout1_17) AT=35.025n

.meas tran vdout1_18ck60 FIND v(dout1_18) AT=35.025n

.meas tran vdout1_19ck60 FIND v(dout1_19) AT=35.025n

.meas tran vdout1_20ck60 FIND v(dout1_20) AT=35.025n

.meas tran vdout1_21ck60 FIND v(dout1_21) AT=35.025n

.meas tran vdout1_22ck60 FIND v(dout1_22) AT=35.025n

.meas tran vdout1_23ck60 FIND v(dout1_23) AT=35.025n

.meas tran vdout0_0ck80 FIND v(dout0_0) AT=45.025n

.meas tran vdout0_1ck80 FIND v(dout0_1) AT=45.025n

.meas tran vdout0_2ck80 FIND v(dout0_2) AT=45.025n

.meas tran vdout0_3ck80 FIND v(dout0_3) AT=45.025n

.meas tran vdout0_4ck80 FIND v(dout0_4) AT=45.025n

.meas tran vdout0_5ck80 FIND v(dout0_5) AT=45.025n

.meas tran vdout0_6ck80 FIND v(dout0_6) AT=45.025n

.meas tran vdout0_7ck80 FIND v(dout0_7) AT=45.025n

.meas tran vdout0_8ck80 FIND v(dout0_8) AT=45.025n

.meas tran vdout0_9ck80 FIND v(dout0_9) AT=45.025n

.meas tran vdout0_10ck80 FIND v(dout0_10) AT=45.025n

.meas tran vdout0_11ck80 FIND v(dout0_11) AT=45.025n

.meas tran vdout0_12ck80 FIND v(dout0_12) AT=45.025n

.meas tran vdout0_13ck80 FIND v(dout0_13) AT=45.025n

.meas tran vdout0_14ck80 FIND v(dout0_14) AT=45.025n

.meas tran vdout0_15ck80 FIND v(dout0_15) AT=45.025n

.meas tran vdout0_16ck80 FIND v(dout0_16) AT=45.025n

.meas tran vdout0_17ck80 FIND v(dout0_17) AT=45.025n

.meas tran vdout0_18ck80 FIND v(dout0_18) AT=45.025n

.meas tran vdout0_19ck80 FIND v(dout0_19) AT=45.025n

.meas tran vdout0_20ck80 FIND v(dout0_20) AT=45.025n

.meas tran vdout0_21ck80 FIND v(dout0_21) AT=45.025n

.meas tran vdout0_22ck80 FIND v(dout0_22) AT=45.025n

.meas tran vdout0_23ck80 FIND v(dout0_23) AT=45.025n

.meas tran vdout0_0ck100 FIND v(dout0_0) AT=55.025n

.meas tran vdout0_1ck100 FIND v(dout0_1) AT=55.025n

.meas tran vdout0_2ck100 FIND v(dout0_2) AT=55.025n

.meas tran vdout0_3ck100 FIND v(dout0_3) AT=55.025n

.meas tran vdout0_4ck100 FIND v(dout0_4) AT=55.025n

.meas tran vdout0_5ck100 FIND v(dout0_5) AT=55.025n

.meas tran vdout0_6ck100 FIND v(dout0_6) AT=55.025n

.meas tran vdout0_7ck100 FIND v(dout0_7) AT=55.025n

.meas tran vdout0_8ck100 FIND v(dout0_8) AT=55.025n

.meas tran vdout0_9ck100 FIND v(dout0_9) AT=55.025n

.meas tran vdout0_10ck100 FIND v(dout0_10) AT=55.025n

.meas tran vdout0_11ck100 FIND v(dout0_11) AT=55.025n

.meas tran vdout0_12ck100 FIND v(dout0_12) AT=55.025n

.meas tran vdout0_13ck100 FIND v(dout0_13) AT=55.025n

.meas tran vdout0_14ck100 FIND v(dout0_14) AT=55.025n

.meas tran vdout0_15ck100 FIND v(dout0_15) AT=55.025n

.meas tran vdout0_16ck100 FIND v(dout0_16) AT=55.025n

.meas tran vdout0_17ck100 FIND v(dout0_17) AT=55.025n

.meas tran vdout0_18ck100 FIND v(dout0_18) AT=55.025n

.meas tran vdout0_19ck100 FIND v(dout0_19) AT=55.025n

.meas tran vdout0_20ck100 FIND v(dout0_20) AT=55.025n

.meas tran vdout0_21ck100 FIND v(dout0_21) AT=55.025n

.meas tran vdout0_22ck100 FIND v(dout0_22) AT=55.025n

.meas tran vdout0_23ck100 FIND v(dout0_23) AT=55.025n

.meas tran vdout1_0ck100 FIND v(dout1_0) AT=55.025n

.meas tran vdout1_1ck100 FIND v(dout1_1) AT=55.025n

.meas tran vdout1_2ck100 FIND v(dout1_2) AT=55.025n

.meas tran vdout1_3ck100 FIND v(dout1_3) AT=55.025n

.meas tran vdout1_4ck100 FIND v(dout1_4) AT=55.025n

.meas tran vdout1_5ck100 FIND v(dout1_5) AT=55.025n

.meas tran vdout1_6ck100 FIND v(dout1_6) AT=55.025n

.meas tran vdout1_7ck100 FIND v(dout1_7) AT=55.025n

.meas tran vdout1_8ck100 FIND v(dout1_8) AT=55.025n

.meas tran vdout1_9ck100 FIND v(dout1_9) AT=55.025n

.meas tran vdout1_10ck100 FIND v(dout1_10) AT=55.025n

.meas tran vdout1_11ck100 FIND v(dout1_11) AT=55.025n

.meas tran vdout1_12ck100 FIND v(dout1_12) AT=55.025n

.meas tran vdout1_13ck100 FIND v(dout1_13) AT=55.025n

.meas tran vdout1_14ck100 FIND v(dout1_14) AT=55.025n

.meas tran vdout1_15ck100 FIND v(dout1_15) AT=55.025n

.meas tran vdout1_16ck100 FIND v(dout1_16) AT=55.025n

.meas tran vdout1_17ck100 FIND v(dout1_17) AT=55.025n

.meas tran vdout1_18ck100 FIND v(dout1_18) AT=55.025n

.meas tran vdout1_19ck100 FIND v(dout1_19) AT=55.025n

.meas tran vdout1_20ck100 FIND v(dout1_20) AT=55.025n

.meas tran vdout1_21ck100 FIND v(dout1_21) AT=55.025n

.meas tran vdout1_22ck100 FIND v(dout1_22) AT=55.025n

.meas tran vdout1_23ck100 FIND v(dout1_23) AT=55.025n

.meas tran vdout0_0ck120 FIND v(dout0_0) AT=65.025n

.meas tran vdout0_1ck120 FIND v(dout0_1) AT=65.025n

.meas tran vdout0_2ck120 FIND v(dout0_2) AT=65.025n

.meas tran vdout0_3ck120 FIND v(dout0_3) AT=65.025n

.meas tran vdout0_4ck120 FIND v(dout0_4) AT=65.025n

.meas tran vdout0_5ck120 FIND v(dout0_5) AT=65.025n

.meas tran vdout0_6ck120 FIND v(dout0_6) AT=65.025n

.meas tran vdout0_7ck120 FIND v(dout0_7) AT=65.025n

.meas tran vdout0_8ck120 FIND v(dout0_8) AT=65.025n

.meas tran vdout0_9ck120 FIND v(dout0_9) AT=65.025n

.meas tran vdout0_10ck120 FIND v(dout0_10) AT=65.025n

.meas tran vdout0_11ck120 FIND v(dout0_11) AT=65.025n

.meas tran vdout0_12ck120 FIND v(dout0_12) AT=65.025n

.meas tran vdout0_13ck120 FIND v(dout0_13) AT=65.025n

.meas tran vdout0_14ck120 FIND v(dout0_14) AT=65.025n

.meas tran vdout0_15ck120 FIND v(dout0_15) AT=65.025n

.meas tran vdout0_16ck120 FIND v(dout0_16) AT=65.025n

.meas tran vdout0_17ck120 FIND v(dout0_17) AT=65.025n

.meas tran vdout0_18ck120 FIND v(dout0_18) AT=65.025n

.meas tran vdout0_19ck120 FIND v(dout0_19) AT=65.025n

.meas tran vdout0_20ck120 FIND v(dout0_20) AT=65.025n

.meas tran vdout0_21ck120 FIND v(dout0_21) AT=65.025n

.meas tran vdout0_22ck120 FIND v(dout0_22) AT=65.025n

.meas tran vdout0_23ck120 FIND v(dout0_23) AT=65.025n

.meas tran vdout1_0ck120 FIND v(dout1_0) AT=65.025n

.meas tran vdout1_1ck120 FIND v(dout1_1) AT=65.025n

.meas tran vdout1_2ck120 FIND v(dout1_2) AT=65.025n

.meas tran vdout1_3ck120 FIND v(dout1_3) AT=65.025n

.meas tran vdout1_4ck120 FIND v(dout1_4) AT=65.025n

.meas tran vdout1_5ck120 FIND v(dout1_5) AT=65.025n

.meas tran vdout1_6ck120 FIND v(dout1_6) AT=65.025n

.meas tran vdout1_7ck120 FIND v(dout1_7) AT=65.025n

.meas tran vdout1_8ck120 FIND v(dout1_8) AT=65.025n

.meas tran vdout1_9ck120 FIND v(dout1_9) AT=65.025n

.meas tran vdout1_10ck120 FIND v(dout1_10) AT=65.025n

.meas tran vdout1_11ck120 FIND v(dout1_11) AT=65.025n

.meas tran vdout1_12ck120 FIND v(dout1_12) AT=65.025n

.meas tran vdout1_13ck120 FIND v(dout1_13) AT=65.025n

.meas tran vdout1_14ck120 FIND v(dout1_14) AT=65.025n

.meas tran vdout1_15ck120 FIND v(dout1_15) AT=65.025n

.meas tran vdout1_16ck120 FIND v(dout1_16) AT=65.025n

.meas tran vdout1_17ck120 FIND v(dout1_17) AT=65.025n

.meas tran vdout1_18ck120 FIND v(dout1_18) AT=65.025n

.meas tran vdout1_19ck120 FIND v(dout1_19) AT=65.025n

.meas tran vdout1_20ck120 FIND v(dout1_20) AT=65.025n

.meas tran vdout1_21ck120 FIND v(dout1_21) AT=65.025n

.meas tran vdout1_22ck120 FIND v(dout1_22) AT=65.025n

.meas tran vdout1_23ck120 FIND v(dout1_23) AT=65.025n

.meas tran vdout0_0ck150 FIND v(dout0_0) AT=80.025n

.meas tran vdout0_1ck150 FIND v(dout0_1) AT=80.025n

.meas tran vdout0_2ck150 FIND v(dout0_2) AT=80.025n

.meas tran vdout0_3ck150 FIND v(dout0_3) AT=80.025n

.meas tran vdout0_4ck150 FIND v(dout0_4) AT=80.025n

.meas tran vdout0_5ck150 FIND v(dout0_5) AT=80.025n

.meas tran vdout0_6ck150 FIND v(dout0_6) AT=80.025n

.meas tran vdout0_7ck150 FIND v(dout0_7) AT=80.025n

.meas tran vdout0_8ck150 FIND v(dout0_8) AT=80.025n

.meas tran vdout0_9ck150 FIND v(dout0_9) AT=80.025n

.meas tran vdout0_10ck150 FIND v(dout0_10) AT=80.025n

.meas tran vdout0_11ck150 FIND v(dout0_11) AT=80.025n

.meas tran vdout0_12ck150 FIND v(dout0_12) AT=80.025n

.meas tran vdout0_13ck150 FIND v(dout0_13) AT=80.025n

.meas tran vdout0_14ck150 FIND v(dout0_14) AT=80.025n

.meas tran vdout0_15ck150 FIND v(dout0_15) AT=80.025n

.meas tran vdout0_16ck150 FIND v(dout0_16) AT=80.025n

.meas tran vdout0_17ck150 FIND v(dout0_17) AT=80.025n

.meas tran vdout0_18ck150 FIND v(dout0_18) AT=80.025n

.meas tran vdout0_19ck150 FIND v(dout0_19) AT=80.025n

.meas tran vdout0_20ck150 FIND v(dout0_20) AT=80.025n

.meas tran vdout0_21ck150 FIND v(dout0_21) AT=80.025n

.meas tran vdout0_22ck150 FIND v(dout0_22) AT=80.025n

.meas tran vdout0_23ck150 FIND v(dout0_23) AT=80.025n

.meas tran vdout0_0ck160 FIND v(dout0_0) AT=85.025n

.meas tran vdout0_1ck160 FIND v(dout0_1) AT=85.025n

.meas tran vdout0_2ck160 FIND v(dout0_2) AT=85.025n

.meas tran vdout0_3ck160 FIND v(dout0_3) AT=85.025n

.meas tran vdout0_4ck160 FIND v(dout0_4) AT=85.025n

.meas tran vdout0_5ck160 FIND v(dout0_5) AT=85.025n

.meas tran vdout0_6ck160 FIND v(dout0_6) AT=85.025n

.meas tran vdout0_7ck160 FIND v(dout0_7) AT=85.025n

.meas tran vdout0_8ck160 FIND v(dout0_8) AT=85.025n

.meas tran vdout0_9ck160 FIND v(dout0_9) AT=85.025n

.meas tran vdout0_10ck160 FIND v(dout0_10) AT=85.025n

.meas tran vdout0_11ck160 FIND v(dout0_11) AT=85.025n

.meas tran vdout0_12ck160 FIND v(dout0_12) AT=85.025n

.meas tran vdout0_13ck160 FIND v(dout0_13) AT=85.025n

.meas tran vdout0_14ck160 FIND v(dout0_14) AT=85.025n

.meas tran vdout0_15ck160 FIND v(dout0_15) AT=85.025n

.meas tran vdout0_16ck160 FIND v(dout0_16) AT=85.025n

.meas tran vdout0_17ck160 FIND v(dout0_17) AT=85.025n

.meas tran vdout0_18ck160 FIND v(dout0_18) AT=85.025n

.meas tran vdout0_19ck160 FIND v(dout0_19) AT=85.025n

.meas tran vdout0_20ck160 FIND v(dout0_20) AT=85.025n

.meas tran vdout0_21ck160 FIND v(dout0_21) AT=85.025n

.meas tran vdout0_22ck160 FIND v(dout0_22) AT=85.025n

.meas tran vdout0_23ck160 FIND v(dout0_23) AT=85.025n

.meas tran vdout1_0ck160 FIND v(dout1_0) AT=85.025n

.meas tran vdout1_1ck160 FIND v(dout1_1) AT=85.025n

.meas tran vdout1_2ck160 FIND v(dout1_2) AT=85.025n

.meas tran vdout1_3ck160 FIND v(dout1_3) AT=85.025n

.meas tran vdout1_4ck160 FIND v(dout1_4) AT=85.025n

.meas tran vdout1_5ck160 FIND v(dout1_5) AT=85.025n

.meas tran vdout1_6ck160 FIND v(dout1_6) AT=85.025n

.meas tran vdout1_7ck160 FIND v(dout1_7) AT=85.025n

.meas tran vdout1_8ck160 FIND v(dout1_8) AT=85.025n

.meas tran vdout1_9ck160 FIND v(dout1_9) AT=85.025n

.meas tran vdout1_10ck160 FIND v(dout1_10) AT=85.025n

.meas tran vdout1_11ck160 FIND v(dout1_11) AT=85.025n

.meas tran vdout1_12ck160 FIND v(dout1_12) AT=85.025n

.meas tran vdout1_13ck160 FIND v(dout1_13) AT=85.025n

.meas tran vdout1_14ck160 FIND v(dout1_14) AT=85.025n

.meas tran vdout1_15ck160 FIND v(dout1_15) AT=85.025n

.meas tran vdout1_16ck160 FIND v(dout1_16) AT=85.025n

.meas tran vdout1_17ck160 FIND v(dout1_17) AT=85.025n

.meas tran vdout1_18ck160 FIND v(dout1_18) AT=85.025n

.meas tran vdout1_19ck160 FIND v(dout1_19) AT=85.025n

.meas tran vdout1_20ck160 FIND v(dout1_20) AT=85.025n

.meas tran vdout1_21ck160 FIND v(dout1_21) AT=85.025n

.meas tran vdout1_22ck160 FIND v(dout1_22) AT=85.025n

.meas tran vdout1_23ck160 FIND v(dout1_23) AT=85.025n

.meas tran vdout0_0ck170 FIND v(dout0_0) AT=90.025n

.meas tran vdout0_1ck170 FIND v(dout0_1) AT=90.025n

.meas tran vdout0_2ck170 FIND v(dout0_2) AT=90.025n

.meas tran vdout0_3ck170 FIND v(dout0_3) AT=90.025n

.meas tran vdout0_4ck170 FIND v(dout0_4) AT=90.025n

.meas tran vdout0_5ck170 FIND v(dout0_5) AT=90.025n

.meas tran vdout0_6ck170 FIND v(dout0_6) AT=90.025n

.meas tran vdout0_7ck170 FIND v(dout0_7) AT=90.025n

.meas tran vdout0_8ck170 FIND v(dout0_8) AT=90.025n

.meas tran vdout0_9ck170 FIND v(dout0_9) AT=90.025n

.meas tran vdout0_10ck170 FIND v(dout0_10) AT=90.025n

.meas tran vdout0_11ck170 FIND v(dout0_11) AT=90.025n

.meas tran vdout0_12ck170 FIND v(dout0_12) AT=90.025n

.meas tran vdout0_13ck170 FIND v(dout0_13) AT=90.025n

.meas tran vdout0_14ck170 FIND v(dout0_14) AT=90.025n

.meas tran vdout0_15ck170 FIND v(dout0_15) AT=90.025n

.meas tran vdout0_16ck170 FIND v(dout0_16) AT=90.025n

.meas tran vdout0_17ck170 FIND v(dout0_17) AT=90.025n

.meas tran vdout0_18ck170 FIND v(dout0_18) AT=90.025n

.meas tran vdout0_19ck170 FIND v(dout0_19) AT=90.025n

.meas tran vdout0_20ck170 FIND v(dout0_20) AT=90.025n

.meas tran vdout0_21ck170 FIND v(dout0_21) AT=90.025n

.meas tran vdout0_22ck170 FIND v(dout0_22) AT=90.025n

.meas tran vdout0_23ck170 FIND v(dout0_23) AT=90.025n

.meas tran vdout1_0ck180 FIND v(dout1_0) AT=95.025n

.meas tran vdout1_1ck180 FIND v(dout1_1) AT=95.025n

.meas tran vdout1_2ck180 FIND v(dout1_2) AT=95.025n

.meas tran vdout1_3ck180 FIND v(dout1_3) AT=95.025n

.meas tran vdout1_4ck180 FIND v(dout1_4) AT=95.025n

.meas tran vdout1_5ck180 FIND v(dout1_5) AT=95.025n

.meas tran vdout1_6ck180 FIND v(dout1_6) AT=95.025n

.meas tran vdout1_7ck180 FIND v(dout1_7) AT=95.025n

.meas tran vdout1_8ck180 FIND v(dout1_8) AT=95.025n

.meas tran vdout1_9ck180 FIND v(dout1_9) AT=95.025n

.meas tran vdout1_10ck180 FIND v(dout1_10) AT=95.025n

.meas tran vdout1_11ck180 FIND v(dout1_11) AT=95.025n

.meas tran vdout1_12ck180 FIND v(dout1_12) AT=95.025n

.meas tran vdout1_13ck180 FIND v(dout1_13) AT=95.025n

.meas tran vdout1_14ck180 FIND v(dout1_14) AT=95.025n

.meas tran vdout1_15ck180 FIND v(dout1_15) AT=95.025n

.meas tran vdout1_16ck180 FIND v(dout1_16) AT=95.025n

.meas tran vdout1_17ck180 FIND v(dout1_17) AT=95.025n

.meas tran vdout1_18ck180 FIND v(dout1_18) AT=95.025n

.meas tran vdout1_19ck180 FIND v(dout1_19) AT=95.025n

.meas tran vdout1_20ck180 FIND v(dout1_20) AT=95.025n

.meas tran vdout1_21ck180 FIND v(dout1_21) AT=95.025n

.meas tran vdout1_22ck180 FIND v(dout1_22) AT=95.025n

.meas tran vdout1_23ck180 FIND v(dout1_23) AT=95.025n

.meas tran vdout1_0ck200 FIND v(dout1_0) AT=105.025n

.meas tran vdout1_1ck200 FIND v(dout1_1) AT=105.025n

.meas tran vdout1_2ck200 FIND v(dout1_2) AT=105.025n

.meas tran vdout1_3ck200 FIND v(dout1_3) AT=105.025n

.meas tran vdout1_4ck200 FIND v(dout1_4) AT=105.025n

.meas tran vdout1_5ck200 FIND v(dout1_5) AT=105.025n

.meas tran vdout1_6ck200 FIND v(dout1_6) AT=105.025n

.meas tran vdout1_7ck200 FIND v(dout1_7) AT=105.025n

.meas tran vdout1_8ck200 FIND v(dout1_8) AT=105.025n

.meas tran vdout1_9ck200 FIND v(dout1_9) AT=105.025n

.meas tran vdout1_10ck200 FIND v(dout1_10) AT=105.025n

.meas tran vdout1_11ck200 FIND v(dout1_11) AT=105.025n

.meas tran vdout1_12ck200 FIND v(dout1_12) AT=105.025n

.meas tran vdout1_13ck200 FIND v(dout1_13) AT=105.025n

.meas tran vdout1_14ck200 FIND v(dout1_14) AT=105.025n

.meas tran vdout1_15ck200 FIND v(dout1_15) AT=105.025n

.meas tran vdout1_16ck200 FIND v(dout1_16) AT=105.025n

.meas tran vdout1_17ck200 FIND v(dout1_17) AT=105.025n

.meas tran vdout1_18ck200 FIND v(dout1_18) AT=105.025n

.meas tran vdout1_19ck200 FIND v(dout1_19) AT=105.025n

.meas tran vdout1_20ck200 FIND v(dout1_20) AT=105.025n

.meas tran vdout1_21ck200 FIND v(dout1_21) AT=105.025n

.meas tran vdout1_22ck200 FIND v(dout1_22) AT=105.025n

.meas tran vdout1_23ck200 FIND v(dout1_23) AT=105.025n

.meas tran vdout0_0ck210 FIND v(dout0_0) AT=110.025n

.meas tran vdout0_1ck210 FIND v(dout0_1) AT=110.025n

.meas tran vdout0_2ck210 FIND v(dout0_2) AT=110.025n

.meas tran vdout0_3ck210 FIND v(dout0_3) AT=110.025n

.meas tran vdout0_4ck210 FIND v(dout0_4) AT=110.025n

.meas tran vdout0_5ck210 FIND v(dout0_5) AT=110.025n

.meas tran vdout0_6ck210 FIND v(dout0_6) AT=110.025n

.meas tran vdout0_7ck210 FIND v(dout0_7) AT=110.025n

.meas tran vdout0_8ck210 FIND v(dout0_8) AT=110.025n

.meas tran vdout0_9ck210 FIND v(dout0_9) AT=110.025n

.meas tran vdout0_10ck210 FIND v(dout0_10) AT=110.025n

.meas tran vdout0_11ck210 FIND v(dout0_11) AT=110.025n

.meas tran vdout0_12ck210 FIND v(dout0_12) AT=110.025n

.meas tran vdout0_13ck210 FIND v(dout0_13) AT=110.025n

.meas tran vdout0_14ck210 FIND v(dout0_14) AT=110.025n

.meas tran vdout0_15ck210 FIND v(dout0_15) AT=110.025n

.meas tran vdout0_16ck210 FIND v(dout0_16) AT=110.025n

.meas tran vdout0_17ck210 FIND v(dout0_17) AT=110.025n

.meas tran vdout0_18ck210 FIND v(dout0_18) AT=110.025n

.meas tran vdout0_19ck210 FIND v(dout0_19) AT=110.025n

.meas tran vdout0_20ck210 FIND v(dout0_20) AT=110.025n

.meas tran vdout0_21ck210 FIND v(dout0_21) AT=110.025n

.meas tran vdout0_22ck210 FIND v(dout0_22) AT=110.025n

.meas tran vdout0_23ck210 FIND v(dout0_23) AT=110.025n

.meas tran vdout1_0ck230 FIND v(dout1_0) AT=120.025n

.meas tran vdout1_1ck230 FIND v(dout1_1) AT=120.025n

.meas tran vdout1_2ck230 FIND v(dout1_2) AT=120.025n

.meas tran vdout1_3ck230 FIND v(dout1_3) AT=120.025n

.meas tran vdout1_4ck230 FIND v(dout1_4) AT=120.025n

.meas tran vdout1_5ck230 FIND v(dout1_5) AT=120.025n

.meas tran vdout1_6ck230 FIND v(dout1_6) AT=120.025n

.meas tran vdout1_7ck230 FIND v(dout1_7) AT=120.025n

.meas tran vdout1_8ck230 FIND v(dout1_8) AT=120.025n

.meas tran vdout1_9ck230 FIND v(dout1_9) AT=120.025n

.meas tran vdout1_10ck230 FIND v(dout1_10) AT=120.025n

.meas tran vdout1_11ck230 FIND v(dout1_11) AT=120.025n

.meas tran vdout1_12ck230 FIND v(dout1_12) AT=120.025n

.meas tran vdout1_13ck230 FIND v(dout1_13) AT=120.025n

.meas tran vdout1_14ck230 FIND v(dout1_14) AT=120.025n

.meas tran vdout1_15ck230 FIND v(dout1_15) AT=120.025n

.meas tran vdout1_16ck230 FIND v(dout1_16) AT=120.025n

.meas tran vdout1_17ck230 FIND v(dout1_17) AT=120.025n

.meas tran vdout1_18ck230 FIND v(dout1_18) AT=120.025n

.meas tran vdout1_19ck230 FIND v(dout1_19) AT=120.025n

.meas tran vdout1_20ck230 FIND v(dout1_20) AT=120.025n

.meas tran vdout1_21ck230 FIND v(dout1_21) AT=120.025n

.meas tran vdout1_22ck230 FIND v(dout1_22) AT=120.025n

.meas tran vdout1_23ck230 FIND v(dout1_23) AT=120.025n

.meas tran vdout1_0ck290 FIND v(dout1_0) AT=150.025n

.meas tran vdout1_1ck290 FIND v(dout1_1) AT=150.025n

.meas tran vdout1_2ck290 FIND v(dout1_2) AT=150.025n

.meas tran vdout1_3ck290 FIND v(dout1_3) AT=150.025n

.meas tran vdout1_4ck290 FIND v(dout1_4) AT=150.025n

.meas tran vdout1_5ck290 FIND v(dout1_5) AT=150.025n

.meas tran vdout1_6ck290 FIND v(dout1_6) AT=150.025n

.meas tran vdout1_7ck290 FIND v(dout1_7) AT=150.025n

.meas tran vdout1_8ck290 FIND v(dout1_8) AT=150.025n

.meas tran vdout1_9ck290 FIND v(dout1_9) AT=150.025n

.meas tran vdout1_10ck290 FIND v(dout1_10) AT=150.025n

.meas tran vdout1_11ck290 FIND v(dout1_11) AT=150.025n

.meas tran vdout1_12ck290 FIND v(dout1_12) AT=150.025n

.meas tran vdout1_13ck290 FIND v(dout1_13) AT=150.025n

.meas tran vdout1_14ck290 FIND v(dout1_14) AT=150.025n

.meas tran vdout1_15ck290 FIND v(dout1_15) AT=150.025n

.meas tran vdout1_16ck290 FIND v(dout1_16) AT=150.025n

.meas tran vdout1_17ck290 FIND v(dout1_17) AT=150.025n

.meas tran vdout1_18ck290 FIND v(dout1_18) AT=150.025n

.meas tran vdout1_19ck290 FIND v(dout1_19) AT=150.025n

.meas tran vdout1_20ck290 FIND v(dout1_20) AT=150.025n

.meas tran vdout1_21ck290 FIND v(dout1_21) AT=150.025n

.meas tran vdout1_22ck290 FIND v(dout1_22) AT=150.025n

.meas tran vdout1_23ck290 FIND v(dout1_23) AT=150.025n

.meas tran vdout0_0ck310 FIND v(dout0_0) AT=160.025n

.meas tran vdout0_1ck310 FIND v(dout0_1) AT=160.025n

.meas tran vdout0_2ck310 FIND v(dout0_2) AT=160.025n

.meas tran vdout0_3ck310 FIND v(dout0_3) AT=160.025n

.meas tran vdout0_4ck310 FIND v(dout0_4) AT=160.025n

.meas tran vdout0_5ck310 FIND v(dout0_5) AT=160.025n

.meas tran vdout0_6ck310 FIND v(dout0_6) AT=160.025n

.meas tran vdout0_7ck310 FIND v(dout0_7) AT=160.025n

.meas tran vdout0_8ck310 FIND v(dout0_8) AT=160.025n

.meas tran vdout0_9ck310 FIND v(dout0_9) AT=160.025n

.meas tran vdout0_10ck310 FIND v(dout0_10) AT=160.025n

.meas tran vdout0_11ck310 FIND v(dout0_11) AT=160.025n

.meas tran vdout0_12ck310 FIND v(dout0_12) AT=160.025n

.meas tran vdout0_13ck310 FIND v(dout0_13) AT=160.025n

.meas tran vdout0_14ck310 FIND v(dout0_14) AT=160.025n

.meas tran vdout0_15ck310 FIND v(dout0_15) AT=160.025n

.meas tran vdout0_16ck310 FIND v(dout0_16) AT=160.025n

.meas tran vdout0_17ck310 FIND v(dout0_17) AT=160.025n

.meas tran vdout0_18ck310 FIND v(dout0_18) AT=160.025n

.meas tran vdout0_19ck310 FIND v(dout0_19) AT=160.025n

.meas tran vdout0_20ck310 FIND v(dout0_20) AT=160.025n

.meas tran vdout0_21ck310 FIND v(dout0_21) AT=160.025n

.meas tran vdout0_22ck310 FIND v(dout0_22) AT=160.025n

.meas tran vdout0_23ck310 FIND v(dout0_23) AT=160.025n

.meas tran vdout1_0ck310 FIND v(dout1_0) AT=160.025n

.meas tran vdout1_1ck310 FIND v(dout1_1) AT=160.025n

.meas tran vdout1_2ck310 FIND v(dout1_2) AT=160.025n

.meas tran vdout1_3ck310 FIND v(dout1_3) AT=160.025n

.meas tran vdout1_4ck310 FIND v(dout1_4) AT=160.025n

.meas tran vdout1_5ck310 FIND v(dout1_5) AT=160.025n

.meas tran vdout1_6ck310 FIND v(dout1_6) AT=160.025n

.meas tran vdout1_7ck310 FIND v(dout1_7) AT=160.025n

.meas tran vdout1_8ck310 FIND v(dout1_8) AT=160.025n

.meas tran vdout1_9ck310 FIND v(dout1_9) AT=160.025n

.meas tran vdout1_10ck310 FIND v(dout1_10) AT=160.025n

.meas tran vdout1_11ck310 FIND v(dout1_11) AT=160.025n

.meas tran vdout1_12ck310 FIND v(dout1_12) AT=160.025n

.meas tran vdout1_13ck310 FIND v(dout1_13) AT=160.025n

.meas tran vdout1_14ck310 FIND v(dout1_14) AT=160.025n

.meas tran vdout1_15ck310 FIND v(dout1_15) AT=160.025n

.meas tran vdout1_16ck310 FIND v(dout1_16) AT=160.025n

.meas tran vdout1_17ck310 FIND v(dout1_17) AT=160.025n

.meas tran vdout1_18ck310 FIND v(dout1_18) AT=160.025n

.meas tran vdout1_19ck310 FIND v(dout1_19) AT=160.025n

.meas tran vdout1_20ck310 FIND v(dout1_20) AT=160.025n

.meas tran vdout1_21ck310 FIND v(dout1_21) AT=160.025n

.meas tran vdout1_22ck310 FIND v(dout1_22) AT=160.025n

.meas tran vdout1_23ck310 FIND v(dout1_23) AT=160.025n

.meas tran vdout0_0ck320 FIND v(dout0_0) AT=165.025n

.meas tran vdout0_1ck320 FIND v(dout0_1) AT=165.025n

.meas tran vdout0_2ck320 FIND v(dout0_2) AT=165.025n

.meas tran vdout0_3ck320 FIND v(dout0_3) AT=165.025n

.meas tran vdout0_4ck320 FIND v(dout0_4) AT=165.025n

.meas tran vdout0_5ck320 FIND v(dout0_5) AT=165.025n

.meas tran vdout0_6ck320 FIND v(dout0_6) AT=165.025n

.meas tran vdout0_7ck320 FIND v(dout0_7) AT=165.025n

.meas tran vdout0_8ck320 FIND v(dout0_8) AT=165.025n

.meas tran vdout0_9ck320 FIND v(dout0_9) AT=165.025n

.meas tran vdout0_10ck320 FIND v(dout0_10) AT=165.025n

.meas tran vdout0_11ck320 FIND v(dout0_11) AT=165.025n

.meas tran vdout0_12ck320 FIND v(dout0_12) AT=165.025n

.meas tran vdout0_13ck320 FIND v(dout0_13) AT=165.025n

.meas tran vdout0_14ck320 FIND v(dout0_14) AT=165.025n

.meas tran vdout0_15ck320 FIND v(dout0_15) AT=165.025n

.meas tran vdout0_16ck320 FIND v(dout0_16) AT=165.025n

.meas tran vdout0_17ck320 FIND v(dout0_17) AT=165.025n

.meas tran vdout0_18ck320 FIND v(dout0_18) AT=165.025n

.meas tran vdout0_19ck320 FIND v(dout0_19) AT=165.025n

.meas tran vdout0_20ck320 FIND v(dout0_20) AT=165.025n

.meas tran vdout0_21ck320 FIND v(dout0_21) AT=165.025n

.meas tran vdout0_22ck320 FIND v(dout0_22) AT=165.025n

.meas tran vdout0_23ck320 FIND v(dout0_23) AT=165.025n

.meas tran vdout1_0ck320 FIND v(dout1_0) AT=165.025n

.meas tran vdout1_1ck320 FIND v(dout1_1) AT=165.025n

.meas tran vdout1_2ck320 FIND v(dout1_2) AT=165.025n

.meas tran vdout1_3ck320 FIND v(dout1_3) AT=165.025n

.meas tran vdout1_4ck320 FIND v(dout1_4) AT=165.025n

.meas tran vdout1_5ck320 FIND v(dout1_5) AT=165.025n

.meas tran vdout1_6ck320 FIND v(dout1_6) AT=165.025n

.meas tran vdout1_7ck320 FIND v(dout1_7) AT=165.025n

.meas tran vdout1_8ck320 FIND v(dout1_8) AT=165.025n

.meas tran vdout1_9ck320 FIND v(dout1_9) AT=165.025n

.meas tran vdout1_10ck320 FIND v(dout1_10) AT=165.025n

.meas tran vdout1_11ck320 FIND v(dout1_11) AT=165.025n

.meas tran vdout1_12ck320 FIND v(dout1_12) AT=165.025n

.meas tran vdout1_13ck320 FIND v(dout1_13) AT=165.025n

.meas tran vdout1_14ck320 FIND v(dout1_14) AT=165.025n

.meas tran vdout1_15ck320 FIND v(dout1_15) AT=165.025n

.meas tran vdout1_16ck320 FIND v(dout1_16) AT=165.025n

.meas tran vdout1_17ck320 FIND v(dout1_17) AT=165.025n

.meas tran vdout1_18ck320 FIND v(dout1_18) AT=165.025n

.meas tran vdout1_19ck320 FIND v(dout1_19) AT=165.025n

.meas tran vdout1_20ck320 FIND v(dout1_20) AT=165.025n

.meas tran vdout1_21ck320 FIND v(dout1_21) AT=165.025n

.meas tran vdout1_22ck320 FIND v(dout1_22) AT=165.025n

.meas tran vdout1_23ck320 FIND v(dout1_23) AT=165.025n

.meas tran vdout0_0ck330 FIND v(dout0_0) AT=170.025n

.meas tran vdout0_1ck330 FIND v(dout0_1) AT=170.025n

.meas tran vdout0_2ck330 FIND v(dout0_2) AT=170.025n

.meas tran vdout0_3ck330 FIND v(dout0_3) AT=170.025n

.meas tran vdout0_4ck330 FIND v(dout0_4) AT=170.025n

.meas tran vdout0_5ck330 FIND v(dout0_5) AT=170.025n

.meas tran vdout0_6ck330 FIND v(dout0_6) AT=170.025n

.meas tran vdout0_7ck330 FIND v(dout0_7) AT=170.025n

.meas tran vdout0_8ck330 FIND v(dout0_8) AT=170.025n

.meas tran vdout0_9ck330 FIND v(dout0_9) AT=170.025n

.meas tran vdout0_10ck330 FIND v(dout0_10) AT=170.025n

.meas tran vdout0_11ck330 FIND v(dout0_11) AT=170.025n

.meas tran vdout0_12ck330 FIND v(dout0_12) AT=170.025n

.meas tran vdout0_13ck330 FIND v(dout0_13) AT=170.025n

.meas tran vdout0_14ck330 FIND v(dout0_14) AT=170.025n

.meas tran vdout0_15ck330 FIND v(dout0_15) AT=170.025n

.meas tran vdout0_16ck330 FIND v(dout0_16) AT=170.025n

.meas tran vdout0_17ck330 FIND v(dout0_17) AT=170.025n

.meas tran vdout0_18ck330 FIND v(dout0_18) AT=170.025n

.meas tran vdout0_19ck330 FIND v(dout0_19) AT=170.025n

.meas tran vdout0_20ck330 FIND v(dout0_20) AT=170.025n

.meas tran vdout0_21ck330 FIND v(dout0_21) AT=170.025n

.meas tran vdout0_22ck330 FIND v(dout0_22) AT=170.025n

.meas tran vdout0_23ck330 FIND v(dout0_23) AT=170.025n

.meas tran vdout1_0ck330 FIND v(dout1_0) AT=170.025n

.meas tran vdout1_1ck330 FIND v(dout1_1) AT=170.025n

.meas tran vdout1_2ck330 FIND v(dout1_2) AT=170.025n

.meas tran vdout1_3ck330 FIND v(dout1_3) AT=170.025n

.meas tran vdout1_4ck330 FIND v(dout1_4) AT=170.025n

.meas tran vdout1_5ck330 FIND v(dout1_5) AT=170.025n

.meas tran vdout1_6ck330 FIND v(dout1_6) AT=170.025n

.meas tran vdout1_7ck330 FIND v(dout1_7) AT=170.025n

.meas tran vdout1_8ck330 FIND v(dout1_8) AT=170.025n

.meas tran vdout1_9ck330 FIND v(dout1_9) AT=170.025n

.meas tran vdout1_10ck330 FIND v(dout1_10) AT=170.025n

.meas tran vdout1_11ck330 FIND v(dout1_11) AT=170.025n

.meas tran vdout1_12ck330 FIND v(dout1_12) AT=170.025n

.meas tran vdout1_13ck330 FIND v(dout1_13) AT=170.025n

.meas tran vdout1_14ck330 FIND v(dout1_14) AT=170.025n

.meas tran vdout1_15ck330 FIND v(dout1_15) AT=170.025n

.meas tran vdout1_16ck330 FIND v(dout1_16) AT=170.025n

.meas tran vdout1_17ck330 FIND v(dout1_17) AT=170.025n

.meas tran vdout1_18ck330 FIND v(dout1_18) AT=170.025n

.meas tran vdout1_19ck330 FIND v(dout1_19) AT=170.025n

.meas tran vdout1_20ck330 FIND v(dout1_20) AT=170.025n

.meas tran vdout1_21ck330 FIND v(dout1_21) AT=170.025n

.meas tran vdout1_22ck330 FIND v(dout1_22) AT=170.025n

.meas tran vdout1_23ck330 FIND v(dout1_23) AT=170.025n

.meas tran vdout0_0ck350 FIND v(dout0_0) AT=180.025n

.meas tran vdout0_1ck350 FIND v(dout0_1) AT=180.025n

.meas tran vdout0_2ck350 FIND v(dout0_2) AT=180.025n

.meas tran vdout0_3ck350 FIND v(dout0_3) AT=180.025n

.meas tran vdout0_4ck350 FIND v(dout0_4) AT=180.025n

.meas tran vdout0_5ck350 FIND v(dout0_5) AT=180.025n

.meas tran vdout0_6ck350 FIND v(dout0_6) AT=180.025n

.meas tran vdout0_7ck350 FIND v(dout0_7) AT=180.025n

.meas tran vdout0_8ck350 FIND v(dout0_8) AT=180.025n

.meas tran vdout0_9ck350 FIND v(dout0_9) AT=180.025n

.meas tran vdout0_10ck350 FIND v(dout0_10) AT=180.025n

.meas tran vdout0_11ck350 FIND v(dout0_11) AT=180.025n

.meas tran vdout0_12ck350 FIND v(dout0_12) AT=180.025n

.meas tran vdout0_13ck350 FIND v(dout0_13) AT=180.025n

.meas tran vdout0_14ck350 FIND v(dout0_14) AT=180.025n

.meas tran vdout0_15ck350 FIND v(dout0_15) AT=180.025n

.meas tran vdout0_16ck350 FIND v(dout0_16) AT=180.025n

.meas tran vdout0_17ck350 FIND v(dout0_17) AT=180.025n

.meas tran vdout0_18ck350 FIND v(dout0_18) AT=180.025n

.meas tran vdout0_19ck350 FIND v(dout0_19) AT=180.025n

.meas tran vdout0_20ck350 FIND v(dout0_20) AT=180.025n

.meas tran vdout0_21ck350 FIND v(dout0_21) AT=180.025n

.meas tran vdout0_22ck350 FIND v(dout0_22) AT=180.025n

.meas tran vdout0_23ck350 FIND v(dout0_23) AT=180.025n

.meas tran vdout1_0ck360 FIND v(dout1_0) AT=185.025n

.meas tran vdout1_1ck360 FIND v(dout1_1) AT=185.025n

.meas tran vdout1_2ck360 FIND v(dout1_2) AT=185.025n

.meas tran vdout1_3ck360 FIND v(dout1_3) AT=185.025n

.meas tran vdout1_4ck360 FIND v(dout1_4) AT=185.025n

.meas tran vdout1_5ck360 FIND v(dout1_5) AT=185.025n

.meas tran vdout1_6ck360 FIND v(dout1_6) AT=185.025n

.meas tran vdout1_7ck360 FIND v(dout1_7) AT=185.025n

.meas tran vdout1_8ck360 FIND v(dout1_8) AT=185.025n

.meas tran vdout1_9ck360 FIND v(dout1_9) AT=185.025n

.meas tran vdout1_10ck360 FIND v(dout1_10) AT=185.025n

.meas tran vdout1_11ck360 FIND v(dout1_11) AT=185.025n

.meas tran vdout1_12ck360 FIND v(dout1_12) AT=185.025n

.meas tran vdout1_13ck360 FIND v(dout1_13) AT=185.025n

.meas tran vdout1_14ck360 FIND v(dout1_14) AT=185.025n

.meas tran vdout1_15ck360 FIND v(dout1_15) AT=185.025n

.meas tran vdout1_16ck360 FIND v(dout1_16) AT=185.025n

.meas tran vdout1_17ck360 FIND v(dout1_17) AT=185.025n

.meas tran vdout1_18ck360 FIND v(dout1_18) AT=185.025n

.meas tran vdout1_19ck360 FIND v(dout1_19) AT=185.025n

.meas tran vdout1_20ck360 FIND v(dout1_20) AT=185.025n

.meas tran vdout1_21ck360 FIND v(dout1_21) AT=185.025n

.meas tran vdout1_22ck360 FIND v(dout1_22) AT=185.025n

.meas tran vdout1_23ck360 FIND v(dout1_23) AT=185.025n

.meas tran vdout0_0ck370 FIND v(dout0_0) AT=190.025n

.meas tran vdout0_1ck370 FIND v(dout0_1) AT=190.025n

.meas tran vdout0_2ck370 FIND v(dout0_2) AT=190.025n

.meas tran vdout0_3ck370 FIND v(dout0_3) AT=190.025n

.meas tran vdout0_4ck370 FIND v(dout0_4) AT=190.025n

.meas tran vdout0_5ck370 FIND v(dout0_5) AT=190.025n

.meas tran vdout0_6ck370 FIND v(dout0_6) AT=190.025n

.meas tran vdout0_7ck370 FIND v(dout0_7) AT=190.025n

.meas tran vdout0_8ck370 FIND v(dout0_8) AT=190.025n

.meas tran vdout0_9ck370 FIND v(dout0_9) AT=190.025n

.meas tran vdout0_10ck370 FIND v(dout0_10) AT=190.025n

.meas tran vdout0_11ck370 FIND v(dout0_11) AT=190.025n

.meas tran vdout0_12ck370 FIND v(dout0_12) AT=190.025n

.meas tran vdout0_13ck370 FIND v(dout0_13) AT=190.025n

.meas tran vdout0_14ck370 FIND v(dout0_14) AT=190.025n

.meas tran vdout0_15ck370 FIND v(dout0_15) AT=190.025n

.meas tran vdout0_16ck370 FIND v(dout0_16) AT=190.025n

.meas tran vdout0_17ck370 FIND v(dout0_17) AT=190.025n

.meas tran vdout0_18ck370 FIND v(dout0_18) AT=190.025n

.meas tran vdout0_19ck370 FIND v(dout0_19) AT=190.025n

.meas tran vdout0_20ck370 FIND v(dout0_20) AT=190.025n

.meas tran vdout0_21ck370 FIND v(dout0_21) AT=190.025n

.meas tran vdout0_22ck370 FIND v(dout0_22) AT=190.025n

.meas tran vdout0_23ck370 FIND v(dout0_23) AT=190.025n

.meas tran vdout0_0ck380 FIND v(dout0_0) AT=195.025n

.meas tran vdout0_1ck380 FIND v(dout0_1) AT=195.025n

.meas tran vdout0_2ck380 FIND v(dout0_2) AT=195.025n

.meas tran vdout0_3ck380 FIND v(dout0_3) AT=195.025n

.meas tran vdout0_4ck380 FIND v(dout0_4) AT=195.025n

.meas tran vdout0_5ck380 FIND v(dout0_5) AT=195.025n

.meas tran vdout0_6ck380 FIND v(dout0_6) AT=195.025n

.meas tran vdout0_7ck380 FIND v(dout0_7) AT=195.025n

.meas tran vdout0_8ck380 FIND v(dout0_8) AT=195.025n

.meas tran vdout0_9ck380 FIND v(dout0_9) AT=195.025n

.meas tran vdout0_10ck380 FIND v(dout0_10) AT=195.025n

.meas tran vdout0_11ck380 FIND v(dout0_11) AT=195.025n

.meas tran vdout0_12ck380 FIND v(dout0_12) AT=195.025n

.meas tran vdout0_13ck380 FIND v(dout0_13) AT=195.025n

.meas tran vdout0_14ck380 FIND v(dout0_14) AT=195.025n

.meas tran vdout0_15ck380 FIND v(dout0_15) AT=195.025n

.meas tran vdout0_16ck380 FIND v(dout0_16) AT=195.025n

.meas tran vdout0_17ck380 FIND v(dout0_17) AT=195.025n

.meas tran vdout0_18ck380 FIND v(dout0_18) AT=195.025n

.meas tran vdout0_19ck380 FIND v(dout0_19) AT=195.025n

.meas tran vdout0_20ck380 FIND v(dout0_20) AT=195.025n

.meas tran vdout0_21ck380 FIND v(dout0_21) AT=195.025n

.meas tran vdout0_22ck380 FIND v(dout0_22) AT=195.025n

.meas tran vdout0_23ck380 FIND v(dout0_23) AT=195.025n

.meas tran vdout0_0ck390 FIND v(dout0_0) AT=200.025n

.meas tran vdout0_1ck390 FIND v(dout0_1) AT=200.025n

.meas tran vdout0_2ck390 FIND v(dout0_2) AT=200.025n

.meas tran vdout0_3ck390 FIND v(dout0_3) AT=200.025n

.meas tran vdout0_4ck390 FIND v(dout0_4) AT=200.025n

.meas tran vdout0_5ck390 FIND v(dout0_5) AT=200.025n

.meas tran vdout0_6ck390 FIND v(dout0_6) AT=200.025n

.meas tran vdout0_7ck390 FIND v(dout0_7) AT=200.025n

.meas tran vdout0_8ck390 FIND v(dout0_8) AT=200.025n

.meas tran vdout0_9ck390 FIND v(dout0_9) AT=200.025n

.meas tran vdout0_10ck390 FIND v(dout0_10) AT=200.025n

.meas tran vdout0_11ck390 FIND v(dout0_11) AT=200.025n

.meas tran vdout0_12ck390 FIND v(dout0_12) AT=200.025n

.meas tran vdout0_13ck390 FIND v(dout0_13) AT=200.025n

.meas tran vdout0_14ck390 FIND v(dout0_14) AT=200.025n

.meas tran vdout0_15ck390 FIND v(dout0_15) AT=200.025n

.meas tran vdout0_16ck390 FIND v(dout0_16) AT=200.025n

.meas tran vdout0_17ck390 FIND v(dout0_17) AT=200.025n

.meas tran vdout0_18ck390 FIND v(dout0_18) AT=200.025n

.meas tran vdout0_19ck390 FIND v(dout0_19) AT=200.025n

.meas tran vdout0_20ck390 FIND v(dout0_20) AT=200.025n

.meas tran vdout0_21ck390 FIND v(dout0_21) AT=200.025n

.meas tran vdout0_22ck390 FIND v(dout0_22) AT=200.025n

.meas tran vdout0_23ck390 FIND v(dout0_23) AT=200.025n

.meas tran vdout0_0ck400 FIND v(dout0_0) AT=205.025n

.meas tran vdout0_1ck400 FIND v(dout0_1) AT=205.025n

.meas tran vdout0_2ck400 FIND v(dout0_2) AT=205.025n

.meas tran vdout0_3ck400 FIND v(dout0_3) AT=205.025n

.meas tran vdout0_4ck400 FIND v(dout0_4) AT=205.025n

.meas tran vdout0_5ck400 FIND v(dout0_5) AT=205.025n

.meas tran vdout0_6ck400 FIND v(dout0_6) AT=205.025n

.meas tran vdout0_7ck400 FIND v(dout0_7) AT=205.025n

.meas tran vdout0_8ck400 FIND v(dout0_8) AT=205.025n

.meas tran vdout0_9ck400 FIND v(dout0_9) AT=205.025n

.meas tran vdout0_10ck400 FIND v(dout0_10) AT=205.025n

.meas tran vdout0_11ck400 FIND v(dout0_11) AT=205.025n

.meas tran vdout0_12ck400 FIND v(dout0_12) AT=205.025n

.meas tran vdout0_13ck400 FIND v(dout0_13) AT=205.025n

.meas tran vdout0_14ck400 FIND v(dout0_14) AT=205.025n

.meas tran vdout0_15ck400 FIND v(dout0_15) AT=205.025n

.meas tran vdout0_16ck400 FIND v(dout0_16) AT=205.025n

.meas tran vdout0_17ck400 FIND v(dout0_17) AT=205.025n

.meas tran vdout0_18ck400 FIND v(dout0_18) AT=205.025n

.meas tran vdout0_19ck400 FIND v(dout0_19) AT=205.025n

.meas tran vdout0_20ck400 FIND v(dout0_20) AT=205.025n

.meas tran vdout0_21ck400 FIND v(dout0_21) AT=205.025n

.meas tran vdout0_22ck400 FIND v(dout0_22) AT=205.025n

.meas tran vdout0_23ck400 FIND v(dout0_23) AT=205.025n

.meas tran vdout1_0ck420 FIND v(dout1_0) AT=215.025n

.meas tran vdout1_1ck420 FIND v(dout1_1) AT=215.025n

.meas tran vdout1_2ck420 FIND v(dout1_2) AT=215.025n

.meas tran vdout1_3ck420 FIND v(dout1_3) AT=215.025n

.meas tran vdout1_4ck420 FIND v(dout1_4) AT=215.025n

.meas tran vdout1_5ck420 FIND v(dout1_5) AT=215.025n

.meas tran vdout1_6ck420 FIND v(dout1_6) AT=215.025n

.meas tran vdout1_7ck420 FIND v(dout1_7) AT=215.025n

.meas tran vdout1_8ck420 FIND v(dout1_8) AT=215.025n

.meas tran vdout1_9ck420 FIND v(dout1_9) AT=215.025n

.meas tran vdout1_10ck420 FIND v(dout1_10) AT=215.025n

.meas tran vdout1_11ck420 FIND v(dout1_11) AT=215.025n

.meas tran vdout1_12ck420 FIND v(dout1_12) AT=215.025n

.meas tran vdout1_13ck420 FIND v(dout1_13) AT=215.025n

.meas tran vdout1_14ck420 FIND v(dout1_14) AT=215.025n

.meas tran vdout1_15ck420 FIND v(dout1_15) AT=215.025n

.meas tran vdout1_16ck420 FIND v(dout1_16) AT=215.025n

.meas tran vdout1_17ck420 FIND v(dout1_17) AT=215.025n

.meas tran vdout1_18ck420 FIND v(dout1_18) AT=215.025n

.meas tran vdout1_19ck420 FIND v(dout1_19) AT=215.025n

.meas tran vdout1_20ck420 FIND v(dout1_20) AT=215.025n

.meas tran vdout1_21ck420 FIND v(dout1_21) AT=215.025n

.meas tran vdout1_22ck420 FIND v(dout1_22) AT=215.025n

.meas tran vdout1_23ck420 FIND v(dout1_23) AT=215.025n

.meas tran vdout0_0ck430 FIND v(dout0_0) AT=220.025n

.meas tran vdout0_1ck430 FIND v(dout0_1) AT=220.025n

.meas tran vdout0_2ck430 FIND v(dout0_2) AT=220.025n

.meas tran vdout0_3ck430 FIND v(dout0_3) AT=220.025n

.meas tran vdout0_4ck430 FIND v(dout0_4) AT=220.025n

.meas tran vdout0_5ck430 FIND v(dout0_5) AT=220.025n

.meas tran vdout0_6ck430 FIND v(dout0_6) AT=220.025n

.meas tran vdout0_7ck430 FIND v(dout0_7) AT=220.025n

.meas tran vdout0_8ck430 FIND v(dout0_8) AT=220.025n

.meas tran vdout0_9ck430 FIND v(dout0_9) AT=220.025n

.meas tran vdout0_10ck430 FIND v(dout0_10) AT=220.025n

.meas tran vdout0_11ck430 FIND v(dout0_11) AT=220.025n

.meas tran vdout0_12ck430 FIND v(dout0_12) AT=220.025n

.meas tran vdout0_13ck430 FIND v(dout0_13) AT=220.025n

.meas tran vdout0_14ck430 FIND v(dout0_14) AT=220.025n

.meas tran vdout0_15ck430 FIND v(dout0_15) AT=220.025n

.meas tran vdout0_16ck430 FIND v(dout0_16) AT=220.025n

.meas tran vdout0_17ck430 FIND v(dout0_17) AT=220.025n

.meas tran vdout0_18ck430 FIND v(dout0_18) AT=220.025n

.meas tran vdout0_19ck430 FIND v(dout0_19) AT=220.025n

.meas tran vdout0_20ck430 FIND v(dout0_20) AT=220.025n

.meas tran vdout0_21ck430 FIND v(dout0_21) AT=220.025n

.meas tran vdout0_22ck430 FIND v(dout0_22) AT=220.025n

.meas tran vdout0_23ck430 FIND v(dout0_23) AT=220.025n

.meas tran vdout1_0ck430 FIND v(dout1_0) AT=220.025n

.meas tran vdout1_1ck430 FIND v(dout1_1) AT=220.025n

.meas tran vdout1_2ck430 FIND v(dout1_2) AT=220.025n

.meas tran vdout1_3ck430 FIND v(dout1_3) AT=220.025n

.meas tran vdout1_4ck430 FIND v(dout1_4) AT=220.025n

.meas tran vdout1_5ck430 FIND v(dout1_5) AT=220.025n

.meas tran vdout1_6ck430 FIND v(dout1_6) AT=220.025n

.meas tran vdout1_7ck430 FIND v(dout1_7) AT=220.025n

.meas tran vdout1_8ck430 FIND v(dout1_8) AT=220.025n

.meas tran vdout1_9ck430 FIND v(dout1_9) AT=220.025n

.meas tran vdout1_10ck430 FIND v(dout1_10) AT=220.025n

.meas tran vdout1_11ck430 FIND v(dout1_11) AT=220.025n

.meas tran vdout1_12ck430 FIND v(dout1_12) AT=220.025n

.meas tran vdout1_13ck430 FIND v(dout1_13) AT=220.025n

.meas tran vdout1_14ck430 FIND v(dout1_14) AT=220.025n

.meas tran vdout1_15ck430 FIND v(dout1_15) AT=220.025n

.meas tran vdout1_16ck430 FIND v(dout1_16) AT=220.025n

.meas tran vdout1_17ck430 FIND v(dout1_17) AT=220.025n

.meas tran vdout1_18ck430 FIND v(dout1_18) AT=220.025n

.meas tran vdout1_19ck430 FIND v(dout1_19) AT=220.025n

.meas tran vdout1_20ck430 FIND v(dout1_20) AT=220.025n

.meas tran vdout1_21ck430 FIND v(dout1_21) AT=220.025n

.meas tran vdout1_22ck430 FIND v(dout1_22) AT=220.025n

.meas tran vdout1_23ck430 FIND v(dout1_23) AT=220.025n

.meas tran vdout0_0ck440 FIND v(dout0_0) AT=225.025n

.meas tran vdout0_1ck440 FIND v(dout0_1) AT=225.025n

.meas tran vdout0_2ck440 FIND v(dout0_2) AT=225.025n

.meas tran vdout0_3ck440 FIND v(dout0_3) AT=225.025n

.meas tran vdout0_4ck440 FIND v(dout0_4) AT=225.025n

.meas tran vdout0_5ck440 FIND v(dout0_5) AT=225.025n

.meas tran vdout0_6ck440 FIND v(dout0_6) AT=225.025n

.meas tran vdout0_7ck440 FIND v(dout0_7) AT=225.025n

.meas tran vdout0_8ck440 FIND v(dout0_8) AT=225.025n

.meas tran vdout0_9ck440 FIND v(dout0_9) AT=225.025n

.meas tran vdout0_10ck440 FIND v(dout0_10) AT=225.025n

.meas tran vdout0_11ck440 FIND v(dout0_11) AT=225.025n

.meas tran vdout0_12ck440 FIND v(dout0_12) AT=225.025n

.meas tran vdout0_13ck440 FIND v(dout0_13) AT=225.025n

.meas tran vdout0_14ck440 FIND v(dout0_14) AT=225.025n

.meas tran vdout0_15ck440 FIND v(dout0_15) AT=225.025n

.meas tran vdout0_16ck440 FIND v(dout0_16) AT=225.025n

.meas tran vdout0_17ck440 FIND v(dout0_17) AT=225.025n

.meas tran vdout0_18ck440 FIND v(dout0_18) AT=225.025n

.meas tran vdout0_19ck440 FIND v(dout0_19) AT=225.025n

.meas tran vdout0_20ck440 FIND v(dout0_20) AT=225.025n

.meas tran vdout0_21ck440 FIND v(dout0_21) AT=225.025n

.meas tran vdout0_22ck440 FIND v(dout0_22) AT=225.025n

.meas tran vdout0_23ck440 FIND v(dout0_23) AT=225.025n

.meas tran vdout1_0ck440 FIND v(dout1_0) AT=225.025n

.meas tran vdout1_1ck440 FIND v(dout1_1) AT=225.025n

.meas tran vdout1_2ck440 FIND v(dout1_2) AT=225.025n

.meas tran vdout1_3ck440 FIND v(dout1_3) AT=225.025n

.meas tran vdout1_4ck440 FIND v(dout1_4) AT=225.025n

.meas tran vdout1_5ck440 FIND v(dout1_5) AT=225.025n

.meas tran vdout1_6ck440 FIND v(dout1_6) AT=225.025n

.meas tran vdout1_7ck440 FIND v(dout1_7) AT=225.025n

.meas tran vdout1_8ck440 FIND v(dout1_8) AT=225.025n

.meas tran vdout1_9ck440 FIND v(dout1_9) AT=225.025n

.meas tran vdout1_10ck440 FIND v(dout1_10) AT=225.025n

.meas tran vdout1_11ck440 FIND v(dout1_11) AT=225.025n

.meas tran vdout1_12ck440 FIND v(dout1_12) AT=225.025n

.meas tran vdout1_13ck440 FIND v(dout1_13) AT=225.025n

.meas tran vdout1_14ck440 FIND v(dout1_14) AT=225.025n

.meas tran vdout1_15ck440 FIND v(dout1_15) AT=225.025n

.meas tran vdout1_16ck440 FIND v(dout1_16) AT=225.025n

.meas tran vdout1_17ck440 FIND v(dout1_17) AT=225.025n

.meas tran vdout1_18ck440 FIND v(dout1_18) AT=225.025n

.meas tran vdout1_19ck440 FIND v(dout1_19) AT=225.025n

.meas tran vdout1_20ck440 FIND v(dout1_20) AT=225.025n

.meas tran vdout1_21ck440 FIND v(dout1_21) AT=225.025n

.meas tran vdout1_22ck440 FIND v(dout1_22) AT=225.025n

.meas tran vdout1_23ck440 FIND v(dout1_23) AT=225.025n

.meas tran vdout0_0ck450 FIND v(dout0_0) AT=230.025n

.meas tran vdout0_1ck450 FIND v(dout0_1) AT=230.025n

.meas tran vdout0_2ck450 FIND v(dout0_2) AT=230.025n

.meas tran vdout0_3ck450 FIND v(dout0_3) AT=230.025n

.meas tran vdout0_4ck450 FIND v(dout0_4) AT=230.025n

.meas tran vdout0_5ck450 FIND v(dout0_5) AT=230.025n

.meas tran vdout0_6ck450 FIND v(dout0_6) AT=230.025n

.meas tran vdout0_7ck450 FIND v(dout0_7) AT=230.025n

.meas tran vdout0_8ck450 FIND v(dout0_8) AT=230.025n

.meas tran vdout0_9ck450 FIND v(dout0_9) AT=230.025n

.meas tran vdout0_10ck450 FIND v(dout0_10) AT=230.025n

.meas tran vdout0_11ck450 FIND v(dout0_11) AT=230.025n

.meas tran vdout0_12ck450 FIND v(dout0_12) AT=230.025n

.meas tran vdout0_13ck450 FIND v(dout0_13) AT=230.025n

.meas tran vdout0_14ck450 FIND v(dout0_14) AT=230.025n

.meas tran vdout0_15ck450 FIND v(dout0_15) AT=230.025n

.meas tran vdout0_16ck450 FIND v(dout0_16) AT=230.025n

.meas tran vdout0_17ck450 FIND v(dout0_17) AT=230.025n

.meas tran vdout0_18ck450 FIND v(dout0_18) AT=230.025n

.meas tran vdout0_19ck450 FIND v(dout0_19) AT=230.025n

.meas tran vdout0_20ck450 FIND v(dout0_20) AT=230.025n

.meas tran vdout0_21ck450 FIND v(dout0_21) AT=230.025n

.meas tran vdout0_22ck450 FIND v(dout0_22) AT=230.025n

.meas tran vdout0_23ck450 FIND v(dout0_23) AT=230.025n

.meas tran vdout1_0ck450 FIND v(dout1_0) AT=230.025n

.meas tran vdout1_1ck450 FIND v(dout1_1) AT=230.025n

.meas tran vdout1_2ck450 FIND v(dout1_2) AT=230.025n

.meas tran vdout1_3ck450 FIND v(dout1_3) AT=230.025n

.meas tran vdout1_4ck450 FIND v(dout1_4) AT=230.025n

.meas tran vdout1_5ck450 FIND v(dout1_5) AT=230.025n

.meas tran vdout1_6ck450 FIND v(dout1_6) AT=230.025n

.meas tran vdout1_7ck450 FIND v(dout1_7) AT=230.025n

.meas tran vdout1_8ck450 FIND v(dout1_8) AT=230.025n

.meas tran vdout1_9ck450 FIND v(dout1_9) AT=230.025n

.meas tran vdout1_10ck450 FIND v(dout1_10) AT=230.025n

.meas tran vdout1_11ck450 FIND v(dout1_11) AT=230.025n

.meas tran vdout1_12ck450 FIND v(dout1_12) AT=230.025n

.meas tran vdout1_13ck450 FIND v(dout1_13) AT=230.025n

.meas tran vdout1_14ck450 FIND v(dout1_14) AT=230.025n

.meas tran vdout1_15ck450 FIND v(dout1_15) AT=230.025n

.meas tran vdout1_16ck450 FIND v(dout1_16) AT=230.025n

.meas tran vdout1_17ck450 FIND v(dout1_17) AT=230.025n

.meas tran vdout1_18ck450 FIND v(dout1_18) AT=230.025n

.meas tran vdout1_19ck450 FIND v(dout1_19) AT=230.025n

.meas tran vdout1_20ck450 FIND v(dout1_20) AT=230.025n

.meas tran vdout1_21ck450 FIND v(dout1_21) AT=230.025n

.meas tran vdout1_22ck450 FIND v(dout1_22) AT=230.025n

.meas tran vdout1_23ck450 FIND v(dout1_23) AT=230.025n

.meas tran vdout0_0ck460 FIND v(dout0_0) AT=235.025n

.meas tran vdout0_1ck460 FIND v(dout0_1) AT=235.025n

.meas tran vdout0_2ck460 FIND v(dout0_2) AT=235.025n

.meas tran vdout0_3ck460 FIND v(dout0_3) AT=235.025n

.meas tran vdout0_4ck460 FIND v(dout0_4) AT=235.025n

.meas tran vdout0_5ck460 FIND v(dout0_5) AT=235.025n

.meas tran vdout0_6ck460 FIND v(dout0_6) AT=235.025n

.meas tran vdout0_7ck460 FIND v(dout0_7) AT=235.025n

.meas tran vdout0_8ck460 FIND v(dout0_8) AT=235.025n

.meas tran vdout0_9ck460 FIND v(dout0_9) AT=235.025n

.meas tran vdout0_10ck460 FIND v(dout0_10) AT=235.025n

.meas tran vdout0_11ck460 FIND v(dout0_11) AT=235.025n

.meas tran vdout0_12ck460 FIND v(dout0_12) AT=235.025n

.meas tran vdout0_13ck460 FIND v(dout0_13) AT=235.025n

.meas tran vdout0_14ck460 FIND v(dout0_14) AT=235.025n

.meas tran vdout0_15ck460 FIND v(dout0_15) AT=235.025n

.meas tran vdout0_16ck460 FIND v(dout0_16) AT=235.025n

.meas tran vdout0_17ck460 FIND v(dout0_17) AT=235.025n

.meas tran vdout0_18ck460 FIND v(dout0_18) AT=235.025n

.meas tran vdout0_19ck460 FIND v(dout0_19) AT=235.025n

.meas tran vdout0_20ck460 FIND v(dout0_20) AT=235.025n

.meas tran vdout0_21ck460 FIND v(dout0_21) AT=235.025n

.meas tran vdout0_22ck460 FIND v(dout0_22) AT=235.025n

.meas tran vdout0_23ck460 FIND v(dout0_23) AT=235.025n

.meas tran vdout1_0ck460 FIND v(dout1_0) AT=235.025n

.meas tran vdout1_1ck460 FIND v(dout1_1) AT=235.025n

.meas tran vdout1_2ck460 FIND v(dout1_2) AT=235.025n

.meas tran vdout1_3ck460 FIND v(dout1_3) AT=235.025n

.meas tran vdout1_4ck460 FIND v(dout1_4) AT=235.025n

.meas tran vdout1_5ck460 FIND v(dout1_5) AT=235.025n

.meas tran vdout1_6ck460 FIND v(dout1_6) AT=235.025n

.meas tran vdout1_7ck460 FIND v(dout1_7) AT=235.025n

.meas tran vdout1_8ck460 FIND v(dout1_8) AT=235.025n

.meas tran vdout1_9ck460 FIND v(dout1_9) AT=235.025n

.meas tran vdout1_10ck460 FIND v(dout1_10) AT=235.025n

.meas tran vdout1_11ck460 FIND v(dout1_11) AT=235.025n

.meas tran vdout1_12ck460 FIND v(dout1_12) AT=235.025n

.meas tran vdout1_13ck460 FIND v(dout1_13) AT=235.025n

.meas tran vdout1_14ck460 FIND v(dout1_14) AT=235.025n

.meas tran vdout1_15ck460 FIND v(dout1_15) AT=235.025n

.meas tran vdout1_16ck460 FIND v(dout1_16) AT=235.025n

.meas tran vdout1_17ck460 FIND v(dout1_17) AT=235.025n

.meas tran vdout1_18ck460 FIND v(dout1_18) AT=235.025n

.meas tran vdout1_19ck460 FIND v(dout1_19) AT=235.025n

.meas tran vdout1_20ck460 FIND v(dout1_20) AT=235.025n

.meas tran vdout1_21ck460 FIND v(dout1_21) AT=235.025n

.meas tran vdout1_22ck460 FIND v(dout1_22) AT=235.025n

.meas tran vdout1_23ck460 FIND v(dout1_23) AT=235.025n

.meas tran vdout0_0ck470 FIND v(dout0_0) AT=240.025n

.meas tran vdout0_1ck470 FIND v(dout0_1) AT=240.025n

.meas tran vdout0_2ck470 FIND v(dout0_2) AT=240.025n

.meas tran vdout0_3ck470 FIND v(dout0_3) AT=240.025n

.meas tran vdout0_4ck470 FIND v(dout0_4) AT=240.025n

.meas tran vdout0_5ck470 FIND v(dout0_5) AT=240.025n

.meas tran vdout0_6ck470 FIND v(dout0_6) AT=240.025n

.meas tran vdout0_7ck470 FIND v(dout0_7) AT=240.025n

.meas tran vdout0_8ck470 FIND v(dout0_8) AT=240.025n

.meas tran vdout0_9ck470 FIND v(dout0_9) AT=240.025n

.meas tran vdout0_10ck470 FIND v(dout0_10) AT=240.025n

.meas tran vdout0_11ck470 FIND v(dout0_11) AT=240.025n

.meas tran vdout0_12ck470 FIND v(dout0_12) AT=240.025n

.meas tran vdout0_13ck470 FIND v(dout0_13) AT=240.025n

.meas tran vdout0_14ck470 FIND v(dout0_14) AT=240.025n

.meas tran vdout0_15ck470 FIND v(dout0_15) AT=240.025n

.meas tran vdout0_16ck470 FIND v(dout0_16) AT=240.025n

.meas tran vdout0_17ck470 FIND v(dout0_17) AT=240.025n

.meas tran vdout0_18ck470 FIND v(dout0_18) AT=240.025n

.meas tran vdout0_19ck470 FIND v(dout0_19) AT=240.025n

.meas tran vdout0_20ck470 FIND v(dout0_20) AT=240.025n

.meas tran vdout0_21ck470 FIND v(dout0_21) AT=240.025n

.meas tran vdout0_22ck470 FIND v(dout0_22) AT=240.025n

.meas tran vdout0_23ck470 FIND v(dout0_23) AT=240.025n

.meas tran vdout1_0ck480 FIND v(dout1_0) AT=245.025n

.meas tran vdout1_1ck480 FIND v(dout1_1) AT=245.025n

.meas tran vdout1_2ck480 FIND v(dout1_2) AT=245.025n

.meas tran vdout1_3ck480 FIND v(dout1_3) AT=245.025n

.meas tran vdout1_4ck480 FIND v(dout1_4) AT=245.025n

.meas tran vdout1_5ck480 FIND v(dout1_5) AT=245.025n

.meas tran vdout1_6ck480 FIND v(dout1_6) AT=245.025n

.meas tran vdout1_7ck480 FIND v(dout1_7) AT=245.025n

.meas tran vdout1_8ck480 FIND v(dout1_8) AT=245.025n

.meas tran vdout1_9ck480 FIND v(dout1_9) AT=245.025n

.meas tran vdout1_10ck480 FIND v(dout1_10) AT=245.025n

.meas tran vdout1_11ck480 FIND v(dout1_11) AT=245.025n

.meas tran vdout1_12ck480 FIND v(dout1_12) AT=245.025n

.meas tran vdout1_13ck480 FIND v(dout1_13) AT=245.025n

.meas tran vdout1_14ck480 FIND v(dout1_14) AT=245.025n

.meas tran vdout1_15ck480 FIND v(dout1_15) AT=245.025n

.meas tran vdout1_16ck480 FIND v(dout1_16) AT=245.025n

.meas tran vdout1_17ck480 FIND v(dout1_17) AT=245.025n

.meas tran vdout1_18ck480 FIND v(dout1_18) AT=245.025n

.meas tran vdout1_19ck480 FIND v(dout1_19) AT=245.025n

.meas tran vdout1_20ck480 FIND v(dout1_20) AT=245.025n

.meas tran vdout1_21ck480 FIND v(dout1_21) AT=245.025n

.meas tran vdout1_22ck480 FIND v(dout1_22) AT=245.025n

.meas tran vdout1_23ck480 FIND v(dout1_23) AT=245.025n

.meas tran vdout0_0ck520 FIND v(dout0_0) AT=265.025n

.meas tran vdout0_1ck520 FIND v(dout0_1) AT=265.025n

.meas tran vdout0_2ck520 FIND v(dout0_2) AT=265.025n

.meas tran vdout0_3ck520 FIND v(dout0_3) AT=265.025n

.meas tran vdout0_4ck520 FIND v(dout0_4) AT=265.025n

.meas tran vdout0_5ck520 FIND v(dout0_5) AT=265.025n

.meas tran vdout0_6ck520 FIND v(dout0_6) AT=265.025n

.meas tran vdout0_7ck520 FIND v(dout0_7) AT=265.025n

.meas tran vdout0_8ck520 FIND v(dout0_8) AT=265.025n

.meas tran vdout0_9ck520 FIND v(dout0_9) AT=265.025n

.meas tran vdout0_10ck520 FIND v(dout0_10) AT=265.025n

.meas tran vdout0_11ck520 FIND v(dout0_11) AT=265.025n

.meas tran vdout0_12ck520 FIND v(dout0_12) AT=265.025n

.meas tran vdout0_13ck520 FIND v(dout0_13) AT=265.025n

.meas tran vdout0_14ck520 FIND v(dout0_14) AT=265.025n

.meas tran vdout0_15ck520 FIND v(dout0_15) AT=265.025n

.meas tran vdout0_16ck520 FIND v(dout0_16) AT=265.025n

.meas tran vdout0_17ck520 FIND v(dout0_17) AT=265.025n

.meas tran vdout0_18ck520 FIND v(dout0_18) AT=265.025n

.meas tran vdout0_19ck520 FIND v(dout0_19) AT=265.025n

.meas tran vdout0_20ck520 FIND v(dout0_20) AT=265.025n

.meas tran vdout0_21ck520 FIND v(dout0_21) AT=265.025n

.meas tran vdout0_22ck520 FIND v(dout0_22) AT=265.025n

.meas tran vdout0_23ck520 FIND v(dout0_23) AT=265.025n

.meas tran vdout0_0ck530 FIND v(dout0_0) AT=270.025n

.meas tran vdout0_1ck530 FIND v(dout0_1) AT=270.025n

.meas tran vdout0_2ck530 FIND v(dout0_2) AT=270.025n

.meas tran vdout0_3ck530 FIND v(dout0_3) AT=270.025n

.meas tran vdout0_4ck530 FIND v(dout0_4) AT=270.025n

.meas tran vdout0_5ck530 FIND v(dout0_5) AT=270.025n

.meas tran vdout0_6ck530 FIND v(dout0_6) AT=270.025n

.meas tran vdout0_7ck530 FIND v(dout0_7) AT=270.025n

.meas tran vdout0_8ck530 FIND v(dout0_8) AT=270.025n

.meas tran vdout0_9ck530 FIND v(dout0_9) AT=270.025n

.meas tran vdout0_10ck530 FIND v(dout0_10) AT=270.025n

.meas tran vdout0_11ck530 FIND v(dout0_11) AT=270.025n

.meas tran vdout0_12ck530 FIND v(dout0_12) AT=270.025n

.meas tran vdout0_13ck530 FIND v(dout0_13) AT=270.025n

.meas tran vdout0_14ck530 FIND v(dout0_14) AT=270.025n

.meas tran vdout0_15ck530 FIND v(dout0_15) AT=270.025n

.meas tran vdout0_16ck530 FIND v(dout0_16) AT=270.025n

.meas tran vdout0_17ck530 FIND v(dout0_17) AT=270.025n

.meas tran vdout0_18ck530 FIND v(dout0_18) AT=270.025n

.meas tran vdout0_19ck530 FIND v(dout0_19) AT=270.025n

.meas tran vdout0_20ck530 FIND v(dout0_20) AT=270.025n

.meas tran vdout0_21ck530 FIND v(dout0_21) AT=270.025n

.meas tran vdout0_22ck530 FIND v(dout0_22) AT=270.025n

.meas tran vdout0_23ck530 FIND v(dout0_23) AT=270.025n

.meas tran vdout0_0ck540 FIND v(dout0_0) AT=275.025n

.meas tran vdout0_1ck540 FIND v(dout0_1) AT=275.025n

.meas tran vdout0_2ck540 FIND v(dout0_2) AT=275.025n

.meas tran vdout0_3ck540 FIND v(dout0_3) AT=275.025n

.meas tran vdout0_4ck540 FIND v(dout0_4) AT=275.025n

.meas tran vdout0_5ck540 FIND v(dout0_5) AT=275.025n

.meas tran vdout0_6ck540 FIND v(dout0_6) AT=275.025n

.meas tran vdout0_7ck540 FIND v(dout0_7) AT=275.025n

.meas tran vdout0_8ck540 FIND v(dout0_8) AT=275.025n

.meas tran vdout0_9ck540 FIND v(dout0_9) AT=275.025n

.meas tran vdout0_10ck540 FIND v(dout0_10) AT=275.025n

.meas tran vdout0_11ck540 FIND v(dout0_11) AT=275.025n

.meas tran vdout0_12ck540 FIND v(dout0_12) AT=275.025n

.meas tran vdout0_13ck540 FIND v(dout0_13) AT=275.025n

.meas tran vdout0_14ck540 FIND v(dout0_14) AT=275.025n

.meas tran vdout0_15ck540 FIND v(dout0_15) AT=275.025n

.meas tran vdout0_16ck540 FIND v(dout0_16) AT=275.025n

.meas tran vdout0_17ck540 FIND v(dout0_17) AT=275.025n

.meas tran vdout0_18ck540 FIND v(dout0_18) AT=275.025n

.meas tran vdout0_19ck540 FIND v(dout0_19) AT=275.025n

.meas tran vdout0_20ck540 FIND v(dout0_20) AT=275.025n

.meas tran vdout0_21ck540 FIND v(dout0_21) AT=275.025n

.meas tran vdout0_22ck540 FIND v(dout0_22) AT=275.025n

.meas tran vdout0_23ck540 FIND v(dout0_23) AT=275.025n

.meas tran vdout1_0ck540 FIND v(dout1_0) AT=275.025n

.meas tran vdout1_1ck540 FIND v(dout1_1) AT=275.025n

.meas tran vdout1_2ck540 FIND v(dout1_2) AT=275.025n

.meas tran vdout1_3ck540 FIND v(dout1_3) AT=275.025n

.meas tran vdout1_4ck540 FIND v(dout1_4) AT=275.025n

.meas tran vdout1_5ck540 FIND v(dout1_5) AT=275.025n

.meas tran vdout1_6ck540 FIND v(dout1_6) AT=275.025n

.meas tran vdout1_7ck540 FIND v(dout1_7) AT=275.025n

.meas tran vdout1_8ck540 FIND v(dout1_8) AT=275.025n

.meas tran vdout1_9ck540 FIND v(dout1_9) AT=275.025n

.meas tran vdout1_10ck540 FIND v(dout1_10) AT=275.025n

.meas tran vdout1_11ck540 FIND v(dout1_11) AT=275.025n

.meas tran vdout1_12ck540 FIND v(dout1_12) AT=275.025n

.meas tran vdout1_13ck540 FIND v(dout1_13) AT=275.025n

.meas tran vdout1_14ck540 FIND v(dout1_14) AT=275.025n

.meas tran vdout1_15ck540 FIND v(dout1_15) AT=275.025n

.meas tran vdout1_16ck540 FIND v(dout1_16) AT=275.025n

.meas tran vdout1_17ck540 FIND v(dout1_17) AT=275.025n

.meas tran vdout1_18ck540 FIND v(dout1_18) AT=275.025n

.meas tran vdout1_19ck540 FIND v(dout1_19) AT=275.025n

.meas tran vdout1_20ck540 FIND v(dout1_20) AT=275.025n

.meas tran vdout1_21ck540 FIND v(dout1_21) AT=275.025n

.meas tran vdout1_22ck540 FIND v(dout1_22) AT=275.025n

.meas tran vdout1_23ck540 FIND v(dout1_23) AT=275.025n

.meas tran vdout0_0ck570 FIND v(dout0_0) AT=290.025n

.meas tran vdout0_1ck570 FIND v(dout0_1) AT=290.025n

.meas tran vdout0_2ck570 FIND v(dout0_2) AT=290.025n

.meas tran vdout0_3ck570 FIND v(dout0_3) AT=290.025n

.meas tran vdout0_4ck570 FIND v(dout0_4) AT=290.025n

.meas tran vdout0_5ck570 FIND v(dout0_5) AT=290.025n

.meas tran vdout0_6ck570 FIND v(dout0_6) AT=290.025n

.meas tran vdout0_7ck570 FIND v(dout0_7) AT=290.025n

.meas tran vdout0_8ck570 FIND v(dout0_8) AT=290.025n

.meas tran vdout0_9ck570 FIND v(dout0_9) AT=290.025n

.meas tran vdout0_10ck570 FIND v(dout0_10) AT=290.025n

.meas tran vdout0_11ck570 FIND v(dout0_11) AT=290.025n

.meas tran vdout0_12ck570 FIND v(dout0_12) AT=290.025n

.meas tran vdout0_13ck570 FIND v(dout0_13) AT=290.025n

.meas tran vdout0_14ck570 FIND v(dout0_14) AT=290.025n

.meas tran vdout0_15ck570 FIND v(dout0_15) AT=290.025n

.meas tran vdout0_16ck570 FIND v(dout0_16) AT=290.025n

.meas tran vdout0_17ck570 FIND v(dout0_17) AT=290.025n

.meas tran vdout0_18ck570 FIND v(dout0_18) AT=290.025n

.meas tran vdout0_19ck570 FIND v(dout0_19) AT=290.025n

.meas tran vdout0_20ck570 FIND v(dout0_20) AT=290.025n

.meas tran vdout0_21ck570 FIND v(dout0_21) AT=290.025n

.meas tran vdout0_22ck570 FIND v(dout0_22) AT=290.025n

.meas tran vdout0_23ck570 FIND v(dout0_23) AT=290.025n

.meas tran vdout1_0ck570 FIND v(dout1_0) AT=290.025n

.meas tran vdout1_1ck570 FIND v(dout1_1) AT=290.025n

.meas tran vdout1_2ck570 FIND v(dout1_2) AT=290.025n

.meas tran vdout1_3ck570 FIND v(dout1_3) AT=290.025n

.meas tran vdout1_4ck570 FIND v(dout1_4) AT=290.025n

.meas tran vdout1_5ck570 FIND v(dout1_5) AT=290.025n

.meas tran vdout1_6ck570 FIND v(dout1_6) AT=290.025n

.meas tran vdout1_7ck570 FIND v(dout1_7) AT=290.025n

.meas tran vdout1_8ck570 FIND v(dout1_8) AT=290.025n

.meas tran vdout1_9ck570 FIND v(dout1_9) AT=290.025n

.meas tran vdout1_10ck570 FIND v(dout1_10) AT=290.025n

.meas tran vdout1_11ck570 FIND v(dout1_11) AT=290.025n

.meas tran vdout1_12ck570 FIND v(dout1_12) AT=290.025n

.meas tran vdout1_13ck570 FIND v(dout1_13) AT=290.025n

.meas tran vdout1_14ck570 FIND v(dout1_14) AT=290.025n

.meas tran vdout1_15ck570 FIND v(dout1_15) AT=290.025n

.meas tran vdout1_16ck570 FIND v(dout1_16) AT=290.025n

.meas tran vdout1_17ck570 FIND v(dout1_17) AT=290.025n

.meas tran vdout1_18ck570 FIND v(dout1_18) AT=290.025n

.meas tran vdout1_19ck570 FIND v(dout1_19) AT=290.025n

.meas tran vdout1_20ck570 FIND v(dout1_20) AT=290.025n

.meas tran vdout1_21ck570 FIND v(dout1_21) AT=290.025n

.meas tran vdout1_22ck570 FIND v(dout1_22) AT=290.025n

.meas tran vdout1_23ck570 FIND v(dout1_23) AT=290.025n

.meas tran vdout0_0ck620 FIND v(dout0_0) AT=315.025n

.meas tran vdout0_1ck620 FIND v(dout0_1) AT=315.025n

.meas tran vdout0_2ck620 FIND v(dout0_2) AT=315.025n

.meas tran vdout0_3ck620 FIND v(dout0_3) AT=315.025n

.meas tran vdout0_4ck620 FIND v(dout0_4) AT=315.025n

.meas tran vdout0_5ck620 FIND v(dout0_5) AT=315.025n

.meas tran vdout0_6ck620 FIND v(dout0_6) AT=315.025n

.meas tran vdout0_7ck620 FIND v(dout0_7) AT=315.025n

.meas tran vdout0_8ck620 FIND v(dout0_8) AT=315.025n

.meas tran vdout0_9ck620 FIND v(dout0_9) AT=315.025n

.meas tran vdout0_10ck620 FIND v(dout0_10) AT=315.025n

.meas tran vdout0_11ck620 FIND v(dout0_11) AT=315.025n

.meas tran vdout0_12ck620 FIND v(dout0_12) AT=315.025n

.meas tran vdout0_13ck620 FIND v(dout0_13) AT=315.025n

.meas tran vdout0_14ck620 FIND v(dout0_14) AT=315.025n

.meas tran vdout0_15ck620 FIND v(dout0_15) AT=315.025n

.meas tran vdout0_16ck620 FIND v(dout0_16) AT=315.025n

.meas tran vdout0_17ck620 FIND v(dout0_17) AT=315.025n

.meas tran vdout0_18ck620 FIND v(dout0_18) AT=315.025n

.meas tran vdout0_19ck620 FIND v(dout0_19) AT=315.025n

.meas tran vdout0_20ck620 FIND v(dout0_20) AT=315.025n

.meas tran vdout0_21ck620 FIND v(dout0_21) AT=315.025n

.meas tran vdout0_22ck620 FIND v(dout0_22) AT=315.025n

.meas tran vdout0_23ck620 FIND v(dout0_23) AT=315.025n

.meas tran vdout1_0ck620 FIND v(dout1_0) AT=315.025n

.meas tran vdout1_1ck620 FIND v(dout1_1) AT=315.025n

.meas tran vdout1_2ck620 FIND v(dout1_2) AT=315.025n

.meas tran vdout1_3ck620 FIND v(dout1_3) AT=315.025n

.meas tran vdout1_4ck620 FIND v(dout1_4) AT=315.025n

.meas tran vdout1_5ck620 FIND v(dout1_5) AT=315.025n

.meas tran vdout1_6ck620 FIND v(dout1_6) AT=315.025n

.meas tran vdout1_7ck620 FIND v(dout1_7) AT=315.025n

.meas tran vdout1_8ck620 FIND v(dout1_8) AT=315.025n

.meas tran vdout1_9ck620 FIND v(dout1_9) AT=315.025n

.meas tran vdout1_10ck620 FIND v(dout1_10) AT=315.025n

.meas tran vdout1_11ck620 FIND v(dout1_11) AT=315.025n

.meas tran vdout1_12ck620 FIND v(dout1_12) AT=315.025n

.meas tran vdout1_13ck620 FIND v(dout1_13) AT=315.025n

.meas tran vdout1_14ck620 FIND v(dout1_14) AT=315.025n

.meas tran vdout1_15ck620 FIND v(dout1_15) AT=315.025n

.meas tran vdout1_16ck620 FIND v(dout1_16) AT=315.025n

.meas tran vdout1_17ck620 FIND v(dout1_17) AT=315.025n

.meas tran vdout1_18ck620 FIND v(dout1_18) AT=315.025n

.meas tran vdout1_19ck620 FIND v(dout1_19) AT=315.025n

.meas tran vdout1_20ck620 FIND v(dout1_20) AT=315.025n

.meas tran vdout1_21ck620 FIND v(dout1_21) AT=315.025n

.meas tran vdout1_22ck620 FIND v(dout1_22) AT=315.025n

.meas tran vdout1_23ck620 FIND v(dout1_23) AT=315.025n

.meas tran vdout0_0ck630 FIND v(dout0_0) AT=320.025n

.meas tran vdout0_1ck630 FIND v(dout0_1) AT=320.025n

.meas tran vdout0_2ck630 FIND v(dout0_2) AT=320.025n

.meas tran vdout0_3ck630 FIND v(dout0_3) AT=320.025n

.meas tran vdout0_4ck630 FIND v(dout0_4) AT=320.025n

.meas tran vdout0_5ck630 FIND v(dout0_5) AT=320.025n

.meas tran vdout0_6ck630 FIND v(dout0_6) AT=320.025n

.meas tran vdout0_7ck630 FIND v(dout0_7) AT=320.025n

.meas tran vdout0_8ck630 FIND v(dout0_8) AT=320.025n

.meas tran vdout0_9ck630 FIND v(dout0_9) AT=320.025n

.meas tran vdout0_10ck630 FIND v(dout0_10) AT=320.025n

.meas tran vdout0_11ck630 FIND v(dout0_11) AT=320.025n

.meas tran vdout0_12ck630 FIND v(dout0_12) AT=320.025n

.meas tran vdout0_13ck630 FIND v(dout0_13) AT=320.025n

.meas tran vdout0_14ck630 FIND v(dout0_14) AT=320.025n

.meas tran vdout0_15ck630 FIND v(dout0_15) AT=320.025n

.meas tran vdout0_16ck630 FIND v(dout0_16) AT=320.025n

.meas tran vdout0_17ck630 FIND v(dout0_17) AT=320.025n

.meas tran vdout0_18ck630 FIND v(dout0_18) AT=320.025n

.meas tran vdout0_19ck630 FIND v(dout0_19) AT=320.025n

.meas tran vdout0_20ck630 FIND v(dout0_20) AT=320.025n

.meas tran vdout0_21ck630 FIND v(dout0_21) AT=320.025n

.meas tran vdout0_22ck630 FIND v(dout0_22) AT=320.025n

.meas tran vdout0_23ck630 FIND v(dout0_23) AT=320.025n

.meas tran vdout1_0ck630 FIND v(dout1_0) AT=320.025n

.meas tran vdout1_1ck630 FIND v(dout1_1) AT=320.025n

.meas tran vdout1_2ck630 FIND v(dout1_2) AT=320.025n

.meas tran vdout1_3ck630 FIND v(dout1_3) AT=320.025n

.meas tran vdout1_4ck630 FIND v(dout1_4) AT=320.025n

.meas tran vdout1_5ck630 FIND v(dout1_5) AT=320.025n

.meas tran vdout1_6ck630 FIND v(dout1_6) AT=320.025n

.meas tran vdout1_7ck630 FIND v(dout1_7) AT=320.025n

.meas tran vdout1_8ck630 FIND v(dout1_8) AT=320.025n

.meas tran vdout1_9ck630 FIND v(dout1_9) AT=320.025n

.meas tran vdout1_10ck630 FIND v(dout1_10) AT=320.025n

.meas tran vdout1_11ck630 FIND v(dout1_11) AT=320.025n

.meas tran vdout1_12ck630 FIND v(dout1_12) AT=320.025n

.meas tran vdout1_13ck630 FIND v(dout1_13) AT=320.025n

.meas tran vdout1_14ck630 FIND v(dout1_14) AT=320.025n

.meas tran vdout1_15ck630 FIND v(dout1_15) AT=320.025n

.meas tran vdout1_16ck630 FIND v(dout1_16) AT=320.025n

.meas tran vdout1_17ck630 FIND v(dout1_17) AT=320.025n

.meas tran vdout1_18ck630 FIND v(dout1_18) AT=320.025n

.meas tran vdout1_19ck630 FIND v(dout1_19) AT=320.025n

.meas tran vdout1_20ck630 FIND v(dout1_20) AT=320.025n

.meas tran vdout1_21ck630 FIND v(dout1_21) AT=320.025n

.meas tran vdout1_22ck630 FIND v(dout1_22) AT=320.025n

.meas tran vdout1_23ck630 FIND v(dout1_23) AT=320.025n

.meas tran vdout0_0ck640 FIND v(dout0_0) AT=325.025n

.meas tran vdout0_1ck640 FIND v(dout0_1) AT=325.025n

.meas tran vdout0_2ck640 FIND v(dout0_2) AT=325.025n

.meas tran vdout0_3ck640 FIND v(dout0_3) AT=325.025n

.meas tran vdout0_4ck640 FIND v(dout0_4) AT=325.025n

.meas tran vdout0_5ck640 FIND v(dout0_5) AT=325.025n

.meas tran vdout0_6ck640 FIND v(dout0_6) AT=325.025n

.meas tran vdout0_7ck640 FIND v(dout0_7) AT=325.025n

.meas tran vdout0_8ck640 FIND v(dout0_8) AT=325.025n

.meas tran vdout0_9ck640 FIND v(dout0_9) AT=325.025n

.meas tran vdout0_10ck640 FIND v(dout0_10) AT=325.025n

.meas tran vdout0_11ck640 FIND v(dout0_11) AT=325.025n

.meas tran vdout0_12ck640 FIND v(dout0_12) AT=325.025n

.meas tran vdout0_13ck640 FIND v(dout0_13) AT=325.025n

.meas tran vdout0_14ck640 FIND v(dout0_14) AT=325.025n

.meas tran vdout0_15ck640 FIND v(dout0_15) AT=325.025n

.meas tran vdout0_16ck640 FIND v(dout0_16) AT=325.025n

.meas tran vdout0_17ck640 FIND v(dout0_17) AT=325.025n

.meas tran vdout0_18ck640 FIND v(dout0_18) AT=325.025n

.meas tran vdout0_19ck640 FIND v(dout0_19) AT=325.025n

.meas tran vdout0_20ck640 FIND v(dout0_20) AT=325.025n

.meas tran vdout0_21ck640 FIND v(dout0_21) AT=325.025n

.meas tran vdout0_22ck640 FIND v(dout0_22) AT=325.025n

.meas tran vdout0_23ck640 FIND v(dout0_23) AT=325.025n

.meas tran vdout1_0ck660 FIND v(dout1_0) AT=335.025n

.meas tran vdout1_1ck660 FIND v(dout1_1) AT=335.025n

.meas tran vdout1_2ck660 FIND v(dout1_2) AT=335.025n

.meas tran vdout1_3ck660 FIND v(dout1_3) AT=335.025n

.meas tran vdout1_4ck660 FIND v(dout1_4) AT=335.025n

.meas tran vdout1_5ck660 FIND v(dout1_5) AT=335.025n

.meas tran vdout1_6ck660 FIND v(dout1_6) AT=335.025n

.meas tran vdout1_7ck660 FIND v(dout1_7) AT=335.025n

.meas tran vdout1_8ck660 FIND v(dout1_8) AT=335.025n

.meas tran vdout1_9ck660 FIND v(dout1_9) AT=335.025n

.meas tran vdout1_10ck660 FIND v(dout1_10) AT=335.025n

.meas tran vdout1_11ck660 FIND v(dout1_11) AT=335.025n

.meas tran vdout1_12ck660 FIND v(dout1_12) AT=335.025n

.meas tran vdout1_13ck660 FIND v(dout1_13) AT=335.025n

.meas tran vdout1_14ck660 FIND v(dout1_14) AT=335.025n

.meas tran vdout1_15ck660 FIND v(dout1_15) AT=335.025n

.meas tran vdout1_16ck660 FIND v(dout1_16) AT=335.025n

.meas tran vdout1_17ck660 FIND v(dout1_17) AT=335.025n

.meas tran vdout1_18ck660 FIND v(dout1_18) AT=335.025n

.meas tran vdout1_19ck660 FIND v(dout1_19) AT=335.025n

.meas tran vdout1_20ck660 FIND v(dout1_20) AT=335.025n

.meas tran vdout1_21ck660 FIND v(dout1_21) AT=335.025n

.meas tran vdout1_22ck660 FIND v(dout1_22) AT=335.025n

.meas tran vdout1_23ck660 FIND v(dout1_23) AT=335.025n

.meas tran vdout0_0ck670 FIND v(dout0_0) AT=340.025n

.meas tran vdout0_1ck670 FIND v(dout0_1) AT=340.025n

.meas tran vdout0_2ck670 FIND v(dout0_2) AT=340.025n

.meas tran vdout0_3ck670 FIND v(dout0_3) AT=340.025n

.meas tran vdout0_4ck670 FIND v(dout0_4) AT=340.025n

.meas tran vdout0_5ck670 FIND v(dout0_5) AT=340.025n

.meas tran vdout0_6ck670 FIND v(dout0_6) AT=340.025n

.meas tran vdout0_7ck670 FIND v(dout0_7) AT=340.025n

.meas tran vdout0_8ck670 FIND v(dout0_8) AT=340.025n

.meas tran vdout0_9ck670 FIND v(dout0_9) AT=340.025n

.meas tran vdout0_10ck670 FIND v(dout0_10) AT=340.025n

.meas tran vdout0_11ck670 FIND v(dout0_11) AT=340.025n

.meas tran vdout0_12ck670 FIND v(dout0_12) AT=340.025n

.meas tran vdout0_13ck670 FIND v(dout0_13) AT=340.025n

.meas tran vdout0_14ck670 FIND v(dout0_14) AT=340.025n

.meas tran vdout0_15ck670 FIND v(dout0_15) AT=340.025n

.meas tran vdout0_16ck670 FIND v(dout0_16) AT=340.025n

.meas tran vdout0_17ck670 FIND v(dout0_17) AT=340.025n

.meas tran vdout0_18ck670 FIND v(dout0_18) AT=340.025n

.meas tran vdout0_19ck670 FIND v(dout0_19) AT=340.025n

.meas tran vdout0_20ck670 FIND v(dout0_20) AT=340.025n

.meas tran vdout0_21ck670 FIND v(dout0_21) AT=340.025n

.meas tran vdout0_22ck670 FIND v(dout0_22) AT=340.025n

.meas tran vdout0_23ck670 FIND v(dout0_23) AT=340.025n

.meas tran vdout0_0ck680 FIND v(dout0_0) AT=345.025n

.meas tran vdout0_1ck680 FIND v(dout0_1) AT=345.025n

.meas tran vdout0_2ck680 FIND v(dout0_2) AT=345.025n

.meas tran vdout0_3ck680 FIND v(dout0_3) AT=345.025n

.meas tran vdout0_4ck680 FIND v(dout0_4) AT=345.025n

.meas tran vdout0_5ck680 FIND v(dout0_5) AT=345.025n

.meas tran vdout0_6ck680 FIND v(dout0_6) AT=345.025n

.meas tran vdout0_7ck680 FIND v(dout0_7) AT=345.025n

.meas tran vdout0_8ck680 FIND v(dout0_8) AT=345.025n

.meas tran vdout0_9ck680 FIND v(dout0_9) AT=345.025n

.meas tran vdout0_10ck680 FIND v(dout0_10) AT=345.025n

.meas tran vdout0_11ck680 FIND v(dout0_11) AT=345.025n

.meas tran vdout0_12ck680 FIND v(dout0_12) AT=345.025n

.meas tran vdout0_13ck680 FIND v(dout0_13) AT=345.025n

.meas tran vdout0_14ck680 FIND v(dout0_14) AT=345.025n

.meas tran vdout0_15ck680 FIND v(dout0_15) AT=345.025n

.meas tran vdout0_16ck680 FIND v(dout0_16) AT=345.025n

.meas tran vdout0_17ck680 FIND v(dout0_17) AT=345.025n

.meas tran vdout0_18ck680 FIND v(dout0_18) AT=345.025n

.meas tran vdout0_19ck680 FIND v(dout0_19) AT=345.025n

.meas tran vdout0_20ck680 FIND v(dout0_20) AT=345.025n

.meas tran vdout0_21ck680 FIND v(dout0_21) AT=345.025n

.meas tran vdout0_22ck680 FIND v(dout0_22) AT=345.025n

.meas tran vdout0_23ck680 FIND v(dout0_23) AT=345.025n

.meas tran vdout0_0ck690 FIND v(dout0_0) AT=350.025n

.meas tran vdout0_1ck690 FIND v(dout0_1) AT=350.025n

.meas tran vdout0_2ck690 FIND v(dout0_2) AT=350.025n

.meas tran vdout0_3ck690 FIND v(dout0_3) AT=350.025n

.meas tran vdout0_4ck690 FIND v(dout0_4) AT=350.025n

.meas tran vdout0_5ck690 FIND v(dout0_5) AT=350.025n

.meas tran vdout0_6ck690 FIND v(dout0_6) AT=350.025n

.meas tran vdout0_7ck690 FIND v(dout0_7) AT=350.025n

.meas tran vdout0_8ck690 FIND v(dout0_8) AT=350.025n

.meas tran vdout0_9ck690 FIND v(dout0_9) AT=350.025n

.meas tran vdout0_10ck690 FIND v(dout0_10) AT=350.025n

.meas tran vdout0_11ck690 FIND v(dout0_11) AT=350.025n

.meas tran vdout0_12ck690 FIND v(dout0_12) AT=350.025n

.meas tran vdout0_13ck690 FIND v(dout0_13) AT=350.025n

.meas tran vdout0_14ck690 FIND v(dout0_14) AT=350.025n

.meas tran vdout0_15ck690 FIND v(dout0_15) AT=350.025n

.meas tran vdout0_16ck690 FIND v(dout0_16) AT=350.025n

.meas tran vdout0_17ck690 FIND v(dout0_17) AT=350.025n

.meas tran vdout0_18ck690 FIND v(dout0_18) AT=350.025n

.meas tran vdout0_19ck690 FIND v(dout0_19) AT=350.025n

.meas tran vdout0_20ck690 FIND v(dout0_20) AT=350.025n

.meas tran vdout0_21ck690 FIND v(dout0_21) AT=350.025n

.meas tran vdout0_22ck690 FIND v(dout0_22) AT=350.025n

.meas tran vdout0_23ck690 FIND v(dout0_23) AT=350.025n

.meas tran vdout0_0ck700 FIND v(dout0_0) AT=355.025n

.meas tran vdout0_1ck700 FIND v(dout0_1) AT=355.025n

.meas tran vdout0_2ck700 FIND v(dout0_2) AT=355.025n

.meas tran vdout0_3ck700 FIND v(dout0_3) AT=355.025n

.meas tran vdout0_4ck700 FIND v(dout0_4) AT=355.025n

.meas tran vdout0_5ck700 FIND v(dout0_5) AT=355.025n

.meas tran vdout0_6ck700 FIND v(dout0_6) AT=355.025n

.meas tran vdout0_7ck700 FIND v(dout0_7) AT=355.025n

.meas tran vdout0_8ck700 FIND v(dout0_8) AT=355.025n

.meas tran vdout0_9ck700 FIND v(dout0_9) AT=355.025n

.meas tran vdout0_10ck700 FIND v(dout0_10) AT=355.025n

.meas tran vdout0_11ck700 FIND v(dout0_11) AT=355.025n

.meas tran vdout0_12ck700 FIND v(dout0_12) AT=355.025n

.meas tran vdout0_13ck700 FIND v(dout0_13) AT=355.025n

.meas tran vdout0_14ck700 FIND v(dout0_14) AT=355.025n

.meas tran vdout0_15ck700 FIND v(dout0_15) AT=355.025n

.meas tran vdout0_16ck700 FIND v(dout0_16) AT=355.025n

.meas tran vdout0_17ck700 FIND v(dout0_17) AT=355.025n

.meas tran vdout0_18ck700 FIND v(dout0_18) AT=355.025n

.meas tran vdout0_19ck700 FIND v(dout0_19) AT=355.025n

.meas tran vdout0_20ck700 FIND v(dout0_20) AT=355.025n

.meas tran vdout0_21ck700 FIND v(dout0_21) AT=355.025n

.meas tran vdout0_22ck700 FIND v(dout0_22) AT=355.025n

.meas tran vdout0_23ck700 FIND v(dout0_23) AT=355.025n

.meas tran vdout1_0ck700 FIND v(dout1_0) AT=355.025n

.meas tran vdout1_1ck700 FIND v(dout1_1) AT=355.025n

.meas tran vdout1_2ck700 FIND v(dout1_2) AT=355.025n

.meas tran vdout1_3ck700 FIND v(dout1_3) AT=355.025n

.meas tran vdout1_4ck700 FIND v(dout1_4) AT=355.025n

.meas tran vdout1_5ck700 FIND v(dout1_5) AT=355.025n

.meas tran vdout1_6ck700 FIND v(dout1_6) AT=355.025n

.meas tran vdout1_7ck700 FIND v(dout1_7) AT=355.025n

.meas tran vdout1_8ck700 FIND v(dout1_8) AT=355.025n

.meas tran vdout1_9ck700 FIND v(dout1_9) AT=355.025n

.meas tran vdout1_10ck700 FIND v(dout1_10) AT=355.025n

.meas tran vdout1_11ck700 FIND v(dout1_11) AT=355.025n

.meas tran vdout1_12ck700 FIND v(dout1_12) AT=355.025n

.meas tran vdout1_13ck700 FIND v(dout1_13) AT=355.025n

.meas tran vdout1_14ck700 FIND v(dout1_14) AT=355.025n

.meas tran vdout1_15ck700 FIND v(dout1_15) AT=355.025n

.meas tran vdout1_16ck700 FIND v(dout1_16) AT=355.025n

.meas tran vdout1_17ck700 FIND v(dout1_17) AT=355.025n

.meas tran vdout1_18ck700 FIND v(dout1_18) AT=355.025n

.meas tran vdout1_19ck700 FIND v(dout1_19) AT=355.025n

.meas tran vdout1_20ck700 FIND v(dout1_20) AT=355.025n

.meas tran vdout1_21ck700 FIND v(dout1_21) AT=355.025n

.meas tran vdout1_22ck700 FIND v(dout1_22) AT=355.025n

.meas tran vdout1_23ck700 FIND v(dout1_23) AT=355.025n

.meas tran vdout0_0ck710 FIND v(dout0_0) AT=360.025n

.meas tran vdout0_1ck710 FIND v(dout0_1) AT=360.025n

.meas tran vdout0_2ck710 FIND v(dout0_2) AT=360.025n

.meas tran vdout0_3ck710 FIND v(dout0_3) AT=360.025n

.meas tran vdout0_4ck710 FIND v(dout0_4) AT=360.025n

.meas tran vdout0_5ck710 FIND v(dout0_5) AT=360.025n

.meas tran vdout0_6ck710 FIND v(dout0_6) AT=360.025n

.meas tran vdout0_7ck710 FIND v(dout0_7) AT=360.025n

.meas tran vdout0_8ck710 FIND v(dout0_8) AT=360.025n

.meas tran vdout0_9ck710 FIND v(dout0_9) AT=360.025n

.meas tran vdout0_10ck710 FIND v(dout0_10) AT=360.025n

.meas tran vdout0_11ck710 FIND v(dout0_11) AT=360.025n

.meas tran vdout0_12ck710 FIND v(dout0_12) AT=360.025n

.meas tran vdout0_13ck710 FIND v(dout0_13) AT=360.025n

.meas tran vdout0_14ck710 FIND v(dout0_14) AT=360.025n

.meas tran vdout0_15ck710 FIND v(dout0_15) AT=360.025n

.meas tran vdout0_16ck710 FIND v(dout0_16) AT=360.025n

.meas tran vdout0_17ck710 FIND v(dout0_17) AT=360.025n

.meas tran vdout0_18ck710 FIND v(dout0_18) AT=360.025n

.meas tran vdout0_19ck710 FIND v(dout0_19) AT=360.025n

.meas tran vdout0_20ck710 FIND v(dout0_20) AT=360.025n

.meas tran vdout0_21ck710 FIND v(dout0_21) AT=360.025n

.meas tran vdout0_22ck710 FIND v(dout0_22) AT=360.025n

.meas tran vdout0_23ck710 FIND v(dout0_23) AT=360.025n

.meas tran vdout1_0ck720 FIND v(dout1_0) AT=365.025n

.meas tran vdout1_1ck720 FIND v(dout1_1) AT=365.025n

.meas tran vdout1_2ck720 FIND v(dout1_2) AT=365.025n

.meas tran vdout1_3ck720 FIND v(dout1_3) AT=365.025n

.meas tran vdout1_4ck720 FIND v(dout1_4) AT=365.025n

.meas tran vdout1_5ck720 FIND v(dout1_5) AT=365.025n

.meas tran vdout1_6ck720 FIND v(dout1_6) AT=365.025n

.meas tran vdout1_7ck720 FIND v(dout1_7) AT=365.025n

.meas tran vdout1_8ck720 FIND v(dout1_8) AT=365.025n

.meas tran vdout1_9ck720 FIND v(dout1_9) AT=365.025n

.meas tran vdout1_10ck720 FIND v(dout1_10) AT=365.025n

.meas tran vdout1_11ck720 FIND v(dout1_11) AT=365.025n

.meas tran vdout1_12ck720 FIND v(dout1_12) AT=365.025n

.meas tran vdout1_13ck720 FIND v(dout1_13) AT=365.025n

.meas tran vdout1_14ck720 FIND v(dout1_14) AT=365.025n

.meas tran vdout1_15ck720 FIND v(dout1_15) AT=365.025n

.meas tran vdout1_16ck720 FIND v(dout1_16) AT=365.025n

.meas tran vdout1_17ck720 FIND v(dout1_17) AT=365.025n

.meas tran vdout1_18ck720 FIND v(dout1_18) AT=365.025n

.meas tran vdout1_19ck720 FIND v(dout1_19) AT=365.025n

.meas tran vdout1_20ck720 FIND v(dout1_20) AT=365.025n

.meas tran vdout1_21ck720 FIND v(dout1_21) AT=365.025n

.meas tran vdout1_22ck720 FIND v(dout1_22) AT=365.025n

.meas tran vdout1_23ck720 FIND v(dout1_23) AT=365.025n

.meas tran vdout0_0ck730 FIND v(dout0_0) AT=370.025n

.meas tran vdout0_1ck730 FIND v(dout0_1) AT=370.025n

.meas tran vdout0_2ck730 FIND v(dout0_2) AT=370.025n

.meas tran vdout0_3ck730 FIND v(dout0_3) AT=370.025n

.meas tran vdout0_4ck730 FIND v(dout0_4) AT=370.025n

.meas tran vdout0_5ck730 FIND v(dout0_5) AT=370.025n

.meas tran vdout0_6ck730 FIND v(dout0_6) AT=370.025n

.meas tran vdout0_7ck730 FIND v(dout0_7) AT=370.025n

.meas tran vdout0_8ck730 FIND v(dout0_8) AT=370.025n

.meas tran vdout0_9ck730 FIND v(dout0_9) AT=370.025n

.meas tran vdout0_10ck730 FIND v(dout0_10) AT=370.025n

.meas tran vdout0_11ck730 FIND v(dout0_11) AT=370.025n

.meas tran vdout0_12ck730 FIND v(dout0_12) AT=370.025n

.meas tran vdout0_13ck730 FIND v(dout0_13) AT=370.025n

.meas tran vdout0_14ck730 FIND v(dout0_14) AT=370.025n

.meas tran vdout0_15ck730 FIND v(dout0_15) AT=370.025n

.meas tran vdout0_16ck730 FIND v(dout0_16) AT=370.025n

.meas tran vdout0_17ck730 FIND v(dout0_17) AT=370.025n

.meas tran vdout0_18ck730 FIND v(dout0_18) AT=370.025n

.meas tran vdout0_19ck730 FIND v(dout0_19) AT=370.025n

.meas tran vdout0_20ck730 FIND v(dout0_20) AT=370.025n

.meas tran vdout0_21ck730 FIND v(dout0_21) AT=370.025n

.meas tran vdout0_22ck730 FIND v(dout0_22) AT=370.025n

.meas tran vdout0_23ck730 FIND v(dout0_23) AT=370.025n

.meas tran vdout1_0ck730 FIND v(dout1_0) AT=370.025n

.meas tran vdout1_1ck730 FIND v(dout1_1) AT=370.025n

.meas tran vdout1_2ck730 FIND v(dout1_2) AT=370.025n

.meas tran vdout1_3ck730 FIND v(dout1_3) AT=370.025n

.meas tran vdout1_4ck730 FIND v(dout1_4) AT=370.025n

.meas tran vdout1_5ck730 FIND v(dout1_5) AT=370.025n

.meas tran vdout1_6ck730 FIND v(dout1_6) AT=370.025n

.meas tran vdout1_7ck730 FIND v(dout1_7) AT=370.025n

.meas tran vdout1_8ck730 FIND v(dout1_8) AT=370.025n

.meas tran vdout1_9ck730 FIND v(dout1_9) AT=370.025n

.meas tran vdout1_10ck730 FIND v(dout1_10) AT=370.025n

.meas tran vdout1_11ck730 FIND v(dout1_11) AT=370.025n

.meas tran vdout1_12ck730 FIND v(dout1_12) AT=370.025n

.meas tran vdout1_13ck730 FIND v(dout1_13) AT=370.025n

.meas tran vdout1_14ck730 FIND v(dout1_14) AT=370.025n

.meas tran vdout1_15ck730 FIND v(dout1_15) AT=370.025n

.meas tran vdout1_16ck730 FIND v(dout1_16) AT=370.025n

.meas tran vdout1_17ck730 FIND v(dout1_17) AT=370.025n

.meas tran vdout1_18ck730 FIND v(dout1_18) AT=370.025n

.meas tran vdout1_19ck730 FIND v(dout1_19) AT=370.025n

.meas tran vdout1_20ck730 FIND v(dout1_20) AT=370.025n

.meas tran vdout1_21ck730 FIND v(dout1_21) AT=370.025n

.meas tran vdout1_22ck730 FIND v(dout1_22) AT=370.025n

.meas tran vdout1_23ck730 FIND v(dout1_23) AT=370.025n

.meas tran vdout0_0ck740 FIND v(dout0_0) AT=375.025n

.meas tran vdout0_1ck740 FIND v(dout0_1) AT=375.025n

.meas tran vdout0_2ck740 FIND v(dout0_2) AT=375.025n

.meas tran vdout0_3ck740 FIND v(dout0_3) AT=375.025n

.meas tran vdout0_4ck740 FIND v(dout0_4) AT=375.025n

.meas tran vdout0_5ck740 FIND v(dout0_5) AT=375.025n

.meas tran vdout0_6ck740 FIND v(dout0_6) AT=375.025n

.meas tran vdout0_7ck740 FIND v(dout0_7) AT=375.025n

.meas tran vdout0_8ck740 FIND v(dout0_8) AT=375.025n

.meas tran vdout0_9ck740 FIND v(dout0_9) AT=375.025n

.meas tran vdout0_10ck740 FIND v(dout0_10) AT=375.025n

.meas tran vdout0_11ck740 FIND v(dout0_11) AT=375.025n

.meas tran vdout0_12ck740 FIND v(dout0_12) AT=375.025n

.meas tran vdout0_13ck740 FIND v(dout0_13) AT=375.025n

.meas tran vdout0_14ck740 FIND v(dout0_14) AT=375.025n

.meas tran vdout0_15ck740 FIND v(dout0_15) AT=375.025n

.meas tran vdout0_16ck740 FIND v(dout0_16) AT=375.025n

.meas tran vdout0_17ck740 FIND v(dout0_17) AT=375.025n

.meas tran vdout0_18ck740 FIND v(dout0_18) AT=375.025n

.meas tran vdout0_19ck740 FIND v(dout0_19) AT=375.025n

.meas tran vdout0_20ck740 FIND v(dout0_20) AT=375.025n

.meas tran vdout0_21ck740 FIND v(dout0_21) AT=375.025n

.meas tran vdout0_22ck740 FIND v(dout0_22) AT=375.025n

.meas tran vdout0_23ck740 FIND v(dout0_23) AT=375.025n

.meas tran vdout1_0ck750 FIND v(dout1_0) AT=380.025n

.meas tran vdout1_1ck750 FIND v(dout1_1) AT=380.025n

.meas tran vdout1_2ck750 FIND v(dout1_2) AT=380.025n

.meas tran vdout1_3ck750 FIND v(dout1_3) AT=380.025n

.meas tran vdout1_4ck750 FIND v(dout1_4) AT=380.025n

.meas tran vdout1_5ck750 FIND v(dout1_5) AT=380.025n

.meas tran vdout1_6ck750 FIND v(dout1_6) AT=380.025n

.meas tran vdout1_7ck750 FIND v(dout1_7) AT=380.025n

.meas tran vdout1_8ck750 FIND v(dout1_8) AT=380.025n

.meas tran vdout1_9ck750 FIND v(dout1_9) AT=380.025n

.meas tran vdout1_10ck750 FIND v(dout1_10) AT=380.025n

.meas tran vdout1_11ck750 FIND v(dout1_11) AT=380.025n

.meas tran vdout1_12ck750 FIND v(dout1_12) AT=380.025n

.meas tran vdout1_13ck750 FIND v(dout1_13) AT=380.025n

.meas tran vdout1_14ck750 FIND v(dout1_14) AT=380.025n

.meas tran vdout1_15ck750 FIND v(dout1_15) AT=380.025n

.meas tran vdout1_16ck750 FIND v(dout1_16) AT=380.025n

.meas tran vdout1_17ck750 FIND v(dout1_17) AT=380.025n

.meas tran vdout1_18ck750 FIND v(dout1_18) AT=380.025n

.meas tran vdout1_19ck750 FIND v(dout1_19) AT=380.025n

.meas tran vdout1_20ck750 FIND v(dout1_20) AT=380.025n

.meas tran vdout1_21ck750 FIND v(dout1_21) AT=380.025n

.meas tran vdout1_22ck750 FIND v(dout1_22) AT=380.025n

.meas tran vdout1_23ck750 FIND v(dout1_23) AT=380.025n

.meas tran vdout0_0ck760 FIND v(dout0_0) AT=385.025n

.meas tran vdout0_1ck760 FIND v(dout0_1) AT=385.025n

.meas tran vdout0_2ck760 FIND v(dout0_2) AT=385.025n

.meas tran vdout0_3ck760 FIND v(dout0_3) AT=385.025n

.meas tran vdout0_4ck760 FIND v(dout0_4) AT=385.025n

.meas tran vdout0_5ck760 FIND v(dout0_5) AT=385.025n

.meas tran vdout0_6ck760 FIND v(dout0_6) AT=385.025n

.meas tran vdout0_7ck760 FIND v(dout0_7) AT=385.025n

.meas tran vdout0_8ck760 FIND v(dout0_8) AT=385.025n

.meas tran vdout0_9ck760 FIND v(dout0_9) AT=385.025n

.meas tran vdout0_10ck760 FIND v(dout0_10) AT=385.025n

.meas tran vdout0_11ck760 FIND v(dout0_11) AT=385.025n

.meas tran vdout0_12ck760 FIND v(dout0_12) AT=385.025n

.meas tran vdout0_13ck760 FIND v(dout0_13) AT=385.025n

.meas tran vdout0_14ck760 FIND v(dout0_14) AT=385.025n

.meas tran vdout0_15ck760 FIND v(dout0_15) AT=385.025n

.meas tran vdout0_16ck760 FIND v(dout0_16) AT=385.025n

.meas tran vdout0_17ck760 FIND v(dout0_17) AT=385.025n

.meas tran vdout0_18ck760 FIND v(dout0_18) AT=385.025n

.meas tran vdout0_19ck760 FIND v(dout0_19) AT=385.025n

.meas tran vdout0_20ck760 FIND v(dout0_20) AT=385.025n

.meas tran vdout0_21ck760 FIND v(dout0_21) AT=385.025n

.meas tran vdout0_22ck760 FIND v(dout0_22) AT=385.025n

.meas tran vdout0_23ck760 FIND v(dout0_23) AT=385.025n

.meas tran vdout1_0ck770 FIND v(dout1_0) AT=390.025n

.meas tran vdout1_1ck770 FIND v(dout1_1) AT=390.025n

.meas tran vdout1_2ck770 FIND v(dout1_2) AT=390.025n

.meas tran vdout1_3ck770 FIND v(dout1_3) AT=390.025n

.meas tran vdout1_4ck770 FIND v(dout1_4) AT=390.025n

.meas tran vdout1_5ck770 FIND v(dout1_5) AT=390.025n

.meas tran vdout1_6ck770 FIND v(dout1_6) AT=390.025n

.meas tran vdout1_7ck770 FIND v(dout1_7) AT=390.025n

.meas tran vdout1_8ck770 FIND v(dout1_8) AT=390.025n

.meas tran vdout1_9ck770 FIND v(dout1_9) AT=390.025n

.meas tran vdout1_10ck770 FIND v(dout1_10) AT=390.025n

.meas tran vdout1_11ck770 FIND v(dout1_11) AT=390.025n

.meas tran vdout1_12ck770 FIND v(dout1_12) AT=390.025n

.meas tran vdout1_13ck770 FIND v(dout1_13) AT=390.025n

.meas tran vdout1_14ck770 FIND v(dout1_14) AT=390.025n

.meas tran vdout1_15ck770 FIND v(dout1_15) AT=390.025n

.meas tran vdout1_16ck770 FIND v(dout1_16) AT=390.025n

.meas tran vdout1_17ck770 FIND v(dout1_17) AT=390.025n

.meas tran vdout1_18ck770 FIND v(dout1_18) AT=390.025n

.meas tran vdout1_19ck770 FIND v(dout1_19) AT=390.025n

.meas tran vdout1_20ck770 FIND v(dout1_20) AT=390.025n

.meas tran vdout1_21ck770 FIND v(dout1_21) AT=390.025n

.meas tran vdout1_22ck770 FIND v(dout1_22) AT=390.025n

.meas tran vdout1_23ck770 FIND v(dout1_23) AT=390.025n

.meas tran vdout0_0ck780 FIND v(dout0_0) AT=395.025n

.meas tran vdout0_1ck780 FIND v(dout0_1) AT=395.025n

.meas tran vdout0_2ck780 FIND v(dout0_2) AT=395.025n

.meas tran vdout0_3ck780 FIND v(dout0_3) AT=395.025n

.meas tran vdout0_4ck780 FIND v(dout0_4) AT=395.025n

.meas tran vdout0_5ck780 FIND v(dout0_5) AT=395.025n

.meas tran vdout0_6ck780 FIND v(dout0_6) AT=395.025n

.meas tran vdout0_7ck780 FIND v(dout0_7) AT=395.025n

.meas tran vdout0_8ck780 FIND v(dout0_8) AT=395.025n

.meas tran vdout0_9ck780 FIND v(dout0_9) AT=395.025n

.meas tran vdout0_10ck780 FIND v(dout0_10) AT=395.025n

.meas tran vdout0_11ck780 FIND v(dout0_11) AT=395.025n

.meas tran vdout0_12ck780 FIND v(dout0_12) AT=395.025n

.meas tran vdout0_13ck780 FIND v(dout0_13) AT=395.025n

.meas tran vdout0_14ck780 FIND v(dout0_14) AT=395.025n

.meas tran vdout0_15ck780 FIND v(dout0_15) AT=395.025n

.meas tran vdout0_16ck780 FIND v(dout0_16) AT=395.025n

.meas tran vdout0_17ck780 FIND v(dout0_17) AT=395.025n

.meas tran vdout0_18ck780 FIND v(dout0_18) AT=395.025n

.meas tran vdout0_19ck780 FIND v(dout0_19) AT=395.025n

.meas tran vdout0_20ck780 FIND v(dout0_20) AT=395.025n

.meas tran vdout0_21ck780 FIND v(dout0_21) AT=395.025n

.meas tran vdout0_22ck780 FIND v(dout0_22) AT=395.025n

.meas tran vdout0_23ck780 FIND v(dout0_23) AT=395.025n

.meas tran vdout1_0ck790 FIND v(dout1_0) AT=400.025n

.meas tran vdout1_1ck790 FIND v(dout1_1) AT=400.025n

.meas tran vdout1_2ck790 FIND v(dout1_2) AT=400.025n

.meas tran vdout1_3ck790 FIND v(dout1_3) AT=400.025n

.meas tran vdout1_4ck790 FIND v(dout1_4) AT=400.025n

.meas tran vdout1_5ck790 FIND v(dout1_5) AT=400.025n

.meas tran vdout1_6ck790 FIND v(dout1_6) AT=400.025n

.meas tran vdout1_7ck790 FIND v(dout1_7) AT=400.025n

.meas tran vdout1_8ck790 FIND v(dout1_8) AT=400.025n

.meas tran vdout1_9ck790 FIND v(dout1_9) AT=400.025n

.meas tran vdout1_10ck790 FIND v(dout1_10) AT=400.025n

.meas tran vdout1_11ck790 FIND v(dout1_11) AT=400.025n

.meas tran vdout1_12ck790 FIND v(dout1_12) AT=400.025n

.meas tran vdout1_13ck790 FIND v(dout1_13) AT=400.025n

.meas tran vdout1_14ck790 FIND v(dout1_14) AT=400.025n

.meas tran vdout1_15ck790 FIND v(dout1_15) AT=400.025n

.meas tran vdout1_16ck790 FIND v(dout1_16) AT=400.025n

.meas tran vdout1_17ck790 FIND v(dout1_17) AT=400.025n

.meas tran vdout1_18ck790 FIND v(dout1_18) AT=400.025n

.meas tran vdout1_19ck790 FIND v(dout1_19) AT=400.025n

.meas tran vdout1_20ck790 FIND v(dout1_20) AT=400.025n

.meas tran vdout1_21ck790 FIND v(dout1_21) AT=400.025n

.meas tran vdout1_22ck790 FIND v(dout1_22) AT=400.025n

.meas tran vdout1_23ck790 FIND v(dout1_23) AT=400.025n

.meas tran vdout1_0ck800 FIND v(dout1_0) AT=405.025n

.meas tran vdout1_1ck800 FIND v(dout1_1) AT=405.025n

.meas tran vdout1_2ck800 FIND v(dout1_2) AT=405.025n

.meas tran vdout1_3ck800 FIND v(dout1_3) AT=405.025n

.meas tran vdout1_4ck800 FIND v(dout1_4) AT=405.025n

.meas tran vdout1_5ck800 FIND v(dout1_5) AT=405.025n

.meas tran vdout1_6ck800 FIND v(dout1_6) AT=405.025n

.meas tran vdout1_7ck800 FIND v(dout1_7) AT=405.025n

.meas tran vdout1_8ck800 FIND v(dout1_8) AT=405.025n

.meas tran vdout1_9ck800 FIND v(dout1_9) AT=405.025n

.meas tran vdout1_10ck800 FIND v(dout1_10) AT=405.025n

.meas tran vdout1_11ck800 FIND v(dout1_11) AT=405.025n

.meas tran vdout1_12ck800 FIND v(dout1_12) AT=405.025n

.meas tran vdout1_13ck800 FIND v(dout1_13) AT=405.025n

.meas tran vdout1_14ck800 FIND v(dout1_14) AT=405.025n

.meas tran vdout1_15ck800 FIND v(dout1_15) AT=405.025n

.meas tran vdout1_16ck800 FIND v(dout1_16) AT=405.025n

.meas tran vdout1_17ck800 FIND v(dout1_17) AT=405.025n

.meas tran vdout1_18ck800 FIND v(dout1_18) AT=405.025n

.meas tran vdout1_19ck800 FIND v(dout1_19) AT=405.025n

.meas tran vdout1_20ck800 FIND v(dout1_20) AT=405.025n

.meas tran vdout1_21ck800 FIND v(dout1_21) AT=405.025n

.meas tran vdout1_22ck800 FIND v(dout1_22) AT=405.025n

.meas tran vdout1_23ck800 FIND v(dout1_23) AT=405.025n

.meas tran vdout0_0ck810 FIND v(dout0_0) AT=410.025n

.meas tran vdout0_1ck810 FIND v(dout0_1) AT=410.025n

.meas tran vdout0_2ck810 FIND v(dout0_2) AT=410.025n

.meas tran vdout0_3ck810 FIND v(dout0_3) AT=410.025n

.meas tran vdout0_4ck810 FIND v(dout0_4) AT=410.025n

.meas tran vdout0_5ck810 FIND v(dout0_5) AT=410.025n

.meas tran vdout0_6ck810 FIND v(dout0_6) AT=410.025n

.meas tran vdout0_7ck810 FIND v(dout0_7) AT=410.025n

.meas tran vdout0_8ck810 FIND v(dout0_8) AT=410.025n

.meas tran vdout0_9ck810 FIND v(dout0_9) AT=410.025n

.meas tran vdout0_10ck810 FIND v(dout0_10) AT=410.025n

.meas tran vdout0_11ck810 FIND v(dout0_11) AT=410.025n

.meas tran vdout0_12ck810 FIND v(dout0_12) AT=410.025n

.meas tran vdout0_13ck810 FIND v(dout0_13) AT=410.025n

.meas tran vdout0_14ck810 FIND v(dout0_14) AT=410.025n

.meas tran vdout0_15ck810 FIND v(dout0_15) AT=410.025n

.meas tran vdout0_16ck810 FIND v(dout0_16) AT=410.025n

.meas tran vdout0_17ck810 FIND v(dout0_17) AT=410.025n

.meas tran vdout0_18ck810 FIND v(dout0_18) AT=410.025n

.meas tran vdout0_19ck810 FIND v(dout0_19) AT=410.025n

.meas tran vdout0_20ck810 FIND v(dout0_20) AT=410.025n

.meas tran vdout0_21ck810 FIND v(dout0_21) AT=410.025n

.meas tran vdout0_22ck810 FIND v(dout0_22) AT=410.025n

.meas tran vdout0_23ck810 FIND v(dout0_23) AT=410.025n

.meas tran vdout1_0ck810 FIND v(dout1_0) AT=410.025n

.meas tran vdout1_1ck810 FIND v(dout1_1) AT=410.025n

.meas tran vdout1_2ck810 FIND v(dout1_2) AT=410.025n

.meas tran vdout1_3ck810 FIND v(dout1_3) AT=410.025n

.meas tran vdout1_4ck810 FIND v(dout1_4) AT=410.025n

.meas tran vdout1_5ck810 FIND v(dout1_5) AT=410.025n

.meas tran vdout1_6ck810 FIND v(dout1_6) AT=410.025n

.meas tran vdout1_7ck810 FIND v(dout1_7) AT=410.025n

.meas tran vdout1_8ck810 FIND v(dout1_8) AT=410.025n

.meas tran vdout1_9ck810 FIND v(dout1_9) AT=410.025n

.meas tran vdout1_10ck810 FIND v(dout1_10) AT=410.025n

.meas tran vdout1_11ck810 FIND v(dout1_11) AT=410.025n

.meas tran vdout1_12ck810 FIND v(dout1_12) AT=410.025n

.meas tran vdout1_13ck810 FIND v(dout1_13) AT=410.025n

.meas tran vdout1_14ck810 FIND v(dout1_14) AT=410.025n

.meas tran vdout1_15ck810 FIND v(dout1_15) AT=410.025n

.meas tran vdout1_16ck810 FIND v(dout1_16) AT=410.025n

.meas tran vdout1_17ck810 FIND v(dout1_17) AT=410.025n

.meas tran vdout1_18ck810 FIND v(dout1_18) AT=410.025n

.meas tran vdout1_19ck810 FIND v(dout1_19) AT=410.025n

.meas tran vdout1_20ck810 FIND v(dout1_20) AT=410.025n

.meas tran vdout1_21ck810 FIND v(dout1_21) AT=410.025n

.meas tran vdout1_22ck810 FIND v(dout1_22) AT=410.025n

.meas tran vdout1_23ck810 FIND v(dout1_23) AT=410.025n

.meas tran vdout0_0ck820 FIND v(dout0_0) AT=415.025n

.meas tran vdout0_1ck820 FIND v(dout0_1) AT=415.025n

.meas tran vdout0_2ck820 FIND v(dout0_2) AT=415.025n

.meas tran vdout0_3ck820 FIND v(dout0_3) AT=415.025n

.meas tran vdout0_4ck820 FIND v(dout0_4) AT=415.025n

.meas tran vdout0_5ck820 FIND v(dout0_5) AT=415.025n

.meas tran vdout0_6ck820 FIND v(dout0_6) AT=415.025n

.meas tran vdout0_7ck820 FIND v(dout0_7) AT=415.025n

.meas tran vdout0_8ck820 FIND v(dout0_8) AT=415.025n

.meas tran vdout0_9ck820 FIND v(dout0_9) AT=415.025n

.meas tran vdout0_10ck820 FIND v(dout0_10) AT=415.025n

.meas tran vdout0_11ck820 FIND v(dout0_11) AT=415.025n

.meas tran vdout0_12ck820 FIND v(dout0_12) AT=415.025n

.meas tran vdout0_13ck820 FIND v(dout0_13) AT=415.025n

.meas tran vdout0_14ck820 FIND v(dout0_14) AT=415.025n

.meas tran vdout0_15ck820 FIND v(dout0_15) AT=415.025n

.meas tran vdout0_16ck820 FIND v(dout0_16) AT=415.025n

.meas tran vdout0_17ck820 FIND v(dout0_17) AT=415.025n

.meas tran vdout0_18ck820 FIND v(dout0_18) AT=415.025n

.meas tran vdout0_19ck820 FIND v(dout0_19) AT=415.025n

.meas tran vdout0_20ck820 FIND v(dout0_20) AT=415.025n

.meas tran vdout0_21ck820 FIND v(dout0_21) AT=415.025n

.meas tran vdout0_22ck820 FIND v(dout0_22) AT=415.025n

.meas tran vdout0_23ck820 FIND v(dout0_23) AT=415.025n

.meas tran vdout1_0ck820 FIND v(dout1_0) AT=415.025n

.meas tran vdout1_1ck820 FIND v(dout1_1) AT=415.025n

.meas tran vdout1_2ck820 FIND v(dout1_2) AT=415.025n

.meas tran vdout1_3ck820 FIND v(dout1_3) AT=415.025n

.meas tran vdout1_4ck820 FIND v(dout1_4) AT=415.025n

.meas tran vdout1_5ck820 FIND v(dout1_5) AT=415.025n

.meas tran vdout1_6ck820 FIND v(dout1_6) AT=415.025n

.meas tran vdout1_7ck820 FIND v(dout1_7) AT=415.025n

.meas tran vdout1_8ck820 FIND v(dout1_8) AT=415.025n

.meas tran vdout1_9ck820 FIND v(dout1_9) AT=415.025n

.meas tran vdout1_10ck820 FIND v(dout1_10) AT=415.025n

.meas tran vdout1_11ck820 FIND v(dout1_11) AT=415.025n

.meas tran vdout1_12ck820 FIND v(dout1_12) AT=415.025n

.meas tran vdout1_13ck820 FIND v(dout1_13) AT=415.025n

.meas tran vdout1_14ck820 FIND v(dout1_14) AT=415.025n

.meas tran vdout1_15ck820 FIND v(dout1_15) AT=415.025n

.meas tran vdout1_16ck820 FIND v(dout1_16) AT=415.025n

.meas tran vdout1_17ck820 FIND v(dout1_17) AT=415.025n

.meas tran vdout1_18ck820 FIND v(dout1_18) AT=415.025n

.meas tran vdout1_19ck820 FIND v(dout1_19) AT=415.025n

.meas tran vdout1_20ck820 FIND v(dout1_20) AT=415.025n

.meas tran vdout1_21ck820 FIND v(dout1_21) AT=415.025n

.meas tran vdout1_22ck820 FIND v(dout1_22) AT=415.025n

.meas tran vdout1_23ck820 FIND v(dout1_23) AT=415.025n

.meas tran vdout0_0ck830 FIND v(dout0_0) AT=420.025n

.meas tran vdout0_1ck830 FIND v(dout0_1) AT=420.025n

.meas tran vdout0_2ck830 FIND v(dout0_2) AT=420.025n

.meas tran vdout0_3ck830 FIND v(dout0_3) AT=420.025n

.meas tran vdout0_4ck830 FIND v(dout0_4) AT=420.025n

.meas tran vdout0_5ck830 FIND v(dout0_5) AT=420.025n

.meas tran vdout0_6ck830 FIND v(dout0_6) AT=420.025n

.meas tran vdout0_7ck830 FIND v(dout0_7) AT=420.025n

.meas tran vdout0_8ck830 FIND v(dout0_8) AT=420.025n

.meas tran vdout0_9ck830 FIND v(dout0_9) AT=420.025n

.meas tran vdout0_10ck830 FIND v(dout0_10) AT=420.025n

.meas tran vdout0_11ck830 FIND v(dout0_11) AT=420.025n

.meas tran vdout0_12ck830 FIND v(dout0_12) AT=420.025n

.meas tran vdout0_13ck830 FIND v(dout0_13) AT=420.025n

.meas tran vdout0_14ck830 FIND v(dout0_14) AT=420.025n

.meas tran vdout0_15ck830 FIND v(dout0_15) AT=420.025n

.meas tran vdout0_16ck830 FIND v(dout0_16) AT=420.025n

.meas tran vdout0_17ck830 FIND v(dout0_17) AT=420.025n

.meas tran vdout0_18ck830 FIND v(dout0_18) AT=420.025n

.meas tran vdout0_19ck830 FIND v(dout0_19) AT=420.025n

.meas tran vdout0_20ck830 FIND v(dout0_20) AT=420.025n

.meas tran vdout0_21ck830 FIND v(dout0_21) AT=420.025n

.meas tran vdout0_22ck830 FIND v(dout0_22) AT=420.025n

.meas tran vdout0_23ck830 FIND v(dout0_23) AT=420.025n

.meas tran vdout0_0ck840 FIND v(dout0_0) AT=425.025n

.meas tran vdout0_1ck840 FIND v(dout0_1) AT=425.025n

.meas tran vdout0_2ck840 FIND v(dout0_2) AT=425.025n

.meas tran vdout0_3ck840 FIND v(dout0_3) AT=425.025n

.meas tran vdout0_4ck840 FIND v(dout0_4) AT=425.025n

.meas tran vdout0_5ck840 FIND v(dout0_5) AT=425.025n

.meas tran vdout0_6ck840 FIND v(dout0_6) AT=425.025n

.meas tran vdout0_7ck840 FIND v(dout0_7) AT=425.025n

.meas tran vdout0_8ck840 FIND v(dout0_8) AT=425.025n

.meas tran vdout0_9ck840 FIND v(dout0_9) AT=425.025n

.meas tran vdout0_10ck840 FIND v(dout0_10) AT=425.025n

.meas tran vdout0_11ck840 FIND v(dout0_11) AT=425.025n

.meas tran vdout0_12ck840 FIND v(dout0_12) AT=425.025n

.meas tran vdout0_13ck840 FIND v(dout0_13) AT=425.025n

.meas tran vdout0_14ck840 FIND v(dout0_14) AT=425.025n

.meas tran vdout0_15ck840 FIND v(dout0_15) AT=425.025n

.meas tran vdout0_16ck840 FIND v(dout0_16) AT=425.025n

.meas tran vdout0_17ck840 FIND v(dout0_17) AT=425.025n

.meas tran vdout0_18ck840 FIND v(dout0_18) AT=425.025n

.meas tran vdout0_19ck840 FIND v(dout0_19) AT=425.025n

.meas tran vdout0_20ck840 FIND v(dout0_20) AT=425.025n

.meas tran vdout0_21ck840 FIND v(dout0_21) AT=425.025n

.meas tran vdout0_22ck840 FIND v(dout0_22) AT=425.025n

.meas tran vdout0_23ck840 FIND v(dout0_23) AT=425.025n

.meas tran vdout1_0ck840 FIND v(dout1_0) AT=425.025n

.meas tran vdout1_1ck840 FIND v(dout1_1) AT=425.025n

.meas tran vdout1_2ck840 FIND v(dout1_2) AT=425.025n

.meas tran vdout1_3ck840 FIND v(dout1_3) AT=425.025n

.meas tran vdout1_4ck840 FIND v(dout1_4) AT=425.025n

.meas tran vdout1_5ck840 FIND v(dout1_5) AT=425.025n

.meas tran vdout1_6ck840 FIND v(dout1_6) AT=425.025n

.meas tran vdout1_7ck840 FIND v(dout1_7) AT=425.025n

.meas tran vdout1_8ck840 FIND v(dout1_8) AT=425.025n

.meas tran vdout1_9ck840 FIND v(dout1_9) AT=425.025n

.meas tran vdout1_10ck840 FIND v(dout1_10) AT=425.025n

.meas tran vdout1_11ck840 FIND v(dout1_11) AT=425.025n

.meas tran vdout1_12ck840 FIND v(dout1_12) AT=425.025n

.meas tran vdout1_13ck840 FIND v(dout1_13) AT=425.025n

.meas tran vdout1_14ck840 FIND v(dout1_14) AT=425.025n

.meas tran vdout1_15ck840 FIND v(dout1_15) AT=425.025n

.meas tran vdout1_16ck840 FIND v(dout1_16) AT=425.025n

.meas tran vdout1_17ck840 FIND v(dout1_17) AT=425.025n

.meas tran vdout1_18ck840 FIND v(dout1_18) AT=425.025n

.meas tran vdout1_19ck840 FIND v(dout1_19) AT=425.025n

.meas tran vdout1_20ck840 FIND v(dout1_20) AT=425.025n

.meas tran vdout1_21ck840 FIND v(dout1_21) AT=425.025n

.meas tran vdout1_22ck840 FIND v(dout1_22) AT=425.025n

.meas tran vdout1_23ck840 FIND v(dout1_23) AT=425.025n

.meas tran vdout0_0ck860 FIND v(dout0_0) AT=435.025n

.meas tran vdout0_1ck860 FIND v(dout0_1) AT=435.025n

.meas tran vdout0_2ck860 FIND v(dout0_2) AT=435.025n

.meas tran vdout0_3ck860 FIND v(dout0_3) AT=435.025n

.meas tran vdout0_4ck860 FIND v(dout0_4) AT=435.025n

.meas tran vdout0_5ck860 FIND v(dout0_5) AT=435.025n

.meas tran vdout0_6ck860 FIND v(dout0_6) AT=435.025n

.meas tran vdout0_7ck860 FIND v(dout0_7) AT=435.025n

.meas tran vdout0_8ck860 FIND v(dout0_8) AT=435.025n

.meas tran vdout0_9ck860 FIND v(dout0_9) AT=435.025n

.meas tran vdout0_10ck860 FIND v(dout0_10) AT=435.025n

.meas tran vdout0_11ck860 FIND v(dout0_11) AT=435.025n

.meas tran vdout0_12ck860 FIND v(dout0_12) AT=435.025n

.meas tran vdout0_13ck860 FIND v(dout0_13) AT=435.025n

.meas tran vdout0_14ck860 FIND v(dout0_14) AT=435.025n

.meas tran vdout0_15ck860 FIND v(dout0_15) AT=435.025n

.meas tran vdout0_16ck860 FIND v(dout0_16) AT=435.025n

.meas tran vdout0_17ck860 FIND v(dout0_17) AT=435.025n

.meas tran vdout0_18ck860 FIND v(dout0_18) AT=435.025n

.meas tran vdout0_19ck860 FIND v(dout0_19) AT=435.025n

.meas tran vdout0_20ck860 FIND v(dout0_20) AT=435.025n

.meas tran vdout0_21ck860 FIND v(dout0_21) AT=435.025n

.meas tran vdout0_22ck860 FIND v(dout0_22) AT=435.025n

.meas tran vdout0_23ck860 FIND v(dout0_23) AT=435.025n

.meas tran vdout0_0ck870 FIND v(dout0_0) AT=440.025n

.meas tran vdout0_1ck870 FIND v(dout0_1) AT=440.025n

.meas tran vdout0_2ck870 FIND v(dout0_2) AT=440.025n

.meas tran vdout0_3ck870 FIND v(dout0_3) AT=440.025n

.meas tran vdout0_4ck870 FIND v(dout0_4) AT=440.025n

.meas tran vdout0_5ck870 FIND v(dout0_5) AT=440.025n

.meas tran vdout0_6ck870 FIND v(dout0_6) AT=440.025n

.meas tran vdout0_7ck870 FIND v(dout0_7) AT=440.025n

.meas tran vdout0_8ck870 FIND v(dout0_8) AT=440.025n

.meas tran vdout0_9ck870 FIND v(dout0_9) AT=440.025n

.meas tran vdout0_10ck870 FIND v(dout0_10) AT=440.025n

.meas tran vdout0_11ck870 FIND v(dout0_11) AT=440.025n

.meas tran vdout0_12ck870 FIND v(dout0_12) AT=440.025n

.meas tran vdout0_13ck870 FIND v(dout0_13) AT=440.025n

.meas tran vdout0_14ck870 FIND v(dout0_14) AT=440.025n

.meas tran vdout0_15ck870 FIND v(dout0_15) AT=440.025n

.meas tran vdout0_16ck870 FIND v(dout0_16) AT=440.025n

.meas tran vdout0_17ck870 FIND v(dout0_17) AT=440.025n

.meas tran vdout0_18ck870 FIND v(dout0_18) AT=440.025n

.meas tran vdout0_19ck870 FIND v(dout0_19) AT=440.025n

.meas tran vdout0_20ck870 FIND v(dout0_20) AT=440.025n

.meas tran vdout0_21ck870 FIND v(dout0_21) AT=440.025n

.meas tran vdout0_22ck870 FIND v(dout0_22) AT=440.025n

.meas tran vdout0_23ck870 FIND v(dout0_23) AT=440.025n

.meas tran vdout1_0ck880 FIND v(dout1_0) AT=445.025n

.meas tran vdout1_1ck880 FIND v(dout1_1) AT=445.025n

.meas tran vdout1_2ck880 FIND v(dout1_2) AT=445.025n

.meas tran vdout1_3ck880 FIND v(dout1_3) AT=445.025n

.meas tran vdout1_4ck880 FIND v(dout1_4) AT=445.025n

.meas tran vdout1_5ck880 FIND v(dout1_5) AT=445.025n

.meas tran vdout1_6ck880 FIND v(dout1_6) AT=445.025n

.meas tran vdout1_7ck880 FIND v(dout1_7) AT=445.025n

.meas tran vdout1_8ck880 FIND v(dout1_8) AT=445.025n

.meas tran vdout1_9ck880 FIND v(dout1_9) AT=445.025n

.meas tran vdout1_10ck880 FIND v(dout1_10) AT=445.025n

.meas tran vdout1_11ck880 FIND v(dout1_11) AT=445.025n

.meas tran vdout1_12ck880 FIND v(dout1_12) AT=445.025n

.meas tran vdout1_13ck880 FIND v(dout1_13) AT=445.025n

.meas tran vdout1_14ck880 FIND v(dout1_14) AT=445.025n

.meas tran vdout1_15ck880 FIND v(dout1_15) AT=445.025n

.meas tran vdout1_16ck880 FIND v(dout1_16) AT=445.025n

.meas tran vdout1_17ck880 FIND v(dout1_17) AT=445.025n

.meas tran vdout1_18ck880 FIND v(dout1_18) AT=445.025n

.meas tran vdout1_19ck880 FIND v(dout1_19) AT=445.025n

.meas tran vdout1_20ck880 FIND v(dout1_20) AT=445.025n

.meas tran vdout1_21ck880 FIND v(dout1_21) AT=445.025n

.meas tran vdout1_22ck880 FIND v(dout1_22) AT=445.025n

.meas tran vdout1_23ck880 FIND v(dout1_23) AT=445.025n

.meas tran vdout0_0ck900 FIND v(dout0_0) AT=455.025n

.meas tran vdout0_1ck900 FIND v(dout0_1) AT=455.025n

.meas tran vdout0_2ck900 FIND v(dout0_2) AT=455.025n

.meas tran vdout0_3ck900 FIND v(dout0_3) AT=455.025n

.meas tran vdout0_4ck900 FIND v(dout0_4) AT=455.025n

.meas tran vdout0_5ck900 FIND v(dout0_5) AT=455.025n

.meas tran vdout0_6ck900 FIND v(dout0_6) AT=455.025n

.meas tran vdout0_7ck900 FIND v(dout0_7) AT=455.025n

.meas tran vdout0_8ck900 FIND v(dout0_8) AT=455.025n

.meas tran vdout0_9ck900 FIND v(dout0_9) AT=455.025n

.meas tran vdout0_10ck900 FIND v(dout0_10) AT=455.025n

.meas tran vdout0_11ck900 FIND v(dout0_11) AT=455.025n

.meas tran vdout0_12ck900 FIND v(dout0_12) AT=455.025n

.meas tran vdout0_13ck900 FIND v(dout0_13) AT=455.025n

.meas tran vdout0_14ck900 FIND v(dout0_14) AT=455.025n

.meas tran vdout0_15ck900 FIND v(dout0_15) AT=455.025n

.meas tran vdout0_16ck900 FIND v(dout0_16) AT=455.025n

.meas tran vdout0_17ck900 FIND v(dout0_17) AT=455.025n

.meas tran vdout0_18ck900 FIND v(dout0_18) AT=455.025n

.meas tran vdout0_19ck900 FIND v(dout0_19) AT=455.025n

.meas tran vdout0_20ck900 FIND v(dout0_20) AT=455.025n

.meas tran vdout0_21ck900 FIND v(dout0_21) AT=455.025n

.meas tran vdout0_22ck900 FIND v(dout0_22) AT=455.025n

.meas tran vdout0_23ck900 FIND v(dout0_23) AT=455.025n

.meas tran vdout1_0ck910 FIND v(dout1_0) AT=460.025n

.meas tran vdout1_1ck910 FIND v(dout1_1) AT=460.025n

.meas tran vdout1_2ck910 FIND v(dout1_2) AT=460.025n

.meas tran vdout1_3ck910 FIND v(dout1_3) AT=460.025n

.meas tran vdout1_4ck910 FIND v(dout1_4) AT=460.025n

.meas tran vdout1_5ck910 FIND v(dout1_5) AT=460.025n

.meas tran vdout1_6ck910 FIND v(dout1_6) AT=460.025n

.meas tran vdout1_7ck910 FIND v(dout1_7) AT=460.025n

.meas tran vdout1_8ck910 FIND v(dout1_8) AT=460.025n

.meas tran vdout1_9ck910 FIND v(dout1_9) AT=460.025n

.meas tran vdout1_10ck910 FIND v(dout1_10) AT=460.025n

.meas tran vdout1_11ck910 FIND v(dout1_11) AT=460.025n

.meas tran vdout1_12ck910 FIND v(dout1_12) AT=460.025n

.meas tran vdout1_13ck910 FIND v(dout1_13) AT=460.025n

.meas tran vdout1_14ck910 FIND v(dout1_14) AT=460.025n

.meas tran vdout1_15ck910 FIND v(dout1_15) AT=460.025n

.meas tran vdout1_16ck910 FIND v(dout1_16) AT=460.025n

.meas tran vdout1_17ck910 FIND v(dout1_17) AT=460.025n

.meas tran vdout1_18ck910 FIND v(dout1_18) AT=460.025n

.meas tran vdout1_19ck910 FIND v(dout1_19) AT=460.025n

.meas tran vdout1_20ck910 FIND v(dout1_20) AT=460.025n

.meas tran vdout1_21ck910 FIND v(dout1_21) AT=460.025n

.meas tran vdout1_22ck910 FIND v(dout1_22) AT=460.025n

.meas tran vdout1_23ck910 FIND v(dout1_23) AT=460.025n

.meas tran vdout1_0ck920 FIND v(dout1_0) AT=465.025n

.meas tran vdout1_1ck920 FIND v(dout1_1) AT=465.025n

.meas tran vdout1_2ck920 FIND v(dout1_2) AT=465.025n

.meas tran vdout1_3ck920 FIND v(dout1_3) AT=465.025n

.meas tran vdout1_4ck920 FIND v(dout1_4) AT=465.025n

.meas tran vdout1_5ck920 FIND v(dout1_5) AT=465.025n

.meas tran vdout1_6ck920 FIND v(dout1_6) AT=465.025n

.meas tran vdout1_7ck920 FIND v(dout1_7) AT=465.025n

.meas tran vdout1_8ck920 FIND v(dout1_8) AT=465.025n

.meas tran vdout1_9ck920 FIND v(dout1_9) AT=465.025n

.meas tran vdout1_10ck920 FIND v(dout1_10) AT=465.025n

.meas tran vdout1_11ck920 FIND v(dout1_11) AT=465.025n

.meas tran vdout1_12ck920 FIND v(dout1_12) AT=465.025n

.meas tran vdout1_13ck920 FIND v(dout1_13) AT=465.025n

.meas tran vdout1_14ck920 FIND v(dout1_14) AT=465.025n

.meas tran vdout1_15ck920 FIND v(dout1_15) AT=465.025n

.meas tran vdout1_16ck920 FIND v(dout1_16) AT=465.025n

.meas tran vdout1_17ck920 FIND v(dout1_17) AT=465.025n

.meas tran vdout1_18ck920 FIND v(dout1_18) AT=465.025n

.meas tran vdout1_19ck920 FIND v(dout1_19) AT=465.025n

.meas tran vdout1_20ck920 FIND v(dout1_20) AT=465.025n

.meas tran vdout1_21ck920 FIND v(dout1_21) AT=465.025n

.meas tran vdout1_22ck920 FIND v(dout1_22) AT=465.025n

.meas tran vdout1_23ck920 FIND v(dout1_23) AT=465.025n

.meas tran vdout1_0ck930 FIND v(dout1_0) AT=470.025n

.meas tran vdout1_1ck930 FIND v(dout1_1) AT=470.025n

.meas tran vdout1_2ck930 FIND v(dout1_2) AT=470.025n

.meas tran vdout1_3ck930 FIND v(dout1_3) AT=470.025n

.meas tran vdout1_4ck930 FIND v(dout1_4) AT=470.025n

.meas tran vdout1_5ck930 FIND v(dout1_5) AT=470.025n

.meas tran vdout1_6ck930 FIND v(dout1_6) AT=470.025n

.meas tran vdout1_7ck930 FIND v(dout1_7) AT=470.025n

.meas tran vdout1_8ck930 FIND v(dout1_8) AT=470.025n

.meas tran vdout1_9ck930 FIND v(dout1_9) AT=470.025n

.meas tran vdout1_10ck930 FIND v(dout1_10) AT=470.025n

.meas tran vdout1_11ck930 FIND v(dout1_11) AT=470.025n

.meas tran vdout1_12ck930 FIND v(dout1_12) AT=470.025n

.meas tran vdout1_13ck930 FIND v(dout1_13) AT=470.025n

.meas tran vdout1_14ck930 FIND v(dout1_14) AT=470.025n

.meas tran vdout1_15ck930 FIND v(dout1_15) AT=470.025n

.meas tran vdout1_16ck930 FIND v(dout1_16) AT=470.025n

.meas tran vdout1_17ck930 FIND v(dout1_17) AT=470.025n

.meas tran vdout1_18ck930 FIND v(dout1_18) AT=470.025n

.meas tran vdout1_19ck930 FIND v(dout1_19) AT=470.025n

.meas tran vdout1_20ck930 FIND v(dout1_20) AT=470.025n

.meas tran vdout1_21ck930 FIND v(dout1_21) AT=470.025n

.meas tran vdout1_22ck930 FIND v(dout1_22) AT=470.025n

.meas tran vdout1_23ck930 FIND v(dout1_23) AT=470.025n

.meas tran vdout1_0ck940 FIND v(dout1_0) AT=475.025n

.meas tran vdout1_1ck940 FIND v(dout1_1) AT=475.025n

.meas tran vdout1_2ck940 FIND v(dout1_2) AT=475.025n

.meas tran vdout1_3ck940 FIND v(dout1_3) AT=475.025n

.meas tran vdout1_4ck940 FIND v(dout1_4) AT=475.025n

.meas tran vdout1_5ck940 FIND v(dout1_5) AT=475.025n

.meas tran vdout1_6ck940 FIND v(dout1_6) AT=475.025n

.meas tran vdout1_7ck940 FIND v(dout1_7) AT=475.025n

.meas tran vdout1_8ck940 FIND v(dout1_8) AT=475.025n

.meas tran vdout1_9ck940 FIND v(dout1_9) AT=475.025n

.meas tran vdout1_10ck940 FIND v(dout1_10) AT=475.025n

.meas tran vdout1_11ck940 FIND v(dout1_11) AT=475.025n

.meas tran vdout1_12ck940 FIND v(dout1_12) AT=475.025n

.meas tran vdout1_13ck940 FIND v(dout1_13) AT=475.025n

.meas tran vdout1_14ck940 FIND v(dout1_14) AT=475.025n

.meas tran vdout1_15ck940 FIND v(dout1_15) AT=475.025n

.meas tran vdout1_16ck940 FIND v(dout1_16) AT=475.025n

.meas tran vdout1_17ck940 FIND v(dout1_17) AT=475.025n

.meas tran vdout1_18ck940 FIND v(dout1_18) AT=475.025n

.meas tran vdout1_19ck940 FIND v(dout1_19) AT=475.025n

.meas tran vdout1_20ck940 FIND v(dout1_20) AT=475.025n

.meas tran vdout1_21ck940 FIND v(dout1_21) AT=475.025n

.meas tran vdout1_22ck940 FIND v(dout1_22) AT=475.025n

.meas tran vdout1_23ck940 FIND v(dout1_23) AT=475.025n

.meas tran vdout1_0ck950 FIND v(dout1_0) AT=480.025n

.meas tran vdout1_1ck950 FIND v(dout1_1) AT=480.025n

.meas tran vdout1_2ck950 FIND v(dout1_2) AT=480.025n

.meas tran vdout1_3ck950 FIND v(dout1_3) AT=480.025n

.meas tran vdout1_4ck950 FIND v(dout1_4) AT=480.025n

.meas tran vdout1_5ck950 FIND v(dout1_5) AT=480.025n

.meas tran vdout1_6ck950 FIND v(dout1_6) AT=480.025n

.meas tran vdout1_7ck950 FIND v(dout1_7) AT=480.025n

.meas tran vdout1_8ck950 FIND v(dout1_8) AT=480.025n

.meas tran vdout1_9ck950 FIND v(dout1_9) AT=480.025n

.meas tran vdout1_10ck950 FIND v(dout1_10) AT=480.025n

.meas tran vdout1_11ck950 FIND v(dout1_11) AT=480.025n

.meas tran vdout1_12ck950 FIND v(dout1_12) AT=480.025n

.meas tran vdout1_13ck950 FIND v(dout1_13) AT=480.025n

.meas tran vdout1_14ck950 FIND v(dout1_14) AT=480.025n

.meas tran vdout1_15ck950 FIND v(dout1_15) AT=480.025n

.meas tran vdout1_16ck950 FIND v(dout1_16) AT=480.025n

.meas tran vdout1_17ck950 FIND v(dout1_17) AT=480.025n

.meas tran vdout1_18ck950 FIND v(dout1_18) AT=480.025n

.meas tran vdout1_19ck950 FIND v(dout1_19) AT=480.025n

.meas tran vdout1_20ck950 FIND v(dout1_20) AT=480.025n

.meas tran vdout1_21ck950 FIND v(dout1_21) AT=480.025n

.meas tran vdout1_22ck950 FIND v(dout1_22) AT=480.025n

.meas tran vdout1_23ck950 FIND v(dout1_23) AT=480.025n

.meas tran vdout1_0ck960 FIND v(dout1_0) AT=485.025n

.meas tran vdout1_1ck960 FIND v(dout1_1) AT=485.025n

.meas tran vdout1_2ck960 FIND v(dout1_2) AT=485.025n

.meas tran vdout1_3ck960 FIND v(dout1_3) AT=485.025n

.meas tran vdout1_4ck960 FIND v(dout1_4) AT=485.025n

.meas tran vdout1_5ck960 FIND v(dout1_5) AT=485.025n

.meas tran vdout1_6ck960 FIND v(dout1_6) AT=485.025n

.meas tran vdout1_7ck960 FIND v(dout1_7) AT=485.025n

.meas tran vdout1_8ck960 FIND v(dout1_8) AT=485.025n

.meas tran vdout1_9ck960 FIND v(dout1_9) AT=485.025n

.meas tran vdout1_10ck960 FIND v(dout1_10) AT=485.025n

.meas tran vdout1_11ck960 FIND v(dout1_11) AT=485.025n

.meas tran vdout1_12ck960 FIND v(dout1_12) AT=485.025n

.meas tran vdout1_13ck960 FIND v(dout1_13) AT=485.025n

.meas tran vdout1_14ck960 FIND v(dout1_14) AT=485.025n

.meas tran vdout1_15ck960 FIND v(dout1_15) AT=485.025n

.meas tran vdout1_16ck960 FIND v(dout1_16) AT=485.025n

.meas tran vdout1_17ck960 FIND v(dout1_17) AT=485.025n

.meas tran vdout1_18ck960 FIND v(dout1_18) AT=485.025n

.meas tran vdout1_19ck960 FIND v(dout1_19) AT=485.025n

.meas tran vdout1_20ck960 FIND v(dout1_20) AT=485.025n

.meas tran vdout1_21ck960 FIND v(dout1_21) AT=485.025n

.meas tran vdout1_22ck960 FIND v(dout1_22) AT=485.025n

.meas tran vdout1_23ck960 FIND v(dout1_23) AT=485.025n

.meas tran vdout0_0ck970 FIND v(dout0_0) AT=490.025n

.meas tran vdout0_1ck970 FIND v(dout0_1) AT=490.025n

.meas tran vdout0_2ck970 FIND v(dout0_2) AT=490.025n

.meas tran vdout0_3ck970 FIND v(dout0_3) AT=490.025n

.meas tran vdout0_4ck970 FIND v(dout0_4) AT=490.025n

.meas tran vdout0_5ck970 FIND v(dout0_5) AT=490.025n

.meas tran vdout0_6ck970 FIND v(dout0_6) AT=490.025n

.meas tran vdout0_7ck970 FIND v(dout0_7) AT=490.025n

.meas tran vdout0_8ck970 FIND v(dout0_8) AT=490.025n

.meas tran vdout0_9ck970 FIND v(dout0_9) AT=490.025n

.meas tran vdout0_10ck970 FIND v(dout0_10) AT=490.025n

.meas tran vdout0_11ck970 FIND v(dout0_11) AT=490.025n

.meas tran vdout0_12ck970 FIND v(dout0_12) AT=490.025n

.meas tran vdout0_13ck970 FIND v(dout0_13) AT=490.025n

.meas tran vdout0_14ck970 FIND v(dout0_14) AT=490.025n

.meas tran vdout0_15ck970 FIND v(dout0_15) AT=490.025n

.meas tran vdout0_16ck970 FIND v(dout0_16) AT=490.025n

.meas tran vdout0_17ck970 FIND v(dout0_17) AT=490.025n

.meas tran vdout0_18ck970 FIND v(dout0_18) AT=490.025n

.meas tran vdout0_19ck970 FIND v(dout0_19) AT=490.025n

.meas tran vdout0_20ck970 FIND v(dout0_20) AT=490.025n

.meas tran vdout0_21ck970 FIND v(dout0_21) AT=490.025n

.meas tran vdout0_22ck970 FIND v(dout0_22) AT=490.025n

.meas tran vdout0_23ck970 FIND v(dout0_23) AT=490.025n

.meas tran vdout0_0ck980 FIND v(dout0_0) AT=495.025n

.meas tran vdout0_1ck980 FIND v(dout0_1) AT=495.025n

.meas tran vdout0_2ck980 FIND v(dout0_2) AT=495.025n

.meas tran vdout0_3ck980 FIND v(dout0_3) AT=495.025n

.meas tran vdout0_4ck980 FIND v(dout0_4) AT=495.025n

.meas tran vdout0_5ck980 FIND v(dout0_5) AT=495.025n

.meas tran vdout0_6ck980 FIND v(dout0_6) AT=495.025n

.meas tran vdout0_7ck980 FIND v(dout0_7) AT=495.025n

.meas tran vdout0_8ck980 FIND v(dout0_8) AT=495.025n

.meas tran vdout0_9ck980 FIND v(dout0_9) AT=495.025n

.meas tran vdout0_10ck980 FIND v(dout0_10) AT=495.025n

.meas tran vdout0_11ck980 FIND v(dout0_11) AT=495.025n

.meas tran vdout0_12ck980 FIND v(dout0_12) AT=495.025n

.meas tran vdout0_13ck980 FIND v(dout0_13) AT=495.025n

.meas tran vdout0_14ck980 FIND v(dout0_14) AT=495.025n

.meas tran vdout0_15ck980 FIND v(dout0_15) AT=495.025n

.meas tran vdout0_16ck980 FIND v(dout0_16) AT=495.025n

.meas tran vdout0_17ck980 FIND v(dout0_17) AT=495.025n

.meas tran vdout0_18ck980 FIND v(dout0_18) AT=495.025n

.meas tran vdout0_19ck980 FIND v(dout0_19) AT=495.025n

.meas tran vdout0_20ck980 FIND v(dout0_20) AT=495.025n

.meas tran vdout0_21ck980 FIND v(dout0_21) AT=495.025n

.meas tran vdout0_22ck980 FIND v(dout0_22) AT=495.025n

.meas tran vdout0_23ck980 FIND v(dout0_23) AT=495.025n

.meas tran vdout0_0ck990 FIND v(dout0_0) AT=500.025n

.meas tran vdout0_1ck990 FIND v(dout0_1) AT=500.025n

.meas tran vdout0_2ck990 FIND v(dout0_2) AT=500.025n

.meas tran vdout0_3ck990 FIND v(dout0_3) AT=500.025n

.meas tran vdout0_4ck990 FIND v(dout0_4) AT=500.025n

.meas tran vdout0_5ck990 FIND v(dout0_5) AT=500.025n

.meas tran vdout0_6ck990 FIND v(dout0_6) AT=500.025n

.meas tran vdout0_7ck990 FIND v(dout0_7) AT=500.025n

.meas tran vdout0_8ck990 FIND v(dout0_8) AT=500.025n

.meas tran vdout0_9ck990 FIND v(dout0_9) AT=500.025n

.meas tran vdout0_10ck990 FIND v(dout0_10) AT=500.025n

.meas tran vdout0_11ck990 FIND v(dout0_11) AT=500.025n

.meas tran vdout0_12ck990 FIND v(dout0_12) AT=500.025n

.meas tran vdout0_13ck990 FIND v(dout0_13) AT=500.025n

.meas tran vdout0_14ck990 FIND v(dout0_14) AT=500.025n

.meas tran vdout0_15ck990 FIND v(dout0_15) AT=500.025n

.meas tran vdout0_16ck990 FIND v(dout0_16) AT=500.025n

.meas tran vdout0_17ck990 FIND v(dout0_17) AT=500.025n

.meas tran vdout0_18ck990 FIND v(dout0_18) AT=500.025n

.meas tran vdout0_19ck990 FIND v(dout0_19) AT=500.025n

.meas tran vdout0_20ck990 FIND v(dout0_20) AT=500.025n

.meas tran vdout0_21ck990 FIND v(dout0_21) AT=500.025n

.meas tran vdout0_22ck990 FIND v(dout0_22) AT=500.025n

.meas tran vdout0_23ck990 FIND v(dout0_23) AT=500.025n

.meas tran vdout1_0ck990 FIND v(dout1_0) AT=500.025n

.meas tran vdout1_1ck990 FIND v(dout1_1) AT=500.025n

.meas tran vdout1_2ck990 FIND v(dout1_2) AT=500.025n

.meas tran vdout1_3ck990 FIND v(dout1_3) AT=500.025n

.meas tran vdout1_4ck990 FIND v(dout1_4) AT=500.025n

.meas tran vdout1_5ck990 FIND v(dout1_5) AT=500.025n

.meas tran vdout1_6ck990 FIND v(dout1_6) AT=500.025n

.meas tran vdout1_7ck990 FIND v(dout1_7) AT=500.025n

.meas tran vdout1_8ck990 FIND v(dout1_8) AT=500.025n

.meas tran vdout1_9ck990 FIND v(dout1_9) AT=500.025n

.meas tran vdout1_10ck990 FIND v(dout1_10) AT=500.025n

.meas tran vdout1_11ck990 FIND v(dout1_11) AT=500.025n

.meas tran vdout1_12ck990 FIND v(dout1_12) AT=500.025n

.meas tran vdout1_13ck990 FIND v(dout1_13) AT=500.025n

.meas tran vdout1_14ck990 FIND v(dout1_14) AT=500.025n

.meas tran vdout1_15ck990 FIND v(dout1_15) AT=500.025n

.meas tran vdout1_16ck990 FIND v(dout1_16) AT=500.025n

.meas tran vdout1_17ck990 FIND v(dout1_17) AT=500.025n

.meas tran vdout1_18ck990 FIND v(dout1_18) AT=500.025n

.meas tran vdout1_19ck990 FIND v(dout1_19) AT=500.025n

.meas tran vdout1_20ck990 FIND v(dout1_20) AT=500.025n

.meas tran vdout1_21ck990 FIND v(dout1_21) AT=500.025n

.meas tran vdout1_22ck990 FIND v(dout1_22) AT=500.025n

.meas tran vdout1_23ck990 FIND v(dout1_23) AT=500.025n

.meas tran vdout0_0ck1000 FIND v(dout0_0) AT=505.025n

.meas tran vdout0_1ck1000 FIND v(dout0_1) AT=505.025n

.meas tran vdout0_2ck1000 FIND v(dout0_2) AT=505.025n

.meas tran vdout0_3ck1000 FIND v(dout0_3) AT=505.025n

.meas tran vdout0_4ck1000 FIND v(dout0_4) AT=505.025n

.meas tran vdout0_5ck1000 FIND v(dout0_5) AT=505.025n

.meas tran vdout0_6ck1000 FIND v(dout0_6) AT=505.025n

.meas tran vdout0_7ck1000 FIND v(dout0_7) AT=505.025n

.meas tran vdout0_8ck1000 FIND v(dout0_8) AT=505.025n

.meas tran vdout0_9ck1000 FIND v(dout0_9) AT=505.025n

.meas tran vdout0_10ck1000 FIND v(dout0_10) AT=505.025n

.meas tran vdout0_11ck1000 FIND v(dout0_11) AT=505.025n

.meas tran vdout0_12ck1000 FIND v(dout0_12) AT=505.025n

.meas tran vdout0_13ck1000 FIND v(dout0_13) AT=505.025n

.meas tran vdout0_14ck1000 FIND v(dout0_14) AT=505.025n

.meas tran vdout0_15ck1000 FIND v(dout0_15) AT=505.025n

.meas tran vdout0_16ck1000 FIND v(dout0_16) AT=505.025n

.meas tran vdout0_17ck1000 FIND v(dout0_17) AT=505.025n

.meas tran vdout0_18ck1000 FIND v(dout0_18) AT=505.025n

.meas tran vdout0_19ck1000 FIND v(dout0_19) AT=505.025n

.meas tran vdout0_20ck1000 FIND v(dout0_20) AT=505.025n

.meas tran vdout0_21ck1000 FIND v(dout0_21) AT=505.025n

.meas tran vdout0_22ck1000 FIND v(dout0_22) AT=505.025n

.meas tran vdout0_23ck1000 FIND v(dout0_23) AT=505.025n

.meas tran vdout1_0ck1010 FIND v(dout1_0) AT=510.025n

.meas tran vdout1_1ck1010 FIND v(dout1_1) AT=510.025n

.meas tran vdout1_2ck1010 FIND v(dout1_2) AT=510.025n

.meas tran vdout1_3ck1010 FIND v(dout1_3) AT=510.025n

.meas tran vdout1_4ck1010 FIND v(dout1_4) AT=510.025n

.meas tran vdout1_5ck1010 FIND v(dout1_5) AT=510.025n

.meas tran vdout1_6ck1010 FIND v(dout1_6) AT=510.025n

.meas tran vdout1_7ck1010 FIND v(dout1_7) AT=510.025n

.meas tran vdout1_8ck1010 FIND v(dout1_8) AT=510.025n

.meas tran vdout1_9ck1010 FIND v(dout1_9) AT=510.025n

.meas tran vdout1_10ck1010 FIND v(dout1_10) AT=510.025n

.meas tran vdout1_11ck1010 FIND v(dout1_11) AT=510.025n

.meas tran vdout1_12ck1010 FIND v(dout1_12) AT=510.025n

.meas tran vdout1_13ck1010 FIND v(dout1_13) AT=510.025n

.meas tran vdout1_14ck1010 FIND v(dout1_14) AT=510.025n

.meas tran vdout1_15ck1010 FIND v(dout1_15) AT=510.025n

.meas tran vdout1_16ck1010 FIND v(dout1_16) AT=510.025n

.meas tran vdout1_17ck1010 FIND v(dout1_17) AT=510.025n

.meas tran vdout1_18ck1010 FIND v(dout1_18) AT=510.025n

.meas tran vdout1_19ck1010 FIND v(dout1_19) AT=510.025n

.meas tran vdout1_20ck1010 FIND v(dout1_20) AT=510.025n

.meas tran vdout1_21ck1010 FIND v(dout1_21) AT=510.025n

.meas tran vdout1_22ck1010 FIND v(dout1_22) AT=510.025n

.meas tran vdout1_23ck1010 FIND v(dout1_23) AT=510.025n

.meas tran vdout0_0ck1030 FIND v(dout0_0) AT=520.025n

.meas tran vdout0_1ck1030 FIND v(dout0_1) AT=520.025n

.meas tran vdout0_2ck1030 FIND v(dout0_2) AT=520.025n

.meas tran vdout0_3ck1030 FIND v(dout0_3) AT=520.025n

.meas tran vdout0_4ck1030 FIND v(dout0_4) AT=520.025n

.meas tran vdout0_5ck1030 FIND v(dout0_5) AT=520.025n

.meas tran vdout0_6ck1030 FIND v(dout0_6) AT=520.025n

.meas tran vdout0_7ck1030 FIND v(dout0_7) AT=520.025n

.meas tran vdout0_8ck1030 FIND v(dout0_8) AT=520.025n

.meas tran vdout0_9ck1030 FIND v(dout0_9) AT=520.025n

.meas tran vdout0_10ck1030 FIND v(dout0_10) AT=520.025n

.meas tran vdout0_11ck1030 FIND v(dout0_11) AT=520.025n

.meas tran vdout0_12ck1030 FIND v(dout0_12) AT=520.025n

.meas tran vdout0_13ck1030 FIND v(dout0_13) AT=520.025n

.meas tran vdout0_14ck1030 FIND v(dout0_14) AT=520.025n

.meas tran vdout0_15ck1030 FIND v(dout0_15) AT=520.025n

.meas tran vdout0_16ck1030 FIND v(dout0_16) AT=520.025n

.meas tran vdout0_17ck1030 FIND v(dout0_17) AT=520.025n

.meas tran vdout0_18ck1030 FIND v(dout0_18) AT=520.025n

.meas tran vdout0_19ck1030 FIND v(dout0_19) AT=520.025n

.meas tran vdout0_20ck1030 FIND v(dout0_20) AT=520.025n

.meas tran vdout0_21ck1030 FIND v(dout0_21) AT=520.025n

.meas tran vdout0_22ck1030 FIND v(dout0_22) AT=520.025n

.meas tran vdout0_23ck1030 FIND v(dout0_23) AT=520.025n

.meas tran vdout1_0ck1030 FIND v(dout1_0) AT=520.025n

.meas tran vdout1_1ck1030 FIND v(dout1_1) AT=520.025n

.meas tran vdout1_2ck1030 FIND v(dout1_2) AT=520.025n

.meas tran vdout1_3ck1030 FIND v(dout1_3) AT=520.025n

.meas tran vdout1_4ck1030 FIND v(dout1_4) AT=520.025n

.meas tran vdout1_5ck1030 FIND v(dout1_5) AT=520.025n

.meas tran vdout1_6ck1030 FIND v(dout1_6) AT=520.025n

.meas tran vdout1_7ck1030 FIND v(dout1_7) AT=520.025n

.meas tran vdout1_8ck1030 FIND v(dout1_8) AT=520.025n

.meas tran vdout1_9ck1030 FIND v(dout1_9) AT=520.025n

.meas tran vdout1_10ck1030 FIND v(dout1_10) AT=520.025n

.meas tran vdout1_11ck1030 FIND v(dout1_11) AT=520.025n

.meas tran vdout1_12ck1030 FIND v(dout1_12) AT=520.025n

.meas tran vdout1_13ck1030 FIND v(dout1_13) AT=520.025n

.meas tran vdout1_14ck1030 FIND v(dout1_14) AT=520.025n

.meas tran vdout1_15ck1030 FIND v(dout1_15) AT=520.025n

.meas tran vdout1_16ck1030 FIND v(dout1_16) AT=520.025n

.meas tran vdout1_17ck1030 FIND v(dout1_17) AT=520.025n

.meas tran vdout1_18ck1030 FIND v(dout1_18) AT=520.025n

.meas tran vdout1_19ck1030 FIND v(dout1_19) AT=520.025n

.meas tran vdout1_20ck1030 FIND v(dout1_20) AT=520.025n

.meas tran vdout1_21ck1030 FIND v(dout1_21) AT=520.025n

.meas tran vdout1_22ck1030 FIND v(dout1_22) AT=520.025n

.meas tran vdout1_23ck1030 FIND v(dout1_23) AT=520.025n

.meas tran vdout0_0ck1040 FIND v(dout0_0) AT=525.025n

.meas tran vdout0_1ck1040 FIND v(dout0_1) AT=525.025n

.meas tran vdout0_2ck1040 FIND v(dout0_2) AT=525.025n

.meas tran vdout0_3ck1040 FIND v(dout0_3) AT=525.025n

.meas tran vdout0_4ck1040 FIND v(dout0_4) AT=525.025n

.meas tran vdout0_5ck1040 FIND v(dout0_5) AT=525.025n

.meas tran vdout0_6ck1040 FIND v(dout0_6) AT=525.025n

.meas tran vdout0_7ck1040 FIND v(dout0_7) AT=525.025n

.meas tran vdout0_8ck1040 FIND v(dout0_8) AT=525.025n

.meas tran vdout0_9ck1040 FIND v(dout0_9) AT=525.025n

.meas tran vdout0_10ck1040 FIND v(dout0_10) AT=525.025n

.meas tran vdout0_11ck1040 FIND v(dout0_11) AT=525.025n

.meas tran vdout0_12ck1040 FIND v(dout0_12) AT=525.025n

.meas tran vdout0_13ck1040 FIND v(dout0_13) AT=525.025n

.meas tran vdout0_14ck1040 FIND v(dout0_14) AT=525.025n

.meas tran vdout0_15ck1040 FIND v(dout0_15) AT=525.025n

.meas tran vdout0_16ck1040 FIND v(dout0_16) AT=525.025n

.meas tran vdout0_17ck1040 FIND v(dout0_17) AT=525.025n

.meas tran vdout0_18ck1040 FIND v(dout0_18) AT=525.025n

.meas tran vdout0_19ck1040 FIND v(dout0_19) AT=525.025n

.meas tran vdout0_20ck1040 FIND v(dout0_20) AT=525.025n

.meas tran vdout0_21ck1040 FIND v(dout0_21) AT=525.025n

.meas tran vdout0_22ck1040 FIND v(dout0_22) AT=525.025n

.meas tran vdout0_23ck1040 FIND v(dout0_23) AT=525.025n

.meas tran vdout1_0ck1040 FIND v(dout1_0) AT=525.025n

.meas tran vdout1_1ck1040 FIND v(dout1_1) AT=525.025n

.meas tran vdout1_2ck1040 FIND v(dout1_2) AT=525.025n

.meas tran vdout1_3ck1040 FIND v(dout1_3) AT=525.025n

.meas tran vdout1_4ck1040 FIND v(dout1_4) AT=525.025n

.meas tran vdout1_5ck1040 FIND v(dout1_5) AT=525.025n

.meas tran vdout1_6ck1040 FIND v(dout1_6) AT=525.025n

.meas tran vdout1_7ck1040 FIND v(dout1_7) AT=525.025n

.meas tran vdout1_8ck1040 FIND v(dout1_8) AT=525.025n

.meas tran vdout1_9ck1040 FIND v(dout1_9) AT=525.025n

.meas tran vdout1_10ck1040 FIND v(dout1_10) AT=525.025n

.meas tran vdout1_11ck1040 FIND v(dout1_11) AT=525.025n

.meas tran vdout1_12ck1040 FIND v(dout1_12) AT=525.025n

.meas tran vdout1_13ck1040 FIND v(dout1_13) AT=525.025n

.meas tran vdout1_14ck1040 FIND v(dout1_14) AT=525.025n

.meas tran vdout1_15ck1040 FIND v(dout1_15) AT=525.025n

.meas tran vdout1_16ck1040 FIND v(dout1_16) AT=525.025n

.meas tran vdout1_17ck1040 FIND v(dout1_17) AT=525.025n

.meas tran vdout1_18ck1040 FIND v(dout1_18) AT=525.025n

.meas tran vdout1_19ck1040 FIND v(dout1_19) AT=525.025n

.meas tran vdout1_20ck1040 FIND v(dout1_20) AT=525.025n

.meas tran vdout1_21ck1040 FIND v(dout1_21) AT=525.025n

.meas tran vdout1_22ck1040 FIND v(dout1_22) AT=525.025n

.meas tran vdout1_23ck1040 FIND v(dout1_23) AT=525.025n

.meas tran vdout0_0ck1050 FIND v(dout0_0) AT=530.025n

.meas tran vdout0_1ck1050 FIND v(dout0_1) AT=530.025n

.meas tran vdout0_2ck1050 FIND v(dout0_2) AT=530.025n

.meas tran vdout0_3ck1050 FIND v(dout0_3) AT=530.025n

.meas tran vdout0_4ck1050 FIND v(dout0_4) AT=530.025n

.meas tran vdout0_5ck1050 FIND v(dout0_5) AT=530.025n

.meas tran vdout0_6ck1050 FIND v(dout0_6) AT=530.025n

.meas tran vdout0_7ck1050 FIND v(dout0_7) AT=530.025n

.meas tran vdout0_8ck1050 FIND v(dout0_8) AT=530.025n

.meas tran vdout0_9ck1050 FIND v(dout0_9) AT=530.025n

.meas tran vdout0_10ck1050 FIND v(dout0_10) AT=530.025n

.meas tran vdout0_11ck1050 FIND v(dout0_11) AT=530.025n

.meas tran vdout0_12ck1050 FIND v(dout0_12) AT=530.025n

.meas tran vdout0_13ck1050 FIND v(dout0_13) AT=530.025n

.meas tran vdout0_14ck1050 FIND v(dout0_14) AT=530.025n

.meas tran vdout0_15ck1050 FIND v(dout0_15) AT=530.025n

.meas tran vdout0_16ck1050 FIND v(dout0_16) AT=530.025n

.meas tran vdout0_17ck1050 FIND v(dout0_17) AT=530.025n

.meas tran vdout0_18ck1050 FIND v(dout0_18) AT=530.025n

.meas tran vdout0_19ck1050 FIND v(dout0_19) AT=530.025n

.meas tran vdout0_20ck1050 FIND v(dout0_20) AT=530.025n

.meas tran vdout0_21ck1050 FIND v(dout0_21) AT=530.025n

.meas tran vdout0_22ck1050 FIND v(dout0_22) AT=530.025n

.meas tran vdout0_23ck1050 FIND v(dout0_23) AT=530.025n

.meas tran vdout1_0ck1050 FIND v(dout1_0) AT=530.025n

.meas tran vdout1_1ck1050 FIND v(dout1_1) AT=530.025n

.meas tran vdout1_2ck1050 FIND v(dout1_2) AT=530.025n

.meas tran vdout1_3ck1050 FIND v(dout1_3) AT=530.025n

.meas tran vdout1_4ck1050 FIND v(dout1_4) AT=530.025n

.meas tran vdout1_5ck1050 FIND v(dout1_5) AT=530.025n

.meas tran vdout1_6ck1050 FIND v(dout1_6) AT=530.025n

.meas tran vdout1_7ck1050 FIND v(dout1_7) AT=530.025n

.meas tran vdout1_8ck1050 FIND v(dout1_8) AT=530.025n

.meas tran vdout1_9ck1050 FIND v(dout1_9) AT=530.025n

.meas tran vdout1_10ck1050 FIND v(dout1_10) AT=530.025n

.meas tran vdout1_11ck1050 FIND v(dout1_11) AT=530.025n

.meas tran vdout1_12ck1050 FIND v(dout1_12) AT=530.025n

.meas tran vdout1_13ck1050 FIND v(dout1_13) AT=530.025n

.meas tran vdout1_14ck1050 FIND v(dout1_14) AT=530.025n

.meas tran vdout1_15ck1050 FIND v(dout1_15) AT=530.025n

.meas tran vdout1_16ck1050 FIND v(dout1_16) AT=530.025n

.meas tran vdout1_17ck1050 FIND v(dout1_17) AT=530.025n

.meas tran vdout1_18ck1050 FIND v(dout1_18) AT=530.025n

.meas tran vdout1_19ck1050 FIND v(dout1_19) AT=530.025n

.meas tran vdout1_20ck1050 FIND v(dout1_20) AT=530.025n

.meas tran vdout1_21ck1050 FIND v(dout1_21) AT=530.025n

.meas tran vdout1_22ck1050 FIND v(dout1_22) AT=530.025n

.meas tran vdout1_23ck1050 FIND v(dout1_23) AT=530.025n

.meas tran vdout1_0ck1060 FIND v(dout1_0) AT=535.025n

.meas tran vdout1_1ck1060 FIND v(dout1_1) AT=535.025n

.meas tran vdout1_2ck1060 FIND v(dout1_2) AT=535.025n

.meas tran vdout1_3ck1060 FIND v(dout1_3) AT=535.025n

.meas tran vdout1_4ck1060 FIND v(dout1_4) AT=535.025n

.meas tran vdout1_5ck1060 FIND v(dout1_5) AT=535.025n

.meas tran vdout1_6ck1060 FIND v(dout1_6) AT=535.025n

.meas tran vdout1_7ck1060 FIND v(dout1_7) AT=535.025n

.meas tran vdout1_8ck1060 FIND v(dout1_8) AT=535.025n

.meas tran vdout1_9ck1060 FIND v(dout1_9) AT=535.025n

.meas tran vdout1_10ck1060 FIND v(dout1_10) AT=535.025n

.meas tran vdout1_11ck1060 FIND v(dout1_11) AT=535.025n

.meas tran vdout1_12ck1060 FIND v(dout1_12) AT=535.025n

.meas tran vdout1_13ck1060 FIND v(dout1_13) AT=535.025n

.meas tran vdout1_14ck1060 FIND v(dout1_14) AT=535.025n

.meas tran vdout1_15ck1060 FIND v(dout1_15) AT=535.025n

.meas tran vdout1_16ck1060 FIND v(dout1_16) AT=535.025n

.meas tran vdout1_17ck1060 FIND v(dout1_17) AT=535.025n

.meas tran vdout1_18ck1060 FIND v(dout1_18) AT=535.025n

.meas tran vdout1_19ck1060 FIND v(dout1_19) AT=535.025n

.meas tran vdout1_20ck1060 FIND v(dout1_20) AT=535.025n

.meas tran vdout1_21ck1060 FIND v(dout1_21) AT=535.025n

.meas tran vdout1_22ck1060 FIND v(dout1_22) AT=535.025n

.meas tran vdout1_23ck1060 FIND v(dout1_23) AT=535.025n

.meas tran vdout0_0ck1070 FIND v(dout0_0) AT=540.025n

.meas tran vdout0_1ck1070 FIND v(dout0_1) AT=540.025n

.meas tran vdout0_2ck1070 FIND v(dout0_2) AT=540.025n

.meas tran vdout0_3ck1070 FIND v(dout0_3) AT=540.025n

.meas tran vdout0_4ck1070 FIND v(dout0_4) AT=540.025n

.meas tran vdout0_5ck1070 FIND v(dout0_5) AT=540.025n

.meas tran vdout0_6ck1070 FIND v(dout0_6) AT=540.025n

.meas tran vdout0_7ck1070 FIND v(dout0_7) AT=540.025n

.meas tran vdout0_8ck1070 FIND v(dout0_8) AT=540.025n

.meas tran vdout0_9ck1070 FIND v(dout0_9) AT=540.025n

.meas tran vdout0_10ck1070 FIND v(dout0_10) AT=540.025n

.meas tran vdout0_11ck1070 FIND v(dout0_11) AT=540.025n

.meas tran vdout0_12ck1070 FIND v(dout0_12) AT=540.025n

.meas tran vdout0_13ck1070 FIND v(dout0_13) AT=540.025n

.meas tran vdout0_14ck1070 FIND v(dout0_14) AT=540.025n

.meas tran vdout0_15ck1070 FIND v(dout0_15) AT=540.025n

.meas tran vdout0_16ck1070 FIND v(dout0_16) AT=540.025n

.meas tran vdout0_17ck1070 FIND v(dout0_17) AT=540.025n

.meas tran vdout0_18ck1070 FIND v(dout0_18) AT=540.025n

.meas tran vdout0_19ck1070 FIND v(dout0_19) AT=540.025n

.meas tran vdout0_20ck1070 FIND v(dout0_20) AT=540.025n

.meas tran vdout0_21ck1070 FIND v(dout0_21) AT=540.025n

.meas tran vdout0_22ck1070 FIND v(dout0_22) AT=540.025n

.meas tran vdout0_23ck1070 FIND v(dout0_23) AT=540.025n

.meas tran vdout1_0ck1070 FIND v(dout1_0) AT=540.025n

.meas tran vdout1_1ck1070 FIND v(dout1_1) AT=540.025n

.meas tran vdout1_2ck1070 FIND v(dout1_2) AT=540.025n

.meas tran vdout1_3ck1070 FIND v(dout1_3) AT=540.025n

.meas tran vdout1_4ck1070 FIND v(dout1_4) AT=540.025n

.meas tran vdout1_5ck1070 FIND v(dout1_5) AT=540.025n

.meas tran vdout1_6ck1070 FIND v(dout1_6) AT=540.025n

.meas tran vdout1_7ck1070 FIND v(dout1_7) AT=540.025n

.meas tran vdout1_8ck1070 FIND v(dout1_8) AT=540.025n

.meas tran vdout1_9ck1070 FIND v(dout1_9) AT=540.025n

.meas tran vdout1_10ck1070 FIND v(dout1_10) AT=540.025n

.meas tran vdout1_11ck1070 FIND v(dout1_11) AT=540.025n

.meas tran vdout1_12ck1070 FIND v(dout1_12) AT=540.025n

.meas tran vdout1_13ck1070 FIND v(dout1_13) AT=540.025n

.meas tran vdout1_14ck1070 FIND v(dout1_14) AT=540.025n

.meas tran vdout1_15ck1070 FIND v(dout1_15) AT=540.025n

.meas tran vdout1_16ck1070 FIND v(dout1_16) AT=540.025n

.meas tran vdout1_17ck1070 FIND v(dout1_17) AT=540.025n

.meas tran vdout1_18ck1070 FIND v(dout1_18) AT=540.025n

.meas tran vdout1_19ck1070 FIND v(dout1_19) AT=540.025n

.meas tran vdout1_20ck1070 FIND v(dout1_20) AT=540.025n

.meas tran vdout1_21ck1070 FIND v(dout1_21) AT=540.025n

.meas tran vdout1_22ck1070 FIND v(dout1_22) AT=540.025n

.meas tran vdout1_23ck1070 FIND v(dout1_23) AT=540.025n

.meas tran vdout1_0ck1080 FIND v(dout1_0) AT=545.025n

.meas tran vdout1_1ck1080 FIND v(dout1_1) AT=545.025n

.meas tran vdout1_2ck1080 FIND v(dout1_2) AT=545.025n

.meas tran vdout1_3ck1080 FIND v(dout1_3) AT=545.025n

.meas tran vdout1_4ck1080 FIND v(dout1_4) AT=545.025n

.meas tran vdout1_5ck1080 FIND v(dout1_5) AT=545.025n

.meas tran vdout1_6ck1080 FIND v(dout1_6) AT=545.025n

.meas tran vdout1_7ck1080 FIND v(dout1_7) AT=545.025n

.meas tran vdout1_8ck1080 FIND v(dout1_8) AT=545.025n

.meas tran vdout1_9ck1080 FIND v(dout1_9) AT=545.025n

.meas tran vdout1_10ck1080 FIND v(dout1_10) AT=545.025n

.meas tran vdout1_11ck1080 FIND v(dout1_11) AT=545.025n

.meas tran vdout1_12ck1080 FIND v(dout1_12) AT=545.025n

.meas tran vdout1_13ck1080 FIND v(dout1_13) AT=545.025n

.meas tran vdout1_14ck1080 FIND v(dout1_14) AT=545.025n

.meas tran vdout1_15ck1080 FIND v(dout1_15) AT=545.025n

.meas tran vdout1_16ck1080 FIND v(dout1_16) AT=545.025n

.meas tran vdout1_17ck1080 FIND v(dout1_17) AT=545.025n

.meas tran vdout1_18ck1080 FIND v(dout1_18) AT=545.025n

.meas tran vdout1_19ck1080 FIND v(dout1_19) AT=545.025n

.meas tran vdout1_20ck1080 FIND v(dout1_20) AT=545.025n

.meas tran vdout1_21ck1080 FIND v(dout1_21) AT=545.025n

.meas tran vdout1_22ck1080 FIND v(dout1_22) AT=545.025n

.meas tran vdout1_23ck1080 FIND v(dout1_23) AT=545.025n

.meas tran vdout0_0ck1090 FIND v(dout0_0) AT=550.025n

.meas tran vdout0_1ck1090 FIND v(dout0_1) AT=550.025n

.meas tran vdout0_2ck1090 FIND v(dout0_2) AT=550.025n

.meas tran vdout0_3ck1090 FIND v(dout0_3) AT=550.025n

.meas tran vdout0_4ck1090 FIND v(dout0_4) AT=550.025n

.meas tran vdout0_5ck1090 FIND v(dout0_5) AT=550.025n

.meas tran vdout0_6ck1090 FIND v(dout0_6) AT=550.025n

.meas tran vdout0_7ck1090 FIND v(dout0_7) AT=550.025n

.meas tran vdout0_8ck1090 FIND v(dout0_8) AT=550.025n

.meas tran vdout0_9ck1090 FIND v(dout0_9) AT=550.025n

.meas tran vdout0_10ck1090 FIND v(dout0_10) AT=550.025n

.meas tran vdout0_11ck1090 FIND v(dout0_11) AT=550.025n

.meas tran vdout0_12ck1090 FIND v(dout0_12) AT=550.025n

.meas tran vdout0_13ck1090 FIND v(dout0_13) AT=550.025n

.meas tran vdout0_14ck1090 FIND v(dout0_14) AT=550.025n

.meas tran vdout0_15ck1090 FIND v(dout0_15) AT=550.025n

.meas tran vdout0_16ck1090 FIND v(dout0_16) AT=550.025n

.meas tran vdout0_17ck1090 FIND v(dout0_17) AT=550.025n

.meas tran vdout0_18ck1090 FIND v(dout0_18) AT=550.025n

.meas tran vdout0_19ck1090 FIND v(dout0_19) AT=550.025n

.meas tran vdout0_20ck1090 FIND v(dout0_20) AT=550.025n

.meas tran vdout0_21ck1090 FIND v(dout0_21) AT=550.025n

.meas tran vdout0_22ck1090 FIND v(dout0_22) AT=550.025n

.meas tran vdout0_23ck1090 FIND v(dout0_23) AT=550.025n

.meas tran vdout1_0ck1090 FIND v(dout1_0) AT=550.025n

.meas tran vdout1_1ck1090 FIND v(dout1_1) AT=550.025n

.meas tran vdout1_2ck1090 FIND v(dout1_2) AT=550.025n

.meas tran vdout1_3ck1090 FIND v(dout1_3) AT=550.025n

.meas tran vdout1_4ck1090 FIND v(dout1_4) AT=550.025n

.meas tran vdout1_5ck1090 FIND v(dout1_5) AT=550.025n

.meas tran vdout1_6ck1090 FIND v(dout1_6) AT=550.025n

.meas tran vdout1_7ck1090 FIND v(dout1_7) AT=550.025n

.meas tran vdout1_8ck1090 FIND v(dout1_8) AT=550.025n

.meas tran vdout1_9ck1090 FIND v(dout1_9) AT=550.025n

.meas tran vdout1_10ck1090 FIND v(dout1_10) AT=550.025n

.meas tran vdout1_11ck1090 FIND v(dout1_11) AT=550.025n

.meas tran vdout1_12ck1090 FIND v(dout1_12) AT=550.025n

.meas tran vdout1_13ck1090 FIND v(dout1_13) AT=550.025n

.meas tran vdout1_14ck1090 FIND v(dout1_14) AT=550.025n

.meas tran vdout1_15ck1090 FIND v(dout1_15) AT=550.025n

.meas tran vdout1_16ck1090 FIND v(dout1_16) AT=550.025n

.meas tran vdout1_17ck1090 FIND v(dout1_17) AT=550.025n

.meas tran vdout1_18ck1090 FIND v(dout1_18) AT=550.025n

.meas tran vdout1_19ck1090 FIND v(dout1_19) AT=550.025n

.meas tran vdout1_20ck1090 FIND v(dout1_20) AT=550.025n

.meas tran vdout1_21ck1090 FIND v(dout1_21) AT=550.025n

.meas tran vdout1_22ck1090 FIND v(dout1_22) AT=550.025n

.meas tran vdout1_23ck1090 FIND v(dout1_23) AT=550.025n

.meas tran vdout0_0ck1100 FIND v(dout0_0) AT=555.025n

.meas tran vdout0_1ck1100 FIND v(dout0_1) AT=555.025n

.meas tran vdout0_2ck1100 FIND v(dout0_2) AT=555.025n

.meas tran vdout0_3ck1100 FIND v(dout0_3) AT=555.025n

.meas tran vdout0_4ck1100 FIND v(dout0_4) AT=555.025n

.meas tran vdout0_5ck1100 FIND v(dout0_5) AT=555.025n

.meas tran vdout0_6ck1100 FIND v(dout0_6) AT=555.025n

.meas tran vdout0_7ck1100 FIND v(dout0_7) AT=555.025n

.meas tran vdout0_8ck1100 FIND v(dout0_8) AT=555.025n

.meas tran vdout0_9ck1100 FIND v(dout0_9) AT=555.025n

.meas tran vdout0_10ck1100 FIND v(dout0_10) AT=555.025n

.meas tran vdout0_11ck1100 FIND v(dout0_11) AT=555.025n

.meas tran vdout0_12ck1100 FIND v(dout0_12) AT=555.025n

.meas tran vdout0_13ck1100 FIND v(dout0_13) AT=555.025n

.meas tran vdout0_14ck1100 FIND v(dout0_14) AT=555.025n

.meas tran vdout0_15ck1100 FIND v(dout0_15) AT=555.025n

.meas tran vdout0_16ck1100 FIND v(dout0_16) AT=555.025n

.meas tran vdout0_17ck1100 FIND v(dout0_17) AT=555.025n

.meas tran vdout0_18ck1100 FIND v(dout0_18) AT=555.025n

.meas tran vdout0_19ck1100 FIND v(dout0_19) AT=555.025n

.meas tran vdout0_20ck1100 FIND v(dout0_20) AT=555.025n

.meas tran vdout0_21ck1100 FIND v(dout0_21) AT=555.025n

.meas tran vdout0_22ck1100 FIND v(dout0_22) AT=555.025n

.meas tran vdout0_23ck1100 FIND v(dout0_23) AT=555.025n

.meas tran vdout1_0ck1110 FIND v(dout1_0) AT=560.025n

.meas tran vdout1_1ck1110 FIND v(dout1_1) AT=560.025n

.meas tran vdout1_2ck1110 FIND v(dout1_2) AT=560.025n

.meas tran vdout1_3ck1110 FIND v(dout1_3) AT=560.025n

.meas tran vdout1_4ck1110 FIND v(dout1_4) AT=560.025n

.meas tran vdout1_5ck1110 FIND v(dout1_5) AT=560.025n

.meas tran vdout1_6ck1110 FIND v(dout1_6) AT=560.025n

.meas tran vdout1_7ck1110 FIND v(dout1_7) AT=560.025n

.meas tran vdout1_8ck1110 FIND v(dout1_8) AT=560.025n

.meas tran vdout1_9ck1110 FIND v(dout1_9) AT=560.025n

.meas tran vdout1_10ck1110 FIND v(dout1_10) AT=560.025n

.meas tran vdout1_11ck1110 FIND v(dout1_11) AT=560.025n

.meas tran vdout1_12ck1110 FIND v(dout1_12) AT=560.025n

.meas tran vdout1_13ck1110 FIND v(dout1_13) AT=560.025n

.meas tran vdout1_14ck1110 FIND v(dout1_14) AT=560.025n

.meas tran vdout1_15ck1110 FIND v(dout1_15) AT=560.025n

.meas tran vdout1_16ck1110 FIND v(dout1_16) AT=560.025n

.meas tran vdout1_17ck1110 FIND v(dout1_17) AT=560.025n

.meas tran vdout1_18ck1110 FIND v(dout1_18) AT=560.025n

.meas tran vdout1_19ck1110 FIND v(dout1_19) AT=560.025n

.meas tran vdout1_20ck1110 FIND v(dout1_20) AT=560.025n

.meas tran vdout1_21ck1110 FIND v(dout1_21) AT=560.025n

.meas tran vdout1_22ck1110 FIND v(dout1_22) AT=560.025n

.meas tran vdout1_23ck1110 FIND v(dout1_23) AT=560.025n

.meas tran vdout1_0ck1120 FIND v(dout1_0) AT=565.025n

.meas tran vdout1_1ck1120 FIND v(dout1_1) AT=565.025n

.meas tran vdout1_2ck1120 FIND v(dout1_2) AT=565.025n

.meas tran vdout1_3ck1120 FIND v(dout1_3) AT=565.025n

.meas tran vdout1_4ck1120 FIND v(dout1_4) AT=565.025n

.meas tran vdout1_5ck1120 FIND v(dout1_5) AT=565.025n

.meas tran vdout1_6ck1120 FIND v(dout1_6) AT=565.025n

.meas tran vdout1_7ck1120 FIND v(dout1_7) AT=565.025n

.meas tran vdout1_8ck1120 FIND v(dout1_8) AT=565.025n

.meas tran vdout1_9ck1120 FIND v(dout1_9) AT=565.025n

.meas tran vdout1_10ck1120 FIND v(dout1_10) AT=565.025n

.meas tran vdout1_11ck1120 FIND v(dout1_11) AT=565.025n

.meas tran vdout1_12ck1120 FIND v(dout1_12) AT=565.025n

.meas tran vdout1_13ck1120 FIND v(dout1_13) AT=565.025n

.meas tran vdout1_14ck1120 FIND v(dout1_14) AT=565.025n

.meas tran vdout1_15ck1120 FIND v(dout1_15) AT=565.025n

.meas tran vdout1_16ck1120 FIND v(dout1_16) AT=565.025n

.meas tran vdout1_17ck1120 FIND v(dout1_17) AT=565.025n

.meas tran vdout1_18ck1120 FIND v(dout1_18) AT=565.025n

.meas tran vdout1_19ck1120 FIND v(dout1_19) AT=565.025n

.meas tran vdout1_20ck1120 FIND v(dout1_20) AT=565.025n

.meas tran vdout1_21ck1120 FIND v(dout1_21) AT=565.025n

.meas tran vdout1_22ck1120 FIND v(dout1_22) AT=565.025n

.meas tran vdout1_23ck1120 FIND v(dout1_23) AT=565.025n

.meas tran vdout1_0ck1160 FIND v(dout1_0) AT=585.025n

.meas tran vdout1_1ck1160 FIND v(dout1_1) AT=585.025n

.meas tran vdout1_2ck1160 FIND v(dout1_2) AT=585.025n

.meas tran vdout1_3ck1160 FIND v(dout1_3) AT=585.025n

.meas tran vdout1_4ck1160 FIND v(dout1_4) AT=585.025n

.meas tran vdout1_5ck1160 FIND v(dout1_5) AT=585.025n

.meas tran vdout1_6ck1160 FIND v(dout1_6) AT=585.025n

.meas tran vdout1_7ck1160 FIND v(dout1_7) AT=585.025n

.meas tran vdout1_8ck1160 FIND v(dout1_8) AT=585.025n

.meas tran vdout1_9ck1160 FIND v(dout1_9) AT=585.025n

.meas tran vdout1_10ck1160 FIND v(dout1_10) AT=585.025n

.meas tran vdout1_11ck1160 FIND v(dout1_11) AT=585.025n

.meas tran vdout1_12ck1160 FIND v(dout1_12) AT=585.025n

.meas tran vdout1_13ck1160 FIND v(dout1_13) AT=585.025n

.meas tran vdout1_14ck1160 FIND v(dout1_14) AT=585.025n

.meas tran vdout1_15ck1160 FIND v(dout1_15) AT=585.025n

.meas tran vdout1_16ck1160 FIND v(dout1_16) AT=585.025n

.meas tran vdout1_17ck1160 FIND v(dout1_17) AT=585.025n

.meas tran vdout1_18ck1160 FIND v(dout1_18) AT=585.025n

.meas tran vdout1_19ck1160 FIND v(dout1_19) AT=585.025n

.meas tran vdout1_20ck1160 FIND v(dout1_20) AT=585.025n

.meas tran vdout1_21ck1160 FIND v(dout1_21) AT=585.025n

.meas tran vdout1_22ck1160 FIND v(dout1_22) AT=585.025n

.meas tran vdout1_23ck1160 FIND v(dout1_23) AT=585.025n

.meas tran vdout1_0ck1170 FIND v(dout1_0) AT=590.025n

.meas tran vdout1_1ck1170 FIND v(dout1_1) AT=590.025n

.meas tran vdout1_2ck1170 FIND v(dout1_2) AT=590.025n

.meas tran vdout1_3ck1170 FIND v(dout1_3) AT=590.025n

.meas tran vdout1_4ck1170 FIND v(dout1_4) AT=590.025n

.meas tran vdout1_5ck1170 FIND v(dout1_5) AT=590.025n

.meas tran vdout1_6ck1170 FIND v(dout1_6) AT=590.025n

.meas tran vdout1_7ck1170 FIND v(dout1_7) AT=590.025n

.meas tran vdout1_8ck1170 FIND v(dout1_8) AT=590.025n

.meas tran vdout1_9ck1170 FIND v(dout1_9) AT=590.025n

.meas tran vdout1_10ck1170 FIND v(dout1_10) AT=590.025n

.meas tran vdout1_11ck1170 FIND v(dout1_11) AT=590.025n

.meas tran vdout1_12ck1170 FIND v(dout1_12) AT=590.025n

.meas tran vdout1_13ck1170 FIND v(dout1_13) AT=590.025n

.meas tran vdout1_14ck1170 FIND v(dout1_14) AT=590.025n

.meas tran vdout1_15ck1170 FIND v(dout1_15) AT=590.025n

.meas tran vdout1_16ck1170 FIND v(dout1_16) AT=590.025n

.meas tran vdout1_17ck1170 FIND v(dout1_17) AT=590.025n

.meas tran vdout1_18ck1170 FIND v(dout1_18) AT=590.025n

.meas tran vdout1_19ck1170 FIND v(dout1_19) AT=590.025n

.meas tran vdout1_20ck1170 FIND v(dout1_20) AT=590.025n

.meas tran vdout1_21ck1170 FIND v(dout1_21) AT=590.025n

.meas tran vdout1_22ck1170 FIND v(dout1_22) AT=590.025n

.meas tran vdout1_23ck1170 FIND v(dout1_23) AT=590.025n

.meas tran vdout1_0ck1180 FIND v(dout1_0) AT=595.025n

.meas tran vdout1_1ck1180 FIND v(dout1_1) AT=595.025n

.meas tran vdout1_2ck1180 FIND v(dout1_2) AT=595.025n

.meas tran vdout1_3ck1180 FIND v(dout1_3) AT=595.025n

.meas tran vdout1_4ck1180 FIND v(dout1_4) AT=595.025n

.meas tran vdout1_5ck1180 FIND v(dout1_5) AT=595.025n

.meas tran vdout1_6ck1180 FIND v(dout1_6) AT=595.025n

.meas tran vdout1_7ck1180 FIND v(dout1_7) AT=595.025n

.meas tran vdout1_8ck1180 FIND v(dout1_8) AT=595.025n

.meas tran vdout1_9ck1180 FIND v(dout1_9) AT=595.025n

.meas tran vdout1_10ck1180 FIND v(dout1_10) AT=595.025n

.meas tran vdout1_11ck1180 FIND v(dout1_11) AT=595.025n

.meas tran vdout1_12ck1180 FIND v(dout1_12) AT=595.025n

.meas tran vdout1_13ck1180 FIND v(dout1_13) AT=595.025n

.meas tran vdout1_14ck1180 FIND v(dout1_14) AT=595.025n

.meas tran vdout1_15ck1180 FIND v(dout1_15) AT=595.025n

.meas tran vdout1_16ck1180 FIND v(dout1_16) AT=595.025n

.meas tran vdout1_17ck1180 FIND v(dout1_17) AT=595.025n

.meas tran vdout1_18ck1180 FIND v(dout1_18) AT=595.025n

.meas tran vdout1_19ck1180 FIND v(dout1_19) AT=595.025n

.meas tran vdout1_20ck1180 FIND v(dout1_20) AT=595.025n

.meas tran vdout1_21ck1180 FIND v(dout1_21) AT=595.025n

.meas tran vdout1_22ck1180 FIND v(dout1_22) AT=595.025n

.meas tran vdout1_23ck1180 FIND v(dout1_23) AT=595.025n

.meas tran vdout1_0ck1190 FIND v(dout1_0) AT=600.025n

.meas tran vdout1_1ck1190 FIND v(dout1_1) AT=600.025n

.meas tran vdout1_2ck1190 FIND v(dout1_2) AT=600.025n

.meas tran vdout1_3ck1190 FIND v(dout1_3) AT=600.025n

.meas tran vdout1_4ck1190 FIND v(dout1_4) AT=600.025n

.meas tran vdout1_5ck1190 FIND v(dout1_5) AT=600.025n

.meas tran vdout1_6ck1190 FIND v(dout1_6) AT=600.025n

.meas tran vdout1_7ck1190 FIND v(dout1_7) AT=600.025n

.meas tran vdout1_8ck1190 FIND v(dout1_8) AT=600.025n

.meas tran vdout1_9ck1190 FIND v(dout1_9) AT=600.025n

.meas tran vdout1_10ck1190 FIND v(dout1_10) AT=600.025n

.meas tran vdout1_11ck1190 FIND v(dout1_11) AT=600.025n

.meas tran vdout1_12ck1190 FIND v(dout1_12) AT=600.025n

.meas tran vdout1_13ck1190 FIND v(dout1_13) AT=600.025n

.meas tran vdout1_14ck1190 FIND v(dout1_14) AT=600.025n

.meas tran vdout1_15ck1190 FIND v(dout1_15) AT=600.025n

.meas tran vdout1_16ck1190 FIND v(dout1_16) AT=600.025n

.meas tran vdout1_17ck1190 FIND v(dout1_17) AT=600.025n

.meas tran vdout1_18ck1190 FIND v(dout1_18) AT=600.025n

.meas tran vdout1_19ck1190 FIND v(dout1_19) AT=600.025n

.meas tran vdout1_20ck1190 FIND v(dout1_20) AT=600.025n

.meas tran vdout1_21ck1190 FIND v(dout1_21) AT=600.025n

.meas tran vdout1_22ck1190 FIND v(dout1_22) AT=600.025n

.meas tran vdout1_23ck1190 FIND v(dout1_23) AT=600.025n

.meas tran vdout0_0ck1200 FIND v(dout0_0) AT=605.025n

.meas tran vdout0_1ck1200 FIND v(dout0_1) AT=605.025n

.meas tran vdout0_2ck1200 FIND v(dout0_2) AT=605.025n

.meas tran vdout0_3ck1200 FIND v(dout0_3) AT=605.025n

.meas tran vdout0_4ck1200 FIND v(dout0_4) AT=605.025n

.meas tran vdout0_5ck1200 FIND v(dout0_5) AT=605.025n

.meas tran vdout0_6ck1200 FIND v(dout0_6) AT=605.025n

.meas tran vdout0_7ck1200 FIND v(dout0_7) AT=605.025n

.meas tran vdout0_8ck1200 FIND v(dout0_8) AT=605.025n

.meas tran vdout0_9ck1200 FIND v(dout0_9) AT=605.025n

.meas tran vdout0_10ck1200 FIND v(dout0_10) AT=605.025n

.meas tran vdout0_11ck1200 FIND v(dout0_11) AT=605.025n

.meas tran vdout0_12ck1200 FIND v(dout0_12) AT=605.025n

.meas tran vdout0_13ck1200 FIND v(dout0_13) AT=605.025n

.meas tran vdout0_14ck1200 FIND v(dout0_14) AT=605.025n

.meas tran vdout0_15ck1200 FIND v(dout0_15) AT=605.025n

.meas tran vdout0_16ck1200 FIND v(dout0_16) AT=605.025n

.meas tran vdout0_17ck1200 FIND v(dout0_17) AT=605.025n

.meas tran vdout0_18ck1200 FIND v(dout0_18) AT=605.025n

.meas tran vdout0_19ck1200 FIND v(dout0_19) AT=605.025n

.meas tran vdout0_20ck1200 FIND v(dout0_20) AT=605.025n

.meas tran vdout0_21ck1200 FIND v(dout0_21) AT=605.025n

.meas tran vdout0_22ck1200 FIND v(dout0_22) AT=605.025n

.meas tran vdout0_23ck1200 FIND v(dout0_23) AT=605.025n

.meas tran vdout0_0ck1210 FIND v(dout0_0) AT=610.025n

.meas tran vdout0_1ck1210 FIND v(dout0_1) AT=610.025n

.meas tran vdout0_2ck1210 FIND v(dout0_2) AT=610.025n

.meas tran vdout0_3ck1210 FIND v(dout0_3) AT=610.025n

.meas tran vdout0_4ck1210 FIND v(dout0_4) AT=610.025n

.meas tran vdout0_5ck1210 FIND v(dout0_5) AT=610.025n

.meas tran vdout0_6ck1210 FIND v(dout0_6) AT=610.025n

.meas tran vdout0_7ck1210 FIND v(dout0_7) AT=610.025n

.meas tran vdout0_8ck1210 FIND v(dout0_8) AT=610.025n

.meas tran vdout0_9ck1210 FIND v(dout0_9) AT=610.025n

.meas tran vdout0_10ck1210 FIND v(dout0_10) AT=610.025n

.meas tran vdout0_11ck1210 FIND v(dout0_11) AT=610.025n

.meas tran vdout0_12ck1210 FIND v(dout0_12) AT=610.025n

.meas tran vdout0_13ck1210 FIND v(dout0_13) AT=610.025n

.meas tran vdout0_14ck1210 FIND v(dout0_14) AT=610.025n

.meas tran vdout0_15ck1210 FIND v(dout0_15) AT=610.025n

.meas tran vdout0_16ck1210 FIND v(dout0_16) AT=610.025n

.meas tran vdout0_17ck1210 FIND v(dout0_17) AT=610.025n

.meas tran vdout0_18ck1210 FIND v(dout0_18) AT=610.025n

.meas tran vdout0_19ck1210 FIND v(dout0_19) AT=610.025n

.meas tran vdout0_20ck1210 FIND v(dout0_20) AT=610.025n

.meas tran vdout0_21ck1210 FIND v(dout0_21) AT=610.025n

.meas tran vdout0_22ck1210 FIND v(dout0_22) AT=610.025n

.meas tran vdout0_23ck1210 FIND v(dout0_23) AT=610.025n

.meas tran vdout0_0ck1220 FIND v(dout0_0) AT=615.025n

.meas tran vdout0_1ck1220 FIND v(dout0_1) AT=615.025n

.meas tran vdout0_2ck1220 FIND v(dout0_2) AT=615.025n

.meas tran vdout0_3ck1220 FIND v(dout0_3) AT=615.025n

.meas tran vdout0_4ck1220 FIND v(dout0_4) AT=615.025n

.meas tran vdout0_5ck1220 FIND v(dout0_5) AT=615.025n

.meas tran vdout0_6ck1220 FIND v(dout0_6) AT=615.025n

.meas tran vdout0_7ck1220 FIND v(dout0_7) AT=615.025n

.meas tran vdout0_8ck1220 FIND v(dout0_8) AT=615.025n

.meas tran vdout0_9ck1220 FIND v(dout0_9) AT=615.025n

.meas tran vdout0_10ck1220 FIND v(dout0_10) AT=615.025n

.meas tran vdout0_11ck1220 FIND v(dout0_11) AT=615.025n

.meas tran vdout0_12ck1220 FIND v(dout0_12) AT=615.025n

.meas tran vdout0_13ck1220 FIND v(dout0_13) AT=615.025n

.meas tran vdout0_14ck1220 FIND v(dout0_14) AT=615.025n

.meas tran vdout0_15ck1220 FIND v(dout0_15) AT=615.025n

.meas tran vdout0_16ck1220 FIND v(dout0_16) AT=615.025n

.meas tran vdout0_17ck1220 FIND v(dout0_17) AT=615.025n

.meas tran vdout0_18ck1220 FIND v(dout0_18) AT=615.025n

.meas tran vdout0_19ck1220 FIND v(dout0_19) AT=615.025n

.meas tran vdout0_20ck1220 FIND v(dout0_20) AT=615.025n

.meas tran vdout0_21ck1220 FIND v(dout0_21) AT=615.025n

.meas tran vdout0_22ck1220 FIND v(dout0_22) AT=615.025n

.meas tran vdout0_23ck1220 FIND v(dout0_23) AT=615.025n

.meas tran vdout1_0ck1220 FIND v(dout1_0) AT=615.025n

.meas tran vdout1_1ck1220 FIND v(dout1_1) AT=615.025n

.meas tran vdout1_2ck1220 FIND v(dout1_2) AT=615.025n

.meas tran vdout1_3ck1220 FIND v(dout1_3) AT=615.025n

.meas tran vdout1_4ck1220 FIND v(dout1_4) AT=615.025n

.meas tran vdout1_5ck1220 FIND v(dout1_5) AT=615.025n

.meas tran vdout1_6ck1220 FIND v(dout1_6) AT=615.025n

.meas tran vdout1_7ck1220 FIND v(dout1_7) AT=615.025n

.meas tran vdout1_8ck1220 FIND v(dout1_8) AT=615.025n

.meas tran vdout1_9ck1220 FIND v(dout1_9) AT=615.025n

.meas tran vdout1_10ck1220 FIND v(dout1_10) AT=615.025n

.meas tran vdout1_11ck1220 FIND v(dout1_11) AT=615.025n

.meas tran vdout1_12ck1220 FIND v(dout1_12) AT=615.025n

.meas tran vdout1_13ck1220 FIND v(dout1_13) AT=615.025n

.meas tran vdout1_14ck1220 FIND v(dout1_14) AT=615.025n

.meas tran vdout1_15ck1220 FIND v(dout1_15) AT=615.025n

.meas tran vdout1_16ck1220 FIND v(dout1_16) AT=615.025n

.meas tran vdout1_17ck1220 FIND v(dout1_17) AT=615.025n

.meas tran vdout1_18ck1220 FIND v(dout1_18) AT=615.025n

.meas tran vdout1_19ck1220 FIND v(dout1_19) AT=615.025n

.meas tran vdout1_20ck1220 FIND v(dout1_20) AT=615.025n

.meas tran vdout1_21ck1220 FIND v(dout1_21) AT=615.025n

.meas tran vdout1_22ck1220 FIND v(dout1_22) AT=615.025n

.meas tran vdout1_23ck1220 FIND v(dout1_23) AT=615.025n

.meas tran vdout0_0ck1230 FIND v(dout0_0) AT=620.025n

.meas tran vdout0_1ck1230 FIND v(dout0_1) AT=620.025n

.meas tran vdout0_2ck1230 FIND v(dout0_2) AT=620.025n

.meas tran vdout0_3ck1230 FIND v(dout0_3) AT=620.025n

.meas tran vdout0_4ck1230 FIND v(dout0_4) AT=620.025n

.meas tran vdout0_5ck1230 FIND v(dout0_5) AT=620.025n

.meas tran vdout0_6ck1230 FIND v(dout0_6) AT=620.025n

.meas tran vdout0_7ck1230 FIND v(dout0_7) AT=620.025n

.meas tran vdout0_8ck1230 FIND v(dout0_8) AT=620.025n

.meas tran vdout0_9ck1230 FIND v(dout0_9) AT=620.025n

.meas tran vdout0_10ck1230 FIND v(dout0_10) AT=620.025n

.meas tran vdout0_11ck1230 FIND v(dout0_11) AT=620.025n

.meas tran vdout0_12ck1230 FIND v(dout0_12) AT=620.025n

.meas tran vdout0_13ck1230 FIND v(dout0_13) AT=620.025n

.meas tran vdout0_14ck1230 FIND v(dout0_14) AT=620.025n

.meas tran vdout0_15ck1230 FIND v(dout0_15) AT=620.025n

.meas tran vdout0_16ck1230 FIND v(dout0_16) AT=620.025n

.meas tran vdout0_17ck1230 FIND v(dout0_17) AT=620.025n

.meas tran vdout0_18ck1230 FIND v(dout0_18) AT=620.025n

.meas tran vdout0_19ck1230 FIND v(dout0_19) AT=620.025n

.meas tran vdout0_20ck1230 FIND v(dout0_20) AT=620.025n

.meas tran vdout0_21ck1230 FIND v(dout0_21) AT=620.025n

.meas tran vdout0_22ck1230 FIND v(dout0_22) AT=620.025n

.meas tran vdout0_23ck1230 FIND v(dout0_23) AT=620.025n

.meas tran vdout1_0ck1240 FIND v(dout1_0) AT=625.025n

.meas tran vdout1_1ck1240 FIND v(dout1_1) AT=625.025n

.meas tran vdout1_2ck1240 FIND v(dout1_2) AT=625.025n

.meas tran vdout1_3ck1240 FIND v(dout1_3) AT=625.025n

.meas tran vdout1_4ck1240 FIND v(dout1_4) AT=625.025n

.meas tran vdout1_5ck1240 FIND v(dout1_5) AT=625.025n

.meas tran vdout1_6ck1240 FIND v(dout1_6) AT=625.025n

.meas tran vdout1_7ck1240 FIND v(dout1_7) AT=625.025n

.meas tran vdout1_8ck1240 FIND v(dout1_8) AT=625.025n

.meas tran vdout1_9ck1240 FIND v(dout1_9) AT=625.025n

.meas tran vdout1_10ck1240 FIND v(dout1_10) AT=625.025n

.meas tran vdout1_11ck1240 FIND v(dout1_11) AT=625.025n

.meas tran vdout1_12ck1240 FIND v(dout1_12) AT=625.025n

.meas tran vdout1_13ck1240 FIND v(dout1_13) AT=625.025n

.meas tran vdout1_14ck1240 FIND v(dout1_14) AT=625.025n

.meas tran vdout1_15ck1240 FIND v(dout1_15) AT=625.025n

.meas tran vdout1_16ck1240 FIND v(dout1_16) AT=625.025n

.meas tran vdout1_17ck1240 FIND v(dout1_17) AT=625.025n

.meas tran vdout1_18ck1240 FIND v(dout1_18) AT=625.025n

.meas tran vdout1_19ck1240 FIND v(dout1_19) AT=625.025n

.meas tran vdout1_20ck1240 FIND v(dout1_20) AT=625.025n

.meas tran vdout1_21ck1240 FIND v(dout1_21) AT=625.025n

.meas tran vdout1_22ck1240 FIND v(dout1_22) AT=625.025n

.meas tran vdout1_23ck1240 FIND v(dout1_23) AT=625.025n

.meas tran vdout0_0ck1250 FIND v(dout0_0) AT=630.025n

.meas tran vdout0_1ck1250 FIND v(dout0_1) AT=630.025n

.meas tran vdout0_2ck1250 FIND v(dout0_2) AT=630.025n

.meas tran vdout0_3ck1250 FIND v(dout0_3) AT=630.025n

.meas tran vdout0_4ck1250 FIND v(dout0_4) AT=630.025n

.meas tran vdout0_5ck1250 FIND v(dout0_5) AT=630.025n

.meas tran vdout0_6ck1250 FIND v(dout0_6) AT=630.025n

.meas tran vdout0_7ck1250 FIND v(dout0_7) AT=630.025n

.meas tran vdout0_8ck1250 FIND v(dout0_8) AT=630.025n

.meas tran vdout0_9ck1250 FIND v(dout0_9) AT=630.025n

.meas tran vdout0_10ck1250 FIND v(dout0_10) AT=630.025n

.meas tran vdout0_11ck1250 FIND v(dout0_11) AT=630.025n

.meas tran vdout0_12ck1250 FIND v(dout0_12) AT=630.025n

.meas tran vdout0_13ck1250 FIND v(dout0_13) AT=630.025n

.meas tran vdout0_14ck1250 FIND v(dout0_14) AT=630.025n

.meas tran vdout0_15ck1250 FIND v(dout0_15) AT=630.025n

.meas tran vdout0_16ck1250 FIND v(dout0_16) AT=630.025n

.meas tran vdout0_17ck1250 FIND v(dout0_17) AT=630.025n

.meas tran vdout0_18ck1250 FIND v(dout0_18) AT=630.025n

.meas tran vdout0_19ck1250 FIND v(dout0_19) AT=630.025n

.meas tran vdout0_20ck1250 FIND v(dout0_20) AT=630.025n

.meas tran vdout0_21ck1250 FIND v(dout0_21) AT=630.025n

.meas tran vdout0_22ck1250 FIND v(dout0_22) AT=630.025n

.meas tran vdout0_23ck1250 FIND v(dout0_23) AT=630.025n

.meas tran vdout1_0ck1250 FIND v(dout1_0) AT=630.025n

.meas tran vdout1_1ck1250 FIND v(dout1_1) AT=630.025n

.meas tran vdout1_2ck1250 FIND v(dout1_2) AT=630.025n

.meas tran vdout1_3ck1250 FIND v(dout1_3) AT=630.025n

.meas tran vdout1_4ck1250 FIND v(dout1_4) AT=630.025n

.meas tran vdout1_5ck1250 FIND v(dout1_5) AT=630.025n

.meas tran vdout1_6ck1250 FIND v(dout1_6) AT=630.025n

.meas tran vdout1_7ck1250 FIND v(dout1_7) AT=630.025n

.meas tran vdout1_8ck1250 FIND v(dout1_8) AT=630.025n

.meas tran vdout1_9ck1250 FIND v(dout1_9) AT=630.025n

.meas tran vdout1_10ck1250 FIND v(dout1_10) AT=630.025n

.meas tran vdout1_11ck1250 FIND v(dout1_11) AT=630.025n

.meas tran vdout1_12ck1250 FIND v(dout1_12) AT=630.025n

.meas tran vdout1_13ck1250 FIND v(dout1_13) AT=630.025n

.meas tran vdout1_14ck1250 FIND v(dout1_14) AT=630.025n

.meas tran vdout1_15ck1250 FIND v(dout1_15) AT=630.025n

.meas tran vdout1_16ck1250 FIND v(dout1_16) AT=630.025n

.meas tran vdout1_17ck1250 FIND v(dout1_17) AT=630.025n

.meas tran vdout1_18ck1250 FIND v(dout1_18) AT=630.025n

.meas tran vdout1_19ck1250 FIND v(dout1_19) AT=630.025n

.meas tran vdout1_20ck1250 FIND v(dout1_20) AT=630.025n

.meas tran vdout1_21ck1250 FIND v(dout1_21) AT=630.025n

.meas tran vdout1_22ck1250 FIND v(dout1_22) AT=630.025n

.meas tran vdout1_23ck1250 FIND v(dout1_23) AT=630.025n

.meas tran vdout0_0ck1260 FIND v(dout0_0) AT=635.025n

.meas tran vdout0_1ck1260 FIND v(dout0_1) AT=635.025n

.meas tran vdout0_2ck1260 FIND v(dout0_2) AT=635.025n

.meas tran vdout0_3ck1260 FIND v(dout0_3) AT=635.025n

.meas tran vdout0_4ck1260 FIND v(dout0_4) AT=635.025n

.meas tran vdout0_5ck1260 FIND v(dout0_5) AT=635.025n

.meas tran vdout0_6ck1260 FIND v(dout0_6) AT=635.025n

.meas tran vdout0_7ck1260 FIND v(dout0_7) AT=635.025n

.meas tran vdout0_8ck1260 FIND v(dout0_8) AT=635.025n

.meas tran vdout0_9ck1260 FIND v(dout0_9) AT=635.025n

.meas tran vdout0_10ck1260 FIND v(dout0_10) AT=635.025n

.meas tran vdout0_11ck1260 FIND v(dout0_11) AT=635.025n

.meas tran vdout0_12ck1260 FIND v(dout0_12) AT=635.025n

.meas tran vdout0_13ck1260 FIND v(dout0_13) AT=635.025n

.meas tran vdout0_14ck1260 FIND v(dout0_14) AT=635.025n

.meas tran vdout0_15ck1260 FIND v(dout0_15) AT=635.025n

.meas tran vdout0_16ck1260 FIND v(dout0_16) AT=635.025n

.meas tran vdout0_17ck1260 FIND v(dout0_17) AT=635.025n

.meas tran vdout0_18ck1260 FIND v(dout0_18) AT=635.025n

.meas tran vdout0_19ck1260 FIND v(dout0_19) AT=635.025n

.meas tran vdout0_20ck1260 FIND v(dout0_20) AT=635.025n

.meas tran vdout0_21ck1260 FIND v(dout0_21) AT=635.025n

.meas tran vdout0_22ck1260 FIND v(dout0_22) AT=635.025n

.meas tran vdout0_23ck1260 FIND v(dout0_23) AT=635.025n

.meas tran vdout1_0ck1260 FIND v(dout1_0) AT=635.025n

.meas tran vdout1_1ck1260 FIND v(dout1_1) AT=635.025n

.meas tran vdout1_2ck1260 FIND v(dout1_2) AT=635.025n

.meas tran vdout1_3ck1260 FIND v(dout1_3) AT=635.025n

.meas tran vdout1_4ck1260 FIND v(dout1_4) AT=635.025n

.meas tran vdout1_5ck1260 FIND v(dout1_5) AT=635.025n

.meas tran vdout1_6ck1260 FIND v(dout1_6) AT=635.025n

.meas tran vdout1_7ck1260 FIND v(dout1_7) AT=635.025n

.meas tran vdout1_8ck1260 FIND v(dout1_8) AT=635.025n

.meas tran vdout1_9ck1260 FIND v(dout1_9) AT=635.025n

.meas tran vdout1_10ck1260 FIND v(dout1_10) AT=635.025n

.meas tran vdout1_11ck1260 FIND v(dout1_11) AT=635.025n

.meas tran vdout1_12ck1260 FIND v(dout1_12) AT=635.025n

.meas tran vdout1_13ck1260 FIND v(dout1_13) AT=635.025n

.meas tran vdout1_14ck1260 FIND v(dout1_14) AT=635.025n

.meas tran vdout1_15ck1260 FIND v(dout1_15) AT=635.025n

.meas tran vdout1_16ck1260 FIND v(dout1_16) AT=635.025n

.meas tran vdout1_17ck1260 FIND v(dout1_17) AT=635.025n

.meas tran vdout1_18ck1260 FIND v(dout1_18) AT=635.025n

.meas tran vdout1_19ck1260 FIND v(dout1_19) AT=635.025n

.meas tran vdout1_20ck1260 FIND v(dout1_20) AT=635.025n

.meas tran vdout1_21ck1260 FIND v(dout1_21) AT=635.025n

.meas tran vdout1_22ck1260 FIND v(dout1_22) AT=635.025n

.meas tran vdout1_23ck1260 FIND v(dout1_23) AT=635.025n

.meas tran vdout0_0ck1270 FIND v(dout0_0) AT=640.025n

.meas tran vdout0_1ck1270 FIND v(dout0_1) AT=640.025n

.meas tran vdout0_2ck1270 FIND v(dout0_2) AT=640.025n

.meas tran vdout0_3ck1270 FIND v(dout0_3) AT=640.025n

.meas tran vdout0_4ck1270 FIND v(dout0_4) AT=640.025n

.meas tran vdout0_5ck1270 FIND v(dout0_5) AT=640.025n

.meas tran vdout0_6ck1270 FIND v(dout0_6) AT=640.025n

.meas tran vdout0_7ck1270 FIND v(dout0_7) AT=640.025n

.meas tran vdout0_8ck1270 FIND v(dout0_8) AT=640.025n

.meas tran vdout0_9ck1270 FIND v(dout0_9) AT=640.025n

.meas tran vdout0_10ck1270 FIND v(dout0_10) AT=640.025n

.meas tran vdout0_11ck1270 FIND v(dout0_11) AT=640.025n

.meas tran vdout0_12ck1270 FIND v(dout0_12) AT=640.025n

.meas tran vdout0_13ck1270 FIND v(dout0_13) AT=640.025n

.meas tran vdout0_14ck1270 FIND v(dout0_14) AT=640.025n

.meas tran vdout0_15ck1270 FIND v(dout0_15) AT=640.025n

.meas tran vdout0_16ck1270 FIND v(dout0_16) AT=640.025n

.meas tran vdout0_17ck1270 FIND v(dout0_17) AT=640.025n

.meas tran vdout0_18ck1270 FIND v(dout0_18) AT=640.025n

.meas tran vdout0_19ck1270 FIND v(dout0_19) AT=640.025n

.meas tran vdout0_20ck1270 FIND v(dout0_20) AT=640.025n

.meas tran vdout0_21ck1270 FIND v(dout0_21) AT=640.025n

.meas tran vdout0_22ck1270 FIND v(dout0_22) AT=640.025n

.meas tran vdout0_23ck1270 FIND v(dout0_23) AT=640.025n

.meas tran vdout0_0ck1280 FIND v(dout0_0) AT=645.025n

.meas tran vdout0_1ck1280 FIND v(dout0_1) AT=645.025n

.meas tran vdout0_2ck1280 FIND v(dout0_2) AT=645.025n

.meas tran vdout0_3ck1280 FIND v(dout0_3) AT=645.025n

.meas tran vdout0_4ck1280 FIND v(dout0_4) AT=645.025n

.meas tran vdout0_5ck1280 FIND v(dout0_5) AT=645.025n

.meas tran vdout0_6ck1280 FIND v(dout0_6) AT=645.025n

.meas tran vdout0_7ck1280 FIND v(dout0_7) AT=645.025n

.meas tran vdout0_8ck1280 FIND v(dout0_8) AT=645.025n

.meas tran vdout0_9ck1280 FIND v(dout0_9) AT=645.025n

.meas tran vdout0_10ck1280 FIND v(dout0_10) AT=645.025n

.meas tran vdout0_11ck1280 FIND v(dout0_11) AT=645.025n

.meas tran vdout0_12ck1280 FIND v(dout0_12) AT=645.025n

.meas tran vdout0_13ck1280 FIND v(dout0_13) AT=645.025n

.meas tran vdout0_14ck1280 FIND v(dout0_14) AT=645.025n

.meas tran vdout0_15ck1280 FIND v(dout0_15) AT=645.025n

.meas tran vdout0_16ck1280 FIND v(dout0_16) AT=645.025n

.meas tran vdout0_17ck1280 FIND v(dout0_17) AT=645.025n

.meas tran vdout0_18ck1280 FIND v(dout0_18) AT=645.025n

.meas tran vdout0_19ck1280 FIND v(dout0_19) AT=645.025n

.meas tran vdout0_20ck1280 FIND v(dout0_20) AT=645.025n

.meas tran vdout0_21ck1280 FIND v(dout0_21) AT=645.025n

.meas tran vdout0_22ck1280 FIND v(dout0_22) AT=645.025n

.meas tran vdout0_23ck1280 FIND v(dout0_23) AT=645.025n

.meas tran vdout1_0ck1290 FIND v(dout1_0) AT=650.025n

.meas tran vdout1_1ck1290 FIND v(dout1_1) AT=650.025n

.meas tran vdout1_2ck1290 FIND v(dout1_2) AT=650.025n

.meas tran vdout1_3ck1290 FIND v(dout1_3) AT=650.025n

.meas tran vdout1_4ck1290 FIND v(dout1_4) AT=650.025n

.meas tran vdout1_5ck1290 FIND v(dout1_5) AT=650.025n

.meas tran vdout1_6ck1290 FIND v(dout1_6) AT=650.025n

.meas tran vdout1_7ck1290 FIND v(dout1_7) AT=650.025n

.meas tran vdout1_8ck1290 FIND v(dout1_8) AT=650.025n

.meas tran vdout1_9ck1290 FIND v(dout1_9) AT=650.025n

.meas tran vdout1_10ck1290 FIND v(dout1_10) AT=650.025n

.meas tran vdout1_11ck1290 FIND v(dout1_11) AT=650.025n

.meas tran vdout1_12ck1290 FIND v(dout1_12) AT=650.025n

.meas tran vdout1_13ck1290 FIND v(dout1_13) AT=650.025n

.meas tran vdout1_14ck1290 FIND v(dout1_14) AT=650.025n

.meas tran vdout1_15ck1290 FIND v(dout1_15) AT=650.025n

.meas tran vdout1_16ck1290 FIND v(dout1_16) AT=650.025n

.meas tran vdout1_17ck1290 FIND v(dout1_17) AT=650.025n

.meas tran vdout1_18ck1290 FIND v(dout1_18) AT=650.025n

.meas tran vdout1_19ck1290 FIND v(dout1_19) AT=650.025n

.meas tran vdout1_20ck1290 FIND v(dout1_20) AT=650.025n

.meas tran vdout1_21ck1290 FIND v(dout1_21) AT=650.025n

.meas tran vdout1_22ck1290 FIND v(dout1_22) AT=650.025n

.meas tran vdout1_23ck1290 FIND v(dout1_23) AT=650.025n

.meas tran vdout0_0ck1300 FIND v(dout0_0) AT=655.025n

.meas tran vdout0_1ck1300 FIND v(dout0_1) AT=655.025n

.meas tran vdout0_2ck1300 FIND v(dout0_2) AT=655.025n

.meas tran vdout0_3ck1300 FIND v(dout0_3) AT=655.025n

.meas tran vdout0_4ck1300 FIND v(dout0_4) AT=655.025n

.meas tran vdout0_5ck1300 FIND v(dout0_5) AT=655.025n

.meas tran vdout0_6ck1300 FIND v(dout0_6) AT=655.025n

.meas tran vdout0_7ck1300 FIND v(dout0_7) AT=655.025n

.meas tran vdout0_8ck1300 FIND v(dout0_8) AT=655.025n

.meas tran vdout0_9ck1300 FIND v(dout0_9) AT=655.025n

.meas tran vdout0_10ck1300 FIND v(dout0_10) AT=655.025n

.meas tran vdout0_11ck1300 FIND v(dout0_11) AT=655.025n

.meas tran vdout0_12ck1300 FIND v(dout0_12) AT=655.025n

.meas tran vdout0_13ck1300 FIND v(dout0_13) AT=655.025n

.meas tran vdout0_14ck1300 FIND v(dout0_14) AT=655.025n

.meas tran vdout0_15ck1300 FIND v(dout0_15) AT=655.025n

.meas tran vdout0_16ck1300 FIND v(dout0_16) AT=655.025n

.meas tran vdout0_17ck1300 FIND v(dout0_17) AT=655.025n

.meas tran vdout0_18ck1300 FIND v(dout0_18) AT=655.025n

.meas tran vdout0_19ck1300 FIND v(dout0_19) AT=655.025n

.meas tran vdout0_20ck1300 FIND v(dout0_20) AT=655.025n

.meas tran vdout0_21ck1300 FIND v(dout0_21) AT=655.025n

.meas tran vdout0_22ck1300 FIND v(dout0_22) AT=655.025n

.meas tran vdout0_23ck1300 FIND v(dout0_23) AT=655.025n

.meas tran vdout1_0ck1300 FIND v(dout1_0) AT=655.025n

.meas tran vdout1_1ck1300 FIND v(dout1_1) AT=655.025n

.meas tran vdout1_2ck1300 FIND v(dout1_2) AT=655.025n

.meas tran vdout1_3ck1300 FIND v(dout1_3) AT=655.025n

.meas tran vdout1_4ck1300 FIND v(dout1_4) AT=655.025n

.meas tran vdout1_5ck1300 FIND v(dout1_5) AT=655.025n

.meas tran vdout1_6ck1300 FIND v(dout1_6) AT=655.025n

.meas tran vdout1_7ck1300 FIND v(dout1_7) AT=655.025n

.meas tran vdout1_8ck1300 FIND v(dout1_8) AT=655.025n

.meas tran vdout1_9ck1300 FIND v(dout1_9) AT=655.025n

.meas tran vdout1_10ck1300 FIND v(dout1_10) AT=655.025n

.meas tran vdout1_11ck1300 FIND v(dout1_11) AT=655.025n

.meas tran vdout1_12ck1300 FIND v(dout1_12) AT=655.025n

.meas tran vdout1_13ck1300 FIND v(dout1_13) AT=655.025n

.meas tran vdout1_14ck1300 FIND v(dout1_14) AT=655.025n

.meas tran vdout1_15ck1300 FIND v(dout1_15) AT=655.025n

.meas tran vdout1_16ck1300 FIND v(dout1_16) AT=655.025n

.meas tran vdout1_17ck1300 FIND v(dout1_17) AT=655.025n

.meas tran vdout1_18ck1300 FIND v(dout1_18) AT=655.025n

.meas tran vdout1_19ck1300 FIND v(dout1_19) AT=655.025n

.meas tran vdout1_20ck1300 FIND v(dout1_20) AT=655.025n

.meas tran vdout1_21ck1300 FIND v(dout1_21) AT=655.025n

.meas tran vdout1_22ck1300 FIND v(dout1_22) AT=655.025n

.meas tran vdout1_23ck1300 FIND v(dout1_23) AT=655.025n

.meas tran vdout0_0ck1330 FIND v(dout0_0) AT=670.025n

.meas tran vdout0_1ck1330 FIND v(dout0_1) AT=670.025n

.meas tran vdout0_2ck1330 FIND v(dout0_2) AT=670.025n

.meas tran vdout0_3ck1330 FIND v(dout0_3) AT=670.025n

.meas tran vdout0_4ck1330 FIND v(dout0_4) AT=670.025n

.meas tran vdout0_5ck1330 FIND v(dout0_5) AT=670.025n

.meas tran vdout0_6ck1330 FIND v(dout0_6) AT=670.025n

.meas tran vdout0_7ck1330 FIND v(dout0_7) AT=670.025n

.meas tran vdout0_8ck1330 FIND v(dout0_8) AT=670.025n

.meas tran vdout0_9ck1330 FIND v(dout0_9) AT=670.025n

.meas tran vdout0_10ck1330 FIND v(dout0_10) AT=670.025n

.meas tran vdout0_11ck1330 FIND v(dout0_11) AT=670.025n

.meas tran vdout0_12ck1330 FIND v(dout0_12) AT=670.025n

.meas tran vdout0_13ck1330 FIND v(dout0_13) AT=670.025n

.meas tran vdout0_14ck1330 FIND v(dout0_14) AT=670.025n

.meas tran vdout0_15ck1330 FIND v(dout0_15) AT=670.025n

.meas tran vdout0_16ck1330 FIND v(dout0_16) AT=670.025n

.meas tran vdout0_17ck1330 FIND v(dout0_17) AT=670.025n

.meas tran vdout0_18ck1330 FIND v(dout0_18) AT=670.025n

.meas tran vdout0_19ck1330 FIND v(dout0_19) AT=670.025n

.meas tran vdout0_20ck1330 FIND v(dout0_20) AT=670.025n

.meas tran vdout0_21ck1330 FIND v(dout0_21) AT=670.025n

.meas tran vdout0_22ck1330 FIND v(dout0_22) AT=670.025n

.meas tran vdout0_23ck1330 FIND v(dout0_23) AT=670.025n

.meas tran vdout1_0ck1340 FIND v(dout1_0) AT=675.025n

.meas tran vdout1_1ck1340 FIND v(dout1_1) AT=675.025n

.meas tran vdout1_2ck1340 FIND v(dout1_2) AT=675.025n

.meas tran vdout1_3ck1340 FIND v(dout1_3) AT=675.025n

.meas tran vdout1_4ck1340 FIND v(dout1_4) AT=675.025n

.meas tran vdout1_5ck1340 FIND v(dout1_5) AT=675.025n

.meas tran vdout1_6ck1340 FIND v(dout1_6) AT=675.025n

.meas tran vdout1_7ck1340 FIND v(dout1_7) AT=675.025n

.meas tran vdout1_8ck1340 FIND v(dout1_8) AT=675.025n

.meas tran vdout1_9ck1340 FIND v(dout1_9) AT=675.025n

.meas tran vdout1_10ck1340 FIND v(dout1_10) AT=675.025n

.meas tran vdout1_11ck1340 FIND v(dout1_11) AT=675.025n

.meas tran vdout1_12ck1340 FIND v(dout1_12) AT=675.025n

.meas tran vdout1_13ck1340 FIND v(dout1_13) AT=675.025n

.meas tran vdout1_14ck1340 FIND v(dout1_14) AT=675.025n

.meas tran vdout1_15ck1340 FIND v(dout1_15) AT=675.025n

.meas tran vdout1_16ck1340 FIND v(dout1_16) AT=675.025n

.meas tran vdout1_17ck1340 FIND v(dout1_17) AT=675.025n

.meas tran vdout1_18ck1340 FIND v(dout1_18) AT=675.025n

.meas tran vdout1_19ck1340 FIND v(dout1_19) AT=675.025n

.meas tran vdout1_20ck1340 FIND v(dout1_20) AT=675.025n

.meas tran vdout1_21ck1340 FIND v(dout1_21) AT=675.025n

.meas tran vdout1_22ck1340 FIND v(dout1_22) AT=675.025n

.meas tran vdout1_23ck1340 FIND v(dout1_23) AT=675.025n

.meas tran vdout0_0ck1350 FIND v(dout0_0) AT=680.025n

.meas tran vdout0_1ck1350 FIND v(dout0_1) AT=680.025n

.meas tran vdout0_2ck1350 FIND v(dout0_2) AT=680.025n

.meas tran vdout0_3ck1350 FIND v(dout0_3) AT=680.025n

.meas tran vdout0_4ck1350 FIND v(dout0_4) AT=680.025n

.meas tran vdout0_5ck1350 FIND v(dout0_5) AT=680.025n

.meas tran vdout0_6ck1350 FIND v(dout0_6) AT=680.025n

.meas tran vdout0_7ck1350 FIND v(dout0_7) AT=680.025n

.meas tran vdout0_8ck1350 FIND v(dout0_8) AT=680.025n

.meas tran vdout0_9ck1350 FIND v(dout0_9) AT=680.025n

.meas tran vdout0_10ck1350 FIND v(dout0_10) AT=680.025n

.meas tran vdout0_11ck1350 FIND v(dout0_11) AT=680.025n

.meas tran vdout0_12ck1350 FIND v(dout0_12) AT=680.025n

.meas tran vdout0_13ck1350 FIND v(dout0_13) AT=680.025n

.meas tran vdout0_14ck1350 FIND v(dout0_14) AT=680.025n

.meas tran vdout0_15ck1350 FIND v(dout0_15) AT=680.025n

.meas tran vdout0_16ck1350 FIND v(dout0_16) AT=680.025n

.meas tran vdout0_17ck1350 FIND v(dout0_17) AT=680.025n

.meas tran vdout0_18ck1350 FIND v(dout0_18) AT=680.025n

.meas tran vdout0_19ck1350 FIND v(dout0_19) AT=680.025n

.meas tran vdout0_20ck1350 FIND v(dout0_20) AT=680.025n

.meas tran vdout0_21ck1350 FIND v(dout0_21) AT=680.025n

.meas tran vdout0_22ck1350 FIND v(dout0_22) AT=680.025n

.meas tran vdout0_23ck1350 FIND v(dout0_23) AT=680.025n

.meas tran vdout1_0ck1350 FIND v(dout1_0) AT=680.025n

.meas tran vdout1_1ck1350 FIND v(dout1_1) AT=680.025n

.meas tran vdout1_2ck1350 FIND v(dout1_2) AT=680.025n

.meas tran vdout1_3ck1350 FIND v(dout1_3) AT=680.025n

.meas tran vdout1_4ck1350 FIND v(dout1_4) AT=680.025n

.meas tran vdout1_5ck1350 FIND v(dout1_5) AT=680.025n

.meas tran vdout1_6ck1350 FIND v(dout1_6) AT=680.025n

.meas tran vdout1_7ck1350 FIND v(dout1_7) AT=680.025n

.meas tran vdout1_8ck1350 FIND v(dout1_8) AT=680.025n

.meas tran vdout1_9ck1350 FIND v(dout1_9) AT=680.025n

.meas tran vdout1_10ck1350 FIND v(dout1_10) AT=680.025n

.meas tran vdout1_11ck1350 FIND v(dout1_11) AT=680.025n

.meas tran vdout1_12ck1350 FIND v(dout1_12) AT=680.025n

.meas tran vdout1_13ck1350 FIND v(dout1_13) AT=680.025n

.meas tran vdout1_14ck1350 FIND v(dout1_14) AT=680.025n

.meas tran vdout1_15ck1350 FIND v(dout1_15) AT=680.025n

.meas tran vdout1_16ck1350 FIND v(dout1_16) AT=680.025n

.meas tran vdout1_17ck1350 FIND v(dout1_17) AT=680.025n

.meas tran vdout1_18ck1350 FIND v(dout1_18) AT=680.025n

.meas tran vdout1_19ck1350 FIND v(dout1_19) AT=680.025n

.meas tran vdout1_20ck1350 FIND v(dout1_20) AT=680.025n

.meas tran vdout1_21ck1350 FIND v(dout1_21) AT=680.025n

.meas tran vdout1_22ck1350 FIND v(dout1_22) AT=680.025n

.meas tran vdout1_23ck1350 FIND v(dout1_23) AT=680.025n

.meas tran vdout0_0ck1360 FIND v(dout0_0) AT=685.025n

.meas tran vdout0_1ck1360 FIND v(dout0_1) AT=685.025n

.meas tran vdout0_2ck1360 FIND v(dout0_2) AT=685.025n

.meas tran vdout0_3ck1360 FIND v(dout0_3) AT=685.025n

.meas tran vdout0_4ck1360 FIND v(dout0_4) AT=685.025n

.meas tran vdout0_5ck1360 FIND v(dout0_5) AT=685.025n

.meas tran vdout0_6ck1360 FIND v(dout0_6) AT=685.025n

.meas tran vdout0_7ck1360 FIND v(dout0_7) AT=685.025n

.meas tran vdout0_8ck1360 FIND v(dout0_8) AT=685.025n

.meas tran vdout0_9ck1360 FIND v(dout0_9) AT=685.025n

.meas tran vdout0_10ck1360 FIND v(dout0_10) AT=685.025n

.meas tran vdout0_11ck1360 FIND v(dout0_11) AT=685.025n

.meas tran vdout0_12ck1360 FIND v(dout0_12) AT=685.025n

.meas tran vdout0_13ck1360 FIND v(dout0_13) AT=685.025n

.meas tran vdout0_14ck1360 FIND v(dout0_14) AT=685.025n

.meas tran vdout0_15ck1360 FIND v(dout0_15) AT=685.025n

.meas tran vdout0_16ck1360 FIND v(dout0_16) AT=685.025n

.meas tran vdout0_17ck1360 FIND v(dout0_17) AT=685.025n

.meas tran vdout0_18ck1360 FIND v(dout0_18) AT=685.025n

.meas tran vdout0_19ck1360 FIND v(dout0_19) AT=685.025n

.meas tran vdout0_20ck1360 FIND v(dout0_20) AT=685.025n

.meas tran vdout0_21ck1360 FIND v(dout0_21) AT=685.025n

.meas tran vdout0_22ck1360 FIND v(dout0_22) AT=685.025n

.meas tran vdout0_23ck1360 FIND v(dout0_23) AT=685.025n

.meas tran vdout1_0ck1380 FIND v(dout1_0) AT=695.025n

.meas tran vdout1_1ck1380 FIND v(dout1_1) AT=695.025n

.meas tran vdout1_2ck1380 FIND v(dout1_2) AT=695.025n

.meas tran vdout1_3ck1380 FIND v(dout1_3) AT=695.025n

.meas tran vdout1_4ck1380 FIND v(dout1_4) AT=695.025n

.meas tran vdout1_5ck1380 FIND v(dout1_5) AT=695.025n

.meas tran vdout1_6ck1380 FIND v(dout1_6) AT=695.025n

.meas tran vdout1_7ck1380 FIND v(dout1_7) AT=695.025n

.meas tran vdout1_8ck1380 FIND v(dout1_8) AT=695.025n

.meas tran vdout1_9ck1380 FIND v(dout1_9) AT=695.025n

.meas tran vdout1_10ck1380 FIND v(dout1_10) AT=695.025n

.meas tran vdout1_11ck1380 FIND v(dout1_11) AT=695.025n

.meas tran vdout1_12ck1380 FIND v(dout1_12) AT=695.025n

.meas tran vdout1_13ck1380 FIND v(dout1_13) AT=695.025n

.meas tran vdout1_14ck1380 FIND v(dout1_14) AT=695.025n

.meas tran vdout1_15ck1380 FIND v(dout1_15) AT=695.025n

.meas tran vdout1_16ck1380 FIND v(dout1_16) AT=695.025n

.meas tran vdout1_17ck1380 FIND v(dout1_17) AT=695.025n

.meas tran vdout1_18ck1380 FIND v(dout1_18) AT=695.025n

.meas tran vdout1_19ck1380 FIND v(dout1_19) AT=695.025n

.meas tran vdout1_20ck1380 FIND v(dout1_20) AT=695.025n

.meas tran vdout1_21ck1380 FIND v(dout1_21) AT=695.025n

.meas tran vdout1_22ck1380 FIND v(dout1_22) AT=695.025n

.meas tran vdout1_23ck1380 FIND v(dout1_23) AT=695.025n

.meas tran vdout0_0ck1390 FIND v(dout0_0) AT=700.025n

.meas tran vdout0_1ck1390 FIND v(dout0_1) AT=700.025n

.meas tran vdout0_2ck1390 FIND v(dout0_2) AT=700.025n

.meas tran vdout0_3ck1390 FIND v(dout0_3) AT=700.025n

.meas tran vdout0_4ck1390 FIND v(dout0_4) AT=700.025n

.meas tran vdout0_5ck1390 FIND v(dout0_5) AT=700.025n

.meas tran vdout0_6ck1390 FIND v(dout0_6) AT=700.025n

.meas tran vdout0_7ck1390 FIND v(dout0_7) AT=700.025n

.meas tran vdout0_8ck1390 FIND v(dout0_8) AT=700.025n

.meas tran vdout0_9ck1390 FIND v(dout0_9) AT=700.025n

.meas tran vdout0_10ck1390 FIND v(dout0_10) AT=700.025n

.meas tran vdout0_11ck1390 FIND v(dout0_11) AT=700.025n

.meas tran vdout0_12ck1390 FIND v(dout0_12) AT=700.025n

.meas tran vdout0_13ck1390 FIND v(dout0_13) AT=700.025n

.meas tran vdout0_14ck1390 FIND v(dout0_14) AT=700.025n

.meas tran vdout0_15ck1390 FIND v(dout0_15) AT=700.025n

.meas tran vdout0_16ck1390 FIND v(dout0_16) AT=700.025n

.meas tran vdout0_17ck1390 FIND v(dout0_17) AT=700.025n

.meas tran vdout0_18ck1390 FIND v(dout0_18) AT=700.025n

.meas tran vdout0_19ck1390 FIND v(dout0_19) AT=700.025n

.meas tran vdout0_20ck1390 FIND v(dout0_20) AT=700.025n

.meas tran vdout0_21ck1390 FIND v(dout0_21) AT=700.025n

.meas tran vdout0_22ck1390 FIND v(dout0_22) AT=700.025n

.meas tran vdout0_23ck1390 FIND v(dout0_23) AT=700.025n

.meas tran vdout1_0ck1390 FIND v(dout1_0) AT=700.025n

.meas tran vdout1_1ck1390 FIND v(dout1_1) AT=700.025n

.meas tran vdout1_2ck1390 FIND v(dout1_2) AT=700.025n

.meas tran vdout1_3ck1390 FIND v(dout1_3) AT=700.025n

.meas tran vdout1_4ck1390 FIND v(dout1_4) AT=700.025n

.meas tran vdout1_5ck1390 FIND v(dout1_5) AT=700.025n

.meas tran vdout1_6ck1390 FIND v(dout1_6) AT=700.025n

.meas tran vdout1_7ck1390 FIND v(dout1_7) AT=700.025n

.meas tran vdout1_8ck1390 FIND v(dout1_8) AT=700.025n

.meas tran vdout1_9ck1390 FIND v(dout1_9) AT=700.025n

.meas tran vdout1_10ck1390 FIND v(dout1_10) AT=700.025n

.meas tran vdout1_11ck1390 FIND v(dout1_11) AT=700.025n

.meas tran vdout1_12ck1390 FIND v(dout1_12) AT=700.025n

.meas tran vdout1_13ck1390 FIND v(dout1_13) AT=700.025n

.meas tran vdout1_14ck1390 FIND v(dout1_14) AT=700.025n

.meas tran vdout1_15ck1390 FIND v(dout1_15) AT=700.025n

.meas tran vdout1_16ck1390 FIND v(dout1_16) AT=700.025n

.meas tran vdout1_17ck1390 FIND v(dout1_17) AT=700.025n

.meas tran vdout1_18ck1390 FIND v(dout1_18) AT=700.025n

.meas tran vdout1_19ck1390 FIND v(dout1_19) AT=700.025n

.meas tran vdout1_20ck1390 FIND v(dout1_20) AT=700.025n

.meas tran vdout1_21ck1390 FIND v(dout1_21) AT=700.025n

.meas tran vdout1_22ck1390 FIND v(dout1_22) AT=700.025n

.meas tran vdout1_23ck1390 FIND v(dout1_23) AT=700.025n

.meas tran vdout1_0ck1400 FIND v(dout1_0) AT=705.025n

.meas tran vdout1_1ck1400 FIND v(dout1_1) AT=705.025n

.meas tran vdout1_2ck1400 FIND v(dout1_2) AT=705.025n

.meas tran vdout1_3ck1400 FIND v(dout1_3) AT=705.025n

.meas tran vdout1_4ck1400 FIND v(dout1_4) AT=705.025n

.meas tran vdout1_5ck1400 FIND v(dout1_5) AT=705.025n

.meas tran vdout1_6ck1400 FIND v(dout1_6) AT=705.025n

.meas tran vdout1_7ck1400 FIND v(dout1_7) AT=705.025n

.meas tran vdout1_8ck1400 FIND v(dout1_8) AT=705.025n

.meas tran vdout1_9ck1400 FIND v(dout1_9) AT=705.025n

.meas tran vdout1_10ck1400 FIND v(dout1_10) AT=705.025n

.meas tran vdout1_11ck1400 FIND v(dout1_11) AT=705.025n

.meas tran vdout1_12ck1400 FIND v(dout1_12) AT=705.025n

.meas tran vdout1_13ck1400 FIND v(dout1_13) AT=705.025n

.meas tran vdout1_14ck1400 FIND v(dout1_14) AT=705.025n

.meas tran vdout1_15ck1400 FIND v(dout1_15) AT=705.025n

.meas tran vdout1_16ck1400 FIND v(dout1_16) AT=705.025n

.meas tran vdout1_17ck1400 FIND v(dout1_17) AT=705.025n

.meas tran vdout1_18ck1400 FIND v(dout1_18) AT=705.025n

.meas tran vdout1_19ck1400 FIND v(dout1_19) AT=705.025n

.meas tran vdout1_20ck1400 FIND v(dout1_20) AT=705.025n

.meas tran vdout1_21ck1400 FIND v(dout1_21) AT=705.025n

.meas tran vdout1_22ck1400 FIND v(dout1_22) AT=705.025n

.meas tran vdout1_23ck1400 FIND v(dout1_23) AT=705.025n

.meas tran vdout0_0ck1410 FIND v(dout0_0) AT=710.025n

.meas tran vdout0_1ck1410 FIND v(dout0_1) AT=710.025n

.meas tran vdout0_2ck1410 FIND v(dout0_2) AT=710.025n

.meas tran vdout0_3ck1410 FIND v(dout0_3) AT=710.025n

.meas tran vdout0_4ck1410 FIND v(dout0_4) AT=710.025n

.meas tran vdout0_5ck1410 FIND v(dout0_5) AT=710.025n

.meas tran vdout0_6ck1410 FIND v(dout0_6) AT=710.025n

.meas tran vdout0_7ck1410 FIND v(dout0_7) AT=710.025n

.meas tran vdout0_8ck1410 FIND v(dout0_8) AT=710.025n

.meas tran vdout0_9ck1410 FIND v(dout0_9) AT=710.025n

.meas tran vdout0_10ck1410 FIND v(dout0_10) AT=710.025n

.meas tran vdout0_11ck1410 FIND v(dout0_11) AT=710.025n

.meas tran vdout0_12ck1410 FIND v(dout0_12) AT=710.025n

.meas tran vdout0_13ck1410 FIND v(dout0_13) AT=710.025n

.meas tran vdout0_14ck1410 FIND v(dout0_14) AT=710.025n

.meas tran vdout0_15ck1410 FIND v(dout0_15) AT=710.025n

.meas tran vdout0_16ck1410 FIND v(dout0_16) AT=710.025n

.meas tran vdout0_17ck1410 FIND v(dout0_17) AT=710.025n

.meas tran vdout0_18ck1410 FIND v(dout0_18) AT=710.025n

.meas tran vdout0_19ck1410 FIND v(dout0_19) AT=710.025n

.meas tran vdout0_20ck1410 FIND v(dout0_20) AT=710.025n

.meas tran vdout0_21ck1410 FIND v(dout0_21) AT=710.025n

.meas tran vdout0_22ck1410 FIND v(dout0_22) AT=710.025n

.meas tran vdout0_23ck1410 FIND v(dout0_23) AT=710.025n

.meas tran vdout1_0ck1410 FIND v(dout1_0) AT=710.025n

.meas tran vdout1_1ck1410 FIND v(dout1_1) AT=710.025n

.meas tran vdout1_2ck1410 FIND v(dout1_2) AT=710.025n

.meas tran vdout1_3ck1410 FIND v(dout1_3) AT=710.025n

.meas tran vdout1_4ck1410 FIND v(dout1_4) AT=710.025n

.meas tran vdout1_5ck1410 FIND v(dout1_5) AT=710.025n

.meas tran vdout1_6ck1410 FIND v(dout1_6) AT=710.025n

.meas tran vdout1_7ck1410 FIND v(dout1_7) AT=710.025n

.meas tran vdout1_8ck1410 FIND v(dout1_8) AT=710.025n

.meas tran vdout1_9ck1410 FIND v(dout1_9) AT=710.025n

.meas tran vdout1_10ck1410 FIND v(dout1_10) AT=710.025n

.meas tran vdout1_11ck1410 FIND v(dout1_11) AT=710.025n

.meas tran vdout1_12ck1410 FIND v(dout1_12) AT=710.025n

.meas tran vdout1_13ck1410 FIND v(dout1_13) AT=710.025n

.meas tran vdout1_14ck1410 FIND v(dout1_14) AT=710.025n

.meas tran vdout1_15ck1410 FIND v(dout1_15) AT=710.025n

.meas tran vdout1_16ck1410 FIND v(dout1_16) AT=710.025n

.meas tran vdout1_17ck1410 FIND v(dout1_17) AT=710.025n

.meas tran vdout1_18ck1410 FIND v(dout1_18) AT=710.025n

.meas tran vdout1_19ck1410 FIND v(dout1_19) AT=710.025n

.meas tran vdout1_20ck1410 FIND v(dout1_20) AT=710.025n

.meas tran vdout1_21ck1410 FIND v(dout1_21) AT=710.025n

.meas tran vdout1_22ck1410 FIND v(dout1_22) AT=710.025n

.meas tran vdout1_23ck1410 FIND v(dout1_23) AT=710.025n

.meas tran vdout0_0ck1420 FIND v(dout0_0) AT=715.025n

.meas tran vdout0_1ck1420 FIND v(dout0_1) AT=715.025n

.meas tran vdout0_2ck1420 FIND v(dout0_2) AT=715.025n

.meas tran vdout0_3ck1420 FIND v(dout0_3) AT=715.025n

.meas tran vdout0_4ck1420 FIND v(dout0_4) AT=715.025n

.meas tran vdout0_5ck1420 FIND v(dout0_5) AT=715.025n

.meas tran vdout0_6ck1420 FIND v(dout0_6) AT=715.025n

.meas tran vdout0_7ck1420 FIND v(dout0_7) AT=715.025n

.meas tran vdout0_8ck1420 FIND v(dout0_8) AT=715.025n

.meas tran vdout0_9ck1420 FIND v(dout0_9) AT=715.025n

.meas tran vdout0_10ck1420 FIND v(dout0_10) AT=715.025n

.meas tran vdout0_11ck1420 FIND v(dout0_11) AT=715.025n

.meas tran vdout0_12ck1420 FIND v(dout0_12) AT=715.025n

.meas tran vdout0_13ck1420 FIND v(dout0_13) AT=715.025n

.meas tran vdout0_14ck1420 FIND v(dout0_14) AT=715.025n

.meas tran vdout0_15ck1420 FIND v(dout0_15) AT=715.025n

.meas tran vdout0_16ck1420 FIND v(dout0_16) AT=715.025n

.meas tran vdout0_17ck1420 FIND v(dout0_17) AT=715.025n

.meas tran vdout0_18ck1420 FIND v(dout0_18) AT=715.025n

.meas tran vdout0_19ck1420 FIND v(dout0_19) AT=715.025n

.meas tran vdout0_20ck1420 FIND v(dout0_20) AT=715.025n

.meas tran vdout0_21ck1420 FIND v(dout0_21) AT=715.025n

.meas tran vdout0_22ck1420 FIND v(dout0_22) AT=715.025n

.meas tran vdout0_23ck1420 FIND v(dout0_23) AT=715.025n

.meas tran vdout1_0ck1420 FIND v(dout1_0) AT=715.025n

.meas tran vdout1_1ck1420 FIND v(dout1_1) AT=715.025n

.meas tran vdout1_2ck1420 FIND v(dout1_2) AT=715.025n

.meas tran vdout1_3ck1420 FIND v(dout1_3) AT=715.025n

.meas tran vdout1_4ck1420 FIND v(dout1_4) AT=715.025n

.meas tran vdout1_5ck1420 FIND v(dout1_5) AT=715.025n

.meas tran vdout1_6ck1420 FIND v(dout1_6) AT=715.025n

.meas tran vdout1_7ck1420 FIND v(dout1_7) AT=715.025n

.meas tran vdout1_8ck1420 FIND v(dout1_8) AT=715.025n

.meas tran vdout1_9ck1420 FIND v(dout1_9) AT=715.025n

.meas tran vdout1_10ck1420 FIND v(dout1_10) AT=715.025n

.meas tran vdout1_11ck1420 FIND v(dout1_11) AT=715.025n

.meas tran vdout1_12ck1420 FIND v(dout1_12) AT=715.025n

.meas tran vdout1_13ck1420 FIND v(dout1_13) AT=715.025n

.meas tran vdout1_14ck1420 FIND v(dout1_14) AT=715.025n

.meas tran vdout1_15ck1420 FIND v(dout1_15) AT=715.025n

.meas tran vdout1_16ck1420 FIND v(dout1_16) AT=715.025n

.meas tran vdout1_17ck1420 FIND v(dout1_17) AT=715.025n

.meas tran vdout1_18ck1420 FIND v(dout1_18) AT=715.025n

.meas tran vdout1_19ck1420 FIND v(dout1_19) AT=715.025n

.meas tran vdout1_20ck1420 FIND v(dout1_20) AT=715.025n

.meas tran vdout1_21ck1420 FIND v(dout1_21) AT=715.025n

.meas tran vdout1_22ck1420 FIND v(dout1_22) AT=715.025n

.meas tran vdout1_23ck1420 FIND v(dout1_23) AT=715.025n

.meas tran vdout0_0ck1430 FIND v(dout0_0) AT=720.025n

.meas tran vdout0_1ck1430 FIND v(dout0_1) AT=720.025n

.meas tran vdout0_2ck1430 FIND v(dout0_2) AT=720.025n

.meas tran vdout0_3ck1430 FIND v(dout0_3) AT=720.025n

.meas tran vdout0_4ck1430 FIND v(dout0_4) AT=720.025n

.meas tran vdout0_5ck1430 FIND v(dout0_5) AT=720.025n

.meas tran vdout0_6ck1430 FIND v(dout0_6) AT=720.025n

.meas tran vdout0_7ck1430 FIND v(dout0_7) AT=720.025n

.meas tran vdout0_8ck1430 FIND v(dout0_8) AT=720.025n

.meas tran vdout0_9ck1430 FIND v(dout0_9) AT=720.025n

.meas tran vdout0_10ck1430 FIND v(dout0_10) AT=720.025n

.meas tran vdout0_11ck1430 FIND v(dout0_11) AT=720.025n

.meas tran vdout0_12ck1430 FIND v(dout0_12) AT=720.025n

.meas tran vdout0_13ck1430 FIND v(dout0_13) AT=720.025n

.meas tran vdout0_14ck1430 FIND v(dout0_14) AT=720.025n

.meas tran vdout0_15ck1430 FIND v(dout0_15) AT=720.025n

.meas tran vdout0_16ck1430 FIND v(dout0_16) AT=720.025n

.meas tran vdout0_17ck1430 FIND v(dout0_17) AT=720.025n

.meas tran vdout0_18ck1430 FIND v(dout0_18) AT=720.025n

.meas tran vdout0_19ck1430 FIND v(dout0_19) AT=720.025n

.meas tran vdout0_20ck1430 FIND v(dout0_20) AT=720.025n

.meas tran vdout0_21ck1430 FIND v(dout0_21) AT=720.025n

.meas tran vdout0_22ck1430 FIND v(dout0_22) AT=720.025n

.meas tran vdout0_23ck1430 FIND v(dout0_23) AT=720.025n

.meas tran vdout0_0ck1440 FIND v(dout0_0) AT=725.025n

.meas tran vdout0_1ck1440 FIND v(dout0_1) AT=725.025n

.meas tran vdout0_2ck1440 FIND v(dout0_2) AT=725.025n

.meas tran vdout0_3ck1440 FIND v(dout0_3) AT=725.025n

.meas tran vdout0_4ck1440 FIND v(dout0_4) AT=725.025n

.meas tran vdout0_5ck1440 FIND v(dout0_5) AT=725.025n

.meas tran vdout0_6ck1440 FIND v(dout0_6) AT=725.025n

.meas tran vdout0_7ck1440 FIND v(dout0_7) AT=725.025n

.meas tran vdout0_8ck1440 FIND v(dout0_8) AT=725.025n

.meas tran vdout0_9ck1440 FIND v(dout0_9) AT=725.025n

.meas tran vdout0_10ck1440 FIND v(dout0_10) AT=725.025n

.meas tran vdout0_11ck1440 FIND v(dout0_11) AT=725.025n

.meas tran vdout0_12ck1440 FIND v(dout0_12) AT=725.025n

.meas tran vdout0_13ck1440 FIND v(dout0_13) AT=725.025n

.meas tran vdout0_14ck1440 FIND v(dout0_14) AT=725.025n

.meas tran vdout0_15ck1440 FIND v(dout0_15) AT=725.025n

.meas tran vdout0_16ck1440 FIND v(dout0_16) AT=725.025n

.meas tran vdout0_17ck1440 FIND v(dout0_17) AT=725.025n

.meas tran vdout0_18ck1440 FIND v(dout0_18) AT=725.025n

.meas tran vdout0_19ck1440 FIND v(dout0_19) AT=725.025n

.meas tran vdout0_20ck1440 FIND v(dout0_20) AT=725.025n

.meas tran vdout0_21ck1440 FIND v(dout0_21) AT=725.025n

.meas tran vdout0_22ck1440 FIND v(dout0_22) AT=725.025n

.meas tran vdout0_23ck1440 FIND v(dout0_23) AT=725.025n

.meas tran vdout0_0ck1450 FIND v(dout0_0) AT=730.025n

.meas tran vdout0_1ck1450 FIND v(dout0_1) AT=730.025n

.meas tran vdout0_2ck1450 FIND v(dout0_2) AT=730.025n

.meas tran vdout0_3ck1450 FIND v(dout0_3) AT=730.025n

.meas tran vdout0_4ck1450 FIND v(dout0_4) AT=730.025n

.meas tran vdout0_5ck1450 FIND v(dout0_5) AT=730.025n

.meas tran vdout0_6ck1450 FIND v(dout0_6) AT=730.025n

.meas tran vdout0_7ck1450 FIND v(dout0_7) AT=730.025n

.meas tran vdout0_8ck1450 FIND v(dout0_8) AT=730.025n

.meas tran vdout0_9ck1450 FIND v(dout0_9) AT=730.025n

.meas tran vdout0_10ck1450 FIND v(dout0_10) AT=730.025n

.meas tran vdout0_11ck1450 FIND v(dout0_11) AT=730.025n

.meas tran vdout0_12ck1450 FIND v(dout0_12) AT=730.025n

.meas tran vdout0_13ck1450 FIND v(dout0_13) AT=730.025n

.meas tran vdout0_14ck1450 FIND v(dout0_14) AT=730.025n

.meas tran vdout0_15ck1450 FIND v(dout0_15) AT=730.025n

.meas tran vdout0_16ck1450 FIND v(dout0_16) AT=730.025n

.meas tran vdout0_17ck1450 FIND v(dout0_17) AT=730.025n

.meas tran vdout0_18ck1450 FIND v(dout0_18) AT=730.025n

.meas tran vdout0_19ck1450 FIND v(dout0_19) AT=730.025n

.meas tran vdout0_20ck1450 FIND v(dout0_20) AT=730.025n

.meas tran vdout0_21ck1450 FIND v(dout0_21) AT=730.025n

.meas tran vdout0_22ck1450 FIND v(dout0_22) AT=730.025n

.meas tran vdout0_23ck1450 FIND v(dout0_23) AT=730.025n

.meas tran vdout0_0ck1470 FIND v(dout0_0) AT=740.025n

.meas tran vdout0_1ck1470 FIND v(dout0_1) AT=740.025n

.meas tran vdout0_2ck1470 FIND v(dout0_2) AT=740.025n

.meas tran vdout0_3ck1470 FIND v(dout0_3) AT=740.025n

.meas tran vdout0_4ck1470 FIND v(dout0_4) AT=740.025n

.meas tran vdout0_5ck1470 FIND v(dout0_5) AT=740.025n

.meas tran vdout0_6ck1470 FIND v(dout0_6) AT=740.025n

.meas tran vdout0_7ck1470 FIND v(dout0_7) AT=740.025n

.meas tran vdout0_8ck1470 FIND v(dout0_8) AT=740.025n

.meas tran vdout0_9ck1470 FIND v(dout0_9) AT=740.025n

.meas tran vdout0_10ck1470 FIND v(dout0_10) AT=740.025n

.meas tran vdout0_11ck1470 FIND v(dout0_11) AT=740.025n

.meas tran vdout0_12ck1470 FIND v(dout0_12) AT=740.025n

.meas tran vdout0_13ck1470 FIND v(dout0_13) AT=740.025n

.meas tran vdout0_14ck1470 FIND v(dout0_14) AT=740.025n

.meas tran vdout0_15ck1470 FIND v(dout0_15) AT=740.025n

.meas tran vdout0_16ck1470 FIND v(dout0_16) AT=740.025n

.meas tran vdout0_17ck1470 FIND v(dout0_17) AT=740.025n

.meas tran vdout0_18ck1470 FIND v(dout0_18) AT=740.025n

.meas tran vdout0_19ck1470 FIND v(dout0_19) AT=740.025n

.meas tran vdout0_20ck1470 FIND v(dout0_20) AT=740.025n

.meas tran vdout0_21ck1470 FIND v(dout0_21) AT=740.025n

.meas tran vdout0_22ck1470 FIND v(dout0_22) AT=740.025n

.meas tran vdout0_23ck1470 FIND v(dout0_23) AT=740.025n

.meas tran vdout1_0ck1490 FIND v(dout1_0) AT=750.025n

.meas tran vdout1_1ck1490 FIND v(dout1_1) AT=750.025n

.meas tran vdout1_2ck1490 FIND v(dout1_2) AT=750.025n

.meas tran vdout1_3ck1490 FIND v(dout1_3) AT=750.025n

.meas tran vdout1_4ck1490 FIND v(dout1_4) AT=750.025n

.meas tran vdout1_5ck1490 FIND v(dout1_5) AT=750.025n

.meas tran vdout1_6ck1490 FIND v(dout1_6) AT=750.025n

.meas tran vdout1_7ck1490 FIND v(dout1_7) AT=750.025n

.meas tran vdout1_8ck1490 FIND v(dout1_8) AT=750.025n

.meas tran vdout1_9ck1490 FIND v(dout1_9) AT=750.025n

.meas tran vdout1_10ck1490 FIND v(dout1_10) AT=750.025n

.meas tran vdout1_11ck1490 FIND v(dout1_11) AT=750.025n

.meas tran vdout1_12ck1490 FIND v(dout1_12) AT=750.025n

.meas tran vdout1_13ck1490 FIND v(dout1_13) AT=750.025n

.meas tran vdout1_14ck1490 FIND v(dout1_14) AT=750.025n

.meas tran vdout1_15ck1490 FIND v(dout1_15) AT=750.025n

.meas tran vdout1_16ck1490 FIND v(dout1_16) AT=750.025n

.meas tran vdout1_17ck1490 FIND v(dout1_17) AT=750.025n

.meas tran vdout1_18ck1490 FIND v(dout1_18) AT=750.025n

.meas tran vdout1_19ck1490 FIND v(dout1_19) AT=750.025n

.meas tran vdout1_20ck1490 FIND v(dout1_20) AT=750.025n

.meas tran vdout1_21ck1490 FIND v(dout1_21) AT=750.025n

.meas tran vdout1_22ck1490 FIND v(dout1_22) AT=750.025n

.meas tran vdout1_23ck1490 FIND v(dout1_23) AT=750.025n

.meas tran vdout1_0ck1500 FIND v(dout1_0) AT=755.025n

.meas tran vdout1_1ck1500 FIND v(dout1_1) AT=755.025n

.meas tran vdout1_2ck1500 FIND v(dout1_2) AT=755.025n

.meas tran vdout1_3ck1500 FIND v(dout1_3) AT=755.025n

.meas tran vdout1_4ck1500 FIND v(dout1_4) AT=755.025n

.meas tran vdout1_5ck1500 FIND v(dout1_5) AT=755.025n

.meas tran vdout1_6ck1500 FIND v(dout1_6) AT=755.025n

.meas tran vdout1_7ck1500 FIND v(dout1_7) AT=755.025n

.meas tran vdout1_8ck1500 FIND v(dout1_8) AT=755.025n

.meas tran vdout1_9ck1500 FIND v(dout1_9) AT=755.025n

.meas tran vdout1_10ck1500 FIND v(dout1_10) AT=755.025n

.meas tran vdout1_11ck1500 FIND v(dout1_11) AT=755.025n

.meas tran vdout1_12ck1500 FIND v(dout1_12) AT=755.025n

.meas tran vdout1_13ck1500 FIND v(dout1_13) AT=755.025n

.meas tran vdout1_14ck1500 FIND v(dout1_14) AT=755.025n

.meas tran vdout1_15ck1500 FIND v(dout1_15) AT=755.025n

.meas tran vdout1_16ck1500 FIND v(dout1_16) AT=755.025n

.meas tran vdout1_17ck1500 FIND v(dout1_17) AT=755.025n

.meas tran vdout1_18ck1500 FIND v(dout1_18) AT=755.025n

.meas tran vdout1_19ck1500 FIND v(dout1_19) AT=755.025n

.meas tran vdout1_20ck1500 FIND v(dout1_20) AT=755.025n

.meas tran vdout1_21ck1500 FIND v(dout1_21) AT=755.025n

.meas tran vdout1_22ck1500 FIND v(dout1_22) AT=755.025n

.meas tran vdout1_23ck1500 FIND v(dout1_23) AT=755.025n

.meas tran vdout0_0ck1510 FIND v(dout0_0) AT=760.025n

.meas tran vdout0_1ck1510 FIND v(dout0_1) AT=760.025n

.meas tran vdout0_2ck1510 FIND v(dout0_2) AT=760.025n

.meas tran vdout0_3ck1510 FIND v(dout0_3) AT=760.025n

.meas tran vdout0_4ck1510 FIND v(dout0_4) AT=760.025n

.meas tran vdout0_5ck1510 FIND v(dout0_5) AT=760.025n

.meas tran vdout0_6ck1510 FIND v(dout0_6) AT=760.025n

.meas tran vdout0_7ck1510 FIND v(dout0_7) AT=760.025n

.meas tran vdout0_8ck1510 FIND v(dout0_8) AT=760.025n

.meas tran vdout0_9ck1510 FIND v(dout0_9) AT=760.025n

.meas tran vdout0_10ck1510 FIND v(dout0_10) AT=760.025n

.meas tran vdout0_11ck1510 FIND v(dout0_11) AT=760.025n

.meas tran vdout0_12ck1510 FIND v(dout0_12) AT=760.025n

.meas tran vdout0_13ck1510 FIND v(dout0_13) AT=760.025n

.meas tran vdout0_14ck1510 FIND v(dout0_14) AT=760.025n

.meas tran vdout0_15ck1510 FIND v(dout0_15) AT=760.025n

.meas tran vdout0_16ck1510 FIND v(dout0_16) AT=760.025n

.meas tran vdout0_17ck1510 FIND v(dout0_17) AT=760.025n

.meas tran vdout0_18ck1510 FIND v(dout0_18) AT=760.025n

.meas tran vdout0_19ck1510 FIND v(dout0_19) AT=760.025n

.meas tran vdout0_20ck1510 FIND v(dout0_20) AT=760.025n

.meas tran vdout0_21ck1510 FIND v(dout0_21) AT=760.025n

.meas tran vdout0_22ck1510 FIND v(dout0_22) AT=760.025n

.meas tran vdout0_23ck1510 FIND v(dout0_23) AT=760.025n

.meas tran vdout1_0ck1510 FIND v(dout1_0) AT=760.025n

.meas tran vdout1_1ck1510 FIND v(dout1_1) AT=760.025n

.meas tran vdout1_2ck1510 FIND v(dout1_2) AT=760.025n

.meas tran vdout1_3ck1510 FIND v(dout1_3) AT=760.025n

.meas tran vdout1_4ck1510 FIND v(dout1_4) AT=760.025n

.meas tran vdout1_5ck1510 FIND v(dout1_5) AT=760.025n

.meas tran vdout1_6ck1510 FIND v(dout1_6) AT=760.025n

.meas tran vdout1_7ck1510 FIND v(dout1_7) AT=760.025n

.meas tran vdout1_8ck1510 FIND v(dout1_8) AT=760.025n

.meas tran vdout1_9ck1510 FIND v(dout1_9) AT=760.025n

.meas tran vdout1_10ck1510 FIND v(dout1_10) AT=760.025n

.meas tran vdout1_11ck1510 FIND v(dout1_11) AT=760.025n

.meas tran vdout1_12ck1510 FIND v(dout1_12) AT=760.025n

.meas tran vdout1_13ck1510 FIND v(dout1_13) AT=760.025n

.meas tran vdout1_14ck1510 FIND v(dout1_14) AT=760.025n

.meas tran vdout1_15ck1510 FIND v(dout1_15) AT=760.025n

.meas tran vdout1_16ck1510 FIND v(dout1_16) AT=760.025n

.meas tran vdout1_17ck1510 FIND v(dout1_17) AT=760.025n

.meas tran vdout1_18ck1510 FIND v(dout1_18) AT=760.025n

.meas tran vdout1_19ck1510 FIND v(dout1_19) AT=760.025n

.meas tran vdout1_20ck1510 FIND v(dout1_20) AT=760.025n

.meas tran vdout1_21ck1510 FIND v(dout1_21) AT=760.025n

.meas tran vdout1_22ck1510 FIND v(dout1_22) AT=760.025n

.meas tran vdout1_23ck1510 FIND v(dout1_23) AT=760.025n

.meas tran vdout0_0ck1530 FIND v(dout0_0) AT=770.025n

.meas tran vdout0_1ck1530 FIND v(dout0_1) AT=770.025n

.meas tran vdout0_2ck1530 FIND v(dout0_2) AT=770.025n

.meas tran vdout0_3ck1530 FIND v(dout0_3) AT=770.025n

.meas tran vdout0_4ck1530 FIND v(dout0_4) AT=770.025n

.meas tran vdout0_5ck1530 FIND v(dout0_5) AT=770.025n

.meas tran vdout0_6ck1530 FIND v(dout0_6) AT=770.025n

.meas tran vdout0_7ck1530 FIND v(dout0_7) AT=770.025n

.meas tran vdout0_8ck1530 FIND v(dout0_8) AT=770.025n

.meas tran vdout0_9ck1530 FIND v(dout0_9) AT=770.025n

.meas tran vdout0_10ck1530 FIND v(dout0_10) AT=770.025n

.meas tran vdout0_11ck1530 FIND v(dout0_11) AT=770.025n

.meas tran vdout0_12ck1530 FIND v(dout0_12) AT=770.025n

.meas tran vdout0_13ck1530 FIND v(dout0_13) AT=770.025n

.meas tran vdout0_14ck1530 FIND v(dout0_14) AT=770.025n

.meas tran vdout0_15ck1530 FIND v(dout0_15) AT=770.025n

.meas tran vdout0_16ck1530 FIND v(dout0_16) AT=770.025n

.meas tran vdout0_17ck1530 FIND v(dout0_17) AT=770.025n

.meas tran vdout0_18ck1530 FIND v(dout0_18) AT=770.025n

.meas tran vdout0_19ck1530 FIND v(dout0_19) AT=770.025n

.meas tran vdout0_20ck1530 FIND v(dout0_20) AT=770.025n

.meas tran vdout0_21ck1530 FIND v(dout0_21) AT=770.025n

.meas tran vdout0_22ck1530 FIND v(dout0_22) AT=770.025n

.meas tran vdout0_23ck1530 FIND v(dout0_23) AT=770.025n

.meas tran vdout0_0ck1550 FIND v(dout0_0) AT=780.025n

.meas tran vdout0_1ck1550 FIND v(dout0_1) AT=780.025n

.meas tran vdout0_2ck1550 FIND v(dout0_2) AT=780.025n

.meas tran vdout0_3ck1550 FIND v(dout0_3) AT=780.025n

.meas tran vdout0_4ck1550 FIND v(dout0_4) AT=780.025n

.meas tran vdout0_5ck1550 FIND v(dout0_5) AT=780.025n

.meas tran vdout0_6ck1550 FIND v(dout0_6) AT=780.025n

.meas tran vdout0_7ck1550 FIND v(dout0_7) AT=780.025n

.meas tran vdout0_8ck1550 FIND v(dout0_8) AT=780.025n

.meas tran vdout0_9ck1550 FIND v(dout0_9) AT=780.025n

.meas tran vdout0_10ck1550 FIND v(dout0_10) AT=780.025n

.meas tran vdout0_11ck1550 FIND v(dout0_11) AT=780.025n

.meas tran vdout0_12ck1550 FIND v(dout0_12) AT=780.025n

.meas tran vdout0_13ck1550 FIND v(dout0_13) AT=780.025n

.meas tran vdout0_14ck1550 FIND v(dout0_14) AT=780.025n

.meas tran vdout0_15ck1550 FIND v(dout0_15) AT=780.025n

.meas tran vdout0_16ck1550 FIND v(dout0_16) AT=780.025n

.meas tran vdout0_17ck1550 FIND v(dout0_17) AT=780.025n

.meas tran vdout0_18ck1550 FIND v(dout0_18) AT=780.025n

.meas tran vdout0_19ck1550 FIND v(dout0_19) AT=780.025n

.meas tran vdout0_20ck1550 FIND v(dout0_20) AT=780.025n

.meas tran vdout0_21ck1550 FIND v(dout0_21) AT=780.025n

.meas tran vdout0_22ck1550 FIND v(dout0_22) AT=780.025n

.meas tran vdout0_23ck1550 FIND v(dout0_23) AT=780.025n

.meas tran vdout0_0ck1580 FIND v(dout0_0) AT=795.025n

.meas tran vdout0_1ck1580 FIND v(dout0_1) AT=795.025n

.meas tran vdout0_2ck1580 FIND v(dout0_2) AT=795.025n

.meas tran vdout0_3ck1580 FIND v(dout0_3) AT=795.025n

.meas tran vdout0_4ck1580 FIND v(dout0_4) AT=795.025n

.meas tran vdout0_5ck1580 FIND v(dout0_5) AT=795.025n

.meas tran vdout0_6ck1580 FIND v(dout0_6) AT=795.025n

.meas tran vdout0_7ck1580 FIND v(dout0_7) AT=795.025n

.meas tran vdout0_8ck1580 FIND v(dout0_8) AT=795.025n

.meas tran vdout0_9ck1580 FIND v(dout0_9) AT=795.025n

.meas tran vdout0_10ck1580 FIND v(dout0_10) AT=795.025n

.meas tran vdout0_11ck1580 FIND v(dout0_11) AT=795.025n

.meas tran vdout0_12ck1580 FIND v(dout0_12) AT=795.025n

.meas tran vdout0_13ck1580 FIND v(dout0_13) AT=795.025n

.meas tran vdout0_14ck1580 FIND v(dout0_14) AT=795.025n

.meas tran vdout0_15ck1580 FIND v(dout0_15) AT=795.025n

.meas tran vdout0_16ck1580 FIND v(dout0_16) AT=795.025n

.meas tran vdout0_17ck1580 FIND v(dout0_17) AT=795.025n

.meas tran vdout0_18ck1580 FIND v(dout0_18) AT=795.025n

.meas tran vdout0_19ck1580 FIND v(dout0_19) AT=795.025n

.meas tran vdout0_20ck1580 FIND v(dout0_20) AT=795.025n

.meas tran vdout0_21ck1580 FIND v(dout0_21) AT=795.025n

.meas tran vdout0_22ck1580 FIND v(dout0_22) AT=795.025n

.meas tran vdout0_23ck1580 FIND v(dout0_23) AT=795.025n

.meas tran vdout0_0ck1600 FIND v(dout0_0) AT=805.025n

.meas tran vdout0_1ck1600 FIND v(dout0_1) AT=805.025n

.meas tran vdout0_2ck1600 FIND v(dout0_2) AT=805.025n

.meas tran vdout0_3ck1600 FIND v(dout0_3) AT=805.025n

.meas tran vdout0_4ck1600 FIND v(dout0_4) AT=805.025n

.meas tran vdout0_5ck1600 FIND v(dout0_5) AT=805.025n

.meas tran vdout0_6ck1600 FIND v(dout0_6) AT=805.025n

.meas tran vdout0_7ck1600 FIND v(dout0_7) AT=805.025n

.meas tran vdout0_8ck1600 FIND v(dout0_8) AT=805.025n

.meas tran vdout0_9ck1600 FIND v(dout0_9) AT=805.025n

.meas tran vdout0_10ck1600 FIND v(dout0_10) AT=805.025n

.meas tran vdout0_11ck1600 FIND v(dout0_11) AT=805.025n

.meas tran vdout0_12ck1600 FIND v(dout0_12) AT=805.025n

.meas tran vdout0_13ck1600 FIND v(dout0_13) AT=805.025n

.meas tran vdout0_14ck1600 FIND v(dout0_14) AT=805.025n

.meas tran vdout0_15ck1600 FIND v(dout0_15) AT=805.025n

.meas tran vdout0_16ck1600 FIND v(dout0_16) AT=805.025n

.meas tran vdout0_17ck1600 FIND v(dout0_17) AT=805.025n

.meas tran vdout0_18ck1600 FIND v(dout0_18) AT=805.025n

.meas tran vdout0_19ck1600 FIND v(dout0_19) AT=805.025n

.meas tran vdout0_20ck1600 FIND v(dout0_20) AT=805.025n

.meas tran vdout0_21ck1600 FIND v(dout0_21) AT=805.025n

.meas tran vdout0_22ck1600 FIND v(dout0_22) AT=805.025n

.meas tran vdout0_23ck1600 FIND v(dout0_23) AT=805.025n

.meas tran vdout0_0ck1610 FIND v(dout0_0) AT=810.025n

.meas tran vdout0_1ck1610 FIND v(dout0_1) AT=810.025n

.meas tran vdout0_2ck1610 FIND v(dout0_2) AT=810.025n

.meas tran vdout0_3ck1610 FIND v(dout0_3) AT=810.025n

.meas tran vdout0_4ck1610 FIND v(dout0_4) AT=810.025n

.meas tran vdout0_5ck1610 FIND v(dout0_5) AT=810.025n

.meas tran vdout0_6ck1610 FIND v(dout0_6) AT=810.025n

.meas tran vdout0_7ck1610 FIND v(dout0_7) AT=810.025n

.meas tran vdout0_8ck1610 FIND v(dout0_8) AT=810.025n

.meas tran vdout0_9ck1610 FIND v(dout0_9) AT=810.025n

.meas tran vdout0_10ck1610 FIND v(dout0_10) AT=810.025n

.meas tran vdout0_11ck1610 FIND v(dout0_11) AT=810.025n

.meas tran vdout0_12ck1610 FIND v(dout0_12) AT=810.025n

.meas tran vdout0_13ck1610 FIND v(dout0_13) AT=810.025n

.meas tran vdout0_14ck1610 FIND v(dout0_14) AT=810.025n

.meas tran vdout0_15ck1610 FIND v(dout0_15) AT=810.025n

.meas tran vdout0_16ck1610 FIND v(dout0_16) AT=810.025n

.meas tran vdout0_17ck1610 FIND v(dout0_17) AT=810.025n

.meas tran vdout0_18ck1610 FIND v(dout0_18) AT=810.025n

.meas tran vdout0_19ck1610 FIND v(dout0_19) AT=810.025n

.meas tran vdout0_20ck1610 FIND v(dout0_20) AT=810.025n

.meas tran vdout0_21ck1610 FIND v(dout0_21) AT=810.025n

.meas tran vdout0_22ck1610 FIND v(dout0_22) AT=810.025n

.meas tran vdout0_23ck1610 FIND v(dout0_23) AT=810.025n

.meas tran vdout1_0ck1610 FIND v(dout1_0) AT=810.025n

.meas tran vdout1_1ck1610 FIND v(dout1_1) AT=810.025n

.meas tran vdout1_2ck1610 FIND v(dout1_2) AT=810.025n

.meas tran vdout1_3ck1610 FIND v(dout1_3) AT=810.025n

.meas tran vdout1_4ck1610 FIND v(dout1_4) AT=810.025n

.meas tran vdout1_5ck1610 FIND v(dout1_5) AT=810.025n

.meas tran vdout1_6ck1610 FIND v(dout1_6) AT=810.025n

.meas tran vdout1_7ck1610 FIND v(dout1_7) AT=810.025n

.meas tran vdout1_8ck1610 FIND v(dout1_8) AT=810.025n

.meas tran vdout1_9ck1610 FIND v(dout1_9) AT=810.025n

.meas tran vdout1_10ck1610 FIND v(dout1_10) AT=810.025n

.meas tran vdout1_11ck1610 FIND v(dout1_11) AT=810.025n

.meas tran vdout1_12ck1610 FIND v(dout1_12) AT=810.025n

.meas tran vdout1_13ck1610 FIND v(dout1_13) AT=810.025n

.meas tran vdout1_14ck1610 FIND v(dout1_14) AT=810.025n

.meas tran vdout1_15ck1610 FIND v(dout1_15) AT=810.025n

.meas tran vdout1_16ck1610 FIND v(dout1_16) AT=810.025n

.meas tran vdout1_17ck1610 FIND v(dout1_17) AT=810.025n

.meas tran vdout1_18ck1610 FIND v(dout1_18) AT=810.025n

.meas tran vdout1_19ck1610 FIND v(dout1_19) AT=810.025n

.meas tran vdout1_20ck1610 FIND v(dout1_20) AT=810.025n

.meas tran vdout1_21ck1610 FIND v(dout1_21) AT=810.025n

.meas tran vdout1_22ck1610 FIND v(dout1_22) AT=810.025n

.meas tran vdout1_23ck1610 FIND v(dout1_23) AT=810.025n

.meas tran vdout0_0ck1620 FIND v(dout0_0) AT=815.025n

.meas tran vdout0_1ck1620 FIND v(dout0_1) AT=815.025n

.meas tran vdout0_2ck1620 FIND v(dout0_2) AT=815.025n

.meas tran vdout0_3ck1620 FIND v(dout0_3) AT=815.025n

.meas tran vdout0_4ck1620 FIND v(dout0_4) AT=815.025n

.meas tran vdout0_5ck1620 FIND v(dout0_5) AT=815.025n

.meas tran vdout0_6ck1620 FIND v(dout0_6) AT=815.025n

.meas tran vdout0_7ck1620 FIND v(dout0_7) AT=815.025n

.meas tran vdout0_8ck1620 FIND v(dout0_8) AT=815.025n

.meas tran vdout0_9ck1620 FIND v(dout0_9) AT=815.025n

.meas tran vdout0_10ck1620 FIND v(dout0_10) AT=815.025n

.meas tran vdout0_11ck1620 FIND v(dout0_11) AT=815.025n

.meas tran vdout0_12ck1620 FIND v(dout0_12) AT=815.025n

.meas tran vdout0_13ck1620 FIND v(dout0_13) AT=815.025n

.meas tran vdout0_14ck1620 FIND v(dout0_14) AT=815.025n

.meas tran vdout0_15ck1620 FIND v(dout0_15) AT=815.025n

.meas tran vdout0_16ck1620 FIND v(dout0_16) AT=815.025n

.meas tran vdout0_17ck1620 FIND v(dout0_17) AT=815.025n

.meas tran vdout0_18ck1620 FIND v(dout0_18) AT=815.025n

.meas tran vdout0_19ck1620 FIND v(dout0_19) AT=815.025n

.meas tran vdout0_20ck1620 FIND v(dout0_20) AT=815.025n

.meas tran vdout0_21ck1620 FIND v(dout0_21) AT=815.025n

.meas tran vdout0_22ck1620 FIND v(dout0_22) AT=815.025n

.meas tran vdout0_23ck1620 FIND v(dout0_23) AT=815.025n

.meas tran vdout1_0ck1620 FIND v(dout1_0) AT=815.025n

.meas tran vdout1_1ck1620 FIND v(dout1_1) AT=815.025n

.meas tran vdout1_2ck1620 FIND v(dout1_2) AT=815.025n

.meas tran vdout1_3ck1620 FIND v(dout1_3) AT=815.025n

.meas tran vdout1_4ck1620 FIND v(dout1_4) AT=815.025n

.meas tran vdout1_5ck1620 FIND v(dout1_5) AT=815.025n

.meas tran vdout1_6ck1620 FIND v(dout1_6) AT=815.025n

.meas tran vdout1_7ck1620 FIND v(dout1_7) AT=815.025n

.meas tran vdout1_8ck1620 FIND v(dout1_8) AT=815.025n

.meas tran vdout1_9ck1620 FIND v(dout1_9) AT=815.025n

.meas tran vdout1_10ck1620 FIND v(dout1_10) AT=815.025n

.meas tran vdout1_11ck1620 FIND v(dout1_11) AT=815.025n

.meas tran vdout1_12ck1620 FIND v(dout1_12) AT=815.025n

.meas tran vdout1_13ck1620 FIND v(dout1_13) AT=815.025n

.meas tran vdout1_14ck1620 FIND v(dout1_14) AT=815.025n

.meas tran vdout1_15ck1620 FIND v(dout1_15) AT=815.025n

.meas tran vdout1_16ck1620 FIND v(dout1_16) AT=815.025n

.meas tran vdout1_17ck1620 FIND v(dout1_17) AT=815.025n

.meas tran vdout1_18ck1620 FIND v(dout1_18) AT=815.025n

.meas tran vdout1_19ck1620 FIND v(dout1_19) AT=815.025n

.meas tran vdout1_20ck1620 FIND v(dout1_20) AT=815.025n

.meas tran vdout1_21ck1620 FIND v(dout1_21) AT=815.025n

.meas tran vdout1_22ck1620 FIND v(dout1_22) AT=815.025n

.meas tran vdout1_23ck1620 FIND v(dout1_23) AT=815.025n

.meas tran vdout0_0ck1630 FIND v(dout0_0) AT=820.025n

.meas tran vdout0_1ck1630 FIND v(dout0_1) AT=820.025n

.meas tran vdout0_2ck1630 FIND v(dout0_2) AT=820.025n

.meas tran vdout0_3ck1630 FIND v(dout0_3) AT=820.025n

.meas tran vdout0_4ck1630 FIND v(dout0_4) AT=820.025n

.meas tran vdout0_5ck1630 FIND v(dout0_5) AT=820.025n

.meas tran vdout0_6ck1630 FIND v(dout0_6) AT=820.025n

.meas tran vdout0_7ck1630 FIND v(dout0_7) AT=820.025n

.meas tran vdout0_8ck1630 FIND v(dout0_8) AT=820.025n

.meas tran vdout0_9ck1630 FIND v(dout0_9) AT=820.025n

.meas tran vdout0_10ck1630 FIND v(dout0_10) AT=820.025n

.meas tran vdout0_11ck1630 FIND v(dout0_11) AT=820.025n

.meas tran vdout0_12ck1630 FIND v(dout0_12) AT=820.025n

.meas tran vdout0_13ck1630 FIND v(dout0_13) AT=820.025n

.meas tran vdout0_14ck1630 FIND v(dout0_14) AT=820.025n

.meas tran vdout0_15ck1630 FIND v(dout0_15) AT=820.025n

.meas tran vdout0_16ck1630 FIND v(dout0_16) AT=820.025n

.meas tran vdout0_17ck1630 FIND v(dout0_17) AT=820.025n

.meas tran vdout0_18ck1630 FIND v(dout0_18) AT=820.025n

.meas tran vdout0_19ck1630 FIND v(dout0_19) AT=820.025n

.meas tran vdout0_20ck1630 FIND v(dout0_20) AT=820.025n

.meas tran vdout0_21ck1630 FIND v(dout0_21) AT=820.025n

.meas tran vdout0_22ck1630 FIND v(dout0_22) AT=820.025n

.meas tran vdout0_23ck1630 FIND v(dout0_23) AT=820.025n

.meas tran vdout1_0ck1640 FIND v(dout1_0) AT=825.025n

.meas tran vdout1_1ck1640 FIND v(dout1_1) AT=825.025n

.meas tran vdout1_2ck1640 FIND v(dout1_2) AT=825.025n

.meas tran vdout1_3ck1640 FIND v(dout1_3) AT=825.025n

.meas tran vdout1_4ck1640 FIND v(dout1_4) AT=825.025n

.meas tran vdout1_5ck1640 FIND v(dout1_5) AT=825.025n

.meas tran vdout1_6ck1640 FIND v(dout1_6) AT=825.025n

.meas tran vdout1_7ck1640 FIND v(dout1_7) AT=825.025n

.meas tran vdout1_8ck1640 FIND v(dout1_8) AT=825.025n

.meas tran vdout1_9ck1640 FIND v(dout1_9) AT=825.025n

.meas tran vdout1_10ck1640 FIND v(dout1_10) AT=825.025n

.meas tran vdout1_11ck1640 FIND v(dout1_11) AT=825.025n

.meas tran vdout1_12ck1640 FIND v(dout1_12) AT=825.025n

.meas tran vdout1_13ck1640 FIND v(dout1_13) AT=825.025n

.meas tran vdout1_14ck1640 FIND v(dout1_14) AT=825.025n

.meas tran vdout1_15ck1640 FIND v(dout1_15) AT=825.025n

.meas tran vdout1_16ck1640 FIND v(dout1_16) AT=825.025n

.meas tran vdout1_17ck1640 FIND v(dout1_17) AT=825.025n

.meas tran vdout1_18ck1640 FIND v(dout1_18) AT=825.025n

.meas tran vdout1_19ck1640 FIND v(dout1_19) AT=825.025n

.meas tran vdout1_20ck1640 FIND v(dout1_20) AT=825.025n

.meas tran vdout1_21ck1640 FIND v(dout1_21) AT=825.025n

.meas tran vdout1_22ck1640 FIND v(dout1_22) AT=825.025n

.meas tran vdout1_23ck1640 FIND v(dout1_23) AT=825.025n

.meas tran vdout0_0ck1650 FIND v(dout0_0) AT=830.025n

.meas tran vdout0_1ck1650 FIND v(dout0_1) AT=830.025n

.meas tran vdout0_2ck1650 FIND v(dout0_2) AT=830.025n

.meas tran vdout0_3ck1650 FIND v(dout0_3) AT=830.025n

.meas tran vdout0_4ck1650 FIND v(dout0_4) AT=830.025n

.meas tran vdout0_5ck1650 FIND v(dout0_5) AT=830.025n

.meas tran vdout0_6ck1650 FIND v(dout0_6) AT=830.025n

.meas tran vdout0_7ck1650 FIND v(dout0_7) AT=830.025n

.meas tran vdout0_8ck1650 FIND v(dout0_8) AT=830.025n

.meas tran vdout0_9ck1650 FIND v(dout0_9) AT=830.025n

.meas tran vdout0_10ck1650 FIND v(dout0_10) AT=830.025n

.meas tran vdout0_11ck1650 FIND v(dout0_11) AT=830.025n

.meas tran vdout0_12ck1650 FIND v(dout0_12) AT=830.025n

.meas tran vdout0_13ck1650 FIND v(dout0_13) AT=830.025n

.meas tran vdout0_14ck1650 FIND v(dout0_14) AT=830.025n

.meas tran vdout0_15ck1650 FIND v(dout0_15) AT=830.025n

.meas tran vdout0_16ck1650 FIND v(dout0_16) AT=830.025n

.meas tran vdout0_17ck1650 FIND v(dout0_17) AT=830.025n

.meas tran vdout0_18ck1650 FIND v(dout0_18) AT=830.025n

.meas tran vdout0_19ck1650 FIND v(dout0_19) AT=830.025n

.meas tran vdout0_20ck1650 FIND v(dout0_20) AT=830.025n

.meas tran vdout0_21ck1650 FIND v(dout0_21) AT=830.025n

.meas tran vdout0_22ck1650 FIND v(dout0_22) AT=830.025n

.meas tran vdout0_23ck1650 FIND v(dout0_23) AT=830.025n

.meas tran vdout1_0ck1680 FIND v(dout1_0) AT=845.025n

.meas tran vdout1_1ck1680 FIND v(dout1_1) AT=845.025n

.meas tran vdout1_2ck1680 FIND v(dout1_2) AT=845.025n

.meas tran vdout1_3ck1680 FIND v(dout1_3) AT=845.025n

.meas tran vdout1_4ck1680 FIND v(dout1_4) AT=845.025n

.meas tran vdout1_5ck1680 FIND v(dout1_5) AT=845.025n

.meas tran vdout1_6ck1680 FIND v(dout1_6) AT=845.025n

.meas tran vdout1_7ck1680 FIND v(dout1_7) AT=845.025n

.meas tran vdout1_8ck1680 FIND v(dout1_8) AT=845.025n

.meas tran vdout1_9ck1680 FIND v(dout1_9) AT=845.025n

.meas tran vdout1_10ck1680 FIND v(dout1_10) AT=845.025n

.meas tran vdout1_11ck1680 FIND v(dout1_11) AT=845.025n

.meas tran vdout1_12ck1680 FIND v(dout1_12) AT=845.025n

.meas tran vdout1_13ck1680 FIND v(dout1_13) AT=845.025n

.meas tran vdout1_14ck1680 FIND v(dout1_14) AT=845.025n

.meas tran vdout1_15ck1680 FIND v(dout1_15) AT=845.025n

.meas tran vdout1_16ck1680 FIND v(dout1_16) AT=845.025n

.meas tran vdout1_17ck1680 FIND v(dout1_17) AT=845.025n

.meas tran vdout1_18ck1680 FIND v(dout1_18) AT=845.025n

.meas tran vdout1_19ck1680 FIND v(dout1_19) AT=845.025n

.meas tran vdout1_20ck1680 FIND v(dout1_20) AT=845.025n

.meas tran vdout1_21ck1680 FIND v(dout1_21) AT=845.025n

.meas tran vdout1_22ck1680 FIND v(dout1_22) AT=845.025n

.meas tran vdout1_23ck1680 FIND v(dout1_23) AT=845.025n

.meas tran vdout1_0ck1690 FIND v(dout1_0) AT=850.025n

.meas tran vdout1_1ck1690 FIND v(dout1_1) AT=850.025n

.meas tran vdout1_2ck1690 FIND v(dout1_2) AT=850.025n

.meas tran vdout1_3ck1690 FIND v(dout1_3) AT=850.025n

.meas tran vdout1_4ck1690 FIND v(dout1_4) AT=850.025n

.meas tran vdout1_5ck1690 FIND v(dout1_5) AT=850.025n

.meas tran vdout1_6ck1690 FIND v(dout1_6) AT=850.025n

.meas tran vdout1_7ck1690 FIND v(dout1_7) AT=850.025n

.meas tran vdout1_8ck1690 FIND v(dout1_8) AT=850.025n

.meas tran vdout1_9ck1690 FIND v(dout1_9) AT=850.025n

.meas tran vdout1_10ck1690 FIND v(dout1_10) AT=850.025n

.meas tran vdout1_11ck1690 FIND v(dout1_11) AT=850.025n

.meas tran vdout1_12ck1690 FIND v(dout1_12) AT=850.025n

.meas tran vdout1_13ck1690 FIND v(dout1_13) AT=850.025n

.meas tran vdout1_14ck1690 FIND v(dout1_14) AT=850.025n

.meas tran vdout1_15ck1690 FIND v(dout1_15) AT=850.025n

.meas tran vdout1_16ck1690 FIND v(dout1_16) AT=850.025n

.meas tran vdout1_17ck1690 FIND v(dout1_17) AT=850.025n

.meas tran vdout1_18ck1690 FIND v(dout1_18) AT=850.025n

.meas tran vdout1_19ck1690 FIND v(dout1_19) AT=850.025n

.meas tran vdout1_20ck1690 FIND v(dout1_20) AT=850.025n

.meas tran vdout1_21ck1690 FIND v(dout1_21) AT=850.025n

.meas tran vdout1_22ck1690 FIND v(dout1_22) AT=850.025n

.meas tran vdout1_23ck1690 FIND v(dout1_23) AT=850.025n

.meas tran vdout1_0ck1700 FIND v(dout1_0) AT=855.025n

.meas tran vdout1_1ck1700 FIND v(dout1_1) AT=855.025n

.meas tran vdout1_2ck1700 FIND v(dout1_2) AT=855.025n

.meas tran vdout1_3ck1700 FIND v(dout1_3) AT=855.025n

.meas tran vdout1_4ck1700 FIND v(dout1_4) AT=855.025n

.meas tran vdout1_5ck1700 FIND v(dout1_5) AT=855.025n

.meas tran vdout1_6ck1700 FIND v(dout1_6) AT=855.025n

.meas tran vdout1_7ck1700 FIND v(dout1_7) AT=855.025n

.meas tran vdout1_8ck1700 FIND v(dout1_8) AT=855.025n

.meas tran vdout1_9ck1700 FIND v(dout1_9) AT=855.025n

.meas tran vdout1_10ck1700 FIND v(dout1_10) AT=855.025n

.meas tran vdout1_11ck1700 FIND v(dout1_11) AT=855.025n

.meas tran vdout1_12ck1700 FIND v(dout1_12) AT=855.025n

.meas tran vdout1_13ck1700 FIND v(dout1_13) AT=855.025n

.meas tran vdout1_14ck1700 FIND v(dout1_14) AT=855.025n

.meas tran vdout1_15ck1700 FIND v(dout1_15) AT=855.025n

.meas tran vdout1_16ck1700 FIND v(dout1_16) AT=855.025n

.meas tran vdout1_17ck1700 FIND v(dout1_17) AT=855.025n

.meas tran vdout1_18ck1700 FIND v(dout1_18) AT=855.025n

.meas tran vdout1_19ck1700 FIND v(dout1_19) AT=855.025n

.meas tran vdout1_20ck1700 FIND v(dout1_20) AT=855.025n

.meas tran vdout1_21ck1700 FIND v(dout1_21) AT=855.025n

.meas tran vdout1_22ck1700 FIND v(dout1_22) AT=855.025n

.meas tran vdout1_23ck1700 FIND v(dout1_23) AT=855.025n

.meas tran vdout0_0ck1710 FIND v(dout0_0) AT=860.025n

.meas tran vdout0_1ck1710 FIND v(dout0_1) AT=860.025n

.meas tran vdout0_2ck1710 FIND v(dout0_2) AT=860.025n

.meas tran vdout0_3ck1710 FIND v(dout0_3) AT=860.025n

.meas tran vdout0_4ck1710 FIND v(dout0_4) AT=860.025n

.meas tran vdout0_5ck1710 FIND v(dout0_5) AT=860.025n

.meas tran vdout0_6ck1710 FIND v(dout0_6) AT=860.025n

.meas tran vdout0_7ck1710 FIND v(dout0_7) AT=860.025n

.meas tran vdout0_8ck1710 FIND v(dout0_8) AT=860.025n

.meas tran vdout0_9ck1710 FIND v(dout0_9) AT=860.025n

.meas tran vdout0_10ck1710 FIND v(dout0_10) AT=860.025n

.meas tran vdout0_11ck1710 FIND v(dout0_11) AT=860.025n

.meas tran vdout0_12ck1710 FIND v(dout0_12) AT=860.025n

.meas tran vdout0_13ck1710 FIND v(dout0_13) AT=860.025n

.meas tran vdout0_14ck1710 FIND v(dout0_14) AT=860.025n

.meas tran vdout0_15ck1710 FIND v(dout0_15) AT=860.025n

.meas tran vdout0_16ck1710 FIND v(dout0_16) AT=860.025n

.meas tran vdout0_17ck1710 FIND v(dout0_17) AT=860.025n

.meas tran vdout0_18ck1710 FIND v(dout0_18) AT=860.025n

.meas tran vdout0_19ck1710 FIND v(dout0_19) AT=860.025n

.meas tran vdout0_20ck1710 FIND v(dout0_20) AT=860.025n

.meas tran vdout0_21ck1710 FIND v(dout0_21) AT=860.025n

.meas tran vdout0_22ck1710 FIND v(dout0_22) AT=860.025n

.meas tran vdout0_23ck1710 FIND v(dout0_23) AT=860.025n

.meas tran vdout0_0ck1720 FIND v(dout0_0) AT=865.025n

.meas tran vdout0_1ck1720 FIND v(dout0_1) AT=865.025n

.meas tran vdout0_2ck1720 FIND v(dout0_2) AT=865.025n

.meas tran vdout0_3ck1720 FIND v(dout0_3) AT=865.025n

.meas tran vdout0_4ck1720 FIND v(dout0_4) AT=865.025n

.meas tran vdout0_5ck1720 FIND v(dout0_5) AT=865.025n

.meas tran vdout0_6ck1720 FIND v(dout0_6) AT=865.025n

.meas tran vdout0_7ck1720 FIND v(dout0_7) AT=865.025n

.meas tran vdout0_8ck1720 FIND v(dout0_8) AT=865.025n

.meas tran vdout0_9ck1720 FIND v(dout0_9) AT=865.025n

.meas tran vdout0_10ck1720 FIND v(dout0_10) AT=865.025n

.meas tran vdout0_11ck1720 FIND v(dout0_11) AT=865.025n

.meas tran vdout0_12ck1720 FIND v(dout0_12) AT=865.025n

.meas tran vdout0_13ck1720 FIND v(dout0_13) AT=865.025n

.meas tran vdout0_14ck1720 FIND v(dout0_14) AT=865.025n

.meas tran vdout0_15ck1720 FIND v(dout0_15) AT=865.025n

.meas tran vdout0_16ck1720 FIND v(dout0_16) AT=865.025n

.meas tran vdout0_17ck1720 FIND v(dout0_17) AT=865.025n

.meas tran vdout0_18ck1720 FIND v(dout0_18) AT=865.025n

.meas tran vdout0_19ck1720 FIND v(dout0_19) AT=865.025n

.meas tran vdout0_20ck1720 FIND v(dout0_20) AT=865.025n

.meas tran vdout0_21ck1720 FIND v(dout0_21) AT=865.025n

.meas tran vdout0_22ck1720 FIND v(dout0_22) AT=865.025n

.meas tran vdout0_23ck1720 FIND v(dout0_23) AT=865.025n

.meas tran vdout0_0ck1730 FIND v(dout0_0) AT=870.025n

.meas tran vdout0_1ck1730 FIND v(dout0_1) AT=870.025n

.meas tran vdout0_2ck1730 FIND v(dout0_2) AT=870.025n

.meas tran vdout0_3ck1730 FIND v(dout0_3) AT=870.025n

.meas tran vdout0_4ck1730 FIND v(dout0_4) AT=870.025n

.meas tran vdout0_5ck1730 FIND v(dout0_5) AT=870.025n

.meas tran vdout0_6ck1730 FIND v(dout0_6) AT=870.025n

.meas tran vdout0_7ck1730 FIND v(dout0_7) AT=870.025n

.meas tran vdout0_8ck1730 FIND v(dout0_8) AT=870.025n

.meas tran vdout0_9ck1730 FIND v(dout0_9) AT=870.025n

.meas tran vdout0_10ck1730 FIND v(dout0_10) AT=870.025n

.meas tran vdout0_11ck1730 FIND v(dout0_11) AT=870.025n

.meas tran vdout0_12ck1730 FIND v(dout0_12) AT=870.025n

.meas tran vdout0_13ck1730 FIND v(dout0_13) AT=870.025n

.meas tran vdout0_14ck1730 FIND v(dout0_14) AT=870.025n

.meas tran vdout0_15ck1730 FIND v(dout0_15) AT=870.025n

.meas tran vdout0_16ck1730 FIND v(dout0_16) AT=870.025n

.meas tran vdout0_17ck1730 FIND v(dout0_17) AT=870.025n

.meas tran vdout0_18ck1730 FIND v(dout0_18) AT=870.025n

.meas tran vdout0_19ck1730 FIND v(dout0_19) AT=870.025n

.meas tran vdout0_20ck1730 FIND v(dout0_20) AT=870.025n

.meas tran vdout0_21ck1730 FIND v(dout0_21) AT=870.025n

.meas tran vdout0_22ck1730 FIND v(dout0_22) AT=870.025n

.meas tran vdout0_23ck1730 FIND v(dout0_23) AT=870.025n

.meas tran vdout1_0ck1730 FIND v(dout1_0) AT=870.025n

.meas tran vdout1_1ck1730 FIND v(dout1_1) AT=870.025n

.meas tran vdout1_2ck1730 FIND v(dout1_2) AT=870.025n

.meas tran vdout1_3ck1730 FIND v(dout1_3) AT=870.025n

.meas tran vdout1_4ck1730 FIND v(dout1_4) AT=870.025n

.meas tran vdout1_5ck1730 FIND v(dout1_5) AT=870.025n

.meas tran vdout1_6ck1730 FIND v(dout1_6) AT=870.025n

.meas tran vdout1_7ck1730 FIND v(dout1_7) AT=870.025n

.meas tran vdout1_8ck1730 FIND v(dout1_8) AT=870.025n

.meas tran vdout1_9ck1730 FIND v(dout1_9) AT=870.025n

.meas tran vdout1_10ck1730 FIND v(dout1_10) AT=870.025n

.meas tran vdout1_11ck1730 FIND v(dout1_11) AT=870.025n

.meas tran vdout1_12ck1730 FIND v(dout1_12) AT=870.025n

.meas tran vdout1_13ck1730 FIND v(dout1_13) AT=870.025n

.meas tran vdout1_14ck1730 FIND v(dout1_14) AT=870.025n

.meas tran vdout1_15ck1730 FIND v(dout1_15) AT=870.025n

.meas tran vdout1_16ck1730 FIND v(dout1_16) AT=870.025n

.meas tran vdout1_17ck1730 FIND v(dout1_17) AT=870.025n

.meas tran vdout1_18ck1730 FIND v(dout1_18) AT=870.025n

.meas tran vdout1_19ck1730 FIND v(dout1_19) AT=870.025n

.meas tran vdout1_20ck1730 FIND v(dout1_20) AT=870.025n

.meas tran vdout1_21ck1730 FIND v(dout1_21) AT=870.025n

.meas tran vdout1_22ck1730 FIND v(dout1_22) AT=870.025n

.meas tran vdout1_23ck1730 FIND v(dout1_23) AT=870.025n

.meas tran vdout0_0ck1740 FIND v(dout0_0) AT=875.025n

.meas tran vdout0_1ck1740 FIND v(dout0_1) AT=875.025n

.meas tran vdout0_2ck1740 FIND v(dout0_2) AT=875.025n

.meas tran vdout0_3ck1740 FIND v(dout0_3) AT=875.025n

.meas tran vdout0_4ck1740 FIND v(dout0_4) AT=875.025n

.meas tran vdout0_5ck1740 FIND v(dout0_5) AT=875.025n

.meas tran vdout0_6ck1740 FIND v(dout0_6) AT=875.025n

.meas tran vdout0_7ck1740 FIND v(dout0_7) AT=875.025n

.meas tran vdout0_8ck1740 FIND v(dout0_8) AT=875.025n

.meas tran vdout0_9ck1740 FIND v(dout0_9) AT=875.025n

.meas tran vdout0_10ck1740 FIND v(dout0_10) AT=875.025n

.meas tran vdout0_11ck1740 FIND v(dout0_11) AT=875.025n

.meas tran vdout0_12ck1740 FIND v(dout0_12) AT=875.025n

.meas tran vdout0_13ck1740 FIND v(dout0_13) AT=875.025n

.meas tran vdout0_14ck1740 FIND v(dout0_14) AT=875.025n

.meas tran vdout0_15ck1740 FIND v(dout0_15) AT=875.025n

.meas tran vdout0_16ck1740 FIND v(dout0_16) AT=875.025n

.meas tran vdout0_17ck1740 FIND v(dout0_17) AT=875.025n

.meas tran vdout0_18ck1740 FIND v(dout0_18) AT=875.025n

.meas tran vdout0_19ck1740 FIND v(dout0_19) AT=875.025n

.meas tran vdout0_20ck1740 FIND v(dout0_20) AT=875.025n

.meas tran vdout0_21ck1740 FIND v(dout0_21) AT=875.025n

.meas tran vdout0_22ck1740 FIND v(dout0_22) AT=875.025n

.meas tran vdout0_23ck1740 FIND v(dout0_23) AT=875.025n

.meas tran vdout1_0ck1740 FIND v(dout1_0) AT=875.025n

.meas tran vdout1_1ck1740 FIND v(dout1_1) AT=875.025n

.meas tran vdout1_2ck1740 FIND v(dout1_2) AT=875.025n

.meas tran vdout1_3ck1740 FIND v(dout1_3) AT=875.025n

.meas tran vdout1_4ck1740 FIND v(dout1_4) AT=875.025n

.meas tran vdout1_5ck1740 FIND v(dout1_5) AT=875.025n

.meas tran vdout1_6ck1740 FIND v(dout1_6) AT=875.025n

.meas tran vdout1_7ck1740 FIND v(dout1_7) AT=875.025n

.meas tran vdout1_8ck1740 FIND v(dout1_8) AT=875.025n

.meas tran vdout1_9ck1740 FIND v(dout1_9) AT=875.025n

.meas tran vdout1_10ck1740 FIND v(dout1_10) AT=875.025n

.meas tran vdout1_11ck1740 FIND v(dout1_11) AT=875.025n

.meas tran vdout1_12ck1740 FIND v(dout1_12) AT=875.025n

.meas tran vdout1_13ck1740 FIND v(dout1_13) AT=875.025n

.meas tran vdout1_14ck1740 FIND v(dout1_14) AT=875.025n

.meas tran vdout1_15ck1740 FIND v(dout1_15) AT=875.025n

.meas tran vdout1_16ck1740 FIND v(dout1_16) AT=875.025n

.meas tran vdout1_17ck1740 FIND v(dout1_17) AT=875.025n

.meas tran vdout1_18ck1740 FIND v(dout1_18) AT=875.025n

.meas tran vdout1_19ck1740 FIND v(dout1_19) AT=875.025n

.meas tran vdout1_20ck1740 FIND v(dout1_20) AT=875.025n

.meas tran vdout1_21ck1740 FIND v(dout1_21) AT=875.025n

.meas tran vdout1_22ck1740 FIND v(dout1_22) AT=875.025n

.meas tran vdout1_23ck1740 FIND v(dout1_23) AT=875.025n

.meas tran vdout0_0ck1750 FIND v(dout0_0) AT=880.025n

.meas tran vdout0_1ck1750 FIND v(dout0_1) AT=880.025n

.meas tran vdout0_2ck1750 FIND v(dout0_2) AT=880.025n

.meas tran vdout0_3ck1750 FIND v(dout0_3) AT=880.025n

.meas tran vdout0_4ck1750 FIND v(dout0_4) AT=880.025n

.meas tran vdout0_5ck1750 FIND v(dout0_5) AT=880.025n

.meas tran vdout0_6ck1750 FIND v(dout0_6) AT=880.025n

.meas tran vdout0_7ck1750 FIND v(dout0_7) AT=880.025n

.meas tran vdout0_8ck1750 FIND v(dout0_8) AT=880.025n

.meas tran vdout0_9ck1750 FIND v(dout0_9) AT=880.025n

.meas tran vdout0_10ck1750 FIND v(dout0_10) AT=880.025n

.meas tran vdout0_11ck1750 FIND v(dout0_11) AT=880.025n

.meas tran vdout0_12ck1750 FIND v(dout0_12) AT=880.025n

.meas tran vdout0_13ck1750 FIND v(dout0_13) AT=880.025n

.meas tran vdout0_14ck1750 FIND v(dout0_14) AT=880.025n

.meas tran vdout0_15ck1750 FIND v(dout0_15) AT=880.025n

.meas tran vdout0_16ck1750 FIND v(dout0_16) AT=880.025n

.meas tran vdout0_17ck1750 FIND v(dout0_17) AT=880.025n

.meas tran vdout0_18ck1750 FIND v(dout0_18) AT=880.025n

.meas tran vdout0_19ck1750 FIND v(dout0_19) AT=880.025n

.meas tran vdout0_20ck1750 FIND v(dout0_20) AT=880.025n

.meas tran vdout0_21ck1750 FIND v(dout0_21) AT=880.025n

.meas tran vdout0_22ck1750 FIND v(dout0_22) AT=880.025n

.meas tran vdout0_23ck1750 FIND v(dout0_23) AT=880.025n

.meas tran vdout1_0ck1750 FIND v(dout1_0) AT=880.025n

.meas tran vdout1_1ck1750 FIND v(dout1_1) AT=880.025n

.meas tran vdout1_2ck1750 FIND v(dout1_2) AT=880.025n

.meas tran vdout1_3ck1750 FIND v(dout1_3) AT=880.025n

.meas tran vdout1_4ck1750 FIND v(dout1_4) AT=880.025n

.meas tran vdout1_5ck1750 FIND v(dout1_5) AT=880.025n

.meas tran vdout1_6ck1750 FIND v(dout1_6) AT=880.025n

.meas tran vdout1_7ck1750 FIND v(dout1_7) AT=880.025n

.meas tran vdout1_8ck1750 FIND v(dout1_8) AT=880.025n

.meas tran vdout1_9ck1750 FIND v(dout1_9) AT=880.025n

.meas tran vdout1_10ck1750 FIND v(dout1_10) AT=880.025n

.meas tran vdout1_11ck1750 FIND v(dout1_11) AT=880.025n

.meas tran vdout1_12ck1750 FIND v(dout1_12) AT=880.025n

.meas tran vdout1_13ck1750 FIND v(dout1_13) AT=880.025n

.meas tran vdout1_14ck1750 FIND v(dout1_14) AT=880.025n

.meas tran vdout1_15ck1750 FIND v(dout1_15) AT=880.025n

.meas tran vdout1_16ck1750 FIND v(dout1_16) AT=880.025n

.meas tran vdout1_17ck1750 FIND v(dout1_17) AT=880.025n

.meas tran vdout1_18ck1750 FIND v(dout1_18) AT=880.025n

.meas tran vdout1_19ck1750 FIND v(dout1_19) AT=880.025n

.meas tran vdout1_20ck1750 FIND v(dout1_20) AT=880.025n

.meas tran vdout1_21ck1750 FIND v(dout1_21) AT=880.025n

.meas tran vdout1_22ck1750 FIND v(dout1_22) AT=880.025n

.meas tran vdout1_23ck1750 FIND v(dout1_23) AT=880.025n

.meas tran vdout0_0ck1760 FIND v(dout0_0) AT=885.025n

.meas tran vdout0_1ck1760 FIND v(dout0_1) AT=885.025n

.meas tran vdout0_2ck1760 FIND v(dout0_2) AT=885.025n

.meas tran vdout0_3ck1760 FIND v(dout0_3) AT=885.025n

.meas tran vdout0_4ck1760 FIND v(dout0_4) AT=885.025n

.meas tran vdout0_5ck1760 FIND v(dout0_5) AT=885.025n

.meas tran vdout0_6ck1760 FIND v(dout0_6) AT=885.025n

.meas tran vdout0_7ck1760 FIND v(dout0_7) AT=885.025n

.meas tran vdout0_8ck1760 FIND v(dout0_8) AT=885.025n

.meas tran vdout0_9ck1760 FIND v(dout0_9) AT=885.025n

.meas tran vdout0_10ck1760 FIND v(dout0_10) AT=885.025n

.meas tran vdout0_11ck1760 FIND v(dout0_11) AT=885.025n

.meas tran vdout0_12ck1760 FIND v(dout0_12) AT=885.025n

.meas tran vdout0_13ck1760 FIND v(dout0_13) AT=885.025n

.meas tran vdout0_14ck1760 FIND v(dout0_14) AT=885.025n

.meas tran vdout0_15ck1760 FIND v(dout0_15) AT=885.025n

.meas tran vdout0_16ck1760 FIND v(dout0_16) AT=885.025n

.meas tran vdout0_17ck1760 FIND v(dout0_17) AT=885.025n

.meas tran vdout0_18ck1760 FIND v(dout0_18) AT=885.025n

.meas tran vdout0_19ck1760 FIND v(dout0_19) AT=885.025n

.meas tran vdout0_20ck1760 FIND v(dout0_20) AT=885.025n

.meas tran vdout0_21ck1760 FIND v(dout0_21) AT=885.025n

.meas tran vdout0_22ck1760 FIND v(dout0_22) AT=885.025n

.meas tran vdout0_23ck1760 FIND v(dout0_23) AT=885.025n

.meas tran vdout1_0ck1760 FIND v(dout1_0) AT=885.025n

.meas tran vdout1_1ck1760 FIND v(dout1_1) AT=885.025n

.meas tran vdout1_2ck1760 FIND v(dout1_2) AT=885.025n

.meas tran vdout1_3ck1760 FIND v(dout1_3) AT=885.025n

.meas tran vdout1_4ck1760 FIND v(dout1_4) AT=885.025n

.meas tran vdout1_5ck1760 FIND v(dout1_5) AT=885.025n

.meas tran vdout1_6ck1760 FIND v(dout1_6) AT=885.025n

.meas tran vdout1_7ck1760 FIND v(dout1_7) AT=885.025n

.meas tran vdout1_8ck1760 FIND v(dout1_8) AT=885.025n

.meas tran vdout1_9ck1760 FIND v(dout1_9) AT=885.025n

.meas tran vdout1_10ck1760 FIND v(dout1_10) AT=885.025n

.meas tran vdout1_11ck1760 FIND v(dout1_11) AT=885.025n

.meas tran vdout1_12ck1760 FIND v(dout1_12) AT=885.025n

.meas tran vdout1_13ck1760 FIND v(dout1_13) AT=885.025n

.meas tran vdout1_14ck1760 FIND v(dout1_14) AT=885.025n

.meas tran vdout1_15ck1760 FIND v(dout1_15) AT=885.025n

.meas tran vdout1_16ck1760 FIND v(dout1_16) AT=885.025n

.meas tran vdout1_17ck1760 FIND v(dout1_17) AT=885.025n

.meas tran vdout1_18ck1760 FIND v(dout1_18) AT=885.025n

.meas tran vdout1_19ck1760 FIND v(dout1_19) AT=885.025n

.meas tran vdout1_20ck1760 FIND v(dout1_20) AT=885.025n

.meas tran vdout1_21ck1760 FIND v(dout1_21) AT=885.025n

.meas tran vdout1_22ck1760 FIND v(dout1_22) AT=885.025n

.meas tran vdout1_23ck1760 FIND v(dout1_23) AT=885.025n

.meas tran vdout0_0ck1770 FIND v(dout0_0) AT=890.025n

.meas tran vdout0_1ck1770 FIND v(dout0_1) AT=890.025n

.meas tran vdout0_2ck1770 FIND v(dout0_2) AT=890.025n

.meas tran vdout0_3ck1770 FIND v(dout0_3) AT=890.025n

.meas tran vdout0_4ck1770 FIND v(dout0_4) AT=890.025n

.meas tran vdout0_5ck1770 FIND v(dout0_5) AT=890.025n

.meas tran vdout0_6ck1770 FIND v(dout0_6) AT=890.025n

.meas tran vdout0_7ck1770 FIND v(dout0_7) AT=890.025n

.meas tran vdout0_8ck1770 FIND v(dout0_8) AT=890.025n

.meas tran vdout0_9ck1770 FIND v(dout0_9) AT=890.025n

.meas tran vdout0_10ck1770 FIND v(dout0_10) AT=890.025n

.meas tran vdout0_11ck1770 FIND v(dout0_11) AT=890.025n

.meas tran vdout0_12ck1770 FIND v(dout0_12) AT=890.025n

.meas tran vdout0_13ck1770 FIND v(dout0_13) AT=890.025n

.meas tran vdout0_14ck1770 FIND v(dout0_14) AT=890.025n

.meas tran vdout0_15ck1770 FIND v(dout0_15) AT=890.025n

.meas tran vdout0_16ck1770 FIND v(dout0_16) AT=890.025n

.meas tran vdout0_17ck1770 FIND v(dout0_17) AT=890.025n

.meas tran vdout0_18ck1770 FIND v(dout0_18) AT=890.025n

.meas tran vdout0_19ck1770 FIND v(dout0_19) AT=890.025n

.meas tran vdout0_20ck1770 FIND v(dout0_20) AT=890.025n

.meas tran vdout0_21ck1770 FIND v(dout0_21) AT=890.025n

.meas tran vdout0_22ck1770 FIND v(dout0_22) AT=890.025n

.meas tran vdout0_23ck1770 FIND v(dout0_23) AT=890.025n

.meas tran vdout1_0ck1790 FIND v(dout1_0) AT=900.025n

.meas tran vdout1_1ck1790 FIND v(dout1_1) AT=900.025n

.meas tran vdout1_2ck1790 FIND v(dout1_2) AT=900.025n

.meas tran vdout1_3ck1790 FIND v(dout1_3) AT=900.025n

.meas tran vdout1_4ck1790 FIND v(dout1_4) AT=900.025n

.meas tran vdout1_5ck1790 FIND v(dout1_5) AT=900.025n

.meas tran vdout1_6ck1790 FIND v(dout1_6) AT=900.025n

.meas tran vdout1_7ck1790 FIND v(dout1_7) AT=900.025n

.meas tran vdout1_8ck1790 FIND v(dout1_8) AT=900.025n

.meas tran vdout1_9ck1790 FIND v(dout1_9) AT=900.025n

.meas tran vdout1_10ck1790 FIND v(dout1_10) AT=900.025n

.meas tran vdout1_11ck1790 FIND v(dout1_11) AT=900.025n

.meas tran vdout1_12ck1790 FIND v(dout1_12) AT=900.025n

.meas tran vdout1_13ck1790 FIND v(dout1_13) AT=900.025n

.meas tran vdout1_14ck1790 FIND v(dout1_14) AT=900.025n

.meas tran vdout1_15ck1790 FIND v(dout1_15) AT=900.025n

.meas tran vdout1_16ck1790 FIND v(dout1_16) AT=900.025n

.meas tran vdout1_17ck1790 FIND v(dout1_17) AT=900.025n

.meas tran vdout1_18ck1790 FIND v(dout1_18) AT=900.025n

.meas tran vdout1_19ck1790 FIND v(dout1_19) AT=900.025n

.meas tran vdout1_20ck1790 FIND v(dout1_20) AT=900.025n

.meas tran vdout1_21ck1790 FIND v(dout1_21) AT=900.025n

.meas tran vdout1_22ck1790 FIND v(dout1_22) AT=900.025n

.meas tran vdout1_23ck1790 FIND v(dout1_23) AT=900.025n

.meas tran vdout0_0ck1800 FIND v(dout0_0) AT=905.025n

.meas tran vdout0_1ck1800 FIND v(dout0_1) AT=905.025n

.meas tran vdout0_2ck1800 FIND v(dout0_2) AT=905.025n

.meas tran vdout0_3ck1800 FIND v(dout0_3) AT=905.025n

.meas tran vdout0_4ck1800 FIND v(dout0_4) AT=905.025n

.meas tran vdout0_5ck1800 FIND v(dout0_5) AT=905.025n

.meas tran vdout0_6ck1800 FIND v(dout0_6) AT=905.025n

.meas tran vdout0_7ck1800 FIND v(dout0_7) AT=905.025n

.meas tran vdout0_8ck1800 FIND v(dout0_8) AT=905.025n

.meas tran vdout0_9ck1800 FIND v(dout0_9) AT=905.025n

.meas tran vdout0_10ck1800 FIND v(dout0_10) AT=905.025n

.meas tran vdout0_11ck1800 FIND v(dout0_11) AT=905.025n

.meas tran vdout0_12ck1800 FIND v(dout0_12) AT=905.025n

.meas tran vdout0_13ck1800 FIND v(dout0_13) AT=905.025n

.meas tran vdout0_14ck1800 FIND v(dout0_14) AT=905.025n

.meas tran vdout0_15ck1800 FIND v(dout0_15) AT=905.025n

.meas tran vdout0_16ck1800 FIND v(dout0_16) AT=905.025n

.meas tran vdout0_17ck1800 FIND v(dout0_17) AT=905.025n

.meas tran vdout0_18ck1800 FIND v(dout0_18) AT=905.025n

.meas tran vdout0_19ck1800 FIND v(dout0_19) AT=905.025n

.meas tran vdout0_20ck1800 FIND v(dout0_20) AT=905.025n

.meas tran vdout0_21ck1800 FIND v(dout0_21) AT=905.025n

.meas tran vdout0_22ck1800 FIND v(dout0_22) AT=905.025n

.meas tran vdout0_23ck1800 FIND v(dout0_23) AT=905.025n

.meas tran vdout1_0ck1810 FIND v(dout1_0) AT=910.025n

.meas tran vdout1_1ck1810 FIND v(dout1_1) AT=910.025n

.meas tran vdout1_2ck1810 FIND v(dout1_2) AT=910.025n

.meas tran vdout1_3ck1810 FIND v(dout1_3) AT=910.025n

.meas tran vdout1_4ck1810 FIND v(dout1_4) AT=910.025n

.meas tran vdout1_5ck1810 FIND v(dout1_5) AT=910.025n

.meas tran vdout1_6ck1810 FIND v(dout1_6) AT=910.025n

.meas tran vdout1_7ck1810 FIND v(dout1_7) AT=910.025n

.meas tran vdout1_8ck1810 FIND v(dout1_8) AT=910.025n

.meas tran vdout1_9ck1810 FIND v(dout1_9) AT=910.025n

.meas tran vdout1_10ck1810 FIND v(dout1_10) AT=910.025n

.meas tran vdout1_11ck1810 FIND v(dout1_11) AT=910.025n

.meas tran vdout1_12ck1810 FIND v(dout1_12) AT=910.025n

.meas tran vdout1_13ck1810 FIND v(dout1_13) AT=910.025n

.meas tran vdout1_14ck1810 FIND v(dout1_14) AT=910.025n

.meas tran vdout1_15ck1810 FIND v(dout1_15) AT=910.025n

.meas tran vdout1_16ck1810 FIND v(dout1_16) AT=910.025n

.meas tran vdout1_17ck1810 FIND v(dout1_17) AT=910.025n

.meas tran vdout1_18ck1810 FIND v(dout1_18) AT=910.025n

.meas tran vdout1_19ck1810 FIND v(dout1_19) AT=910.025n

.meas tran vdout1_20ck1810 FIND v(dout1_20) AT=910.025n

.meas tran vdout1_21ck1810 FIND v(dout1_21) AT=910.025n

.meas tran vdout1_22ck1810 FIND v(dout1_22) AT=910.025n

.meas tran vdout1_23ck1810 FIND v(dout1_23) AT=910.025n

.meas tran vdout1_0ck1820 FIND v(dout1_0) AT=915.025n

.meas tran vdout1_1ck1820 FIND v(dout1_1) AT=915.025n

.meas tran vdout1_2ck1820 FIND v(dout1_2) AT=915.025n

.meas tran vdout1_3ck1820 FIND v(dout1_3) AT=915.025n

.meas tran vdout1_4ck1820 FIND v(dout1_4) AT=915.025n

.meas tran vdout1_5ck1820 FIND v(dout1_5) AT=915.025n

.meas tran vdout1_6ck1820 FIND v(dout1_6) AT=915.025n

.meas tran vdout1_7ck1820 FIND v(dout1_7) AT=915.025n

.meas tran vdout1_8ck1820 FIND v(dout1_8) AT=915.025n

.meas tran vdout1_9ck1820 FIND v(dout1_9) AT=915.025n

.meas tran vdout1_10ck1820 FIND v(dout1_10) AT=915.025n

.meas tran vdout1_11ck1820 FIND v(dout1_11) AT=915.025n

.meas tran vdout1_12ck1820 FIND v(dout1_12) AT=915.025n

.meas tran vdout1_13ck1820 FIND v(dout1_13) AT=915.025n

.meas tran vdout1_14ck1820 FIND v(dout1_14) AT=915.025n

.meas tran vdout1_15ck1820 FIND v(dout1_15) AT=915.025n

.meas tran vdout1_16ck1820 FIND v(dout1_16) AT=915.025n

.meas tran vdout1_17ck1820 FIND v(dout1_17) AT=915.025n

.meas tran vdout1_18ck1820 FIND v(dout1_18) AT=915.025n

.meas tran vdout1_19ck1820 FIND v(dout1_19) AT=915.025n

.meas tran vdout1_20ck1820 FIND v(dout1_20) AT=915.025n

.meas tran vdout1_21ck1820 FIND v(dout1_21) AT=915.025n

.meas tran vdout1_22ck1820 FIND v(dout1_22) AT=915.025n

.meas tran vdout1_23ck1820 FIND v(dout1_23) AT=915.025n

.meas tran vdout0_0ck1830 FIND v(dout0_0) AT=920.025n

.meas tran vdout0_1ck1830 FIND v(dout0_1) AT=920.025n

.meas tran vdout0_2ck1830 FIND v(dout0_2) AT=920.025n

.meas tran vdout0_3ck1830 FIND v(dout0_3) AT=920.025n

.meas tran vdout0_4ck1830 FIND v(dout0_4) AT=920.025n

.meas tran vdout0_5ck1830 FIND v(dout0_5) AT=920.025n

.meas tran vdout0_6ck1830 FIND v(dout0_6) AT=920.025n

.meas tran vdout0_7ck1830 FIND v(dout0_7) AT=920.025n

.meas tran vdout0_8ck1830 FIND v(dout0_8) AT=920.025n

.meas tran vdout0_9ck1830 FIND v(dout0_9) AT=920.025n

.meas tran vdout0_10ck1830 FIND v(dout0_10) AT=920.025n

.meas tran vdout0_11ck1830 FIND v(dout0_11) AT=920.025n

.meas tran vdout0_12ck1830 FIND v(dout0_12) AT=920.025n

.meas tran vdout0_13ck1830 FIND v(dout0_13) AT=920.025n

.meas tran vdout0_14ck1830 FIND v(dout0_14) AT=920.025n

.meas tran vdout0_15ck1830 FIND v(dout0_15) AT=920.025n

.meas tran vdout0_16ck1830 FIND v(dout0_16) AT=920.025n

.meas tran vdout0_17ck1830 FIND v(dout0_17) AT=920.025n

.meas tran vdout0_18ck1830 FIND v(dout0_18) AT=920.025n

.meas tran vdout0_19ck1830 FIND v(dout0_19) AT=920.025n

.meas tran vdout0_20ck1830 FIND v(dout0_20) AT=920.025n

.meas tran vdout0_21ck1830 FIND v(dout0_21) AT=920.025n

.meas tran vdout0_22ck1830 FIND v(dout0_22) AT=920.025n

.meas tran vdout0_23ck1830 FIND v(dout0_23) AT=920.025n

.meas tran vdout1_0ck1830 FIND v(dout1_0) AT=920.025n

.meas tran vdout1_1ck1830 FIND v(dout1_1) AT=920.025n

.meas tran vdout1_2ck1830 FIND v(dout1_2) AT=920.025n

.meas tran vdout1_3ck1830 FIND v(dout1_3) AT=920.025n

.meas tran vdout1_4ck1830 FIND v(dout1_4) AT=920.025n

.meas tran vdout1_5ck1830 FIND v(dout1_5) AT=920.025n

.meas tran vdout1_6ck1830 FIND v(dout1_6) AT=920.025n

.meas tran vdout1_7ck1830 FIND v(dout1_7) AT=920.025n

.meas tran vdout1_8ck1830 FIND v(dout1_8) AT=920.025n

.meas tran vdout1_9ck1830 FIND v(dout1_9) AT=920.025n

.meas tran vdout1_10ck1830 FIND v(dout1_10) AT=920.025n

.meas tran vdout1_11ck1830 FIND v(dout1_11) AT=920.025n

.meas tran vdout1_12ck1830 FIND v(dout1_12) AT=920.025n

.meas tran vdout1_13ck1830 FIND v(dout1_13) AT=920.025n

.meas tran vdout1_14ck1830 FIND v(dout1_14) AT=920.025n

.meas tran vdout1_15ck1830 FIND v(dout1_15) AT=920.025n

.meas tran vdout1_16ck1830 FIND v(dout1_16) AT=920.025n

.meas tran vdout1_17ck1830 FIND v(dout1_17) AT=920.025n

.meas tran vdout1_18ck1830 FIND v(dout1_18) AT=920.025n

.meas tran vdout1_19ck1830 FIND v(dout1_19) AT=920.025n

.meas tran vdout1_20ck1830 FIND v(dout1_20) AT=920.025n

.meas tran vdout1_21ck1830 FIND v(dout1_21) AT=920.025n

.meas tran vdout1_22ck1830 FIND v(dout1_22) AT=920.025n

.meas tran vdout1_23ck1830 FIND v(dout1_23) AT=920.025n

.meas tran vdout0_0ck1840 FIND v(dout0_0) AT=925.025n

.meas tran vdout0_1ck1840 FIND v(dout0_1) AT=925.025n

.meas tran vdout0_2ck1840 FIND v(dout0_2) AT=925.025n

.meas tran vdout0_3ck1840 FIND v(dout0_3) AT=925.025n

.meas tran vdout0_4ck1840 FIND v(dout0_4) AT=925.025n

.meas tran vdout0_5ck1840 FIND v(dout0_5) AT=925.025n

.meas tran vdout0_6ck1840 FIND v(dout0_6) AT=925.025n

.meas tran vdout0_7ck1840 FIND v(dout0_7) AT=925.025n

.meas tran vdout0_8ck1840 FIND v(dout0_8) AT=925.025n

.meas tran vdout0_9ck1840 FIND v(dout0_9) AT=925.025n

.meas tran vdout0_10ck1840 FIND v(dout0_10) AT=925.025n

.meas tran vdout0_11ck1840 FIND v(dout0_11) AT=925.025n

.meas tran vdout0_12ck1840 FIND v(dout0_12) AT=925.025n

.meas tran vdout0_13ck1840 FIND v(dout0_13) AT=925.025n

.meas tran vdout0_14ck1840 FIND v(dout0_14) AT=925.025n

.meas tran vdout0_15ck1840 FIND v(dout0_15) AT=925.025n

.meas tran vdout0_16ck1840 FIND v(dout0_16) AT=925.025n

.meas tran vdout0_17ck1840 FIND v(dout0_17) AT=925.025n

.meas tran vdout0_18ck1840 FIND v(dout0_18) AT=925.025n

.meas tran vdout0_19ck1840 FIND v(dout0_19) AT=925.025n

.meas tran vdout0_20ck1840 FIND v(dout0_20) AT=925.025n

.meas tran vdout0_21ck1840 FIND v(dout0_21) AT=925.025n

.meas tran vdout0_22ck1840 FIND v(dout0_22) AT=925.025n

.meas tran vdout0_23ck1840 FIND v(dout0_23) AT=925.025n

.meas tran vdout1_0ck1840 FIND v(dout1_0) AT=925.025n

.meas tran vdout1_1ck1840 FIND v(dout1_1) AT=925.025n

.meas tran vdout1_2ck1840 FIND v(dout1_2) AT=925.025n

.meas tran vdout1_3ck1840 FIND v(dout1_3) AT=925.025n

.meas tran vdout1_4ck1840 FIND v(dout1_4) AT=925.025n

.meas tran vdout1_5ck1840 FIND v(dout1_5) AT=925.025n

.meas tran vdout1_6ck1840 FIND v(dout1_6) AT=925.025n

.meas tran vdout1_7ck1840 FIND v(dout1_7) AT=925.025n

.meas tran vdout1_8ck1840 FIND v(dout1_8) AT=925.025n

.meas tran vdout1_9ck1840 FIND v(dout1_9) AT=925.025n

.meas tran vdout1_10ck1840 FIND v(dout1_10) AT=925.025n

.meas tran vdout1_11ck1840 FIND v(dout1_11) AT=925.025n

.meas tran vdout1_12ck1840 FIND v(dout1_12) AT=925.025n

.meas tran vdout1_13ck1840 FIND v(dout1_13) AT=925.025n

.meas tran vdout1_14ck1840 FIND v(dout1_14) AT=925.025n

.meas tran vdout1_15ck1840 FIND v(dout1_15) AT=925.025n

.meas tran vdout1_16ck1840 FIND v(dout1_16) AT=925.025n

.meas tran vdout1_17ck1840 FIND v(dout1_17) AT=925.025n

.meas tran vdout1_18ck1840 FIND v(dout1_18) AT=925.025n

.meas tran vdout1_19ck1840 FIND v(dout1_19) AT=925.025n

.meas tran vdout1_20ck1840 FIND v(dout1_20) AT=925.025n

.meas tran vdout1_21ck1840 FIND v(dout1_21) AT=925.025n

.meas tran vdout1_22ck1840 FIND v(dout1_22) AT=925.025n

.meas tran vdout1_23ck1840 FIND v(dout1_23) AT=925.025n

.meas tran vdout0_0ck1850 FIND v(dout0_0) AT=930.025n

.meas tran vdout0_1ck1850 FIND v(dout0_1) AT=930.025n

.meas tran vdout0_2ck1850 FIND v(dout0_2) AT=930.025n

.meas tran vdout0_3ck1850 FIND v(dout0_3) AT=930.025n

.meas tran vdout0_4ck1850 FIND v(dout0_4) AT=930.025n

.meas tran vdout0_5ck1850 FIND v(dout0_5) AT=930.025n

.meas tran vdout0_6ck1850 FIND v(dout0_6) AT=930.025n

.meas tran vdout0_7ck1850 FIND v(dout0_7) AT=930.025n

.meas tran vdout0_8ck1850 FIND v(dout0_8) AT=930.025n

.meas tran vdout0_9ck1850 FIND v(dout0_9) AT=930.025n

.meas tran vdout0_10ck1850 FIND v(dout0_10) AT=930.025n

.meas tran vdout0_11ck1850 FIND v(dout0_11) AT=930.025n

.meas tran vdout0_12ck1850 FIND v(dout0_12) AT=930.025n

.meas tran vdout0_13ck1850 FIND v(dout0_13) AT=930.025n

.meas tran vdout0_14ck1850 FIND v(dout0_14) AT=930.025n

.meas tran vdout0_15ck1850 FIND v(dout0_15) AT=930.025n

.meas tran vdout0_16ck1850 FIND v(dout0_16) AT=930.025n

.meas tran vdout0_17ck1850 FIND v(dout0_17) AT=930.025n

.meas tran vdout0_18ck1850 FIND v(dout0_18) AT=930.025n

.meas tran vdout0_19ck1850 FIND v(dout0_19) AT=930.025n

.meas tran vdout0_20ck1850 FIND v(dout0_20) AT=930.025n

.meas tran vdout0_21ck1850 FIND v(dout0_21) AT=930.025n

.meas tran vdout0_22ck1850 FIND v(dout0_22) AT=930.025n

.meas tran vdout0_23ck1850 FIND v(dout0_23) AT=930.025n

.meas tran vdout1_0ck1850 FIND v(dout1_0) AT=930.025n

.meas tran vdout1_1ck1850 FIND v(dout1_1) AT=930.025n

.meas tran vdout1_2ck1850 FIND v(dout1_2) AT=930.025n

.meas tran vdout1_3ck1850 FIND v(dout1_3) AT=930.025n

.meas tran vdout1_4ck1850 FIND v(dout1_4) AT=930.025n

.meas tran vdout1_5ck1850 FIND v(dout1_5) AT=930.025n

.meas tran vdout1_6ck1850 FIND v(dout1_6) AT=930.025n

.meas tran vdout1_7ck1850 FIND v(dout1_7) AT=930.025n

.meas tran vdout1_8ck1850 FIND v(dout1_8) AT=930.025n

.meas tran vdout1_9ck1850 FIND v(dout1_9) AT=930.025n

.meas tran vdout1_10ck1850 FIND v(dout1_10) AT=930.025n

.meas tran vdout1_11ck1850 FIND v(dout1_11) AT=930.025n

.meas tran vdout1_12ck1850 FIND v(dout1_12) AT=930.025n

.meas tran vdout1_13ck1850 FIND v(dout1_13) AT=930.025n

.meas tran vdout1_14ck1850 FIND v(dout1_14) AT=930.025n

.meas tran vdout1_15ck1850 FIND v(dout1_15) AT=930.025n

.meas tran vdout1_16ck1850 FIND v(dout1_16) AT=930.025n

.meas tran vdout1_17ck1850 FIND v(dout1_17) AT=930.025n

.meas tran vdout1_18ck1850 FIND v(dout1_18) AT=930.025n

.meas tran vdout1_19ck1850 FIND v(dout1_19) AT=930.025n

.meas tran vdout1_20ck1850 FIND v(dout1_20) AT=930.025n

.meas tran vdout1_21ck1850 FIND v(dout1_21) AT=930.025n

.meas tran vdout1_22ck1850 FIND v(dout1_22) AT=930.025n

.meas tran vdout1_23ck1850 FIND v(dout1_23) AT=930.025n

.meas tran vdout0_0ck1860 FIND v(dout0_0) AT=935.025n

.meas tran vdout0_1ck1860 FIND v(dout0_1) AT=935.025n

.meas tran vdout0_2ck1860 FIND v(dout0_2) AT=935.025n

.meas tran vdout0_3ck1860 FIND v(dout0_3) AT=935.025n

.meas tran vdout0_4ck1860 FIND v(dout0_4) AT=935.025n

.meas tran vdout0_5ck1860 FIND v(dout0_5) AT=935.025n

.meas tran vdout0_6ck1860 FIND v(dout0_6) AT=935.025n

.meas tran vdout0_7ck1860 FIND v(dout0_7) AT=935.025n

.meas tran vdout0_8ck1860 FIND v(dout0_8) AT=935.025n

.meas tran vdout0_9ck1860 FIND v(dout0_9) AT=935.025n

.meas tran vdout0_10ck1860 FIND v(dout0_10) AT=935.025n

.meas tran vdout0_11ck1860 FIND v(dout0_11) AT=935.025n

.meas tran vdout0_12ck1860 FIND v(dout0_12) AT=935.025n

.meas tran vdout0_13ck1860 FIND v(dout0_13) AT=935.025n

.meas tran vdout0_14ck1860 FIND v(dout0_14) AT=935.025n

.meas tran vdout0_15ck1860 FIND v(dout0_15) AT=935.025n

.meas tran vdout0_16ck1860 FIND v(dout0_16) AT=935.025n

.meas tran vdout0_17ck1860 FIND v(dout0_17) AT=935.025n

.meas tran vdout0_18ck1860 FIND v(dout0_18) AT=935.025n

.meas tran vdout0_19ck1860 FIND v(dout0_19) AT=935.025n

.meas tran vdout0_20ck1860 FIND v(dout0_20) AT=935.025n

.meas tran vdout0_21ck1860 FIND v(dout0_21) AT=935.025n

.meas tran vdout0_22ck1860 FIND v(dout0_22) AT=935.025n

.meas tran vdout0_23ck1860 FIND v(dout0_23) AT=935.025n

.meas tran vdout1_0ck1870 FIND v(dout1_0) AT=940.025n

.meas tran vdout1_1ck1870 FIND v(dout1_1) AT=940.025n

.meas tran vdout1_2ck1870 FIND v(dout1_2) AT=940.025n

.meas tran vdout1_3ck1870 FIND v(dout1_3) AT=940.025n

.meas tran vdout1_4ck1870 FIND v(dout1_4) AT=940.025n

.meas tran vdout1_5ck1870 FIND v(dout1_5) AT=940.025n

.meas tran vdout1_6ck1870 FIND v(dout1_6) AT=940.025n

.meas tran vdout1_7ck1870 FIND v(dout1_7) AT=940.025n

.meas tran vdout1_8ck1870 FIND v(dout1_8) AT=940.025n

.meas tran vdout1_9ck1870 FIND v(dout1_9) AT=940.025n

.meas tran vdout1_10ck1870 FIND v(dout1_10) AT=940.025n

.meas tran vdout1_11ck1870 FIND v(dout1_11) AT=940.025n

.meas tran vdout1_12ck1870 FIND v(dout1_12) AT=940.025n

.meas tran vdout1_13ck1870 FIND v(dout1_13) AT=940.025n

.meas tran vdout1_14ck1870 FIND v(dout1_14) AT=940.025n

.meas tran vdout1_15ck1870 FIND v(dout1_15) AT=940.025n

.meas tran vdout1_16ck1870 FIND v(dout1_16) AT=940.025n

.meas tran vdout1_17ck1870 FIND v(dout1_17) AT=940.025n

.meas tran vdout1_18ck1870 FIND v(dout1_18) AT=940.025n

.meas tran vdout1_19ck1870 FIND v(dout1_19) AT=940.025n

.meas tran vdout1_20ck1870 FIND v(dout1_20) AT=940.025n

.meas tran vdout1_21ck1870 FIND v(dout1_21) AT=940.025n

.meas tran vdout1_22ck1870 FIND v(dout1_22) AT=940.025n

.meas tran vdout1_23ck1870 FIND v(dout1_23) AT=940.025n

.meas tran vdout1_0ck1880 FIND v(dout1_0) AT=945.025n

.meas tran vdout1_1ck1880 FIND v(dout1_1) AT=945.025n

.meas tran vdout1_2ck1880 FIND v(dout1_2) AT=945.025n

.meas tran vdout1_3ck1880 FIND v(dout1_3) AT=945.025n

.meas tran vdout1_4ck1880 FIND v(dout1_4) AT=945.025n

.meas tran vdout1_5ck1880 FIND v(dout1_5) AT=945.025n

.meas tran vdout1_6ck1880 FIND v(dout1_6) AT=945.025n

.meas tran vdout1_7ck1880 FIND v(dout1_7) AT=945.025n

.meas tran vdout1_8ck1880 FIND v(dout1_8) AT=945.025n

.meas tran vdout1_9ck1880 FIND v(dout1_9) AT=945.025n

.meas tran vdout1_10ck1880 FIND v(dout1_10) AT=945.025n

.meas tran vdout1_11ck1880 FIND v(dout1_11) AT=945.025n

.meas tran vdout1_12ck1880 FIND v(dout1_12) AT=945.025n

.meas tran vdout1_13ck1880 FIND v(dout1_13) AT=945.025n

.meas tran vdout1_14ck1880 FIND v(dout1_14) AT=945.025n

.meas tran vdout1_15ck1880 FIND v(dout1_15) AT=945.025n

.meas tran vdout1_16ck1880 FIND v(dout1_16) AT=945.025n

.meas tran vdout1_17ck1880 FIND v(dout1_17) AT=945.025n

.meas tran vdout1_18ck1880 FIND v(dout1_18) AT=945.025n

.meas tran vdout1_19ck1880 FIND v(dout1_19) AT=945.025n

.meas tran vdout1_20ck1880 FIND v(dout1_20) AT=945.025n

.meas tran vdout1_21ck1880 FIND v(dout1_21) AT=945.025n

.meas tran vdout1_22ck1880 FIND v(dout1_22) AT=945.025n

.meas tran vdout1_23ck1880 FIND v(dout1_23) AT=945.025n

.meas tran vdout1_0ck1890 FIND v(dout1_0) AT=950.025n

.meas tran vdout1_1ck1890 FIND v(dout1_1) AT=950.025n

.meas tran vdout1_2ck1890 FIND v(dout1_2) AT=950.025n

.meas tran vdout1_3ck1890 FIND v(dout1_3) AT=950.025n

.meas tran vdout1_4ck1890 FIND v(dout1_4) AT=950.025n

.meas tran vdout1_5ck1890 FIND v(dout1_5) AT=950.025n

.meas tran vdout1_6ck1890 FIND v(dout1_6) AT=950.025n

.meas tran vdout1_7ck1890 FIND v(dout1_7) AT=950.025n

.meas tran vdout1_8ck1890 FIND v(dout1_8) AT=950.025n

.meas tran vdout1_9ck1890 FIND v(dout1_9) AT=950.025n

.meas tran vdout1_10ck1890 FIND v(dout1_10) AT=950.025n

.meas tran vdout1_11ck1890 FIND v(dout1_11) AT=950.025n

.meas tran vdout1_12ck1890 FIND v(dout1_12) AT=950.025n

.meas tran vdout1_13ck1890 FIND v(dout1_13) AT=950.025n

.meas tran vdout1_14ck1890 FIND v(dout1_14) AT=950.025n

.meas tran vdout1_15ck1890 FIND v(dout1_15) AT=950.025n

.meas tran vdout1_16ck1890 FIND v(dout1_16) AT=950.025n

.meas tran vdout1_17ck1890 FIND v(dout1_17) AT=950.025n

.meas tran vdout1_18ck1890 FIND v(dout1_18) AT=950.025n

.meas tran vdout1_19ck1890 FIND v(dout1_19) AT=950.025n

.meas tran vdout1_20ck1890 FIND v(dout1_20) AT=950.025n

.meas tran vdout1_21ck1890 FIND v(dout1_21) AT=950.025n

.meas tran vdout1_22ck1890 FIND v(dout1_22) AT=950.025n

.meas tran vdout1_23ck1890 FIND v(dout1_23) AT=950.025n

.meas tran vdout1_0ck1900 FIND v(dout1_0) AT=955.025n

.meas tran vdout1_1ck1900 FIND v(dout1_1) AT=955.025n

.meas tran vdout1_2ck1900 FIND v(dout1_2) AT=955.025n

.meas tran vdout1_3ck1900 FIND v(dout1_3) AT=955.025n

.meas tran vdout1_4ck1900 FIND v(dout1_4) AT=955.025n

.meas tran vdout1_5ck1900 FIND v(dout1_5) AT=955.025n

.meas tran vdout1_6ck1900 FIND v(dout1_6) AT=955.025n

.meas tran vdout1_7ck1900 FIND v(dout1_7) AT=955.025n

.meas tran vdout1_8ck1900 FIND v(dout1_8) AT=955.025n

.meas tran vdout1_9ck1900 FIND v(dout1_9) AT=955.025n

.meas tran vdout1_10ck1900 FIND v(dout1_10) AT=955.025n

.meas tran vdout1_11ck1900 FIND v(dout1_11) AT=955.025n

.meas tran vdout1_12ck1900 FIND v(dout1_12) AT=955.025n

.meas tran vdout1_13ck1900 FIND v(dout1_13) AT=955.025n

.meas tran vdout1_14ck1900 FIND v(dout1_14) AT=955.025n

.meas tran vdout1_15ck1900 FIND v(dout1_15) AT=955.025n

.meas tran vdout1_16ck1900 FIND v(dout1_16) AT=955.025n

.meas tran vdout1_17ck1900 FIND v(dout1_17) AT=955.025n

.meas tran vdout1_18ck1900 FIND v(dout1_18) AT=955.025n

.meas tran vdout1_19ck1900 FIND v(dout1_19) AT=955.025n

.meas tran vdout1_20ck1900 FIND v(dout1_20) AT=955.025n

.meas tran vdout1_21ck1900 FIND v(dout1_21) AT=955.025n

.meas tran vdout1_22ck1900 FIND v(dout1_22) AT=955.025n

.meas tran vdout1_23ck1900 FIND v(dout1_23) AT=955.025n

.meas tran vdout1_0ck1920 FIND v(dout1_0) AT=965.025n

.meas tran vdout1_1ck1920 FIND v(dout1_1) AT=965.025n

.meas tran vdout1_2ck1920 FIND v(dout1_2) AT=965.025n

.meas tran vdout1_3ck1920 FIND v(dout1_3) AT=965.025n

.meas tran vdout1_4ck1920 FIND v(dout1_4) AT=965.025n

.meas tran vdout1_5ck1920 FIND v(dout1_5) AT=965.025n

.meas tran vdout1_6ck1920 FIND v(dout1_6) AT=965.025n

.meas tran vdout1_7ck1920 FIND v(dout1_7) AT=965.025n

.meas tran vdout1_8ck1920 FIND v(dout1_8) AT=965.025n

.meas tran vdout1_9ck1920 FIND v(dout1_9) AT=965.025n

.meas tran vdout1_10ck1920 FIND v(dout1_10) AT=965.025n

.meas tran vdout1_11ck1920 FIND v(dout1_11) AT=965.025n

.meas tran vdout1_12ck1920 FIND v(dout1_12) AT=965.025n

.meas tran vdout1_13ck1920 FIND v(dout1_13) AT=965.025n

.meas tran vdout1_14ck1920 FIND v(dout1_14) AT=965.025n

.meas tran vdout1_15ck1920 FIND v(dout1_15) AT=965.025n

.meas tran vdout1_16ck1920 FIND v(dout1_16) AT=965.025n

.meas tran vdout1_17ck1920 FIND v(dout1_17) AT=965.025n

.meas tran vdout1_18ck1920 FIND v(dout1_18) AT=965.025n

.meas tran vdout1_19ck1920 FIND v(dout1_19) AT=965.025n

.meas tran vdout1_20ck1920 FIND v(dout1_20) AT=965.025n

.meas tran vdout1_21ck1920 FIND v(dout1_21) AT=965.025n

.meas tran vdout1_22ck1920 FIND v(dout1_22) AT=965.025n

.meas tran vdout1_23ck1920 FIND v(dout1_23) AT=965.025n

.meas tran vdout0_0ck1930 FIND v(dout0_0) AT=970.025n

.meas tran vdout0_1ck1930 FIND v(dout0_1) AT=970.025n

.meas tran vdout0_2ck1930 FIND v(dout0_2) AT=970.025n

.meas tran vdout0_3ck1930 FIND v(dout0_3) AT=970.025n

.meas tran vdout0_4ck1930 FIND v(dout0_4) AT=970.025n

.meas tran vdout0_5ck1930 FIND v(dout0_5) AT=970.025n

.meas tran vdout0_6ck1930 FIND v(dout0_6) AT=970.025n

.meas tran vdout0_7ck1930 FIND v(dout0_7) AT=970.025n

.meas tran vdout0_8ck1930 FIND v(dout0_8) AT=970.025n

.meas tran vdout0_9ck1930 FIND v(dout0_9) AT=970.025n

.meas tran vdout0_10ck1930 FIND v(dout0_10) AT=970.025n

.meas tran vdout0_11ck1930 FIND v(dout0_11) AT=970.025n

.meas tran vdout0_12ck1930 FIND v(dout0_12) AT=970.025n

.meas tran vdout0_13ck1930 FIND v(dout0_13) AT=970.025n

.meas tran vdout0_14ck1930 FIND v(dout0_14) AT=970.025n

.meas tran vdout0_15ck1930 FIND v(dout0_15) AT=970.025n

.meas tran vdout0_16ck1930 FIND v(dout0_16) AT=970.025n

.meas tran vdout0_17ck1930 FIND v(dout0_17) AT=970.025n

.meas tran vdout0_18ck1930 FIND v(dout0_18) AT=970.025n

.meas tran vdout0_19ck1930 FIND v(dout0_19) AT=970.025n

.meas tran vdout0_20ck1930 FIND v(dout0_20) AT=970.025n

.meas tran vdout0_21ck1930 FIND v(dout0_21) AT=970.025n

.meas tran vdout0_22ck1930 FIND v(dout0_22) AT=970.025n

.meas tran vdout0_23ck1930 FIND v(dout0_23) AT=970.025n

.meas tran vdout1_0ck1940 FIND v(dout1_0) AT=975.025n

.meas tran vdout1_1ck1940 FIND v(dout1_1) AT=975.025n

.meas tran vdout1_2ck1940 FIND v(dout1_2) AT=975.025n

.meas tran vdout1_3ck1940 FIND v(dout1_3) AT=975.025n

.meas tran vdout1_4ck1940 FIND v(dout1_4) AT=975.025n

.meas tran vdout1_5ck1940 FIND v(dout1_5) AT=975.025n

.meas tran vdout1_6ck1940 FIND v(dout1_6) AT=975.025n

.meas tran vdout1_7ck1940 FIND v(dout1_7) AT=975.025n

.meas tran vdout1_8ck1940 FIND v(dout1_8) AT=975.025n

.meas tran vdout1_9ck1940 FIND v(dout1_9) AT=975.025n

.meas tran vdout1_10ck1940 FIND v(dout1_10) AT=975.025n

.meas tran vdout1_11ck1940 FIND v(dout1_11) AT=975.025n

.meas tran vdout1_12ck1940 FIND v(dout1_12) AT=975.025n

.meas tran vdout1_13ck1940 FIND v(dout1_13) AT=975.025n

.meas tran vdout1_14ck1940 FIND v(dout1_14) AT=975.025n

.meas tran vdout1_15ck1940 FIND v(dout1_15) AT=975.025n

.meas tran vdout1_16ck1940 FIND v(dout1_16) AT=975.025n

.meas tran vdout1_17ck1940 FIND v(dout1_17) AT=975.025n

.meas tran vdout1_18ck1940 FIND v(dout1_18) AT=975.025n

.meas tran vdout1_19ck1940 FIND v(dout1_19) AT=975.025n

.meas tran vdout1_20ck1940 FIND v(dout1_20) AT=975.025n

.meas tran vdout1_21ck1940 FIND v(dout1_21) AT=975.025n

.meas tran vdout1_22ck1940 FIND v(dout1_22) AT=975.025n

.meas tran vdout1_23ck1940 FIND v(dout1_23) AT=975.025n

.meas tran vdout1_0ck1950 FIND v(dout1_0) AT=980.025n

.meas tran vdout1_1ck1950 FIND v(dout1_1) AT=980.025n

.meas tran vdout1_2ck1950 FIND v(dout1_2) AT=980.025n

.meas tran vdout1_3ck1950 FIND v(dout1_3) AT=980.025n

.meas tran vdout1_4ck1950 FIND v(dout1_4) AT=980.025n

.meas tran vdout1_5ck1950 FIND v(dout1_5) AT=980.025n

.meas tran vdout1_6ck1950 FIND v(dout1_6) AT=980.025n

.meas tran vdout1_7ck1950 FIND v(dout1_7) AT=980.025n

.meas tran vdout1_8ck1950 FIND v(dout1_8) AT=980.025n

.meas tran vdout1_9ck1950 FIND v(dout1_9) AT=980.025n

.meas tran vdout1_10ck1950 FIND v(dout1_10) AT=980.025n

.meas tran vdout1_11ck1950 FIND v(dout1_11) AT=980.025n

.meas tran vdout1_12ck1950 FIND v(dout1_12) AT=980.025n

.meas tran vdout1_13ck1950 FIND v(dout1_13) AT=980.025n

.meas tran vdout1_14ck1950 FIND v(dout1_14) AT=980.025n

.meas tran vdout1_15ck1950 FIND v(dout1_15) AT=980.025n

.meas tran vdout1_16ck1950 FIND v(dout1_16) AT=980.025n

.meas tran vdout1_17ck1950 FIND v(dout1_17) AT=980.025n

.meas tran vdout1_18ck1950 FIND v(dout1_18) AT=980.025n

.meas tran vdout1_19ck1950 FIND v(dout1_19) AT=980.025n

.meas tran vdout1_20ck1950 FIND v(dout1_20) AT=980.025n

.meas tran vdout1_21ck1950 FIND v(dout1_21) AT=980.025n

.meas tran vdout1_22ck1950 FIND v(dout1_22) AT=980.025n

.meas tran vdout1_23ck1950 FIND v(dout1_23) AT=980.025n

.meas tran vdout0_0ck1960 FIND v(dout0_0) AT=985.025n

.meas tran vdout0_1ck1960 FIND v(dout0_1) AT=985.025n

.meas tran vdout0_2ck1960 FIND v(dout0_2) AT=985.025n

.meas tran vdout0_3ck1960 FIND v(dout0_3) AT=985.025n

.meas tran vdout0_4ck1960 FIND v(dout0_4) AT=985.025n

.meas tran vdout0_5ck1960 FIND v(dout0_5) AT=985.025n

.meas tran vdout0_6ck1960 FIND v(dout0_6) AT=985.025n

.meas tran vdout0_7ck1960 FIND v(dout0_7) AT=985.025n

.meas tran vdout0_8ck1960 FIND v(dout0_8) AT=985.025n

.meas tran vdout0_9ck1960 FIND v(dout0_9) AT=985.025n

.meas tran vdout0_10ck1960 FIND v(dout0_10) AT=985.025n

.meas tran vdout0_11ck1960 FIND v(dout0_11) AT=985.025n

.meas tran vdout0_12ck1960 FIND v(dout0_12) AT=985.025n

.meas tran vdout0_13ck1960 FIND v(dout0_13) AT=985.025n

.meas tran vdout0_14ck1960 FIND v(dout0_14) AT=985.025n

.meas tran vdout0_15ck1960 FIND v(dout0_15) AT=985.025n

.meas tran vdout0_16ck1960 FIND v(dout0_16) AT=985.025n

.meas tran vdout0_17ck1960 FIND v(dout0_17) AT=985.025n

.meas tran vdout0_18ck1960 FIND v(dout0_18) AT=985.025n

.meas tran vdout0_19ck1960 FIND v(dout0_19) AT=985.025n

.meas tran vdout0_20ck1960 FIND v(dout0_20) AT=985.025n

.meas tran vdout0_21ck1960 FIND v(dout0_21) AT=985.025n

.meas tran vdout0_22ck1960 FIND v(dout0_22) AT=985.025n

.meas tran vdout0_23ck1960 FIND v(dout0_23) AT=985.025n

.meas tran vdout1_0ck1960 FIND v(dout1_0) AT=985.025n

.meas tran vdout1_1ck1960 FIND v(dout1_1) AT=985.025n

.meas tran vdout1_2ck1960 FIND v(dout1_2) AT=985.025n

.meas tran vdout1_3ck1960 FIND v(dout1_3) AT=985.025n

.meas tran vdout1_4ck1960 FIND v(dout1_4) AT=985.025n

.meas tran vdout1_5ck1960 FIND v(dout1_5) AT=985.025n

.meas tran vdout1_6ck1960 FIND v(dout1_6) AT=985.025n

.meas tran vdout1_7ck1960 FIND v(dout1_7) AT=985.025n

.meas tran vdout1_8ck1960 FIND v(dout1_8) AT=985.025n

.meas tran vdout1_9ck1960 FIND v(dout1_9) AT=985.025n

.meas tran vdout1_10ck1960 FIND v(dout1_10) AT=985.025n

.meas tran vdout1_11ck1960 FIND v(dout1_11) AT=985.025n

.meas tran vdout1_12ck1960 FIND v(dout1_12) AT=985.025n

.meas tran vdout1_13ck1960 FIND v(dout1_13) AT=985.025n

.meas tran vdout1_14ck1960 FIND v(dout1_14) AT=985.025n

.meas tran vdout1_15ck1960 FIND v(dout1_15) AT=985.025n

.meas tran vdout1_16ck1960 FIND v(dout1_16) AT=985.025n

.meas tran vdout1_17ck1960 FIND v(dout1_17) AT=985.025n

.meas tran vdout1_18ck1960 FIND v(dout1_18) AT=985.025n

.meas tran vdout1_19ck1960 FIND v(dout1_19) AT=985.025n

.meas tran vdout1_20ck1960 FIND v(dout1_20) AT=985.025n

.meas tran vdout1_21ck1960 FIND v(dout1_21) AT=985.025n

.meas tran vdout1_22ck1960 FIND v(dout1_22) AT=985.025n

.meas tran vdout1_23ck1960 FIND v(dout1_23) AT=985.025n

.meas tran vdout0_0ck1970 FIND v(dout0_0) AT=990.025n

.meas tran vdout0_1ck1970 FIND v(dout0_1) AT=990.025n

.meas tran vdout0_2ck1970 FIND v(dout0_2) AT=990.025n

.meas tran vdout0_3ck1970 FIND v(dout0_3) AT=990.025n

.meas tran vdout0_4ck1970 FIND v(dout0_4) AT=990.025n

.meas tran vdout0_5ck1970 FIND v(dout0_5) AT=990.025n

.meas tran vdout0_6ck1970 FIND v(dout0_6) AT=990.025n

.meas tran vdout0_7ck1970 FIND v(dout0_7) AT=990.025n

.meas tran vdout0_8ck1970 FIND v(dout0_8) AT=990.025n

.meas tran vdout0_9ck1970 FIND v(dout0_9) AT=990.025n

.meas tran vdout0_10ck1970 FIND v(dout0_10) AT=990.025n

.meas tran vdout0_11ck1970 FIND v(dout0_11) AT=990.025n

.meas tran vdout0_12ck1970 FIND v(dout0_12) AT=990.025n

.meas tran vdout0_13ck1970 FIND v(dout0_13) AT=990.025n

.meas tran vdout0_14ck1970 FIND v(dout0_14) AT=990.025n

.meas tran vdout0_15ck1970 FIND v(dout0_15) AT=990.025n

.meas tran vdout0_16ck1970 FIND v(dout0_16) AT=990.025n

.meas tran vdout0_17ck1970 FIND v(dout0_17) AT=990.025n

.meas tran vdout0_18ck1970 FIND v(dout0_18) AT=990.025n

.meas tran vdout0_19ck1970 FIND v(dout0_19) AT=990.025n

.meas tran vdout0_20ck1970 FIND v(dout0_20) AT=990.025n

.meas tran vdout0_21ck1970 FIND v(dout0_21) AT=990.025n

.meas tran vdout0_22ck1970 FIND v(dout0_22) AT=990.025n

.meas tran vdout0_23ck1970 FIND v(dout0_23) AT=990.025n

.meas tran vdout1_0ck1970 FIND v(dout1_0) AT=990.025n

.meas tran vdout1_1ck1970 FIND v(dout1_1) AT=990.025n

.meas tran vdout1_2ck1970 FIND v(dout1_2) AT=990.025n

.meas tran vdout1_3ck1970 FIND v(dout1_3) AT=990.025n

.meas tran vdout1_4ck1970 FIND v(dout1_4) AT=990.025n

.meas tran vdout1_5ck1970 FIND v(dout1_5) AT=990.025n

.meas tran vdout1_6ck1970 FIND v(dout1_6) AT=990.025n

.meas tran vdout1_7ck1970 FIND v(dout1_7) AT=990.025n

.meas tran vdout1_8ck1970 FIND v(dout1_8) AT=990.025n

.meas tran vdout1_9ck1970 FIND v(dout1_9) AT=990.025n

.meas tran vdout1_10ck1970 FIND v(dout1_10) AT=990.025n

.meas tran vdout1_11ck1970 FIND v(dout1_11) AT=990.025n

.meas tran vdout1_12ck1970 FIND v(dout1_12) AT=990.025n

.meas tran vdout1_13ck1970 FIND v(dout1_13) AT=990.025n

.meas tran vdout1_14ck1970 FIND v(dout1_14) AT=990.025n

.meas tran vdout1_15ck1970 FIND v(dout1_15) AT=990.025n

.meas tran vdout1_16ck1970 FIND v(dout1_16) AT=990.025n

.meas tran vdout1_17ck1970 FIND v(dout1_17) AT=990.025n

.meas tran vdout1_18ck1970 FIND v(dout1_18) AT=990.025n

.meas tran vdout1_19ck1970 FIND v(dout1_19) AT=990.025n

.meas tran vdout1_20ck1970 FIND v(dout1_20) AT=990.025n

.meas tran vdout1_21ck1970 FIND v(dout1_21) AT=990.025n

.meas tran vdout1_22ck1970 FIND v(dout1_22) AT=990.025n

.meas tran vdout1_23ck1970 FIND v(dout1_23) AT=990.025n

.meas tran vdout0_0ck1980 FIND v(dout0_0) AT=995.025n

.meas tran vdout0_1ck1980 FIND v(dout0_1) AT=995.025n

.meas tran vdout0_2ck1980 FIND v(dout0_2) AT=995.025n

.meas tran vdout0_3ck1980 FIND v(dout0_3) AT=995.025n

.meas tran vdout0_4ck1980 FIND v(dout0_4) AT=995.025n

.meas tran vdout0_5ck1980 FIND v(dout0_5) AT=995.025n

.meas tran vdout0_6ck1980 FIND v(dout0_6) AT=995.025n

.meas tran vdout0_7ck1980 FIND v(dout0_7) AT=995.025n

.meas tran vdout0_8ck1980 FIND v(dout0_8) AT=995.025n

.meas tran vdout0_9ck1980 FIND v(dout0_9) AT=995.025n

.meas tran vdout0_10ck1980 FIND v(dout0_10) AT=995.025n

.meas tran vdout0_11ck1980 FIND v(dout0_11) AT=995.025n

.meas tran vdout0_12ck1980 FIND v(dout0_12) AT=995.025n

.meas tran vdout0_13ck1980 FIND v(dout0_13) AT=995.025n

.meas tran vdout0_14ck1980 FIND v(dout0_14) AT=995.025n

.meas tran vdout0_15ck1980 FIND v(dout0_15) AT=995.025n

.meas tran vdout0_16ck1980 FIND v(dout0_16) AT=995.025n

.meas tran vdout0_17ck1980 FIND v(dout0_17) AT=995.025n

.meas tran vdout0_18ck1980 FIND v(dout0_18) AT=995.025n

.meas tran vdout0_19ck1980 FIND v(dout0_19) AT=995.025n

.meas tran vdout0_20ck1980 FIND v(dout0_20) AT=995.025n

.meas tran vdout0_21ck1980 FIND v(dout0_21) AT=995.025n

.meas tran vdout0_22ck1980 FIND v(dout0_22) AT=995.025n

.meas tran vdout0_23ck1980 FIND v(dout0_23) AT=995.025n

.meas tran vdout0_0ck2010 FIND v(dout0_0) AT=1010.025n

.meas tran vdout0_1ck2010 FIND v(dout0_1) AT=1010.025n

.meas tran vdout0_2ck2010 FIND v(dout0_2) AT=1010.025n

.meas tran vdout0_3ck2010 FIND v(dout0_3) AT=1010.025n

.meas tran vdout0_4ck2010 FIND v(dout0_4) AT=1010.025n

.meas tran vdout0_5ck2010 FIND v(dout0_5) AT=1010.025n

.meas tran vdout0_6ck2010 FIND v(dout0_6) AT=1010.025n

.meas tran vdout0_7ck2010 FIND v(dout0_7) AT=1010.025n

.meas tran vdout0_8ck2010 FIND v(dout0_8) AT=1010.025n

.meas tran vdout0_9ck2010 FIND v(dout0_9) AT=1010.025n

.meas tran vdout0_10ck2010 FIND v(dout0_10) AT=1010.025n

.meas tran vdout0_11ck2010 FIND v(dout0_11) AT=1010.025n

.meas tran vdout0_12ck2010 FIND v(dout0_12) AT=1010.025n

.meas tran vdout0_13ck2010 FIND v(dout0_13) AT=1010.025n

.meas tran vdout0_14ck2010 FIND v(dout0_14) AT=1010.025n

.meas tran vdout0_15ck2010 FIND v(dout0_15) AT=1010.025n

.meas tran vdout0_16ck2010 FIND v(dout0_16) AT=1010.025n

.meas tran vdout0_17ck2010 FIND v(dout0_17) AT=1010.025n

.meas tran vdout0_18ck2010 FIND v(dout0_18) AT=1010.025n

.meas tran vdout0_19ck2010 FIND v(dout0_19) AT=1010.025n

.meas tran vdout0_20ck2010 FIND v(dout0_20) AT=1010.025n

.meas tran vdout0_21ck2010 FIND v(dout0_21) AT=1010.025n

.meas tran vdout0_22ck2010 FIND v(dout0_22) AT=1010.025n

.meas tran vdout0_23ck2010 FIND v(dout0_23) AT=1010.025n

.meas tran vdout0_0ck2020 FIND v(dout0_0) AT=1015.025n

.meas tran vdout0_1ck2020 FIND v(dout0_1) AT=1015.025n

.meas tran vdout0_2ck2020 FIND v(dout0_2) AT=1015.025n

.meas tran vdout0_3ck2020 FIND v(dout0_3) AT=1015.025n

.meas tran vdout0_4ck2020 FIND v(dout0_4) AT=1015.025n

.meas tran vdout0_5ck2020 FIND v(dout0_5) AT=1015.025n

.meas tran vdout0_6ck2020 FIND v(dout0_6) AT=1015.025n

.meas tran vdout0_7ck2020 FIND v(dout0_7) AT=1015.025n

.meas tran vdout0_8ck2020 FIND v(dout0_8) AT=1015.025n

.meas tran vdout0_9ck2020 FIND v(dout0_9) AT=1015.025n

.meas tran vdout0_10ck2020 FIND v(dout0_10) AT=1015.025n

.meas tran vdout0_11ck2020 FIND v(dout0_11) AT=1015.025n

.meas tran vdout0_12ck2020 FIND v(dout0_12) AT=1015.025n

.meas tran vdout0_13ck2020 FIND v(dout0_13) AT=1015.025n

.meas tran vdout0_14ck2020 FIND v(dout0_14) AT=1015.025n

.meas tran vdout0_15ck2020 FIND v(dout0_15) AT=1015.025n

.meas tran vdout0_16ck2020 FIND v(dout0_16) AT=1015.025n

.meas tran vdout0_17ck2020 FIND v(dout0_17) AT=1015.025n

.meas tran vdout0_18ck2020 FIND v(dout0_18) AT=1015.025n

.meas tran vdout0_19ck2020 FIND v(dout0_19) AT=1015.025n

.meas tran vdout0_20ck2020 FIND v(dout0_20) AT=1015.025n

.meas tran vdout0_21ck2020 FIND v(dout0_21) AT=1015.025n

.meas tran vdout0_22ck2020 FIND v(dout0_22) AT=1015.025n

.meas tran vdout0_23ck2020 FIND v(dout0_23) AT=1015.025n

.meas tran vdout1_0ck2020 FIND v(dout1_0) AT=1015.025n

.meas tran vdout1_1ck2020 FIND v(dout1_1) AT=1015.025n

.meas tran vdout1_2ck2020 FIND v(dout1_2) AT=1015.025n

.meas tran vdout1_3ck2020 FIND v(dout1_3) AT=1015.025n

.meas tran vdout1_4ck2020 FIND v(dout1_4) AT=1015.025n

.meas tran vdout1_5ck2020 FIND v(dout1_5) AT=1015.025n

.meas tran vdout1_6ck2020 FIND v(dout1_6) AT=1015.025n

.meas tran vdout1_7ck2020 FIND v(dout1_7) AT=1015.025n

.meas tran vdout1_8ck2020 FIND v(dout1_8) AT=1015.025n

.meas tran vdout1_9ck2020 FIND v(dout1_9) AT=1015.025n

.meas tran vdout1_10ck2020 FIND v(dout1_10) AT=1015.025n

.meas tran vdout1_11ck2020 FIND v(dout1_11) AT=1015.025n

.meas tran vdout1_12ck2020 FIND v(dout1_12) AT=1015.025n

.meas tran vdout1_13ck2020 FIND v(dout1_13) AT=1015.025n

.meas tran vdout1_14ck2020 FIND v(dout1_14) AT=1015.025n

.meas tran vdout1_15ck2020 FIND v(dout1_15) AT=1015.025n

.meas tran vdout1_16ck2020 FIND v(dout1_16) AT=1015.025n

.meas tran vdout1_17ck2020 FIND v(dout1_17) AT=1015.025n

.meas tran vdout1_18ck2020 FIND v(dout1_18) AT=1015.025n

.meas tran vdout1_19ck2020 FIND v(dout1_19) AT=1015.025n

.meas tran vdout1_20ck2020 FIND v(dout1_20) AT=1015.025n

.meas tran vdout1_21ck2020 FIND v(dout1_21) AT=1015.025n

.meas tran vdout1_22ck2020 FIND v(dout1_22) AT=1015.025n

.meas tran vdout1_23ck2020 FIND v(dout1_23) AT=1015.025n

.meas tran vdout0_0ck2030 FIND v(dout0_0) AT=1020.025n

.meas tran vdout0_1ck2030 FIND v(dout0_1) AT=1020.025n

.meas tran vdout0_2ck2030 FIND v(dout0_2) AT=1020.025n

.meas tran vdout0_3ck2030 FIND v(dout0_3) AT=1020.025n

.meas tran vdout0_4ck2030 FIND v(dout0_4) AT=1020.025n

.meas tran vdout0_5ck2030 FIND v(dout0_5) AT=1020.025n

.meas tran vdout0_6ck2030 FIND v(dout0_6) AT=1020.025n

.meas tran vdout0_7ck2030 FIND v(dout0_7) AT=1020.025n

.meas tran vdout0_8ck2030 FIND v(dout0_8) AT=1020.025n

.meas tran vdout0_9ck2030 FIND v(dout0_9) AT=1020.025n

.meas tran vdout0_10ck2030 FIND v(dout0_10) AT=1020.025n

.meas tran vdout0_11ck2030 FIND v(dout0_11) AT=1020.025n

.meas tran vdout0_12ck2030 FIND v(dout0_12) AT=1020.025n

.meas tran vdout0_13ck2030 FIND v(dout0_13) AT=1020.025n

.meas tran vdout0_14ck2030 FIND v(dout0_14) AT=1020.025n

.meas tran vdout0_15ck2030 FIND v(dout0_15) AT=1020.025n

.meas tran vdout0_16ck2030 FIND v(dout0_16) AT=1020.025n

.meas tran vdout0_17ck2030 FIND v(dout0_17) AT=1020.025n

.meas tran vdout0_18ck2030 FIND v(dout0_18) AT=1020.025n

.meas tran vdout0_19ck2030 FIND v(dout0_19) AT=1020.025n

.meas tran vdout0_20ck2030 FIND v(dout0_20) AT=1020.025n

.meas tran vdout0_21ck2030 FIND v(dout0_21) AT=1020.025n

.meas tran vdout0_22ck2030 FIND v(dout0_22) AT=1020.025n

.meas tran vdout0_23ck2030 FIND v(dout0_23) AT=1020.025n

.meas tran vdout1_0ck2030 FIND v(dout1_0) AT=1020.025n

.meas tran vdout1_1ck2030 FIND v(dout1_1) AT=1020.025n

.meas tran vdout1_2ck2030 FIND v(dout1_2) AT=1020.025n

.meas tran vdout1_3ck2030 FIND v(dout1_3) AT=1020.025n

.meas tran vdout1_4ck2030 FIND v(dout1_4) AT=1020.025n

.meas tran vdout1_5ck2030 FIND v(dout1_5) AT=1020.025n

.meas tran vdout1_6ck2030 FIND v(dout1_6) AT=1020.025n

.meas tran vdout1_7ck2030 FIND v(dout1_7) AT=1020.025n

.meas tran vdout1_8ck2030 FIND v(dout1_8) AT=1020.025n

.meas tran vdout1_9ck2030 FIND v(dout1_9) AT=1020.025n

.meas tran vdout1_10ck2030 FIND v(dout1_10) AT=1020.025n

.meas tran vdout1_11ck2030 FIND v(dout1_11) AT=1020.025n

.meas tran vdout1_12ck2030 FIND v(dout1_12) AT=1020.025n

.meas tran vdout1_13ck2030 FIND v(dout1_13) AT=1020.025n

.meas tran vdout1_14ck2030 FIND v(dout1_14) AT=1020.025n

.meas tran vdout1_15ck2030 FIND v(dout1_15) AT=1020.025n

.meas tran vdout1_16ck2030 FIND v(dout1_16) AT=1020.025n

.meas tran vdout1_17ck2030 FIND v(dout1_17) AT=1020.025n

.meas tran vdout1_18ck2030 FIND v(dout1_18) AT=1020.025n

.meas tran vdout1_19ck2030 FIND v(dout1_19) AT=1020.025n

.meas tran vdout1_20ck2030 FIND v(dout1_20) AT=1020.025n

.meas tran vdout1_21ck2030 FIND v(dout1_21) AT=1020.025n

.meas tran vdout1_22ck2030 FIND v(dout1_22) AT=1020.025n

.meas tran vdout1_23ck2030 FIND v(dout1_23) AT=1020.025n
