* Functional test stimulus file for 5ns period

* TT process corner
.include "/home/ihs24/OpenRAM/technology/freepdk45/models/tran_models/models_nom/PMOS_VTG.inc"
.include "/home/ihs24/OpenRAM/technology/freepdk45/models/tran_models/models_nom/NMOS_VTG.inc"
.include "/tmp/openram_ihs24_638756_temp/sram.sp"

* Global Power Supplies
Vvdd vdd 0 1.0

*Nodes gnd and 0 are the same global ground node in ngspice/hspice/xa. Otherwise, this source may be needed.
*Vgnd gnd 0 0.0

* Instantiation of the SRAM
Xsram_512x64_2rw din0_0 din0_1 din0_2 din0_3 din0_4 din0_5 din0_6 din0_7 din0_8 din0_9 din0_10 din0_11 din0_12 din0_13 din0_14 din0_15 din0_16 din0_17 din0_18 din0_19 din0_20 din0_21 din0_22 din0_23 din0_24 din0_25 din0_26 din0_27 din0_28 din0_29 din0_30 din0_31 din0_32 din0_33 din0_34 din0_35 din0_36 din0_37 din0_38 din0_39 din0_40 din0_41 din0_42 din0_43 din0_44 din0_45 din0_46 din0_47 din0_48 din0_49 din0_50 din0_51 din0_52 din0_53 din0_54 din0_55 din0_56 din0_57 din0_58 din0_59 din0_60 din0_61 din0_62 din0_63 din1_0 din1_1 din1_2 din1_3 din1_4 din1_5 din1_6 din1_7 din1_8 din1_9 din1_10 din1_11 din1_12 din1_13 din1_14 din1_15 din1_16 din1_17 din1_18 din1_19 din1_20 din1_21 din1_22 din1_23 din1_24 din1_25 din1_26 din1_27 din1_28 din1_29 din1_30 din1_31 din1_32 din1_33 din1_34 din1_35 din1_36 din1_37 din1_38 din1_39 din1_40 din1_41 din1_42 din1_43 din1_44 din1_45 din1_46 din1_47 din1_48 din1_49 din1_50 din1_51 din1_52 din1_53 din1_54 din1_55 din1_56 din1_57 din1_58 din1_59 din1_60 din1_61 din1_62 din1_63 a0_0 a0_1 a0_2 a0_3 a0_4 a0_5 a0_6 a0_7 a0_8 a1_0 a1_1 a1_2 a1_3 a1_4 a1_5 a1_6 a1_7 a1_8 CSB0 CSB1 WEB0 WEB1 clk0 clk1 dout0_0 dout0_1 dout0_2 dout0_3 dout0_4 dout0_5 dout0_6 dout0_7 dout0_8 dout0_9 dout0_10 dout0_11 dout0_12 dout0_13 dout0_14 dout0_15 dout0_16 dout0_17 dout0_18 dout0_19 dout0_20 dout0_21 dout0_22 dout0_23 dout0_24 dout0_25 dout0_26 dout0_27 dout0_28 dout0_29 dout0_30 dout0_31 dout0_32 dout0_33 dout0_34 dout0_35 dout0_36 dout0_37 dout0_38 dout0_39 dout0_40 dout0_41 dout0_42 dout0_43 dout0_44 dout0_45 dout0_46 dout0_47 dout0_48 dout0_49 dout0_50 dout0_51 dout0_52 dout0_53 dout0_54 dout0_55 dout0_56 dout0_57 dout0_58 dout0_59 dout0_60 dout0_61 dout0_62 dout0_63 dout1_0 dout1_1 dout1_2 dout1_3 dout1_4 dout1_5 dout1_6 dout1_7 dout1_8 dout1_9 dout1_10 dout1_11 dout1_12 dout1_13 dout1_14 dout1_15 dout1_16 dout1_17 dout1_18 dout1_19 dout1_20 dout1_21 dout1_22 dout1_23 dout1_24 dout1_25 dout1_26 dout1_27 dout1_28 dout1_29 dout1_30 dout1_31 dout1_32 dout1_33 dout1_34 dout1_35 dout1_36 dout1_37 dout1_38 dout1_39 dout1_40 dout1_41 dout1_42 dout1_43 dout1_44 dout1_45 dout1_46 dout1_47 dout1_48 dout1_49 dout1_50 dout1_51 dout1_52 dout1_53 dout1_54 dout1_55 dout1_56 dout1_57 dout1_58 dout1_59 dout1_60 dout1_61 dout1_62 dout1_63 vdd gnd sram_512x64_2rw

* SRAM output loads
CD00 dout0_0  0 0.8364f
CD01 dout0_1  0 0.8364f
CD02 dout0_2  0 0.8364f
CD03 dout0_3  0 0.8364f
CD04 dout0_4  0 0.8364f
CD05 dout0_5  0 0.8364f
CD06 dout0_6  0 0.8364f
CD07 dout0_7  0 0.8364f
CD08 dout0_8  0 0.8364f
CD09 dout0_9  0 0.8364f
CD010 dout0_10  0 0.8364f
CD011 dout0_11  0 0.8364f
CD012 dout0_12  0 0.8364f
CD013 dout0_13  0 0.8364f
CD014 dout0_14  0 0.8364f
CD015 dout0_15  0 0.8364f
CD016 dout0_16  0 0.8364f
CD017 dout0_17  0 0.8364f
CD018 dout0_18  0 0.8364f
CD019 dout0_19  0 0.8364f
CD020 dout0_20  0 0.8364f
CD021 dout0_21  0 0.8364f
CD022 dout0_22  0 0.8364f
CD023 dout0_23  0 0.8364f
CD024 dout0_24  0 0.8364f
CD025 dout0_25  0 0.8364f
CD026 dout0_26  0 0.8364f
CD027 dout0_27  0 0.8364f
CD028 dout0_28  0 0.8364f
CD029 dout0_29  0 0.8364f
CD030 dout0_30  0 0.8364f
CD031 dout0_31  0 0.8364f
CD032 dout0_32  0 0.8364f
CD033 dout0_33  0 0.8364f
CD034 dout0_34  0 0.8364f
CD035 dout0_35  0 0.8364f
CD036 dout0_36  0 0.8364f
CD037 dout0_37  0 0.8364f
CD038 dout0_38  0 0.8364f
CD039 dout0_39  0 0.8364f
CD040 dout0_40  0 0.8364f
CD041 dout0_41  0 0.8364f
CD042 dout0_42  0 0.8364f
CD043 dout0_43  0 0.8364f
CD044 dout0_44  0 0.8364f
CD045 dout0_45  0 0.8364f
CD046 dout0_46  0 0.8364f
CD047 dout0_47  0 0.8364f
CD048 dout0_48  0 0.8364f
CD049 dout0_49  0 0.8364f
CD050 dout0_50  0 0.8364f
CD051 dout0_51  0 0.8364f
CD052 dout0_52  0 0.8364f
CD053 dout0_53  0 0.8364f
CD054 dout0_54  0 0.8364f
CD055 dout0_55  0 0.8364f
CD056 dout0_56  0 0.8364f
CD057 dout0_57  0 0.8364f
CD058 dout0_58  0 0.8364f
CD059 dout0_59  0 0.8364f
CD060 dout0_60  0 0.8364f
CD061 dout0_61  0 0.8364f
CD062 dout0_62  0 0.8364f
CD063 dout0_63  0 0.8364f
CD10 dout1_0  0 0.8364f
CD11 dout1_1  0 0.8364f
CD12 dout1_2  0 0.8364f
CD13 dout1_3  0 0.8364f
CD14 dout1_4  0 0.8364f
CD15 dout1_5  0 0.8364f
CD16 dout1_6  0 0.8364f
CD17 dout1_7  0 0.8364f
CD18 dout1_8  0 0.8364f
CD19 dout1_9  0 0.8364f
CD110 dout1_10  0 0.8364f
CD111 dout1_11  0 0.8364f
CD112 dout1_12  0 0.8364f
CD113 dout1_13  0 0.8364f
CD114 dout1_14  0 0.8364f
CD115 dout1_15  0 0.8364f
CD116 dout1_16  0 0.8364f
CD117 dout1_17  0 0.8364f
CD118 dout1_18  0 0.8364f
CD119 dout1_19  0 0.8364f
CD120 dout1_20  0 0.8364f
CD121 dout1_21  0 0.8364f
CD122 dout1_22  0 0.8364f
CD123 dout1_23  0 0.8364f
CD124 dout1_24  0 0.8364f
CD125 dout1_25  0 0.8364f
CD126 dout1_26  0 0.8364f
CD127 dout1_27  0 0.8364f
CD128 dout1_28  0 0.8364f
CD129 dout1_29  0 0.8364f
CD130 dout1_30  0 0.8364f
CD131 dout1_31  0 0.8364f
CD132 dout1_32  0 0.8364f
CD133 dout1_33  0 0.8364f
CD134 dout1_34  0 0.8364f
CD135 dout1_35  0 0.8364f
CD136 dout1_36  0 0.8364f
CD137 dout1_37  0 0.8364f
CD138 dout1_38  0 0.8364f
CD139 dout1_39  0 0.8364f
CD140 dout1_40  0 0.8364f
CD141 dout1_41  0 0.8364f
CD142 dout1_42  0 0.8364f
CD143 dout1_43  0 0.8364f
CD144 dout1_44  0 0.8364f
CD145 dout1_45  0 0.8364f
CD146 dout1_46  0 0.8364f
CD147 dout1_47  0 0.8364f
CD148 dout1_48  0 0.8364f
CD149 dout1_49  0 0.8364f
CD150 dout1_50  0 0.8364f
CD151 dout1_51  0 0.8364f
CD152 dout1_52  0 0.8364f
CD153 dout1_53  0 0.8364f
CD154 dout1_54  0 0.8364f
CD155 dout1_55  0 0.8364f
CD156 dout1_56  0 0.8364f
CD157 dout1_57  0 0.8364f
CD158 dout1_58  0 0.8364f
CD159 dout1_59  0 0.8364f
CD160 dout1_60  0 0.8364f
CD161 dout1_61  0 0.8364f
CD162 dout1_62  0 0.8364f
CD163 dout1_63  0 0.8364f

* Important signals for debug
* bl:	xsram:xbank0:bl_0_1
* br:	xsram:xbank0:br_0_1
* s_en:	xsram:s_en
* q:	xsram:xbank0:xbitcell_array:xbitcell_array:xbit_r0_c0.Q
* qbar:	xsram:xbank0:xbitcell_array:xbitcell_array:xbit_r0_c0.Q_bar

* Sequence of operations
*	Idle during cycle 0 (0ns - 5ns)
*	Writing 1101000100101101111011000010011111111001100101111101101000101100  to  address 000000011 (from port 0) during cycle 1 (5ns - 10ns)
*	Writing 1110111101111101110101011111010110100101101100100000101011100000  to  address 000000010 (from port 1) during cycle 1 (5ns - 10ns)
*	Writing 0000101100000100001001011001110111111111001000010101001001010100  to  address 000000010 (from port 0) during cycle 2 (10ns - 15ns)
*	Writing 1011101001110001010001111111010011111001000010000100011001010001  to  address 000000001 (from port 1) during cycle 2 (10ns - 15ns)
*	Writing 0111111111010101101111101010101011011101101111011101110101101010  to  address 000000010 (from port 0) during cycle 3 (15ns - 20ns)
*	Writing 1111011001010111100100100101101111110111010111001100001010010000  to  address 111111101 (from port 1) during cycle 3 (15ns - 20ns)
*	Reading 1101000100101101111011000010011111111001100101111101101000101100 from address 000000011 (from port 0) during cycle 4 (20ns - 25ns)
*	Reading 1111011001010111100100100101101111110111010111001100001010010000 from address 111111101 (from port 1) during cycle 4 (20ns - 25ns)
*	Reading 1011101001110001010001111111010011111001000010000100011001010001 from address 000000001 (from port 0) during cycle 5 (25ns - 30ns)
*	Reading 0111111111010101101111101010101011011101101111011101110101101010 from address 000000010 (from port 1) during cycle 5 (25ns - 30ns)
*	Writing 1000000111001011000111101010011101100100011011000111001000110010  to  address 000000001 (from port 0) during cycle 6 (30ns - 35ns)
*	Reading 1101000100101101111011000010011111111001100101111101101000101100 from address 000000011 (from port 0) during cycle 7 (35ns - 40ns)
*	Writing 0000110100011101101111001001010001101010010000110011110010010110  to  address 000000001 (from port 0) during cycle 8 (40ns - 45ns)
*	Reading 1111011001010111100100100101101111110111010111001100001010010000 from address 111111101 (from port 1) during cycle 8 (40ns - 45ns)
*	Writing 0010001100101110010010000101100111101000111000000011101100111010  to  address 111111100 (from port 0) during cycle 10 (50ns - 55ns)
*	Reading 1101000100101101111011000010011111111001100101111101101000101100 from address 000000011 (from port 1) during cycle 10 (50ns - 55ns)
*	Reading 1111011001010111100100100101101111110111010111001100001010010000 from address 111111101 (from port 0) during cycle 11 (55ns - 60ns)
*	Reading 1111011001010111100100100101101111110111010111001100001010010000 from address 111111101 (from port 1) during cycle 11 (55ns - 60ns)
*	Reading 0111111111010101101111101010101011011101101111011101110101101010 from address 000000010 (from port 0) during cycle 12 (60ns - 65ns)
*	Writing 0101001100011011101011100011011110010111011011110100110001000101  to  address 111111100 (from port 1) during cycle 12 (60ns - 65ns)
*	Writing 0001010000011011000111011100010111001110100001100111111010010110  to  address 000000010 (from port 0) during cycle 13 (65ns - 70ns)
*	Reading 1101000100101101111011000010011111111001100101111101101000101100 from address 000000011 (from port 1) during cycle 13 (65ns - 70ns)
*	Reading 1101000100101101111011000010011111111001100101111101101000101100 from address 000000011 (from port 0) during cycle 14 (70ns - 75ns)
*	Reading 1101000100101101111011000010011111111001100101111101101000101100 from address 000000011 (from port 1) during cycle 14 (70ns - 75ns)
*	Reading 0000110100011101101111001001010001101010010000110011110010010110 from address 000000001 (from port 0) during cycle 15 (75ns - 80ns)
*	Reading 0001010000011011000111011100010111001110100001100111111010010110 from address 000000010 (from port 1) during cycle 15 (75ns - 80ns)
*	Reading 1101000100101101111011000010011111111001100101111101101000101100 from address 000000011 (from port 0) during cycle 16 (80ns - 85ns)
*	Writing 1100011110100100110111111000011101101000100100001001100000101011  to  address 111111101 (from port 1) during cycle 16 (80ns - 85ns)
*	Writing 0101110100001110100111100110010001101011000111111010111010110101  to  address 000000000 (from port 0) during cycle 17 (85ns - 90ns)
*	Reading 0101001100011011101011100011011110010111011011110100110001000101 from address 111111100 (from port 1) during cycle 17 (85ns - 90ns)
*	Reading 0101110100001110100111100110010001101011000111111010111010110101 from address 000000000 (from port 0) during cycle 18 (90ns - 95ns)
*	Writing 0110001011100100001101011001111011110111100011110101010110001010  to  address 111111100 (from port 1) during cycle 18 (90ns - 95ns)
*	Reading 1100011110100100110111111000011101101000100100001001100000101011 from address 111111101 (from port 0) during cycle 19 (95ns - 100ns)
*	Writing 0010010011100011001000010010111101110001101101000100111101000011  to  address 111111101 (from port 0) during cycle 20 (100ns - 105ns)
*	Writing 0101101110001000111110011110111110001010001010000011101011000000  to  address 000000000 (from port 0) during cycle 21 (105ns - 110ns)
*	Reading 0000110100011101101111001001010001101010010000110011110010010110 from address 000000001 (from port 1) during cycle 21 (105ns - 110ns)
*	Reading 0110001011100100001101011001111011110111100011110101010110001010 from address 111111100 (from port 1) during cycle 22 (110ns - 115ns)
*	Writing 0011010100100011001010000110010001001111001011000001101101101010  to  address 000000000 (from port 0) during cycle 23 (115ns - 120ns)
*	Reading 1101000100101101111011000010011111111001100101111101101000101100 from address 000000011 (from port 0) during cycle 24 (120ns - 125ns)
*	Reading 0010010011100011001000010010111101110001101101000100111101000011 from address 111111101 (from port 0) during cycle 26 (130ns - 135ns)
*	Writing 1101001110010001111111010011111010101001001111110010111001000100  to  address 111111011 (from port 1) during cycle 26 (130ns - 135ns)
*	Reading 0001010000011011000111011100010111001110100001100111111010010110 from address 000000010 (from port 0) during cycle 27 (135ns - 140ns)
*	Reading 0110001011100100001101011001111011110111100011110101010110001010 from address 111111100 (from port 1) during cycle 27 (135ns - 140ns)
*	Reading 0011010100100011001010000110010001001111001011000001101101101010 from address 000000000 (from port 0) during cycle 28 (140ns - 145ns)
*	Reading 0000110100011101101111001001010001101010010000110011110010010110 from address 000000001 (from port 1) during cycle 28 (140ns - 145ns)
*	Reading 0010010011100011001000010010111101110001101101000100111101000011 from address 111111101 (from port 0) during cycle 29 (145ns - 150ns)
*	Writing 0011000101111010011110101001101110100010110011110011110101111110  to  address 000000011 (from port 1) during cycle 29 (145ns - 150ns)
*	Writing 0100001111010101110110111011110000101000000100100000101010100000  to  address 000000010 (from port 0) during cycle 31 (155ns - 160ns)
*	Reading 0011000101111010011110101001101110100010110011110011110101111110 from address 000000011 (from port 1) during cycle 32 (160ns - 165ns)
*	Reading 0000110100011101101111001001010001101010010000110011110010010110 from address 000000001 (from port 1) during cycle 33 (165ns - 170ns)
*	Reading 0110001011100100001101011001111011110111100011110101010110001010 from address 111111100 (from port 0) during cycle 34 (170ns - 175ns)
*	Writing 0111101111111110001101111011101011110110100111011101001000111111  to  address 111111110 (from port 0) during cycle 35 (175ns - 180ns)
*	Writing 0011110101000001001011110000001001101100101011000101010000100001  to  address 000000010 (from port 1) during cycle 35 (175ns - 180ns)
*	Writing 1110011101011100000111001011111101001010100010010111001000101011  to  address 111111101 (from port 1) during cycle 36 (180ns - 185ns)
*	Reading 1101001110010001111111010011111010101001001111110010111001000100 from address 111111011 (from port 0) during cycle 37 (185ns - 190ns)
*	Writing 1100010110001000010100011000101001101001110000011100101001100101  to  address 000000011 (from port 0) during cycle 38 (190ns - 195ns)
*	Writing 1010000011111101100111010001010111100111010011111110101011011001  to  address 111111011 (from port 0) during cycle 39 (195ns - 200ns)
*	Reading 0011110101000001001011110000001001101100101011000101010000100001 from address 000000010 (from port 0) during cycle 40 (200ns - 205ns)
*	Reading 0011010100100011001010000110010001001111001011000001101101101010 from address 000000000 (from port 0) during cycle 41 (205ns - 210ns)
*	Reading 0110001011100100001101011001111011110111100011110101010110001010 from address 111111100 (from port 1) during cycle 41 (205ns - 210ns)
*	Reading 1010000011111101100111010001010111100111010011111110101011011001 from address 111111011 (from port 0) during cycle 42 (210ns - 215ns)
*	Reading 0011010100100011001010000110010001001111001011000001101101101010 from address 000000000 (from port 1) during cycle 42 (210ns - 215ns)
*	Reading 0000110100011101101111001001010001101010010000110011110010010110 from address 000000001 (from port 0) during cycle 43 (215ns - 220ns)
*	Reading 0110001011100100001101011001111011110111100011110101010110001010 from address 111111100 (from port 1) during cycle 43 (215ns - 220ns)
*	Reading 1100010110001000010100011000101001101001110000011100101001100101 from address 000000011 (from port 0) during cycle 44 (220ns - 225ns)
*	Reading 1100010110001000010100011000101001101001110000011100101001100101 from address 000000011 (from port 1) during cycle 44 (220ns - 225ns)
*	Reading 0110001011100100001101011001111011110111100011110101010110001010 from address 111111100 (from port 0) during cycle 46 (230ns - 235ns)
*	Reading 1110011101011100000111001011111101001010100010010111001000101011 from address 111111101 (from port 1) during cycle 46 (230ns - 235ns)
*	Reading 1010000011111101100111010001010111100111010011111110101011011001 from address 111111011 (from port 0) during cycle 47 (235ns - 240ns)
*	Reading 0011010100100011001010000110010001001111001011000001101101101010 from address 000000000 (from port 1) during cycle 47 (235ns - 240ns)
*	Reading 1110011101011100000111001011111101001010100010010111001000101011 from address 111111101 (from port 0) during cycle 48 (240ns - 245ns)
*	Reading 0111101111111110001101111011101011110110100111011101001000111111 from address 111111110 (from port 1) during cycle 48 (240ns - 245ns)
*	Writing 0101001110010010000010000011110101001000110110011010101011010000  to  address 000000000 (from port 0) during cycle 49 (245ns - 250ns)
*	Writing 0111011011111000010111001010100001001110010001000110110001000000  to  address 111111100 (from port 1) during cycle 49 (245ns - 250ns)
*	Reading 0111011011111000010111001010100001001110010001000110110001000000 from address 111111100 (from port 0) during cycle 50 (250ns - 255ns)
*	Writing 1010101100111001111001101001010001000111100001001001010011111001  to  address 111111110 (from port 1) during cycle 50 (250ns - 255ns)
*	Reading 1010101100111001111001101001010001000111100001001001010011111001 from address 111111110 (from port 1) during cycle 51 (255ns - 260ns)
*	Reading 0000110100011101101111001001010001101010010000110011110010010110 from address 000000001 (from port 0) during cycle 53 (265ns - 270ns)
*	Reading 1010000011111101100111010001010111100111010011111110101011011001 from address 111111011 (from port 1) during cycle 53 (265ns - 270ns)
*	Reading 0101001110010010000010000011110101001000110110011010101011010000 from address 000000000 (from port 0) during cycle 55 (275ns - 280ns)
*	Reading 0101001110010010000010000011110101001000110110011010101011010000 from address 000000000 (from port 1) during cycle 55 (275ns - 280ns)
*	Reading 0101001110010010000010000011110101001000110110011010101011010000 from address 000000000 (from port 0) during cycle 56 (280ns - 285ns)
*	Reading 0101001110010010000010000011110101001000110110011010101011010000 from address 000000000 (from port 1) during cycle 56 (280ns - 285ns)
*	Reading 1100010110001000010100011000101001101001110000011100101001100101 from address 000000011 (from port 0) during cycle 57 (285ns - 290ns)
*	Writing 0111001011110101111001110010111111110100101111000110111011100110  to  address 000000001 (from port 1) during cycle 57 (285ns - 290ns)
*	Writing 0011001011001011110000111100010000011111100100010000001001000000  to  address 111111110 (from port 0) during cycle 58 (290ns - 295ns)
*	Reading 0111011011111000010111001010100001001110010001000110110001000000 from address 111111100 (from port 0) during cycle 59 (295ns - 300ns)
*	Reading 1010000011111101100111010001010111100111010011111110101011011001 from address 111111011 (from port 1) during cycle 59 (295ns - 300ns)
*	Reading 0101001110010010000010000011110101001000110110011010101011010000 from address 000000000 (from port 0) during cycle 60 (300ns - 305ns)
*	Writing 0001111010000101100111111010100110010101100010011000111110010110  to  address 111111011 (from port 1) during cycle 60 (300ns - 305ns)
*	Reading 1110011101011100000111001011111101001010100010010111001000101011 from address 111111101 (from port 0) during cycle 62 (310ns - 315ns)
*	Reading 1110011101011100000111001011111101001010100010010111001000101011 from address 111111101 (from port 1) during cycle 62 (310ns - 315ns)
*	Reading 0111011011111000010111001010100001001110010001000110110001000000 from address 111111100 (from port 1) during cycle 64 (320ns - 325ns)
*	Reading 1100010110001000010100011000101001101001110000011100101001100101 from address 000000011 (from port 1) during cycle 65 (325ns - 330ns)
*	Writing 1101111011001010110001100010011110110011010100101000100100101101  to  address 111111110 (from port 0) during cycle 67 (335ns - 340ns)
*	Reading 0111011011111000010111001010100001001110010001000110110001000000 from address 111111100 (from port 0) during cycle 68 (340ns - 345ns)
*	Reading 1100010110001000010100011000101001101001110000011100101001100101 from address 000000011 (from port 1) during cycle 68 (340ns - 345ns)
*	Reading 0011110101000001001011110000001001101100101011000101010000100001 from address 000000010 (from port 0) during cycle 69 (345ns - 350ns)
*	Reading 0111011011111000010111001010100001001110010001000110110001000000 from address 111111100 (from port 1) during cycle 69 (345ns - 350ns)
*	Writing 0101001010101100110000101000011000010001111111111101011111111000  to  address 111111100 (from port 0) during cycle 70 (350ns - 355ns)
*	Reading 1100010110001000010100011000101001101001110000011100101001100101 from address 000000011 (from port 1) during cycle 70 (350ns - 355ns)
*	Reading 1110011101011100000111001011111101001010100010010111001000101011 from address 111111101 (from port 1) during cycle 71 (355ns - 360ns)
*	Reading 1110011101011100000111001011111101001010100010010111001000101011 from address 111111101 (from port 1) during cycle 72 (360ns - 365ns)
*	Reading 1101111011001010110001100010011110110011010100101000100100101101 from address 111111110 (from port 0) during cycle 73 (365ns - 370ns)
*	Writing 0111111110011100100101011001000110101011110000001001111011111101  to  address 000000011 (from port 1) during cycle 73 (365ns - 370ns)
*	Reading 1101111011001010110001100010011110110011010100101000100100101101 from address 111111110 (from port 0) during cycle 74 (370ns - 375ns)
*	Reading 0111001011110101111001110010111111110100101111000110111011100110 from address 000000001 (from port 1) during cycle 75 (375ns - 380ns)
*	Reading 0101001010101100110000101000011000010001111111111101011111111000 from address 111111100 (from port 0) during cycle 76 (380ns - 385ns)
*	Writing 1011110100010000111000000010010100001011101111110000110101000111  to  address 111111011 (from port 1) during cycle 76 (380ns - 385ns)
*	Reading 0101001110010010000010000011110101001000110110011010101011010000 from address 000000000 (from port 1) during cycle 77 (385ns - 390ns)
*	Reading 0101001110010010000010000011110101001000110110011010101011010000 from address 000000000 (from port 0) during cycle 78 (390ns - 395ns)
*	Writing 0010100000001100100000010111101110110110000000101000000011101110  to  address 111111100 (from port 1) during cycle 78 (390ns - 395ns)
*	Reading 0010100000001100100000010111101110110110000000101000000011101110 from address 111111100 (from port 0) during cycle 79 (395ns - 400ns)
*	Writing 1011110010010110001111011110001001100100100010010101110000100010  to  address 111111100 (from port 1) during cycle 79 (395ns - 400ns)
*	Writing 0011000100101100001100010111001100000100100111111011011101001010  to  address 111111101 (from port 1) during cycle 80 (400ns - 405ns)
*	Reading 0111001011110101111001110010111111110100101111000110111011100110 from address 000000001 (from port 0) during cycle 81 (405ns - 410ns)
*	Reading 0111001011110101111001110010111111110100101111000110111011100110 from address 000000001 (from port 1) during cycle 81 (405ns - 410ns)
*	Writing 0001110100011111010101010010000000010010011100000111011000101100  to  address 000000001 (from port 0) during cycle 82 (410ns - 415ns)
*	Reading 1011110010010110001111011110001001100100100010010101110000100010 from address 111111100 (from port 1) during cycle 82 (410ns - 415ns)
*	Reading 0011110101000001001011110000001001101100101011000101010000100001 from address 000000010 (from port 0) during cycle 83 (415ns - 420ns)
*	Reading 1101111011001010110001100010011110110011010100101000100100101101 from address 111111110 (from port 1) during cycle 83 (415ns - 420ns)
*	Reading 1101111011001010110001100010011110110011010100101000100100101101 from address 111111110 (from port 0) during cycle 84 (420ns - 425ns)
*	Writing 0001100001111100011000000110000010011101101001111111100010010111  to  address 111111110 (from port 1) during cycle 84 (420ns - 425ns)
*	Reading 1011110100010000111000000010010100001011101111110000110101000111 from address 111111011 (from port 0) during cycle 86 (430ns - 435ns)
*	Reading 0001110100011111010101010010000000010010011100000111011000101100 from address 000000001 (from port 1) during cycle 86 (430ns - 435ns)
*	Writing 0001000100001000101011111011101110111101001000111100000100111001  to  address 000000010 (from port 0) during cycle 87 (435ns - 440ns)
*	Reading 0101001110010010000010000011110101001000110110011010101011010000 from address 000000000 (from port 1) during cycle 88 (440ns - 445ns)
*	Writing 0011000111100110111111100111010011001100011001001110100000011011  to  address 000000010 (from port 0) during cycle 89 (445ns - 450ns)
*	Reading 1011110100010000111000000010010100001011101111110000110101000111 from address 111111011 (from port 0) during cycle 90 (450ns - 455ns)
*	Reading 0001110100011111010101010010000000010010011100000111011000101100 from address 000000001 (from port 0) during cycle 91 (455ns - 460ns)
*	Reading 0011000111100110111111100111010011001100011001001110100000011011 from address 000000010 (from port 1) during cycle 91 (455ns - 460ns)
*	Reading 0111111110011100100101011001000110101011110000001001111011111101 from address 000000011 (from port 0) during cycle 92 (460ns - 465ns)
*	Reading 0111111110011100100101011001000110101011110000001001111011111101 from address 000000011 (from port 1) during cycle 92 (460ns - 465ns)
*	Reading 0001110100011111010101010010000000010010011100000111011000101100 from address 000000001 (from port 0) during cycle 93 (465ns - 470ns)
*	Writing 1110011011101101001100111111101101010000100010010101100110011111  to  address 000000000 (from port 1) during cycle 93 (465ns - 470ns)
*	Reading 0011000100101100001100010111001100000100100111111011011101001010 from address 111111101 (from port 0) during cycle 94 (470ns - 475ns)
*	Reading 1110011011101101001100111111101101010000100010010101100110011111 from address 000000000 (from port 1) during cycle 94 (470ns - 475ns)
*	Reading 1011110010010110001111011110001001100100100010010101110000100010 from address 111111100 (from port 0) during cycle 95 (475ns - 480ns)
*	Reading 0001110100011111010101010010000000010010011100000111011000101100 from address 000000001 (from port 1) during cycle 95 (475ns - 480ns)
*	Reading 1011110100010000111000000010010100001011101111110000110101000111 from address 111111011 (from port 0) during cycle 96 (480ns - 485ns)
*	Writing 0001100110111110011100100001011100110001110011011110100011110111  to  address 111111110 (from port 0) during cycle 97 (485ns - 490ns)
*	Writing 0101110010001111011000011110100001101111011111100111000011000111  to  address 000000001 (from port 1) during cycle 97 (485ns - 490ns)
*	Writing 1000100110110110000001110111011111010101100101010101111101100110  to  address 111111110 (from port 0) during cycle 98 (490ns - 495ns)
*	Reading 1011110100010000111000000010010100001011101111110000110101000111 from address 111111011 (from port 1) during cycle 98 (490ns - 495ns)
*	Reading 1011110100010000111000000010010100001011101111110000110101000111 from address 111111011 (from port 0) during cycle 99 (495ns - 500ns)
*	Reading 0101110010001111011000011110100001101111011111100111000011000111 from address 000000001 (from port 1) during cycle 99 (495ns - 500ns)
*	Writing 0011011001000010001010100010111100100011101111001111100100001011  to  address 111111110 (from port 0) during cycle 100 (500ns - 505ns)
*	Reading 0111111110011100100101011001000110101011110000001001111011111101 from address 000000011 (from port 1) during cycle 100 (500ns - 505ns)
*	Reading 1011110010010110001111011110001001100100100010010101110000100010 from address 111111100 (from port 0) during cycle 101 (505ns - 510ns)
*	Writing 1001010000000001100010011011111001100011111101000111111100100001  to  address 111111110 (from port 1) during cycle 101 (505ns - 510ns)
*	Reading 1011110010010110001111011110001001100100100010010101110000100010 from address 111111100 (from port 1) during cycle 102 (510ns - 515ns)
*	Writing 0100111100011100001000100101110110100101010011110111000001110111  to  address 000000010 (from port 0) during cycle 103 (515ns - 520ns)
*	Reading 1001010000000001100010011011111001100011111101000111111100100001 from address 111111110 (from port 1) during cycle 103 (515ns - 520ns)
*	Reading 0011000100101100001100010111001100000100100111111011011101001010 from address 111111101 (from port 0) during cycle 104 (520ns - 525ns)
*	Writing 0000110110101001101100001100110000100010001101010010000111001000  to  address 111111110 (from port 1) during cycle 104 (520ns - 525ns)
*	Reading 1011110100010000111000000010010100001011101111110000110101000111 from address 111111011 (from port 0) during cycle 105 (525ns - 530ns)
*	Writing 0011001111011101110110010010111001110111010100001011011100010111  to  address 000000011 (from port 0) during cycle 107 (535ns - 540ns)
*	Reading 0100111100011100001000100101110110100101010011110111000001110111 from address 000000010 (from port 1) during cycle 107 (535ns - 540ns)
*	Writing 0011110010001100101000010110111101100100011010101010011001111001  to  address 000000001 (from port 0) during cycle 108 (540ns - 545ns)
*	Writing 0111101100100010001101101001101010110100100011100000110100010100  to  address 000000001 (from port 0) during cycle 109 (545ns - 550ns)
*	Writing 1101001101100101010111010000101100010000000111100000101110100111  to  address 000000011 (from port 0) during cycle 110 (550ns - 555ns)
*	Reading 0011000100101100001100010111001100000100100111111011011101001010 from address 111111101 (from port 0) during cycle 111 (555ns - 560ns)
*	Reading 0111101100100010001101101001101010110100100011100000110100010100 from address 000000001 (from port 1) during cycle 111 (555ns - 560ns)
*	Writing 0000000101100000110111000110000001010100010010111100000001000100  to  address 111111011 (from port 0) during cycle 112 (560ns - 565ns)
*	Reading 0000110110101001101100001100110000100010001101010010000111001000 from address 111111110 (from port 1) during cycle 112 (560ns - 565ns)
*	Reading 0111101100100010001101101001101010110100100011100000110100010100 from address 000000001 (from port 0) during cycle 113 (565ns - 570ns)
*	Reading 0011000100101100001100010111001100000100100111111011011101001010 from address 111111101 (from port 1) during cycle 113 (565ns - 570ns)
*	Reading 1011110010010110001111011110001001100100100010010101110000100010 from address 111111100 (from port 0) during cycle 114 (570ns - 575ns)
*	Reading 1011110010010110001111011110001001100100100010010101110000100010 from address 111111100 (from port 1) during cycle 114 (570ns - 575ns)
*	Reading 1101001101100101010111010000101100010000000111100000101110100111 from address 000000011 (from port 0) during cycle 115 (575ns - 580ns)
*	Writing 1001011111001100010110101011111010001000101011111111001001000101  to  address 111111110 (from port 1) during cycle 116 (580ns - 585ns)
*	Writing 0011111100110000011100110011111001010011010000011000110001101110  to  address 111111110 (from port 1) during cycle 117 (585ns - 590ns)
*	Reading 1011110010010110001111011110001001100100100010010101110000100010 from address 111111100 (from port 1) during cycle 118 (590ns - 595ns)
*	Reading 0111101100100010001101101001101010110100100011100000110100010100 from address 000000001 (from port 0) during cycle 119 (595ns - 600ns)
*	Reading 0011000100101100001100010111001100000100100111111011011101001010 from address 111111101 (from port 1) during cycle 119 (595ns - 600ns)
*	Writing 1110011101101100001001110011110111000000101111100010110110001010  to  address 111111011 (from port 0) during cycle 120 (600ns - 605ns)
*	Reading 1110011011101101001100111111101101010000100010010101100110011111 from address 000000000 (from port 1) during cycle 120 (600ns - 605ns)
*	Reading 1011110010010110001111011110001001100100100010010101110000100010 from address 111111100 (from port 0) during cycle 121 (605ns - 610ns)
*	Writing 1001101101010011011001111010100001101101111100101100001010011100  to  address 111111100 (from port 1) during cycle 121 (605ns - 610ns)
*	Writing 1111111000101010001110011010001001011110000100110001011010111110  to  address 111111101 (from port 0) during cycle 122 (610ns - 615ns)
*	Reading 1001101101010011011001111010100001101101111100101100001010011100 from address 111111100 (from port 1) during cycle 122 (610ns - 615ns)
*	Reading 1110011101101100001001110011110111000000101111100010110110001010 from address 111111011 (from port 0) during cycle 123 (615ns - 620ns)
*	Writing 0100100100010011100110001111000111111011000100010110101101101001  to  address 111111100 (from port 1) during cycle 123 (615ns - 620ns)
*	Writing 0100011010110100010011110000000011100100011010000000110111100001  to  address 000000010 (from port 0) during cycle 124 (620ns - 625ns)
*	Reading 0111101100100010001101101001101010110100100011100000110100010100 from address 000000001 (from port 1) during cycle 124 (620ns - 625ns)
*	Reading 0111101100100010001101101001101010110100100011100000110100010100 from address 000000001 (from port 0) during cycle 125 (625ns - 630ns)
*	Reading 0011111100110000011100110011111001010011010000011000110001101110 from address 111111110 (from port 0) during cycle 126 (630ns - 635ns)
*	Writing 0100001100000111001011110110101000000001110110111000101011101000  to  address 000000011 (from port 0) during cycle 127 (635ns - 640ns)
*	Reading 0100011010110100010011110000000011100100011010000000110111100001 from address 000000010 (from port 1) during cycle 128 (640ns - 645ns)
*	Writing 0100001100001000101000111011011001011110110111101101010110110101  to  address 111111101 (from port 0) during cycle 129 (645ns - 650ns)
*	Writing 1111010001100100101110111000001100011111100010101100011011001000  to  address 000000010 (from port 0) during cycle 130 (650ns - 655ns)
*	Reading 0100001100001000101000111011011001011110110111101101010110110101 from address 111111101 (from port 1) during cycle 130 (650ns - 655ns)
*	Writing 1010011010100001011001000011000100010000000001100001101111100101  to  address 111111101 (from port 0) during cycle 131 (655ns - 660ns)
*	Reading 1110011101101100001001110011110111000000101111100010110110001010 from address 111111011 (from port 1) during cycle 131 (655ns - 660ns)
*	Reading 0011111100110000011100110011111001010011010000011000110001101110 from address 111111110 (from port 0) during cycle 133 (665ns - 670ns)
*	Reading 0100001100000111001011110110101000000001110110111000101011101000 from address 000000011 (from port 1) during cycle 133 (665ns - 670ns)
*	Writing 0111001011010110101111000000101001111111101111000111101011000011  to  address 000000011 (from port 0) during cycle 134 (670ns - 675ns)
*	Reading 0011111100110000011100110011111001010011010000011000110001101110 from address 111111110 (from port 0) during cycle 135 (675ns - 680ns)
*	Reading 1111010001100100101110111000001100011111100010101100011011001000 from address 000000010 (from port 1) during cycle 135 (675ns - 680ns)
*	Reading 1010011010100001011001000011000100010000000001100001101111100101 from address 111111101 (from port 0) during cycle 136 (680ns - 685ns)
*	Reading 0111101100100010001101101001101010110100100011100000110100010100 from address 000000001 (from port 1) during cycle 136 (680ns - 685ns)
*	Reading 0100100100010011100110001111000111111011000100010110101101101001 from address 111111100 (from port 0) during cycle 137 (685ns - 690ns)
*	Reading 1010011010100001011001000011000100010000000001100001101111100101 from address 111111101 (from port 1) during cycle 137 (685ns - 690ns)
*	Reading 1110011101101100001001110011110111000000101111100010110110001010 from address 111111011 (from port 0) during cycle 138 (690ns - 695ns)
*	Writing 1000110010000101011001001100011001110100000100110010101010100011  to  address 111111011 (from port 1) during cycle 138 (690ns - 695ns)
*	Reading 1010011010100001011001000011000100010000000001100001101111100101 from address 111111101 (from port 0) during cycle 139 (695ns - 700ns)
*	Reading 1110011011101101001100111111101101010000100010010101100110011111 from address 000000000 (from port 1) during cycle 139 (695ns - 700ns)
*	Reading 1000110010000101011001001100011001110100000100110010101010100011 from address 111111011 (from port 0) during cycle 140 (700ns - 705ns)
*	Reading 1110011011101101001100111111101101010000100010010101100110011111 from address 000000000 (from port 1) during cycle 140 (700ns - 705ns)
*	Reading 1110011011101101001100111111101101010000100010010101100110011111 from address 000000000 (from port 0) during cycle 141 (705ns - 710ns)
*	Reading 0111101100100010001101101001101010110100100011100000110100010100 from address 000000001 (from port 1) during cycle 141 (705ns - 710ns)
*	Reading 0111001011010110101111000000101001111111101111000111101011000011 from address 000000011 (from port 0) during cycle 142 (710ns - 715ns)
*	Reading 1000110010000101011001001100011001110100000100110010101010100011 from address 111111011 (from port 0) during cycle 143 (715ns - 720ns)
*	Reading 0011111100110000011100110011111001010011010000011000110001101110 from address 111111110 (from port 1) during cycle 143 (715ns - 720ns)
*	Writing 0111001011000110010111110110001001011100010111101001111100010100  to  address 111111011 (from port 0) during cycle 144 (720ns - 725ns)
*	Reading 1111010001100100101110111000001100011111100010101100011011001000 from address 000000010 (from port 1) during cycle 144 (720ns - 725ns)
*	Reading 1010011010100001011001000011000100010000000001100001101111100101 from address 111111101 (from port 0) during cycle 145 (725ns - 730ns)
*	Reading 1010011010100001011001000011000100010000000001100001101111100101 from address 111111101 (from port 1) during cycle 145 (725ns - 730ns)
*	Reading 0111001011010110101111000000101001111111101111000111101011000011 from address 000000011 (from port 0) during cycle 146 (730ns - 735ns)
*	Writing 0110001011011000010100100000111100001111000011110010100010101110  to  address 000000011 (from port 1) during cycle 146 (730ns - 735ns)
*	Reading 0100100100010011100110001111000111111011000100010110101101101001 from address 111111100 (from port 0) during cycle 147 (735ns - 740ns)
*	Writing 0110100001000110111110001001001101010001010010110001100010110101  to  address 111111110 (from port 1) during cycle 147 (735ns - 740ns)
*	Writing 1100001001100001111111000011010111100011000011010111101101010101  to  address 111111101 (from port 0) during cycle 148 (740ns - 745ns)
*	Reading 0111101100100010001101101001101010110100100011100000110100010100 from address 000000001 (from port 0) during cycle 149 (745ns - 750ns)
*	Reading 0111001011000110010111110110001001011100010111101001111100010100 from address 111111011 (from port 1) during cycle 149 (745ns - 750ns)
*	Reading 0100100100010011100110001111000111111011000100010110101101101001 from address 111111100 (from port 0) during cycle 150 (750ns - 755ns)
*	Reading 0100100100010011100110001111000111111011000100010110101101101001 from address 111111100 (from port 1) during cycle 150 (750ns - 755ns)
*	Reading 1110011011101101001100111111101101010000100010010101100110011111 from address 000000000 (from port 1) during cycle 151 (755ns - 760ns)
*	Reading 0110100001000110111110001001001101010001010010110001100010110101 from address 111111110 (from port 0) during cycle 152 (760ns - 765ns)
*	Writing 1110110111010000011000010000111100000010010011111100100110001100  to  address 111111101 (from port 1) during cycle 152 (760ns - 765ns)
*	Reading 1111010001100100101110111000001100011111100010101100011011001000 from address 000000010 (from port 0) during cycle 153 (765ns - 770ns)
*	Writing 1111000101010001011011111101001111110010001011001001000011010001  to  address 000000011 (from port 1) during cycle 153 (765ns - 770ns)
*	Writing 1101100100010000111000110001011101110111110000110100101010010011  to  address 111111100 (from port 0) during cycle 154 (770ns - 775ns)
*	Writing 1111101110010110000110001001101000110011111010100000001011100001  to  address 000000001 (from port 1) during cycle 154 (770ns - 775ns)
*	Reading 1111010001100100101110111000001100011111100010101100011011001000 from address 000000010 (from port 0) during cycle 155 (775ns - 780ns)
*	Reading 1110011011101101001100111111101101010000100010010101100110011111 from address 000000000 (from port 1) during cycle 155 (775ns - 780ns)
*	Writing 0111001100111111011000110011110001110000010001111011011010111110  to  address 111111011 (from port 0) during cycle 156 (780ns - 785ns)
*	Reading 1110110111010000011000010000111100000010010011111100100110001100 from address 111111101 (from port 0) during cycle 157 (785ns - 790ns)
*	Reading 1110011011101101001100111111101101010000100010010101100110011111 from address 000000000 (from port 0) during cycle 158 (790ns - 795ns)
*	Writing 0010000010001100001000010001100100001101100111000000101111101101  to  address 111111110 (from port 1) during cycle 158 (790ns - 795ns)
*	Reading 0111001100111111011000110011110001110000010001111011011010111110 from address 111111011 (from port 0) during cycle 159 (795ns - 800ns)
*	Reading 0010000010001100001000010001100100001101100111000000101111101101 from address 111111110 (from port 1) during cycle 160 (800ns - 805ns)
*	Writing 0111001011011111101000000010101011101100110011101101001110000011  to  address 000000001 (from port 0) during cycle 161 (805ns - 810ns)
*	Reading 1111000101010001011011111101001111110010001011001001000011010001 from address 000000011 (from port 1) during cycle 161 (805ns - 810ns)
*	Writing 0111000101111101001110011011101010110110011111110101000100010000  to  address 111111101 (from port 0) during cycle 162 (810ns - 815ns)
*	Writing 1101100001111001110000000010100100111100101110101010010000001000  to  address 000000001 (from port 1) during cycle 162 (810ns - 815ns)
*	Reading 1101100001111001110000000010100100111100101110101010010000001000 from address 000000001 (from port 0) during cycle 163 (815ns - 820ns)
*	Reading 0010000010001100001000010001100100001101100111000000101111101101 from address 111111110 (from port 0) during cycle 164 (820ns - 825ns)
*	Reading 1111010001100100101110111000001100011111100010101100011011001000 from address 000000010 (from port 1) during cycle 164 (820ns - 825ns)
*	Reading 0111000101111101001110011011101010110110011111110101000100010000 from address 111111101 (from port 0) during cycle 165 (825ns - 830ns)
*	Reading 1111000101010001011011111101001111110010001011001001000011010001 from address 000000011 (from port 0) during cycle 166 (830ns - 835ns)
*	Writing 0110101011101110010001110101001100000010001100100101110111001100  to  address 111111011 (from port 1) during cycle 166 (830ns - 835ns)
*	Reading 0110101011101110010001110101001100000010001100100101110111001100 from address 111111011 (from port 0) during cycle 167 (835ns - 840ns)
*	Reading 1111000101010001011011111101001111110010001011001001000011010001 from address 000000011 (from port 1) during cycle 167 (835ns - 840ns)
*	Writing 1000100111011110000111010111110001001001011100110011000111010000  to  address 111111100 (from port 0) during cycle 168 (840ns - 845ns)
*	Reading 1110011011101101001100111111101101010000100010010101100110011111 from address 000000000 (from port 1) during cycle 168 (840ns - 845ns)
*	Reading 1101100001111001110000000010100100111100101110101010010000001000 from address 000000001 (from port 1) during cycle 169 (845ns - 850ns)
*	Writing 1101101001101100110000010011101010000011110001011001010011011111  to  address 000000001 (from port 0) during cycle 170 (850ns - 855ns)
*	Reading 1110011011101101001100111111101101010000100010010101100110011111 from address 000000000 (from port 1) during cycle 170 (850ns - 855ns)
*	Writing 0000111010100101011100001000011010001110110110101101000000011000  to  address 111111011 (from port 0) during cycle 171 (855ns - 860ns)
*	Reading 1101101001101100110000010011101010000011110001011001010011011111 from address 000000001 (from port 1) during cycle 171 (855ns - 860ns)
*	Reading 1111010001100100101110111000001100011111100010101100011011001000 from address 000000010 (from port 0) during cycle 172 (860ns - 865ns)
*	Writing 0111110110111111111101010101110101011101101011010001110000110000  to  address 000000010 (from port 1) during cycle 172 (860ns - 865ns)
*	Writing 1101000001001110000001010111011011111001000111001000101011100011  to  address 111111100 (from port 0) during cycle 173 (865ns - 870ns)
*	Writing 0111111001110111001011111111110011110010000001000010000001100010  to  address 000000001 (from port 0) during cycle 174 (870ns - 875ns)
*	Reading 0111110110111111111101010101110101011101101011010001110000110000 from address 000000010 (from port 1) during cycle 174 (870ns - 875ns)
*	Reading 0111000101111101001110011011101010110110011111110101000100010000 from address 111111101 (from port 0) during cycle 175 (875ns - 880ns)
*	Reading 1111000101010001011011111101001111110010001011001001000011010001 from address 000000011 (from port 1) during cycle 175 (875ns - 880ns)
*	Reading 0111111001110111001011111111110011110010000001000010000001100010 from address 000000001 (from port 0) during cycle 176 (880ns - 885ns)
*	Writing 1000100110010110010100110001110000100000001101011011001000111000  to  address 111111101 (from port 1) during cycle 176 (880ns - 885ns)
*	Reading 1110011011101101001100111111101101010000100010010101100110011111 from address 000000000 (from port 0) during cycle 177 (885ns - 890ns)
*	Reading 0111110110111111111101010101110101011101101011010001110000110000 from address 000000010 (from port 0) during cycle 178 (890ns - 895ns)
*	Reading 1000100110010110010100110001110000100000001101011011001000111000 from address 111111101 (from port 1) during cycle 178 (890ns - 895ns)
*	Reading 0010000010001100001000010001100100001101100111000000101111101101 from address 111111110 (from port 0) during cycle 179 (895ns - 900ns)
*	Reading 0000111010100101011100001000011010001110110110101101000000011000 from address 111111011 (from port 1) during cycle 179 (895ns - 900ns)
*	Reading 1111000101010001011011111101001111110010001011001001000011010001 from address 000000011 (from port 0) during cycle 180 (900ns - 905ns)
*	Writing 1111101110011000010011010011011010001010000001011111110101110011  to  address 111111011 (from port 1) during cycle 180 (900ns - 905ns)
*	Reading 1110011011101101001100111111101101010000100010010101100110011111 from address 000000000 (from port 0) during cycle 181 (905ns - 910ns)
*	Writing 1001100100000111110011110110010011101001101011111010111110101011  to  address 000000000 (from port 1) during cycle 181 (905ns - 910ns)
*	Writing 0110110110111100101001101110010111010000111010101100110000101111  to  address 111111100 (from port 0) during cycle 182 (910ns - 915ns)
*	Writing 0101000111001001110010100110110010001110100100001111000110001110  to  address 000000010 (from port 0) during cycle 183 (915ns - 920ns)
*	Reading 0110110110111100101001101110010111010000111010101100110000101111 from address 111111100 (from port 1) during cycle 183 (915ns - 920ns)
*	Reading 1111101110011000010011010011011010001010000001011111110101110011 from address 111111011 (from port 1) during cycle 184 (920ns - 925ns)
*	Reading 1111000101010001011011111101001111110010001011001001000011010001 from address 000000011 (from port 0) during cycle 185 (925ns - 930ns)
*	Writing 0111111100100111000001111111011100101001000000100001100111011011  to  address 000000010 (from port 1) during cycle 185 (925ns - 930ns)
*	Writing 1111001111010011011011100010010010111110010101100111110010001000  to  address 111111101 (from port 0) during cycle 186 (930ns - 935ns)
*	Writing 1000111001010100001001101001011100110110111010101100001111000110  to  address 111111100 (from port 1) during cycle 186 (930ns - 935ns)
*	Reading 1001100100000111110011110110010011101001101011111010111110101011 from address 000000000 (from port 0) during cycle 188 (940ns - 945ns)
*	Reading 0111111001110111001011111111110011110010000001000010000001100010 from address 000000001 (from port 1) during cycle 188 (940ns - 945ns)
*	Reading 1111101110011000010011010011011010001010000001011111110101110011 from address 111111011 (from port 0) during cycle 189 (945ns - 950ns)
*	Writing 0000100110001001111000110110111000110111000001011000000110110111  to  address 000000001 (from port 1) during cycle 189 (945ns - 950ns)
*	Reading 1111000101010001011011111101001111110010001011001001000011010001 from address 000000011 (from port 1) during cycle 190 (950ns - 955ns)
*	Reading 1111001111010011011011100010010010111110010101100111110010001000 from address 111111101 (from port 0) during cycle 191 (955ns - 960ns)
*	Reading 0111111100100111000001111111011100101001000000100001100111011011 from address 000000010 (from port 1) during cycle 192 (960ns - 965ns)
*	Writing 1110110110010100110101101000000001001000010000000111011101000111  to  address 000000010 (from port 0) during cycle 193 (965ns - 970ns)
*	Reading 1111101110011000010011010011011010001010000001011111110101110011 from address 111111011 (from port 1) during cycle 193 (965ns - 970ns)
*	Reading 0010000010001100001000010001100100001101100111000000101111101101 from address 111111110 (from port 0) during cycle 194 (970ns - 975ns)
*	Reading 1110110110010100110101101000000001001000010000000111011101000111 from address 000000010 (from port 1) during cycle 194 (970ns - 975ns)
*	Reading 1001100100000111110011110110010011101001101011111010111110101011 from address 000000000 (from port 0) during cycle 195 (975ns - 980ns)
*	Reading 1001100100000111110011110110010011101001101011111010111110101011 from address 000000000 (from port 0) during cycle 196 (980ns - 985ns)
*	Reading 1001100100000111110011110110010011101001101011111010111110101011 from address 000000000 (from port 0) during cycle 197 (985ns - 990ns)
*	Reading 1110110110010100110101101000000001001000010000000111011101000111 from address 000000010 (from port 1) during cycle 197 (985ns - 990ns)
*	Reading 1001100100000111110011110110010011101001101011111010111110101011 from address 000000000 (from port 1) during cycle 198 (990ns - 995ns)
*	Reading 1111000101010001011011111101001111110010001011001001000011010001 from address 000000011 (from port 1) during cycle 199 (995ns - 1000ns)
*	Reading 1111001111010011011011100010010010111110010101100111110010001000 from address 111111101 (from port 0) during cycle 200 (1000ns - 1005ns)
*	Writing 1111001111010110101110011111000110011101000101101011011100101101  to  address 111111100 (from port 1) during cycle 200 (1000ns - 1005ns)
*	Reading 1111001111010110101110011111000110011101000101101011011100101101 from address 111111100 (from port 0) during cycle 201 (1005ns - 1010ns)
*	Writing 0010111111111100101011010010100101010010101101110001010111111001  to  address 000000010 (from port 1) during cycle 202 (1010ns - 1015ns)
*	Reading 0010111111111100101011010010100101010010101101110001010111111001 from address 000000010 (from port 0) during cycle 203 (1015ns - 1020ns)
*	Reading 1111001111010011011011100010010010111110010101100111110010001000 from address 111111101 (from port 1) during cycle 203 (1015ns - 1020ns)
*	Writing 0101111100000000010010010100101000011011001111111110001111100111  to  address 111111011 (from port 0) during cycle 204 (1020ns - 1025ns)
*	Writing 1111101001111011010110110011000100010010000111111000011110001100  to  address 111111110 (from port 1) during cycle 204 (1020ns - 1025ns)
*	Idle during cycle 205 (1025ns - 1030ns)

* Generation of data and address signals
* (time, data): [(0, 0), (5, 0), (10, 0), (15, 0), (20, 0), (25, 0), (30, 0), (35, 0), (40, 0), (45, 0), (50, 0), (55, 0), (60, 0), (65, 0), (70, 0), (75, 0), (80, 0), (85, 1), (90, 1), (95, 1), (100, 1), (105, 0), (110, 0), (115, 0), (120, 0), (125, 0), (130, 0), (135, 0), (140, 0), (145, 0), (150, 0), (155, 0), (160, 0), (165, 0), (170, 0), (175, 1), (180, 1), (185, 1), (190, 1), (195, 1), (200, 1), (205, 1), (210, 1), (215, 1), (220, 1), (225, 1), (230, 1), (235, 1), (240, 1), (245, 0), (250, 0), (255, 0), (260, 0), (265, 0), (270, 0), (275, 0), (280, 0), (285, 0), (290, 0), (295, 0), (300, 0), (305, 0), (310, 0), (315, 0), (320, 0), (325, 0), (330, 0), (335, 1), (340, 1), (345, 1), (350, 0), (355, 0), (360, 0), (365, 0), (370, 0), (375, 0), (380, 0), (385, 0), (390, 0), (395, 0), (400, 0), (405, 0), (410, 0), (415, 0), (420, 0), (425, 0), (430, 0), (435, 1), (440, 1), (445, 1), (450, 1), (455, 1), (460, 1), (465, 1), (470, 1), (475, 1), (480, 1), (485, 1), (490, 0), (495, 0), (500, 1), (505, 1), (510, 1), (515, 1), (520, 1), (525, 1), (530, 1), (535, 1), (540, 1), (545, 0), (550, 1), (555, 1), (560, 0), (565, 0), (570, 0), (575, 0), (580, 0), (585, 0), (590, 0), (595, 0), (600, 0), (605, 0), (610, 0), (615, 0), (620, 1), (625, 1), (630, 1), (635, 0), (640, 0), (645, 1), (650, 0), (655, 1), (660, 1), (665, 1), (670, 1), (675, 1), (680, 1), (685, 1), (690, 1), (695, 1), (700, 1), (705, 1), (710, 1), (715, 1), (720, 0), (725, 0), (730, 0), (735, 0), (740, 1), (745, 1), (750, 1), (755, 1), (760, 1), (765, 1), (770, 1), (775, 1), (780, 0), (785, 0), (790, 0), (795, 0), (800, 0), (805, 1), (810, 0), (815, 0), (820, 0), (825, 0), (830, 0), (835, 0), (840, 0), (845, 0), (850, 1), (855, 0), (860, 0), (865, 1), (870, 0), (875, 0), (880, 0), (885, 0), (890, 0), (895, 0), (900, 0), (905, 0), (910, 1), (915, 0), (920, 0), (925, 0), (930, 0), (935, 0), (940, 0), (945, 0), (950, 0), (955, 0), (960, 0), (965, 1), (970, 1), (975, 1), (980, 1), (985, 1), (990, 1), (995, 1), (1000, 1), (1005, 1), (1010, 1), (1015, 1), (1020, 1), (1025, 1)]
Vdin0_0  din0_0  0 PWL (0n 0.0v 4.745n 0.0v 4.755n 0.0v 9.745n 0.0v 9.755n 0.0v 14.745n 0.0v 14.755n 0.0v 19.745n 0.0v 19.755n 0.0v 24.745n 0.0v 24.755n 0.0v 29.745n 0.0v 29.755n 0.0v 34.745n 0.0v 34.755n 0.0v 39.745n 0.0v 39.755n 0.0v 44.745n 0.0v 44.755n 0.0v 49.745n 0.0v 49.755n 0.0v 54.745n 0.0v 54.755n 0.0v 59.745n 0.0v 59.755n 0.0v 64.745n 0.0v 64.755n 0.0v 69.745n 0.0v 69.755n 0.0v 74.745n 0.0v 74.755n 0.0v 79.745n 0.0v 79.755n 0.0v 84.745n 0.0v 84.755n 1.0v 89.745n 1.0v 89.755n 1.0v 94.745n 1.0v 94.755n 1.0v 99.745n 1.0v 99.755n 1.0v 104.745n 1.0v 104.755n 0.0v 109.745n 0.0v 109.755n 0.0v 114.745n 0.0v 114.755n 0.0v 119.745n 0.0v 119.755n 0.0v 124.745n 0.0v 124.755n 0.0v 129.745n 0.0v 129.755n 0.0v 134.745n 0.0v 134.755n 0.0v 139.745n 0.0v 139.755n 0.0v 144.745n 0.0v 144.755n 0.0v 149.745n 0.0v 149.755n 0.0v 154.745n 0.0v 154.755n 0.0v 159.745n 0.0v 159.755n 0.0v 164.745n 0.0v 164.755n 0.0v 169.745n 0.0v 169.755n 0.0v 174.745n 0.0v 174.755n 1.0v 179.745n 1.0v 179.755n 1.0v 184.745n 1.0v 184.755n 1.0v 189.745n 1.0v 189.755n 1.0v 194.745n 1.0v 194.755n 1.0v 199.745n 1.0v 199.755n 1.0v 204.745n 1.0v 204.755n 1.0v 209.745n 1.0v 209.755n 1.0v 214.745n 1.0v 214.755n 1.0v 219.745n 1.0v 219.755n 1.0v 224.745n 1.0v 224.755n 1.0v 229.745n 1.0v 229.755n 1.0v 234.745n 1.0v 234.755n 1.0v 239.745n 1.0v 239.755n 1.0v 244.745n 1.0v 244.755n 0.0v 249.745n 0.0v 249.755n 0.0v 254.745n 0.0v 254.755n 0.0v 259.745n 0.0v 259.755n 0.0v 264.745n 0.0v 264.755n 0.0v 269.745n 0.0v 269.755n 0.0v 274.745n 0.0v 274.755n 0.0v 279.745n 0.0v 279.755n 0.0v 284.745n 0.0v 284.755n 0.0v 289.745n 0.0v 289.755n 0.0v 294.745n 0.0v 294.755n 0.0v 299.745n 0.0v 299.755n 0.0v 304.745n 0.0v 304.755n 0.0v 309.745n 0.0v 309.755n 0.0v 314.745n 0.0v 314.755n 0.0v 319.745n 0.0v 319.755n 0.0v 324.745n 0.0v 324.755n 0.0v 329.745n 0.0v 329.755n 0.0v 334.745n 0.0v 334.755n 1.0v 339.745n 1.0v 339.755n 1.0v 344.745n 1.0v 344.755n 1.0v 349.745n 1.0v 349.755n 0.0v 354.745n 0.0v 354.755n 0.0v 359.745n 0.0v 359.755n 0.0v 364.745n 0.0v 364.755n 0.0v 369.745n 0.0v 369.755n 0.0v 374.745n 0.0v 374.755n 0.0v 379.745n 0.0v 379.755n 0.0v 384.745n 0.0v 384.755n 0.0v 389.745n 0.0v 389.755n 0.0v 394.745n 0.0v 394.755n 0.0v 399.745n 0.0v 399.755n 0.0v 404.745n 0.0v 404.755n 0.0v 409.745n 0.0v 409.755n 0.0v 414.745n 0.0v 414.755n 0.0v 419.745n 0.0v 419.755n 0.0v 424.745n 0.0v 424.755n 0.0v 429.745n 0.0v 429.755n 0.0v 434.745n 0.0v 434.755n 1.0v 439.745n 1.0v 439.755n 1.0v 444.745n 1.0v 444.755n 1.0v 449.745n 1.0v 449.755n 1.0v 454.745n 1.0v 454.755n 1.0v 459.745n 1.0v 459.755n 1.0v 464.745n 1.0v 464.755n 1.0v 469.745n 1.0v 469.755n 1.0v 474.745n 1.0v 474.755n 1.0v 479.745n 1.0v 479.755n 1.0v 484.745n 1.0v 484.755n 1.0v 489.745n 1.0v 489.755n 0.0v 494.745n 0.0v 494.755n 0.0v 499.745n 0.0v 499.755n 1.0v 504.745n 1.0v 504.755n 1.0v 509.745n 1.0v 509.755n 1.0v 514.745n 1.0v 514.755n 1.0v 519.745n 1.0v 519.755n 1.0v 524.745n 1.0v 524.755n 1.0v 529.745n 1.0v 529.755n 1.0v 534.745n 1.0v 534.755n 1.0v 539.745n 1.0v 539.755n 1.0v 544.745n 1.0v 544.755n 0.0v 549.745n 0.0v 549.755n 1.0v 554.745n 1.0v 554.755n 1.0v 559.745n 1.0v 559.755n 0.0v 564.745n 0.0v 564.755n 0.0v 569.745n 0.0v 569.755n 0.0v 574.745n 0.0v 574.755n 0.0v 579.745n 0.0v 579.755n 0.0v 584.745n 0.0v 584.755n 0.0v 589.745n 0.0v 589.755n 0.0v 594.745n 0.0v 594.755n 0.0v 599.745n 0.0v 599.755n 0.0v 604.745n 0.0v 604.755n 0.0v 609.745n 0.0v 609.755n 0.0v 614.745n 0.0v 614.755n 0.0v 619.745n 0.0v 619.755n 1.0v 624.745n 1.0v 624.755n 1.0v 629.745n 1.0v 629.755n 1.0v 634.745n 1.0v 634.755n 0.0v 639.745n 0.0v 639.755n 0.0v 644.745n 0.0v 644.755n 1.0v 649.745n 1.0v 649.755n 0.0v 654.745n 0.0v 654.755n 1.0v 659.745n 1.0v 659.755n 1.0v 664.745n 1.0v 664.755n 1.0v 669.745n 1.0v 669.755n 1.0v 674.745n 1.0v 674.755n 1.0v 679.745n 1.0v 679.755n 1.0v 684.745n 1.0v 684.755n 1.0v 689.745n 1.0v 689.755n 1.0v 694.745n 1.0v 694.755n 1.0v 699.745n 1.0v 699.755n 1.0v 704.745n 1.0v 704.755n 1.0v 709.745n 1.0v 709.755n 1.0v 714.745n 1.0v 714.755n 1.0v 719.745n 1.0v 719.755n 0.0v 724.745n 0.0v 724.755n 0.0v 729.745n 0.0v 729.755n 0.0v 734.745n 0.0v 734.755n 0.0v 739.745n 0.0v 739.755n 1.0v 744.745n 1.0v 744.755n 1.0v 749.745n 1.0v 749.755n 1.0v 754.745n 1.0v 754.755n 1.0v 759.745n 1.0v 759.755n 1.0v 764.745n 1.0v 764.755n 1.0v 769.745n 1.0v 769.755n 1.0v 774.745n 1.0v 774.755n 1.0v 779.745n 1.0v 779.755n 0.0v 784.745n 0.0v 784.755n 0.0v 789.745n 0.0v 789.755n 0.0v 794.745n 0.0v 794.755n 0.0v 799.745n 0.0v 799.755n 0.0v 804.745n 0.0v 804.755n 1.0v 809.745n 1.0v 809.755n 0.0v 814.745n 0.0v 814.755n 0.0v 819.745n 0.0v 819.755n 0.0v 824.745n 0.0v 824.755n 0.0v 829.745n 0.0v 829.755n 0.0v 834.745n 0.0v 834.755n 0.0v 839.745n 0.0v 839.755n 0.0v 844.745n 0.0v 844.755n 0.0v 849.745n 0.0v 849.755n 1.0v 854.745n 1.0v 854.755n 0.0v 859.745n 0.0v 859.755n 0.0v 864.745n 0.0v 864.755n 1.0v 869.745n 1.0v 869.755n 0.0v 874.745n 0.0v 874.755n 0.0v 879.745n 0.0v 879.755n 0.0v 884.745n 0.0v 884.755n 0.0v 889.745n 0.0v 889.755n 0.0v 894.745n 0.0v 894.755n 0.0v 899.745n 0.0v 899.755n 0.0v 904.745n 0.0v 904.755n 0.0v 909.745n 0.0v 909.755n 1.0v 914.745n 1.0v 914.755n 0.0v 919.745n 0.0v 919.755n 0.0v 924.745n 0.0v 924.755n 0.0v 929.745n 0.0v 929.755n 0.0v 934.745n 0.0v 934.755n 0.0v 939.745n 0.0v 939.755n 0.0v 944.745n 0.0v 944.755n 0.0v 949.745n 0.0v 949.755n 0.0v 954.745n 0.0v 954.755n 0.0v 959.745n 0.0v 959.755n 0.0v 964.745n 0.0v 964.755n 1.0v 969.745n 1.0v 969.755n 1.0v 974.745n 1.0v 974.755n 1.0v 979.745n 1.0v 979.755n 1.0v 984.745n 1.0v 984.755n 1.0v 989.745n 1.0v 989.755n 1.0v 994.745n 1.0v 994.755n 1.0v 999.745n 1.0v 999.755n 1.0v 1004.745n 1.0v 1004.755n 1.0v 1009.745n 1.0v 1009.755n 1.0v 1014.745n 1.0v 1014.755n 1.0v 1019.745n 1.0v 1019.755n 1.0v 1024.745n 1.0v 1024.755n 1.0v )
* (time, data): [(0, 0), (5, 0), (10, 0), (15, 1), (20, 1), (25, 1), (30, 1), (35, 1), (40, 1), (45, 1), (50, 1), (55, 1), (60, 1), (65, 1), (70, 1), (75, 1), (80, 1), (85, 0), (90, 0), (95, 0), (100, 1), (105, 0), (110, 0), (115, 1), (120, 1), (125, 1), (130, 1), (135, 1), (140, 1), (145, 1), (150, 1), (155, 0), (160, 0), (165, 0), (170, 0), (175, 1), (180, 1), (185, 1), (190, 0), (195, 0), (200, 0), (205, 0), (210, 0), (215, 0), (220, 0), (225, 0), (230, 0), (235, 0), (240, 0), (245, 0), (250, 0), (255, 0), (260, 0), (265, 0), (270, 0), (275, 0), (280, 0), (285, 0), (290, 0), (295, 0), (300, 0), (305, 0), (310, 0), (315, 0), (320, 0), (325, 0), (330, 0), (335, 0), (340, 0), (345, 0), (350, 0), (355, 0), (360, 0), (365, 0), (370, 0), (375, 0), (380, 0), (385, 0), (390, 0), (395, 0), (400, 0), (405, 0), (410, 0), (415, 0), (420, 0), (425, 0), (430, 0), (435, 0), (440, 0), (445, 1), (450, 1), (455, 1), (460, 1), (465, 1), (470, 1), (475, 1), (480, 1), (485, 1), (490, 1), (495, 1), (500, 1), (505, 1), (510, 1), (515, 1), (520, 1), (525, 1), (530, 1), (535, 1), (540, 0), (545, 0), (550, 1), (555, 1), (560, 0), (565, 0), (570, 0), (575, 0), (580, 0), (585, 0), (590, 0), (595, 0), (600, 1), (605, 1), (610, 1), (615, 1), (620, 0), (625, 0), (630, 0), (635, 0), (640, 0), (645, 0), (650, 0), (655, 0), (660, 0), (665, 0), (670, 1), (675, 1), (680, 1), (685, 1), (690, 1), (695, 1), (700, 1), (705, 1), (710, 1), (715, 1), (720, 0), (725, 0), (730, 0), (735, 0), (740, 0), (745, 0), (750, 0), (755, 0), (760, 0), (765, 0), (770, 1), (775, 1), (780, 1), (785, 1), (790, 1), (795, 1), (800, 1), (805, 1), (810, 0), (815, 0), (820, 0), (825, 0), (830, 0), (835, 0), (840, 0), (845, 0), (850, 1), (855, 0), (860, 0), (865, 1), (870, 1), (875, 1), (880, 1), (885, 1), (890, 1), (895, 1), (900, 1), (905, 1), (910, 1), (915, 1), (920, 1), (925, 1), (930, 0), (935, 0), (940, 0), (945, 0), (950, 0), (955, 0), (960, 0), (965, 1), (970, 1), (975, 1), (980, 1), (985, 1), (990, 1), (995, 1), (1000, 1), (1005, 1), (1010, 1), (1015, 1), (1020, 1), (1025, 1)]
Vdin0_1  din0_1  0 PWL (0n 0.0v 4.745n 0.0v 4.755n 0.0v 9.745n 0.0v 9.755n 0.0v 14.745n 0.0v 14.755n 1.0v 19.745n 1.0v 19.755n 1.0v 24.745n 1.0v 24.755n 1.0v 29.745n 1.0v 29.755n 1.0v 34.745n 1.0v 34.755n 1.0v 39.745n 1.0v 39.755n 1.0v 44.745n 1.0v 44.755n 1.0v 49.745n 1.0v 49.755n 1.0v 54.745n 1.0v 54.755n 1.0v 59.745n 1.0v 59.755n 1.0v 64.745n 1.0v 64.755n 1.0v 69.745n 1.0v 69.755n 1.0v 74.745n 1.0v 74.755n 1.0v 79.745n 1.0v 79.755n 1.0v 84.745n 1.0v 84.755n 0.0v 89.745n 0.0v 89.755n 0.0v 94.745n 0.0v 94.755n 0.0v 99.745n 0.0v 99.755n 1.0v 104.745n 1.0v 104.755n 0.0v 109.745n 0.0v 109.755n 0.0v 114.745n 0.0v 114.755n 1.0v 119.745n 1.0v 119.755n 1.0v 124.745n 1.0v 124.755n 1.0v 129.745n 1.0v 129.755n 1.0v 134.745n 1.0v 134.755n 1.0v 139.745n 1.0v 139.755n 1.0v 144.745n 1.0v 144.755n 1.0v 149.745n 1.0v 149.755n 1.0v 154.745n 1.0v 154.755n 0.0v 159.745n 0.0v 159.755n 0.0v 164.745n 0.0v 164.755n 0.0v 169.745n 0.0v 169.755n 0.0v 174.745n 0.0v 174.755n 1.0v 179.745n 1.0v 179.755n 1.0v 184.745n 1.0v 184.755n 1.0v 189.745n 1.0v 189.755n 0.0v 194.745n 0.0v 194.755n 0.0v 199.745n 0.0v 199.755n 0.0v 204.745n 0.0v 204.755n 0.0v 209.745n 0.0v 209.755n 0.0v 214.745n 0.0v 214.755n 0.0v 219.745n 0.0v 219.755n 0.0v 224.745n 0.0v 224.755n 0.0v 229.745n 0.0v 229.755n 0.0v 234.745n 0.0v 234.755n 0.0v 239.745n 0.0v 239.755n 0.0v 244.745n 0.0v 244.755n 0.0v 249.745n 0.0v 249.755n 0.0v 254.745n 0.0v 254.755n 0.0v 259.745n 0.0v 259.755n 0.0v 264.745n 0.0v 264.755n 0.0v 269.745n 0.0v 269.755n 0.0v 274.745n 0.0v 274.755n 0.0v 279.745n 0.0v 279.755n 0.0v 284.745n 0.0v 284.755n 0.0v 289.745n 0.0v 289.755n 0.0v 294.745n 0.0v 294.755n 0.0v 299.745n 0.0v 299.755n 0.0v 304.745n 0.0v 304.755n 0.0v 309.745n 0.0v 309.755n 0.0v 314.745n 0.0v 314.755n 0.0v 319.745n 0.0v 319.755n 0.0v 324.745n 0.0v 324.755n 0.0v 329.745n 0.0v 329.755n 0.0v 334.745n 0.0v 334.755n 0.0v 339.745n 0.0v 339.755n 0.0v 344.745n 0.0v 344.755n 0.0v 349.745n 0.0v 349.755n 0.0v 354.745n 0.0v 354.755n 0.0v 359.745n 0.0v 359.755n 0.0v 364.745n 0.0v 364.755n 0.0v 369.745n 0.0v 369.755n 0.0v 374.745n 0.0v 374.755n 0.0v 379.745n 0.0v 379.755n 0.0v 384.745n 0.0v 384.755n 0.0v 389.745n 0.0v 389.755n 0.0v 394.745n 0.0v 394.755n 0.0v 399.745n 0.0v 399.755n 0.0v 404.745n 0.0v 404.755n 0.0v 409.745n 0.0v 409.755n 0.0v 414.745n 0.0v 414.755n 0.0v 419.745n 0.0v 419.755n 0.0v 424.745n 0.0v 424.755n 0.0v 429.745n 0.0v 429.755n 0.0v 434.745n 0.0v 434.755n 0.0v 439.745n 0.0v 439.755n 0.0v 444.745n 0.0v 444.755n 1.0v 449.745n 1.0v 449.755n 1.0v 454.745n 1.0v 454.755n 1.0v 459.745n 1.0v 459.755n 1.0v 464.745n 1.0v 464.755n 1.0v 469.745n 1.0v 469.755n 1.0v 474.745n 1.0v 474.755n 1.0v 479.745n 1.0v 479.755n 1.0v 484.745n 1.0v 484.755n 1.0v 489.745n 1.0v 489.755n 1.0v 494.745n 1.0v 494.755n 1.0v 499.745n 1.0v 499.755n 1.0v 504.745n 1.0v 504.755n 1.0v 509.745n 1.0v 509.755n 1.0v 514.745n 1.0v 514.755n 1.0v 519.745n 1.0v 519.755n 1.0v 524.745n 1.0v 524.755n 1.0v 529.745n 1.0v 529.755n 1.0v 534.745n 1.0v 534.755n 1.0v 539.745n 1.0v 539.755n 0.0v 544.745n 0.0v 544.755n 0.0v 549.745n 0.0v 549.755n 1.0v 554.745n 1.0v 554.755n 1.0v 559.745n 1.0v 559.755n 0.0v 564.745n 0.0v 564.755n 0.0v 569.745n 0.0v 569.755n 0.0v 574.745n 0.0v 574.755n 0.0v 579.745n 0.0v 579.755n 0.0v 584.745n 0.0v 584.755n 0.0v 589.745n 0.0v 589.755n 0.0v 594.745n 0.0v 594.755n 0.0v 599.745n 0.0v 599.755n 1.0v 604.745n 1.0v 604.755n 1.0v 609.745n 1.0v 609.755n 1.0v 614.745n 1.0v 614.755n 1.0v 619.745n 1.0v 619.755n 0.0v 624.745n 0.0v 624.755n 0.0v 629.745n 0.0v 629.755n 0.0v 634.745n 0.0v 634.755n 0.0v 639.745n 0.0v 639.755n 0.0v 644.745n 0.0v 644.755n 0.0v 649.745n 0.0v 649.755n 0.0v 654.745n 0.0v 654.755n 0.0v 659.745n 0.0v 659.755n 0.0v 664.745n 0.0v 664.755n 0.0v 669.745n 0.0v 669.755n 1.0v 674.745n 1.0v 674.755n 1.0v 679.745n 1.0v 679.755n 1.0v 684.745n 1.0v 684.755n 1.0v 689.745n 1.0v 689.755n 1.0v 694.745n 1.0v 694.755n 1.0v 699.745n 1.0v 699.755n 1.0v 704.745n 1.0v 704.755n 1.0v 709.745n 1.0v 709.755n 1.0v 714.745n 1.0v 714.755n 1.0v 719.745n 1.0v 719.755n 0.0v 724.745n 0.0v 724.755n 0.0v 729.745n 0.0v 729.755n 0.0v 734.745n 0.0v 734.755n 0.0v 739.745n 0.0v 739.755n 0.0v 744.745n 0.0v 744.755n 0.0v 749.745n 0.0v 749.755n 0.0v 754.745n 0.0v 754.755n 0.0v 759.745n 0.0v 759.755n 0.0v 764.745n 0.0v 764.755n 0.0v 769.745n 0.0v 769.755n 1.0v 774.745n 1.0v 774.755n 1.0v 779.745n 1.0v 779.755n 1.0v 784.745n 1.0v 784.755n 1.0v 789.745n 1.0v 789.755n 1.0v 794.745n 1.0v 794.755n 1.0v 799.745n 1.0v 799.755n 1.0v 804.745n 1.0v 804.755n 1.0v 809.745n 1.0v 809.755n 0.0v 814.745n 0.0v 814.755n 0.0v 819.745n 0.0v 819.755n 0.0v 824.745n 0.0v 824.755n 0.0v 829.745n 0.0v 829.755n 0.0v 834.745n 0.0v 834.755n 0.0v 839.745n 0.0v 839.755n 0.0v 844.745n 0.0v 844.755n 0.0v 849.745n 0.0v 849.755n 1.0v 854.745n 1.0v 854.755n 0.0v 859.745n 0.0v 859.755n 0.0v 864.745n 0.0v 864.755n 1.0v 869.745n 1.0v 869.755n 1.0v 874.745n 1.0v 874.755n 1.0v 879.745n 1.0v 879.755n 1.0v 884.745n 1.0v 884.755n 1.0v 889.745n 1.0v 889.755n 1.0v 894.745n 1.0v 894.755n 1.0v 899.745n 1.0v 899.755n 1.0v 904.745n 1.0v 904.755n 1.0v 909.745n 1.0v 909.755n 1.0v 914.745n 1.0v 914.755n 1.0v 919.745n 1.0v 919.755n 1.0v 924.745n 1.0v 924.755n 1.0v 929.745n 1.0v 929.755n 0.0v 934.745n 0.0v 934.755n 0.0v 939.745n 0.0v 939.755n 0.0v 944.745n 0.0v 944.755n 0.0v 949.745n 0.0v 949.755n 0.0v 954.745n 0.0v 954.755n 0.0v 959.745n 0.0v 959.755n 0.0v 964.745n 0.0v 964.755n 1.0v 969.745n 1.0v 969.755n 1.0v 974.745n 1.0v 974.755n 1.0v 979.745n 1.0v 979.755n 1.0v 984.745n 1.0v 984.755n 1.0v 989.745n 1.0v 989.755n 1.0v 994.745n 1.0v 994.755n 1.0v 999.745n 1.0v 999.755n 1.0v 1004.745n 1.0v 1004.755n 1.0v 1009.745n 1.0v 1009.755n 1.0v 1014.745n 1.0v 1014.755n 1.0v 1019.745n 1.0v 1019.755n 1.0v 1024.745n 1.0v 1024.755n 1.0v )
* (time, data): [(0, 0), (5, 1), (10, 1), (15, 0), (20, 0), (25, 0), (30, 0), (35, 0), (40, 1), (45, 1), (50, 0), (55, 0), (60, 0), (65, 1), (70, 1), (75, 1), (80, 1), (85, 1), (90, 1), (95, 1), (100, 0), (105, 0), (110, 0), (115, 0), (120, 0), (125, 0), (130, 0), (135, 0), (140, 0), (145, 0), (150, 0), (155, 0), (160, 0), (165, 0), (170, 0), (175, 1), (180, 1), (185, 1), (190, 1), (195, 0), (200, 0), (205, 0), (210, 0), (215, 0), (220, 0), (225, 0), (230, 0), (235, 0), (240, 0), (245, 0), (250, 0), (255, 0), (260, 0), (265, 0), (270, 0), (275, 0), (280, 0), (285, 0), (290, 0), (295, 0), (300, 0), (305, 0), (310, 0), (315, 0), (320, 0), (325, 0), (330, 0), (335, 1), (340, 1), (345, 1), (350, 0), (355, 0), (360, 0), (365, 0), (370, 0), (375, 0), (380, 0), (385, 0), (390, 0), (395, 0), (400, 0), (405, 0), (410, 1), (415, 1), (420, 1), (425, 1), (430, 1), (435, 0), (440, 0), (445, 0), (450, 0), (455, 0), (460, 0), (465, 0), (470, 0), (475, 0), (480, 0), (485, 1), (490, 1), (495, 1), (500, 0), (505, 0), (510, 0), (515, 1), (520, 1), (525, 1), (530, 1), (535, 1), (540, 0), (545, 1), (550, 1), (555, 1), (560, 1), (565, 1), (570, 1), (575, 1), (580, 1), (585, 1), (590, 1), (595, 1), (600, 0), (605, 0), (610, 1), (615, 1), (620, 0), (625, 0), (630, 0), (635, 0), (640, 0), (645, 1), (650, 0), (655, 1), (660, 1), (665, 1), (670, 0), (675, 0), (680, 0), (685, 0), (690, 0), (695, 0), (700, 0), (705, 0), (710, 0), (715, 0), (720, 1), (725, 1), (730, 1), (735, 1), (740, 1), (745, 1), (750, 1), (755, 1), (760, 1), (765, 1), (770, 0), (775, 0), (780, 1), (785, 1), (790, 1), (795, 1), (800, 1), (805, 0), (810, 0), (815, 0), (820, 0), (825, 0), (830, 0), (835, 0), (840, 0), (845, 0), (850, 1), (855, 0), (860, 0), (865, 0), (870, 0), (875, 0), (880, 0), (885, 0), (890, 0), (895, 0), (900, 0), (905, 0), (910, 1), (915, 1), (920, 1), (925, 1), (930, 0), (935, 0), (940, 0), (945, 0), (950, 0), (955, 0), (960, 0), (965, 1), (970, 1), (975, 1), (980, 1), (985, 1), (990, 1), (995, 1), (1000, 1), (1005, 1), (1010, 1), (1015, 1), (1020, 1), (1025, 1)]
Vdin0_2  din0_2  0 PWL (0n 0.0v 4.745n 0.0v 4.755n 1.0v 9.745n 1.0v 9.755n 1.0v 14.745n 1.0v 14.755n 0.0v 19.745n 0.0v 19.755n 0.0v 24.745n 0.0v 24.755n 0.0v 29.745n 0.0v 29.755n 0.0v 34.745n 0.0v 34.755n 0.0v 39.745n 0.0v 39.755n 1.0v 44.745n 1.0v 44.755n 1.0v 49.745n 1.0v 49.755n 0.0v 54.745n 0.0v 54.755n 0.0v 59.745n 0.0v 59.755n 0.0v 64.745n 0.0v 64.755n 1.0v 69.745n 1.0v 69.755n 1.0v 74.745n 1.0v 74.755n 1.0v 79.745n 1.0v 79.755n 1.0v 84.745n 1.0v 84.755n 1.0v 89.745n 1.0v 89.755n 1.0v 94.745n 1.0v 94.755n 1.0v 99.745n 1.0v 99.755n 0.0v 104.745n 0.0v 104.755n 0.0v 109.745n 0.0v 109.755n 0.0v 114.745n 0.0v 114.755n 0.0v 119.745n 0.0v 119.755n 0.0v 124.745n 0.0v 124.755n 0.0v 129.745n 0.0v 129.755n 0.0v 134.745n 0.0v 134.755n 0.0v 139.745n 0.0v 139.755n 0.0v 144.745n 0.0v 144.755n 0.0v 149.745n 0.0v 149.755n 0.0v 154.745n 0.0v 154.755n 0.0v 159.745n 0.0v 159.755n 0.0v 164.745n 0.0v 164.755n 0.0v 169.745n 0.0v 169.755n 0.0v 174.745n 0.0v 174.755n 1.0v 179.745n 1.0v 179.755n 1.0v 184.745n 1.0v 184.755n 1.0v 189.745n 1.0v 189.755n 1.0v 194.745n 1.0v 194.755n 0.0v 199.745n 0.0v 199.755n 0.0v 204.745n 0.0v 204.755n 0.0v 209.745n 0.0v 209.755n 0.0v 214.745n 0.0v 214.755n 0.0v 219.745n 0.0v 219.755n 0.0v 224.745n 0.0v 224.755n 0.0v 229.745n 0.0v 229.755n 0.0v 234.745n 0.0v 234.755n 0.0v 239.745n 0.0v 239.755n 0.0v 244.745n 0.0v 244.755n 0.0v 249.745n 0.0v 249.755n 0.0v 254.745n 0.0v 254.755n 0.0v 259.745n 0.0v 259.755n 0.0v 264.745n 0.0v 264.755n 0.0v 269.745n 0.0v 269.755n 0.0v 274.745n 0.0v 274.755n 0.0v 279.745n 0.0v 279.755n 0.0v 284.745n 0.0v 284.755n 0.0v 289.745n 0.0v 289.755n 0.0v 294.745n 0.0v 294.755n 0.0v 299.745n 0.0v 299.755n 0.0v 304.745n 0.0v 304.755n 0.0v 309.745n 0.0v 309.755n 0.0v 314.745n 0.0v 314.755n 0.0v 319.745n 0.0v 319.755n 0.0v 324.745n 0.0v 324.755n 0.0v 329.745n 0.0v 329.755n 0.0v 334.745n 0.0v 334.755n 1.0v 339.745n 1.0v 339.755n 1.0v 344.745n 1.0v 344.755n 1.0v 349.745n 1.0v 349.755n 0.0v 354.745n 0.0v 354.755n 0.0v 359.745n 0.0v 359.755n 0.0v 364.745n 0.0v 364.755n 0.0v 369.745n 0.0v 369.755n 0.0v 374.745n 0.0v 374.755n 0.0v 379.745n 0.0v 379.755n 0.0v 384.745n 0.0v 384.755n 0.0v 389.745n 0.0v 389.755n 0.0v 394.745n 0.0v 394.755n 0.0v 399.745n 0.0v 399.755n 0.0v 404.745n 0.0v 404.755n 0.0v 409.745n 0.0v 409.755n 1.0v 414.745n 1.0v 414.755n 1.0v 419.745n 1.0v 419.755n 1.0v 424.745n 1.0v 424.755n 1.0v 429.745n 1.0v 429.755n 1.0v 434.745n 1.0v 434.755n 0.0v 439.745n 0.0v 439.755n 0.0v 444.745n 0.0v 444.755n 0.0v 449.745n 0.0v 449.755n 0.0v 454.745n 0.0v 454.755n 0.0v 459.745n 0.0v 459.755n 0.0v 464.745n 0.0v 464.755n 0.0v 469.745n 0.0v 469.755n 0.0v 474.745n 0.0v 474.755n 0.0v 479.745n 0.0v 479.755n 0.0v 484.745n 0.0v 484.755n 1.0v 489.745n 1.0v 489.755n 1.0v 494.745n 1.0v 494.755n 1.0v 499.745n 1.0v 499.755n 0.0v 504.745n 0.0v 504.755n 0.0v 509.745n 0.0v 509.755n 0.0v 514.745n 0.0v 514.755n 1.0v 519.745n 1.0v 519.755n 1.0v 524.745n 1.0v 524.755n 1.0v 529.745n 1.0v 529.755n 1.0v 534.745n 1.0v 534.755n 1.0v 539.745n 1.0v 539.755n 0.0v 544.745n 0.0v 544.755n 1.0v 549.745n 1.0v 549.755n 1.0v 554.745n 1.0v 554.755n 1.0v 559.745n 1.0v 559.755n 1.0v 564.745n 1.0v 564.755n 1.0v 569.745n 1.0v 569.755n 1.0v 574.745n 1.0v 574.755n 1.0v 579.745n 1.0v 579.755n 1.0v 584.745n 1.0v 584.755n 1.0v 589.745n 1.0v 589.755n 1.0v 594.745n 1.0v 594.755n 1.0v 599.745n 1.0v 599.755n 0.0v 604.745n 0.0v 604.755n 0.0v 609.745n 0.0v 609.755n 1.0v 614.745n 1.0v 614.755n 1.0v 619.745n 1.0v 619.755n 0.0v 624.745n 0.0v 624.755n 0.0v 629.745n 0.0v 629.755n 0.0v 634.745n 0.0v 634.755n 0.0v 639.745n 0.0v 639.755n 0.0v 644.745n 0.0v 644.755n 1.0v 649.745n 1.0v 649.755n 0.0v 654.745n 0.0v 654.755n 1.0v 659.745n 1.0v 659.755n 1.0v 664.745n 1.0v 664.755n 1.0v 669.745n 1.0v 669.755n 0.0v 674.745n 0.0v 674.755n 0.0v 679.745n 0.0v 679.755n 0.0v 684.745n 0.0v 684.755n 0.0v 689.745n 0.0v 689.755n 0.0v 694.745n 0.0v 694.755n 0.0v 699.745n 0.0v 699.755n 0.0v 704.745n 0.0v 704.755n 0.0v 709.745n 0.0v 709.755n 0.0v 714.745n 0.0v 714.755n 0.0v 719.745n 0.0v 719.755n 1.0v 724.745n 1.0v 724.755n 1.0v 729.745n 1.0v 729.755n 1.0v 734.745n 1.0v 734.755n 1.0v 739.745n 1.0v 739.755n 1.0v 744.745n 1.0v 744.755n 1.0v 749.745n 1.0v 749.755n 1.0v 754.745n 1.0v 754.755n 1.0v 759.745n 1.0v 759.755n 1.0v 764.745n 1.0v 764.755n 1.0v 769.745n 1.0v 769.755n 0.0v 774.745n 0.0v 774.755n 0.0v 779.745n 0.0v 779.755n 1.0v 784.745n 1.0v 784.755n 1.0v 789.745n 1.0v 789.755n 1.0v 794.745n 1.0v 794.755n 1.0v 799.745n 1.0v 799.755n 1.0v 804.745n 1.0v 804.755n 0.0v 809.745n 0.0v 809.755n 0.0v 814.745n 0.0v 814.755n 0.0v 819.745n 0.0v 819.755n 0.0v 824.745n 0.0v 824.755n 0.0v 829.745n 0.0v 829.755n 0.0v 834.745n 0.0v 834.755n 0.0v 839.745n 0.0v 839.755n 0.0v 844.745n 0.0v 844.755n 0.0v 849.745n 0.0v 849.755n 1.0v 854.745n 1.0v 854.755n 0.0v 859.745n 0.0v 859.755n 0.0v 864.745n 0.0v 864.755n 0.0v 869.745n 0.0v 869.755n 0.0v 874.745n 0.0v 874.755n 0.0v 879.745n 0.0v 879.755n 0.0v 884.745n 0.0v 884.755n 0.0v 889.745n 0.0v 889.755n 0.0v 894.745n 0.0v 894.755n 0.0v 899.745n 0.0v 899.755n 0.0v 904.745n 0.0v 904.755n 0.0v 909.745n 0.0v 909.755n 1.0v 914.745n 1.0v 914.755n 1.0v 919.745n 1.0v 919.755n 1.0v 924.745n 1.0v 924.755n 1.0v 929.745n 1.0v 929.755n 0.0v 934.745n 0.0v 934.755n 0.0v 939.745n 0.0v 939.755n 0.0v 944.745n 0.0v 944.755n 0.0v 949.745n 0.0v 949.755n 0.0v 954.745n 0.0v 954.755n 0.0v 959.745n 0.0v 959.755n 0.0v 964.745n 0.0v 964.755n 1.0v 969.745n 1.0v 969.755n 1.0v 974.745n 1.0v 974.755n 1.0v 979.745n 1.0v 979.755n 1.0v 984.745n 1.0v 984.755n 1.0v 989.745n 1.0v 989.755n 1.0v 994.745n 1.0v 994.755n 1.0v 999.745n 1.0v 999.755n 1.0v 1004.745n 1.0v 1004.755n 1.0v 1009.745n 1.0v 1009.755n 1.0v 1014.745n 1.0v 1014.755n 1.0v 1019.745n 1.0v 1019.755n 1.0v 1024.745n 1.0v 1024.755n 1.0v )
* (time, data): [(0, 0), (5, 1), (10, 0), (15, 1), (20, 1), (25, 1), (30, 0), (35, 0), (40, 0), (45, 0), (50, 1), (55, 1), (60, 1), (65, 0), (70, 0), (75, 0), (80, 0), (85, 0), (90, 0), (95, 0), (100, 0), (105, 0), (110, 0), (115, 1), (120, 1), (125, 1), (130, 1), (135, 1), (140, 1), (145, 1), (150, 1), (155, 0), (160, 0), (165, 0), (170, 0), (175, 1), (180, 1), (185, 1), (190, 0), (195, 1), (200, 1), (205, 1), (210, 1), (215, 1), (220, 1), (225, 1), (230, 1), (235, 1), (240, 1), (245, 0), (250, 0), (255, 0), (260, 0), (265, 0), (270, 0), (275, 0), (280, 0), (285, 0), (290, 0), (295, 0), (300, 0), (305, 0), (310, 0), (315, 0), (320, 0), (325, 0), (330, 0), (335, 1), (340, 1), (345, 1), (350, 1), (355, 1), (360, 1), (365, 1), (370, 1), (375, 1), (380, 1), (385, 1), (390, 1), (395, 1), (400, 1), (405, 1), (410, 1), (415, 1), (420, 1), (425, 1), (430, 1), (435, 1), (440, 1), (445, 1), (450, 1), (455, 1), (460, 1), (465, 1), (470, 1), (475, 1), (480, 1), (485, 0), (490, 0), (495, 0), (500, 1), (505, 1), (510, 1), (515, 0), (520, 0), (525, 0), (530, 0), (535, 0), (540, 1), (545, 0), (550, 0), (555, 0), (560, 0), (565, 0), (570, 0), (575, 0), (580, 0), (585, 0), (590, 0), (595, 0), (600, 1), (605, 1), (610, 1), (615, 1), (620, 0), (625, 0), (630, 0), (635, 1), (640, 1), (645, 0), (650, 1), (655, 0), (660, 0), (665, 0), (670, 0), (675, 0), (680, 0), (685, 0), (690, 0), (695, 0), (700, 0), (705, 0), (710, 0), (715, 0), (720, 0), (725, 0), (730, 0), (735, 0), (740, 0), (745, 0), (750, 0), (755, 0), (760, 0), (765, 0), (770, 0), (775, 0), (780, 1), (785, 1), (790, 1), (795, 1), (800, 1), (805, 0), (810, 0), (815, 0), (820, 0), (825, 0), (830, 0), (835, 0), (840, 0), (845, 0), (850, 1), (855, 1), (860, 1), (865, 0), (870, 0), (875, 0), (880, 0), (885, 0), (890, 0), (895, 0), (900, 0), (905, 0), (910, 1), (915, 1), (920, 1), (925, 1), (930, 1), (935, 1), (940, 1), (945, 1), (950, 1), (955, 1), (960, 1), (965, 0), (970, 0), (975, 0), (980, 0), (985, 0), (990, 0), (995, 0), (1000, 0), (1005, 0), (1010, 0), (1015, 0), (1020, 0), (1025, 0)]
Vdin0_3  din0_3  0 PWL (0n 0.0v 4.745n 0.0v 4.755n 1.0v 9.745n 1.0v 9.755n 0.0v 14.745n 0.0v 14.755n 1.0v 19.745n 1.0v 19.755n 1.0v 24.745n 1.0v 24.755n 1.0v 29.745n 1.0v 29.755n 0.0v 34.745n 0.0v 34.755n 0.0v 39.745n 0.0v 39.755n 0.0v 44.745n 0.0v 44.755n 0.0v 49.745n 0.0v 49.755n 1.0v 54.745n 1.0v 54.755n 1.0v 59.745n 1.0v 59.755n 1.0v 64.745n 1.0v 64.755n 0.0v 69.745n 0.0v 69.755n 0.0v 74.745n 0.0v 74.755n 0.0v 79.745n 0.0v 79.755n 0.0v 84.745n 0.0v 84.755n 0.0v 89.745n 0.0v 89.755n 0.0v 94.745n 0.0v 94.755n 0.0v 99.745n 0.0v 99.755n 0.0v 104.745n 0.0v 104.755n 0.0v 109.745n 0.0v 109.755n 0.0v 114.745n 0.0v 114.755n 1.0v 119.745n 1.0v 119.755n 1.0v 124.745n 1.0v 124.755n 1.0v 129.745n 1.0v 129.755n 1.0v 134.745n 1.0v 134.755n 1.0v 139.745n 1.0v 139.755n 1.0v 144.745n 1.0v 144.755n 1.0v 149.745n 1.0v 149.755n 1.0v 154.745n 1.0v 154.755n 0.0v 159.745n 0.0v 159.755n 0.0v 164.745n 0.0v 164.755n 0.0v 169.745n 0.0v 169.755n 0.0v 174.745n 0.0v 174.755n 1.0v 179.745n 1.0v 179.755n 1.0v 184.745n 1.0v 184.755n 1.0v 189.745n 1.0v 189.755n 0.0v 194.745n 0.0v 194.755n 1.0v 199.745n 1.0v 199.755n 1.0v 204.745n 1.0v 204.755n 1.0v 209.745n 1.0v 209.755n 1.0v 214.745n 1.0v 214.755n 1.0v 219.745n 1.0v 219.755n 1.0v 224.745n 1.0v 224.755n 1.0v 229.745n 1.0v 229.755n 1.0v 234.745n 1.0v 234.755n 1.0v 239.745n 1.0v 239.755n 1.0v 244.745n 1.0v 244.755n 0.0v 249.745n 0.0v 249.755n 0.0v 254.745n 0.0v 254.755n 0.0v 259.745n 0.0v 259.755n 0.0v 264.745n 0.0v 264.755n 0.0v 269.745n 0.0v 269.755n 0.0v 274.745n 0.0v 274.755n 0.0v 279.745n 0.0v 279.755n 0.0v 284.745n 0.0v 284.755n 0.0v 289.745n 0.0v 289.755n 0.0v 294.745n 0.0v 294.755n 0.0v 299.745n 0.0v 299.755n 0.0v 304.745n 0.0v 304.755n 0.0v 309.745n 0.0v 309.755n 0.0v 314.745n 0.0v 314.755n 0.0v 319.745n 0.0v 319.755n 0.0v 324.745n 0.0v 324.755n 0.0v 329.745n 0.0v 329.755n 0.0v 334.745n 0.0v 334.755n 1.0v 339.745n 1.0v 339.755n 1.0v 344.745n 1.0v 344.755n 1.0v 349.745n 1.0v 349.755n 1.0v 354.745n 1.0v 354.755n 1.0v 359.745n 1.0v 359.755n 1.0v 364.745n 1.0v 364.755n 1.0v 369.745n 1.0v 369.755n 1.0v 374.745n 1.0v 374.755n 1.0v 379.745n 1.0v 379.755n 1.0v 384.745n 1.0v 384.755n 1.0v 389.745n 1.0v 389.755n 1.0v 394.745n 1.0v 394.755n 1.0v 399.745n 1.0v 399.755n 1.0v 404.745n 1.0v 404.755n 1.0v 409.745n 1.0v 409.755n 1.0v 414.745n 1.0v 414.755n 1.0v 419.745n 1.0v 419.755n 1.0v 424.745n 1.0v 424.755n 1.0v 429.745n 1.0v 429.755n 1.0v 434.745n 1.0v 434.755n 1.0v 439.745n 1.0v 439.755n 1.0v 444.745n 1.0v 444.755n 1.0v 449.745n 1.0v 449.755n 1.0v 454.745n 1.0v 454.755n 1.0v 459.745n 1.0v 459.755n 1.0v 464.745n 1.0v 464.755n 1.0v 469.745n 1.0v 469.755n 1.0v 474.745n 1.0v 474.755n 1.0v 479.745n 1.0v 479.755n 1.0v 484.745n 1.0v 484.755n 0.0v 489.745n 0.0v 489.755n 0.0v 494.745n 0.0v 494.755n 0.0v 499.745n 0.0v 499.755n 1.0v 504.745n 1.0v 504.755n 1.0v 509.745n 1.0v 509.755n 1.0v 514.745n 1.0v 514.755n 0.0v 519.745n 0.0v 519.755n 0.0v 524.745n 0.0v 524.755n 0.0v 529.745n 0.0v 529.755n 0.0v 534.745n 0.0v 534.755n 0.0v 539.745n 0.0v 539.755n 1.0v 544.745n 1.0v 544.755n 0.0v 549.745n 0.0v 549.755n 0.0v 554.745n 0.0v 554.755n 0.0v 559.745n 0.0v 559.755n 0.0v 564.745n 0.0v 564.755n 0.0v 569.745n 0.0v 569.755n 0.0v 574.745n 0.0v 574.755n 0.0v 579.745n 0.0v 579.755n 0.0v 584.745n 0.0v 584.755n 0.0v 589.745n 0.0v 589.755n 0.0v 594.745n 0.0v 594.755n 0.0v 599.745n 0.0v 599.755n 1.0v 604.745n 1.0v 604.755n 1.0v 609.745n 1.0v 609.755n 1.0v 614.745n 1.0v 614.755n 1.0v 619.745n 1.0v 619.755n 0.0v 624.745n 0.0v 624.755n 0.0v 629.745n 0.0v 629.755n 0.0v 634.745n 0.0v 634.755n 1.0v 639.745n 1.0v 639.755n 1.0v 644.745n 1.0v 644.755n 0.0v 649.745n 0.0v 649.755n 1.0v 654.745n 1.0v 654.755n 0.0v 659.745n 0.0v 659.755n 0.0v 664.745n 0.0v 664.755n 0.0v 669.745n 0.0v 669.755n 0.0v 674.745n 0.0v 674.755n 0.0v 679.745n 0.0v 679.755n 0.0v 684.745n 0.0v 684.755n 0.0v 689.745n 0.0v 689.755n 0.0v 694.745n 0.0v 694.755n 0.0v 699.745n 0.0v 699.755n 0.0v 704.745n 0.0v 704.755n 0.0v 709.745n 0.0v 709.755n 0.0v 714.745n 0.0v 714.755n 0.0v 719.745n 0.0v 719.755n 0.0v 724.745n 0.0v 724.755n 0.0v 729.745n 0.0v 729.755n 0.0v 734.745n 0.0v 734.755n 0.0v 739.745n 0.0v 739.755n 0.0v 744.745n 0.0v 744.755n 0.0v 749.745n 0.0v 749.755n 0.0v 754.745n 0.0v 754.755n 0.0v 759.745n 0.0v 759.755n 0.0v 764.745n 0.0v 764.755n 0.0v 769.745n 0.0v 769.755n 0.0v 774.745n 0.0v 774.755n 0.0v 779.745n 0.0v 779.755n 1.0v 784.745n 1.0v 784.755n 1.0v 789.745n 1.0v 789.755n 1.0v 794.745n 1.0v 794.755n 1.0v 799.745n 1.0v 799.755n 1.0v 804.745n 1.0v 804.755n 0.0v 809.745n 0.0v 809.755n 0.0v 814.745n 0.0v 814.755n 0.0v 819.745n 0.0v 819.755n 0.0v 824.745n 0.0v 824.755n 0.0v 829.745n 0.0v 829.755n 0.0v 834.745n 0.0v 834.755n 0.0v 839.745n 0.0v 839.755n 0.0v 844.745n 0.0v 844.755n 0.0v 849.745n 0.0v 849.755n 1.0v 854.745n 1.0v 854.755n 1.0v 859.745n 1.0v 859.755n 1.0v 864.745n 1.0v 864.755n 0.0v 869.745n 0.0v 869.755n 0.0v 874.745n 0.0v 874.755n 0.0v 879.745n 0.0v 879.755n 0.0v 884.745n 0.0v 884.755n 0.0v 889.745n 0.0v 889.755n 0.0v 894.745n 0.0v 894.755n 0.0v 899.745n 0.0v 899.755n 0.0v 904.745n 0.0v 904.755n 0.0v 909.745n 0.0v 909.755n 1.0v 914.745n 1.0v 914.755n 1.0v 919.745n 1.0v 919.755n 1.0v 924.745n 1.0v 924.755n 1.0v 929.745n 1.0v 929.755n 1.0v 934.745n 1.0v 934.755n 1.0v 939.745n 1.0v 939.755n 1.0v 944.745n 1.0v 944.755n 1.0v 949.745n 1.0v 949.755n 1.0v 954.745n 1.0v 954.755n 1.0v 959.745n 1.0v 959.755n 1.0v 964.745n 1.0v 964.755n 0.0v 969.745n 0.0v 969.755n 0.0v 974.745n 0.0v 974.755n 0.0v 979.745n 0.0v 979.755n 0.0v 984.745n 0.0v 984.755n 0.0v 989.745n 0.0v 989.755n 0.0v 994.745n 0.0v 994.755n 0.0v 999.745n 0.0v 999.755n 0.0v 1004.745n 0.0v 1004.755n 0.0v 1009.745n 0.0v 1009.755n 0.0v 1014.745n 0.0v 1014.755n 0.0v 1019.745n 0.0v 1019.755n 0.0v 1024.745n 0.0v 1024.755n 0.0v )
* (time, data): [(0, 0), (5, 0), (10, 1), (15, 0), (20, 0), (25, 0), (30, 1), (35, 1), (40, 1), (45, 1), (50, 1), (55, 1), (60, 1), (65, 1), (70, 1), (75, 1), (80, 1), (85, 1), (90, 1), (95, 1), (100, 0), (105, 0), (110, 0), (115, 0), (120, 0), (125, 0), (130, 0), (135, 0), (140, 0), (145, 0), (150, 0), (155, 0), (160, 0), (165, 0), (170, 0), (175, 1), (180, 1), (185, 1), (190, 0), (195, 1), (200, 1), (205, 1), (210, 1), (215, 1), (220, 1), (225, 1), (230, 1), (235, 1), (240, 1), (245, 1), (250, 1), (255, 1), (260, 1), (265, 1), (270, 1), (275, 1), (280, 1), (285, 1), (290, 0), (295, 0), (300, 0), (305, 0), (310, 0), (315, 0), (320, 0), (325, 0), (330, 0), (335, 0), (340, 0), (345, 0), (350, 1), (355, 1), (360, 1), (365, 1), (370, 1), (375, 1), (380, 1), (385, 1), (390, 1), (395, 1), (400, 1), (405, 1), (410, 0), (415, 0), (420, 0), (425, 0), (430, 0), (435, 1), (440, 1), (445, 1), (450, 1), (455, 1), (460, 1), (465, 1), (470, 1), (475, 1), (480, 1), (485, 1), (490, 0), (495, 0), (500, 0), (505, 0), (510, 0), (515, 1), (520, 1), (525, 1), (530, 1), (535, 1), (540, 1), (545, 1), (550, 0), (555, 0), (560, 0), (565, 0), (570, 0), (575, 0), (580, 0), (585, 0), (590, 0), (595, 0), (600, 0), (605, 0), (610, 1), (615, 1), (620, 0), (625, 0), (630, 0), (635, 0), (640, 0), (645, 1), (650, 0), (655, 0), (660, 0), (665, 0), (670, 0), (675, 0), (680, 0), (685, 0), (690, 0), (695, 0), (700, 0), (705, 0), (710, 0), (715, 0), (720, 1), (725, 1), (730, 1), (735, 1), (740, 1), (745, 1), (750, 1), (755, 1), (760, 1), (765, 1), (770, 1), (775, 1), (780, 1), (785, 1), (790, 1), (795, 1), (800, 1), (805, 0), (810, 1), (815, 1), (820, 1), (825, 1), (830, 1), (835, 1), (840, 1), (845, 1), (850, 1), (855, 1), (860, 1), (865, 0), (870, 0), (875, 0), (880, 0), (885, 0), (890, 0), (895, 0), (900, 0), (905, 0), (910, 0), (915, 0), (920, 0), (925, 0), (930, 0), (935, 0), (940, 0), (945, 0), (950, 0), (955, 0), (960, 0), (965, 0), (970, 0), (975, 0), (980, 0), (985, 0), (990, 0), (995, 0), (1000, 0), (1005, 0), (1010, 0), (1015, 0), (1020, 0), (1025, 0)]
Vdin0_4  din0_4  0 PWL (0n 0.0v 4.745n 0.0v 4.755n 0.0v 9.745n 0.0v 9.755n 1.0v 14.745n 1.0v 14.755n 0.0v 19.745n 0.0v 19.755n 0.0v 24.745n 0.0v 24.755n 0.0v 29.745n 0.0v 29.755n 1.0v 34.745n 1.0v 34.755n 1.0v 39.745n 1.0v 39.755n 1.0v 44.745n 1.0v 44.755n 1.0v 49.745n 1.0v 49.755n 1.0v 54.745n 1.0v 54.755n 1.0v 59.745n 1.0v 59.755n 1.0v 64.745n 1.0v 64.755n 1.0v 69.745n 1.0v 69.755n 1.0v 74.745n 1.0v 74.755n 1.0v 79.745n 1.0v 79.755n 1.0v 84.745n 1.0v 84.755n 1.0v 89.745n 1.0v 89.755n 1.0v 94.745n 1.0v 94.755n 1.0v 99.745n 1.0v 99.755n 0.0v 104.745n 0.0v 104.755n 0.0v 109.745n 0.0v 109.755n 0.0v 114.745n 0.0v 114.755n 0.0v 119.745n 0.0v 119.755n 0.0v 124.745n 0.0v 124.755n 0.0v 129.745n 0.0v 129.755n 0.0v 134.745n 0.0v 134.755n 0.0v 139.745n 0.0v 139.755n 0.0v 144.745n 0.0v 144.755n 0.0v 149.745n 0.0v 149.755n 0.0v 154.745n 0.0v 154.755n 0.0v 159.745n 0.0v 159.755n 0.0v 164.745n 0.0v 164.755n 0.0v 169.745n 0.0v 169.755n 0.0v 174.745n 0.0v 174.755n 1.0v 179.745n 1.0v 179.755n 1.0v 184.745n 1.0v 184.755n 1.0v 189.745n 1.0v 189.755n 0.0v 194.745n 0.0v 194.755n 1.0v 199.745n 1.0v 199.755n 1.0v 204.745n 1.0v 204.755n 1.0v 209.745n 1.0v 209.755n 1.0v 214.745n 1.0v 214.755n 1.0v 219.745n 1.0v 219.755n 1.0v 224.745n 1.0v 224.755n 1.0v 229.745n 1.0v 229.755n 1.0v 234.745n 1.0v 234.755n 1.0v 239.745n 1.0v 239.755n 1.0v 244.745n 1.0v 244.755n 1.0v 249.745n 1.0v 249.755n 1.0v 254.745n 1.0v 254.755n 1.0v 259.745n 1.0v 259.755n 1.0v 264.745n 1.0v 264.755n 1.0v 269.745n 1.0v 269.755n 1.0v 274.745n 1.0v 274.755n 1.0v 279.745n 1.0v 279.755n 1.0v 284.745n 1.0v 284.755n 1.0v 289.745n 1.0v 289.755n 0.0v 294.745n 0.0v 294.755n 0.0v 299.745n 0.0v 299.755n 0.0v 304.745n 0.0v 304.755n 0.0v 309.745n 0.0v 309.755n 0.0v 314.745n 0.0v 314.755n 0.0v 319.745n 0.0v 319.755n 0.0v 324.745n 0.0v 324.755n 0.0v 329.745n 0.0v 329.755n 0.0v 334.745n 0.0v 334.755n 0.0v 339.745n 0.0v 339.755n 0.0v 344.745n 0.0v 344.755n 0.0v 349.745n 0.0v 349.755n 1.0v 354.745n 1.0v 354.755n 1.0v 359.745n 1.0v 359.755n 1.0v 364.745n 1.0v 364.755n 1.0v 369.745n 1.0v 369.755n 1.0v 374.745n 1.0v 374.755n 1.0v 379.745n 1.0v 379.755n 1.0v 384.745n 1.0v 384.755n 1.0v 389.745n 1.0v 389.755n 1.0v 394.745n 1.0v 394.755n 1.0v 399.745n 1.0v 399.755n 1.0v 404.745n 1.0v 404.755n 1.0v 409.745n 1.0v 409.755n 0.0v 414.745n 0.0v 414.755n 0.0v 419.745n 0.0v 419.755n 0.0v 424.745n 0.0v 424.755n 0.0v 429.745n 0.0v 429.755n 0.0v 434.745n 0.0v 434.755n 1.0v 439.745n 1.0v 439.755n 1.0v 444.745n 1.0v 444.755n 1.0v 449.745n 1.0v 449.755n 1.0v 454.745n 1.0v 454.755n 1.0v 459.745n 1.0v 459.755n 1.0v 464.745n 1.0v 464.755n 1.0v 469.745n 1.0v 469.755n 1.0v 474.745n 1.0v 474.755n 1.0v 479.745n 1.0v 479.755n 1.0v 484.745n 1.0v 484.755n 1.0v 489.745n 1.0v 489.755n 0.0v 494.745n 0.0v 494.755n 0.0v 499.745n 0.0v 499.755n 0.0v 504.745n 0.0v 504.755n 0.0v 509.745n 0.0v 509.755n 0.0v 514.745n 0.0v 514.755n 1.0v 519.745n 1.0v 519.755n 1.0v 524.745n 1.0v 524.755n 1.0v 529.745n 1.0v 529.755n 1.0v 534.745n 1.0v 534.755n 1.0v 539.745n 1.0v 539.755n 1.0v 544.745n 1.0v 544.755n 1.0v 549.745n 1.0v 549.755n 0.0v 554.745n 0.0v 554.755n 0.0v 559.745n 0.0v 559.755n 0.0v 564.745n 0.0v 564.755n 0.0v 569.745n 0.0v 569.755n 0.0v 574.745n 0.0v 574.755n 0.0v 579.745n 0.0v 579.755n 0.0v 584.745n 0.0v 584.755n 0.0v 589.745n 0.0v 589.755n 0.0v 594.745n 0.0v 594.755n 0.0v 599.745n 0.0v 599.755n 0.0v 604.745n 0.0v 604.755n 0.0v 609.745n 0.0v 609.755n 1.0v 614.745n 1.0v 614.755n 1.0v 619.745n 1.0v 619.755n 0.0v 624.745n 0.0v 624.755n 0.0v 629.745n 0.0v 629.755n 0.0v 634.745n 0.0v 634.755n 0.0v 639.745n 0.0v 639.755n 0.0v 644.745n 0.0v 644.755n 1.0v 649.745n 1.0v 649.755n 0.0v 654.745n 0.0v 654.755n 0.0v 659.745n 0.0v 659.755n 0.0v 664.745n 0.0v 664.755n 0.0v 669.745n 0.0v 669.755n 0.0v 674.745n 0.0v 674.755n 0.0v 679.745n 0.0v 679.755n 0.0v 684.745n 0.0v 684.755n 0.0v 689.745n 0.0v 689.755n 0.0v 694.745n 0.0v 694.755n 0.0v 699.745n 0.0v 699.755n 0.0v 704.745n 0.0v 704.755n 0.0v 709.745n 0.0v 709.755n 0.0v 714.745n 0.0v 714.755n 0.0v 719.745n 0.0v 719.755n 1.0v 724.745n 1.0v 724.755n 1.0v 729.745n 1.0v 729.755n 1.0v 734.745n 1.0v 734.755n 1.0v 739.745n 1.0v 739.755n 1.0v 744.745n 1.0v 744.755n 1.0v 749.745n 1.0v 749.755n 1.0v 754.745n 1.0v 754.755n 1.0v 759.745n 1.0v 759.755n 1.0v 764.745n 1.0v 764.755n 1.0v 769.745n 1.0v 769.755n 1.0v 774.745n 1.0v 774.755n 1.0v 779.745n 1.0v 779.755n 1.0v 784.745n 1.0v 784.755n 1.0v 789.745n 1.0v 789.755n 1.0v 794.745n 1.0v 794.755n 1.0v 799.745n 1.0v 799.755n 1.0v 804.745n 1.0v 804.755n 0.0v 809.745n 0.0v 809.755n 1.0v 814.745n 1.0v 814.755n 1.0v 819.745n 1.0v 819.755n 1.0v 824.745n 1.0v 824.755n 1.0v 829.745n 1.0v 829.755n 1.0v 834.745n 1.0v 834.755n 1.0v 839.745n 1.0v 839.755n 1.0v 844.745n 1.0v 844.755n 1.0v 849.745n 1.0v 849.755n 1.0v 854.745n 1.0v 854.755n 1.0v 859.745n 1.0v 859.755n 1.0v 864.745n 1.0v 864.755n 0.0v 869.745n 0.0v 869.755n 0.0v 874.745n 0.0v 874.755n 0.0v 879.745n 0.0v 879.755n 0.0v 884.745n 0.0v 884.755n 0.0v 889.745n 0.0v 889.755n 0.0v 894.745n 0.0v 894.755n 0.0v 899.745n 0.0v 899.755n 0.0v 904.745n 0.0v 904.755n 0.0v 909.745n 0.0v 909.755n 0.0v 914.745n 0.0v 914.755n 0.0v 919.745n 0.0v 919.755n 0.0v 924.745n 0.0v 924.755n 0.0v 929.745n 0.0v 929.755n 0.0v 934.745n 0.0v 934.755n 0.0v 939.745n 0.0v 939.755n 0.0v 944.745n 0.0v 944.755n 0.0v 949.745n 0.0v 949.755n 0.0v 954.745n 0.0v 954.755n 0.0v 959.745n 0.0v 959.755n 0.0v 964.745n 0.0v 964.755n 0.0v 969.745n 0.0v 969.755n 0.0v 974.745n 0.0v 974.755n 0.0v 979.745n 0.0v 979.755n 0.0v 984.745n 0.0v 984.755n 0.0v 989.745n 0.0v 989.755n 0.0v 994.745n 0.0v 994.755n 0.0v 999.745n 0.0v 999.755n 0.0v 1004.745n 0.0v 1004.755n 0.0v 1009.745n 0.0v 1009.755n 0.0v 1014.745n 0.0v 1014.755n 0.0v 1019.745n 0.0v 1019.755n 0.0v 1024.745n 0.0v 1024.755n 0.0v )
* (time, data): [(0, 0), (5, 1), (10, 0), (15, 1), (20, 1), (25, 1), (30, 1), (35, 1), (40, 0), (45, 0), (50, 1), (55, 1), (60, 1), (65, 0), (70, 0), (75, 0), (80, 0), (85, 1), (90, 1), (95, 1), (100, 0), (105, 0), (110, 0), (115, 1), (120, 1), (125, 1), (130, 1), (135, 1), (140, 1), (145, 1), (150, 1), (155, 1), (160, 1), (165, 1), (170, 1), (175, 1), (180, 1), (185, 1), (190, 1), (195, 0), (200, 0), (205, 0), (210, 0), (215, 0), (220, 0), (225, 0), (230, 0), (235, 0), (240, 0), (245, 0), (250, 0), (255, 0), (260, 0), (265, 0), (270, 0), (275, 0), (280, 0), (285, 0), (290, 0), (295, 0), (300, 0), (305, 0), (310, 0), (315, 0), (320, 0), (325, 0), (330, 0), (335, 1), (340, 1), (345, 1), (350, 1), (355, 1), (360, 1), (365, 1), (370, 1), (375, 1), (380, 1), (385, 1), (390, 1), (395, 1), (400, 1), (405, 1), (410, 1), (415, 1), (420, 1), (425, 1), (430, 1), (435, 1), (440, 1), (445, 0), (450, 0), (455, 0), (460, 0), (465, 0), (470, 0), (475, 0), (480, 0), (485, 1), (490, 1), (495, 1), (500, 0), (505, 0), (510, 0), (515, 1), (520, 1), (525, 1), (530, 1), (535, 0), (540, 1), (545, 0), (550, 1), (555, 1), (560, 0), (565, 0), (570, 0), (575, 0), (580, 0), (585, 0), (590, 0), (595, 0), (600, 0), (605, 0), (610, 1), (615, 1), (620, 1), (625, 1), (630, 1), (635, 1), (640, 1), (645, 1), (650, 0), (655, 1), (660, 1), (665, 1), (670, 0), (675, 0), (680, 0), (685, 0), (690, 0), (695, 0), (700, 0), (705, 0), (710, 0), (715, 0), (720, 0), (725, 0), (730, 0), (735, 0), (740, 0), (745, 0), (750, 0), (755, 0), (760, 0), (765, 0), (770, 0), (775, 0), (780, 1), (785, 1), (790, 1), (795, 1), (800, 1), (805, 0), (810, 0), (815, 0), (820, 0), (825, 0), (830, 0), (835, 0), (840, 0), (845, 0), (850, 0), (855, 0), (860, 0), (865, 1), (870, 1), (875, 1), (880, 1), (885, 1), (890, 1), (895, 1), (900, 1), (905, 1), (910, 1), (915, 0), (920, 0), (925, 0), (930, 0), (935, 0), (940, 0), (945, 0), (950, 0), (955, 0), (960, 0), (965, 0), (970, 0), (975, 0), (980, 0), (985, 0), (990, 0), (995, 0), (1000, 0), (1005, 0), (1010, 0), (1015, 0), (1020, 1), (1025, 1)]
Vdin0_5  din0_5  0 PWL (0n 0.0v 4.745n 0.0v 4.755n 1.0v 9.745n 1.0v 9.755n 0.0v 14.745n 0.0v 14.755n 1.0v 19.745n 1.0v 19.755n 1.0v 24.745n 1.0v 24.755n 1.0v 29.745n 1.0v 29.755n 1.0v 34.745n 1.0v 34.755n 1.0v 39.745n 1.0v 39.755n 0.0v 44.745n 0.0v 44.755n 0.0v 49.745n 0.0v 49.755n 1.0v 54.745n 1.0v 54.755n 1.0v 59.745n 1.0v 59.755n 1.0v 64.745n 1.0v 64.755n 0.0v 69.745n 0.0v 69.755n 0.0v 74.745n 0.0v 74.755n 0.0v 79.745n 0.0v 79.755n 0.0v 84.745n 0.0v 84.755n 1.0v 89.745n 1.0v 89.755n 1.0v 94.745n 1.0v 94.755n 1.0v 99.745n 1.0v 99.755n 0.0v 104.745n 0.0v 104.755n 0.0v 109.745n 0.0v 109.755n 0.0v 114.745n 0.0v 114.755n 1.0v 119.745n 1.0v 119.755n 1.0v 124.745n 1.0v 124.755n 1.0v 129.745n 1.0v 129.755n 1.0v 134.745n 1.0v 134.755n 1.0v 139.745n 1.0v 139.755n 1.0v 144.745n 1.0v 144.755n 1.0v 149.745n 1.0v 149.755n 1.0v 154.745n 1.0v 154.755n 1.0v 159.745n 1.0v 159.755n 1.0v 164.745n 1.0v 164.755n 1.0v 169.745n 1.0v 169.755n 1.0v 174.745n 1.0v 174.755n 1.0v 179.745n 1.0v 179.755n 1.0v 184.745n 1.0v 184.755n 1.0v 189.745n 1.0v 189.755n 1.0v 194.745n 1.0v 194.755n 0.0v 199.745n 0.0v 199.755n 0.0v 204.745n 0.0v 204.755n 0.0v 209.745n 0.0v 209.755n 0.0v 214.745n 0.0v 214.755n 0.0v 219.745n 0.0v 219.755n 0.0v 224.745n 0.0v 224.755n 0.0v 229.745n 0.0v 229.755n 0.0v 234.745n 0.0v 234.755n 0.0v 239.745n 0.0v 239.755n 0.0v 244.745n 0.0v 244.755n 0.0v 249.745n 0.0v 249.755n 0.0v 254.745n 0.0v 254.755n 0.0v 259.745n 0.0v 259.755n 0.0v 264.745n 0.0v 264.755n 0.0v 269.745n 0.0v 269.755n 0.0v 274.745n 0.0v 274.755n 0.0v 279.745n 0.0v 279.755n 0.0v 284.745n 0.0v 284.755n 0.0v 289.745n 0.0v 289.755n 0.0v 294.745n 0.0v 294.755n 0.0v 299.745n 0.0v 299.755n 0.0v 304.745n 0.0v 304.755n 0.0v 309.745n 0.0v 309.755n 0.0v 314.745n 0.0v 314.755n 0.0v 319.745n 0.0v 319.755n 0.0v 324.745n 0.0v 324.755n 0.0v 329.745n 0.0v 329.755n 0.0v 334.745n 0.0v 334.755n 1.0v 339.745n 1.0v 339.755n 1.0v 344.745n 1.0v 344.755n 1.0v 349.745n 1.0v 349.755n 1.0v 354.745n 1.0v 354.755n 1.0v 359.745n 1.0v 359.755n 1.0v 364.745n 1.0v 364.755n 1.0v 369.745n 1.0v 369.755n 1.0v 374.745n 1.0v 374.755n 1.0v 379.745n 1.0v 379.755n 1.0v 384.745n 1.0v 384.755n 1.0v 389.745n 1.0v 389.755n 1.0v 394.745n 1.0v 394.755n 1.0v 399.745n 1.0v 399.755n 1.0v 404.745n 1.0v 404.755n 1.0v 409.745n 1.0v 409.755n 1.0v 414.745n 1.0v 414.755n 1.0v 419.745n 1.0v 419.755n 1.0v 424.745n 1.0v 424.755n 1.0v 429.745n 1.0v 429.755n 1.0v 434.745n 1.0v 434.755n 1.0v 439.745n 1.0v 439.755n 1.0v 444.745n 1.0v 444.755n 0.0v 449.745n 0.0v 449.755n 0.0v 454.745n 0.0v 454.755n 0.0v 459.745n 0.0v 459.755n 0.0v 464.745n 0.0v 464.755n 0.0v 469.745n 0.0v 469.755n 0.0v 474.745n 0.0v 474.755n 0.0v 479.745n 0.0v 479.755n 0.0v 484.745n 0.0v 484.755n 1.0v 489.745n 1.0v 489.755n 1.0v 494.745n 1.0v 494.755n 1.0v 499.745n 1.0v 499.755n 0.0v 504.745n 0.0v 504.755n 0.0v 509.745n 0.0v 509.755n 0.0v 514.745n 0.0v 514.755n 1.0v 519.745n 1.0v 519.755n 1.0v 524.745n 1.0v 524.755n 1.0v 529.745n 1.0v 529.755n 1.0v 534.745n 1.0v 534.755n 0.0v 539.745n 0.0v 539.755n 1.0v 544.745n 1.0v 544.755n 0.0v 549.745n 0.0v 549.755n 1.0v 554.745n 1.0v 554.755n 1.0v 559.745n 1.0v 559.755n 0.0v 564.745n 0.0v 564.755n 0.0v 569.745n 0.0v 569.755n 0.0v 574.745n 0.0v 574.755n 0.0v 579.745n 0.0v 579.755n 0.0v 584.745n 0.0v 584.755n 0.0v 589.745n 0.0v 589.755n 0.0v 594.745n 0.0v 594.755n 0.0v 599.745n 0.0v 599.755n 0.0v 604.745n 0.0v 604.755n 0.0v 609.745n 0.0v 609.755n 1.0v 614.745n 1.0v 614.755n 1.0v 619.745n 1.0v 619.755n 1.0v 624.745n 1.0v 624.755n 1.0v 629.745n 1.0v 629.755n 1.0v 634.745n 1.0v 634.755n 1.0v 639.745n 1.0v 639.755n 1.0v 644.745n 1.0v 644.755n 1.0v 649.745n 1.0v 649.755n 0.0v 654.745n 0.0v 654.755n 1.0v 659.745n 1.0v 659.755n 1.0v 664.745n 1.0v 664.755n 1.0v 669.745n 1.0v 669.755n 0.0v 674.745n 0.0v 674.755n 0.0v 679.745n 0.0v 679.755n 0.0v 684.745n 0.0v 684.755n 0.0v 689.745n 0.0v 689.755n 0.0v 694.745n 0.0v 694.755n 0.0v 699.745n 0.0v 699.755n 0.0v 704.745n 0.0v 704.755n 0.0v 709.745n 0.0v 709.755n 0.0v 714.745n 0.0v 714.755n 0.0v 719.745n 0.0v 719.755n 0.0v 724.745n 0.0v 724.755n 0.0v 729.745n 0.0v 729.755n 0.0v 734.745n 0.0v 734.755n 0.0v 739.745n 0.0v 739.755n 0.0v 744.745n 0.0v 744.755n 0.0v 749.745n 0.0v 749.755n 0.0v 754.745n 0.0v 754.755n 0.0v 759.745n 0.0v 759.755n 0.0v 764.745n 0.0v 764.755n 0.0v 769.745n 0.0v 769.755n 0.0v 774.745n 0.0v 774.755n 0.0v 779.745n 0.0v 779.755n 1.0v 784.745n 1.0v 784.755n 1.0v 789.745n 1.0v 789.755n 1.0v 794.745n 1.0v 794.755n 1.0v 799.745n 1.0v 799.755n 1.0v 804.745n 1.0v 804.755n 0.0v 809.745n 0.0v 809.755n 0.0v 814.745n 0.0v 814.755n 0.0v 819.745n 0.0v 819.755n 0.0v 824.745n 0.0v 824.755n 0.0v 829.745n 0.0v 829.755n 0.0v 834.745n 0.0v 834.755n 0.0v 839.745n 0.0v 839.755n 0.0v 844.745n 0.0v 844.755n 0.0v 849.745n 0.0v 849.755n 0.0v 854.745n 0.0v 854.755n 0.0v 859.745n 0.0v 859.755n 0.0v 864.745n 0.0v 864.755n 1.0v 869.745n 1.0v 869.755n 1.0v 874.745n 1.0v 874.755n 1.0v 879.745n 1.0v 879.755n 1.0v 884.745n 1.0v 884.755n 1.0v 889.745n 1.0v 889.755n 1.0v 894.745n 1.0v 894.755n 1.0v 899.745n 1.0v 899.755n 1.0v 904.745n 1.0v 904.755n 1.0v 909.745n 1.0v 909.755n 1.0v 914.745n 1.0v 914.755n 0.0v 919.745n 0.0v 919.755n 0.0v 924.745n 0.0v 924.755n 0.0v 929.745n 0.0v 929.755n 0.0v 934.745n 0.0v 934.755n 0.0v 939.745n 0.0v 939.755n 0.0v 944.745n 0.0v 944.755n 0.0v 949.745n 0.0v 949.755n 0.0v 954.745n 0.0v 954.755n 0.0v 959.745n 0.0v 959.755n 0.0v 964.745n 0.0v 964.755n 0.0v 969.745n 0.0v 969.755n 0.0v 974.745n 0.0v 974.755n 0.0v 979.745n 0.0v 979.755n 0.0v 984.745n 0.0v 984.755n 0.0v 989.745n 0.0v 989.755n 0.0v 994.745n 0.0v 994.755n 0.0v 999.745n 0.0v 999.755n 0.0v 1004.745n 0.0v 1004.755n 0.0v 1009.745n 0.0v 1009.755n 0.0v 1014.745n 0.0v 1014.755n 0.0v 1019.745n 0.0v 1019.755n 1.0v 1024.745n 1.0v 1024.755n 1.0v )
* (time, data): [(0, 0), (5, 0), (10, 1), (15, 1), (20, 1), (25, 1), (30, 0), (35, 0), (40, 0), (45, 0), (50, 0), (55, 0), (60, 0), (65, 0), (70, 0), (75, 0), (80, 0), (85, 0), (90, 0), (95, 0), (100, 1), (105, 1), (110, 1), (115, 1), (120, 1), (125, 1), (130, 1), (135, 1), (140, 1), (145, 1), (150, 1), (155, 0), (160, 0), (165, 0), (170, 0), (175, 0), (180, 0), (185, 0), (190, 1), (195, 1), (200, 1), (205, 1), (210, 1), (215, 1), (220, 1), (225, 1), (230, 1), (235, 1), (240, 1), (245, 1), (250, 1), (255, 1), (260, 1), (265, 1), (270, 1), (275, 1), (280, 1), (285, 1), (290, 1), (295, 1), (300, 1), (305, 1), (310, 1), (315, 1), (320, 1), (325, 1), (330, 1), (335, 0), (340, 0), (345, 0), (350, 1), (355, 1), (360, 1), (365, 1), (370, 1), (375, 1), (380, 1), (385, 1), (390, 1), (395, 1), (400, 1), (405, 1), (410, 0), (415, 0), (420, 0), (425, 0), (430, 0), (435, 0), (440, 0), (445, 0), (450, 0), (455, 0), (460, 0), (465, 0), (470, 0), (475, 0), (480, 0), (485, 1), (490, 1), (495, 1), (500, 0), (505, 0), (510, 0), (515, 1), (520, 1), (525, 1), (530, 1), (535, 0), (540, 1), (545, 0), (550, 0), (555, 0), (560, 1), (565, 1), (570, 1), (575, 1), (580, 1), (585, 1), (590, 1), (595, 1), (600, 0), (605, 0), (610, 0), (615, 0), (620, 1), (625, 1), (630, 1), (635, 1), (640, 1), (645, 0), (650, 1), (655, 1), (660, 1), (665, 1), (670, 1), (675, 1), (680, 1), (685, 1), (690, 1), (695, 1), (700, 1), (705, 1), (710, 1), (715, 1), (720, 0), (725, 0), (730, 0), (735, 0), (740, 1), (745, 1), (750, 1), (755, 1), (760, 1), (765, 1), (770, 0), (775, 0), (780, 0), (785, 0), (790, 0), (795, 0), (800, 0), (805, 0), (810, 0), (815, 0), (820, 0), (825, 0), (830, 0), (835, 0), (840, 1), (845, 1), (850, 1), (855, 0), (860, 0), (865, 1), (870, 1), (875, 1), (880, 1), (885, 1), (890, 1), (895, 1), (900, 1), (905, 1), (910, 0), (915, 0), (920, 0), (925, 0), (930, 0), (935, 0), (940, 0), (945, 0), (950, 0), (955, 0), (960, 0), (965, 1), (970, 1), (975, 1), (980, 1), (985, 1), (990, 1), (995, 1), (1000, 1), (1005, 1), (1010, 1), (1015, 1), (1020, 1), (1025, 1)]
Vdin0_6  din0_6  0 PWL (0n 0.0v 4.745n 0.0v 4.755n 0.0v 9.745n 0.0v 9.755n 1.0v 14.745n 1.0v 14.755n 1.0v 19.745n 1.0v 19.755n 1.0v 24.745n 1.0v 24.755n 1.0v 29.745n 1.0v 29.755n 0.0v 34.745n 0.0v 34.755n 0.0v 39.745n 0.0v 39.755n 0.0v 44.745n 0.0v 44.755n 0.0v 49.745n 0.0v 49.755n 0.0v 54.745n 0.0v 54.755n 0.0v 59.745n 0.0v 59.755n 0.0v 64.745n 0.0v 64.755n 0.0v 69.745n 0.0v 69.755n 0.0v 74.745n 0.0v 74.755n 0.0v 79.745n 0.0v 79.755n 0.0v 84.745n 0.0v 84.755n 0.0v 89.745n 0.0v 89.755n 0.0v 94.745n 0.0v 94.755n 0.0v 99.745n 0.0v 99.755n 1.0v 104.745n 1.0v 104.755n 1.0v 109.745n 1.0v 109.755n 1.0v 114.745n 1.0v 114.755n 1.0v 119.745n 1.0v 119.755n 1.0v 124.745n 1.0v 124.755n 1.0v 129.745n 1.0v 129.755n 1.0v 134.745n 1.0v 134.755n 1.0v 139.745n 1.0v 139.755n 1.0v 144.745n 1.0v 144.755n 1.0v 149.745n 1.0v 149.755n 1.0v 154.745n 1.0v 154.755n 0.0v 159.745n 0.0v 159.755n 0.0v 164.745n 0.0v 164.755n 0.0v 169.745n 0.0v 169.755n 0.0v 174.745n 0.0v 174.755n 0.0v 179.745n 0.0v 179.755n 0.0v 184.745n 0.0v 184.755n 0.0v 189.745n 0.0v 189.755n 1.0v 194.745n 1.0v 194.755n 1.0v 199.745n 1.0v 199.755n 1.0v 204.745n 1.0v 204.755n 1.0v 209.745n 1.0v 209.755n 1.0v 214.745n 1.0v 214.755n 1.0v 219.745n 1.0v 219.755n 1.0v 224.745n 1.0v 224.755n 1.0v 229.745n 1.0v 229.755n 1.0v 234.745n 1.0v 234.755n 1.0v 239.745n 1.0v 239.755n 1.0v 244.745n 1.0v 244.755n 1.0v 249.745n 1.0v 249.755n 1.0v 254.745n 1.0v 254.755n 1.0v 259.745n 1.0v 259.755n 1.0v 264.745n 1.0v 264.755n 1.0v 269.745n 1.0v 269.755n 1.0v 274.745n 1.0v 274.755n 1.0v 279.745n 1.0v 279.755n 1.0v 284.745n 1.0v 284.755n 1.0v 289.745n 1.0v 289.755n 1.0v 294.745n 1.0v 294.755n 1.0v 299.745n 1.0v 299.755n 1.0v 304.745n 1.0v 304.755n 1.0v 309.745n 1.0v 309.755n 1.0v 314.745n 1.0v 314.755n 1.0v 319.745n 1.0v 319.755n 1.0v 324.745n 1.0v 324.755n 1.0v 329.745n 1.0v 329.755n 1.0v 334.745n 1.0v 334.755n 0.0v 339.745n 0.0v 339.755n 0.0v 344.745n 0.0v 344.755n 0.0v 349.745n 0.0v 349.755n 1.0v 354.745n 1.0v 354.755n 1.0v 359.745n 1.0v 359.755n 1.0v 364.745n 1.0v 364.755n 1.0v 369.745n 1.0v 369.755n 1.0v 374.745n 1.0v 374.755n 1.0v 379.745n 1.0v 379.755n 1.0v 384.745n 1.0v 384.755n 1.0v 389.745n 1.0v 389.755n 1.0v 394.745n 1.0v 394.755n 1.0v 399.745n 1.0v 399.755n 1.0v 404.745n 1.0v 404.755n 1.0v 409.745n 1.0v 409.755n 0.0v 414.745n 0.0v 414.755n 0.0v 419.745n 0.0v 419.755n 0.0v 424.745n 0.0v 424.755n 0.0v 429.745n 0.0v 429.755n 0.0v 434.745n 0.0v 434.755n 0.0v 439.745n 0.0v 439.755n 0.0v 444.745n 0.0v 444.755n 0.0v 449.745n 0.0v 449.755n 0.0v 454.745n 0.0v 454.755n 0.0v 459.745n 0.0v 459.755n 0.0v 464.745n 0.0v 464.755n 0.0v 469.745n 0.0v 469.755n 0.0v 474.745n 0.0v 474.755n 0.0v 479.745n 0.0v 479.755n 0.0v 484.745n 0.0v 484.755n 1.0v 489.745n 1.0v 489.755n 1.0v 494.745n 1.0v 494.755n 1.0v 499.745n 1.0v 499.755n 0.0v 504.745n 0.0v 504.755n 0.0v 509.745n 0.0v 509.755n 0.0v 514.745n 0.0v 514.755n 1.0v 519.745n 1.0v 519.755n 1.0v 524.745n 1.0v 524.755n 1.0v 529.745n 1.0v 529.755n 1.0v 534.745n 1.0v 534.755n 0.0v 539.745n 0.0v 539.755n 1.0v 544.745n 1.0v 544.755n 0.0v 549.745n 0.0v 549.755n 0.0v 554.745n 0.0v 554.755n 0.0v 559.745n 0.0v 559.755n 1.0v 564.745n 1.0v 564.755n 1.0v 569.745n 1.0v 569.755n 1.0v 574.745n 1.0v 574.755n 1.0v 579.745n 1.0v 579.755n 1.0v 584.745n 1.0v 584.755n 1.0v 589.745n 1.0v 589.755n 1.0v 594.745n 1.0v 594.755n 1.0v 599.745n 1.0v 599.755n 0.0v 604.745n 0.0v 604.755n 0.0v 609.745n 0.0v 609.755n 0.0v 614.745n 0.0v 614.755n 0.0v 619.745n 0.0v 619.755n 1.0v 624.745n 1.0v 624.755n 1.0v 629.745n 1.0v 629.755n 1.0v 634.745n 1.0v 634.755n 1.0v 639.745n 1.0v 639.755n 1.0v 644.745n 1.0v 644.755n 0.0v 649.745n 0.0v 649.755n 1.0v 654.745n 1.0v 654.755n 1.0v 659.745n 1.0v 659.755n 1.0v 664.745n 1.0v 664.755n 1.0v 669.745n 1.0v 669.755n 1.0v 674.745n 1.0v 674.755n 1.0v 679.745n 1.0v 679.755n 1.0v 684.745n 1.0v 684.755n 1.0v 689.745n 1.0v 689.755n 1.0v 694.745n 1.0v 694.755n 1.0v 699.745n 1.0v 699.755n 1.0v 704.745n 1.0v 704.755n 1.0v 709.745n 1.0v 709.755n 1.0v 714.745n 1.0v 714.755n 1.0v 719.745n 1.0v 719.755n 0.0v 724.745n 0.0v 724.755n 0.0v 729.745n 0.0v 729.755n 0.0v 734.745n 0.0v 734.755n 0.0v 739.745n 0.0v 739.755n 1.0v 744.745n 1.0v 744.755n 1.0v 749.745n 1.0v 749.755n 1.0v 754.745n 1.0v 754.755n 1.0v 759.745n 1.0v 759.755n 1.0v 764.745n 1.0v 764.755n 1.0v 769.745n 1.0v 769.755n 0.0v 774.745n 0.0v 774.755n 0.0v 779.745n 0.0v 779.755n 0.0v 784.745n 0.0v 784.755n 0.0v 789.745n 0.0v 789.755n 0.0v 794.745n 0.0v 794.755n 0.0v 799.745n 0.0v 799.755n 0.0v 804.745n 0.0v 804.755n 0.0v 809.745n 0.0v 809.755n 0.0v 814.745n 0.0v 814.755n 0.0v 819.745n 0.0v 819.755n 0.0v 824.745n 0.0v 824.755n 0.0v 829.745n 0.0v 829.755n 0.0v 834.745n 0.0v 834.755n 0.0v 839.745n 0.0v 839.755n 1.0v 844.745n 1.0v 844.755n 1.0v 849.745n 1.0v 849.755n 1.0v 854.745n 1.0v 854.755n 0.0v 859.745n 0.0v 859.755n 0.0v 864.745n 0.0v 864.755n 1.0v 869.745n 1.0v 869.755n 1.0v 874.745n 1.0v 874.755n 1.0v 879.745n 1.0v 879.755n 1.0v 884.745n 1.0v 884.755n 1.0v 889.745n 1.0v 889.755n 1.0v 894.745n 1.0v 894.755n 1.0v 899.745n 1.0v 899.755n 1.0v 904.745n 1.0v 904.755n 1.0v 909.745n 1.0v 909.755n 0.0v 914.745n 0.0v 914.755n 0.0v 919.745n 0.0v 919.755n 0.0v 924.745n 0.0v 924.755n 0.0v 929.745n 0.0v 929.755n 0.0v 934.745n 0.0v 934.755n 0.0v 939.745n 0.0v 939.755n 0.0v 944.745n 0.0v 944.755n 0.0v 949.745n 0.0v 949.755n 0.0v 954.745n 0.0v 954.755n 0.0v 959.745n 0.0v 959.755n 0.0v 964.745n 0.0v 964.755n 1.0v 969.745n 1.0v 969.755n 1.0v 974.745n 1.0v 974.755n 1.0v 979.745n 1.0v 979.755n 1.0v 984.745n 1.0v 984.755n 1.0v 989.745n 1.0v 989.755n 1.0v 994.745n 1.0v 994.755n 1.0v 999.745n 1.0v 999.755n 1.0v 1004.745n 1.0v 1004.755n 1.0v 1009.745n 1.0v 1009.755n 1.0v 1014.745n 1.0v 1014.755n 1.0v 1019.745n 1.0v 1019.755n 1.0v 1024.745n 1.0v 1024.755n 1.0v )
* (time, data): [(0, 0), (5, 0), (10, 0), (15, 0), (20, 0), (25, 0), (30, 0), (35, 0), (40, 1), (45, 1), (50, 0), (55, 0), (60, 0), (65, 1), (70, 1), (75, 1), (80, 1), (85, 1), (90, 1), (95, 1), (100, 0), (105, 1), (110, 1), (115, 0), (120, 0), (125, 0), (130, 0), (135, 0), (140, 0), (145, 0), (150, 0), (155, 1), (160, 1), (165, 1), (170, 1), (175, 0), (180, 0), (185, 0), (190, 0), (195, 1), (200, 1), (205, 1), (210, 1), (215, 1), (220, 1), (225, 1), (230, 1), (235, 1), (240, 1), (245, 1), (250, 1), (255, 1), (260, 1), (265, 1), (270, 1), (275, 1), (280, 1), (285, 1), (290, 0), (295, 0), (300, 0), (305, 0), (310, 0), (315, 0), (320, 0), (325, 0), (330, 0), (335, 0), (340, 0), (345, 0), (350, 1), (355, 1), (360, 1), (365, 1), (370, 1), (375, 1), (380, 1), (385, 1), (390, 1), (395, 1), (400, 1), (405, 1), (410, 0), (415, 0), (420, 0), (425, 0), (430, 0), (435, 0), (440, 0), (445, 0), (450, 0), (455, 0), (460, 0), (465, 0), (470, 0), (475, 0), (480, 0), (485, 1), (490, 0), (495, 0), (500, 0), (505, 0), (510, 0), (515, 0), (520, 0), (525, 0), (530, 0), (535, 0), (540, 0), (545, 0), (550, 1), (555, 1), (560, 0), (565, 0), (570, 0), (575, 0), (580, 0), (585, 0), (590, 0), (595, 0), (600, 1), (605, 1), (610, 1), (615, 1), (620, 1), (625, 1), (630, 1), (635, 1), (640, 1), (645, 1), (650, 1), (655, 1), (660, 1), (665, 1), (670, 1), (675, 1), (680, 1), (685, 1), (690, 1), (695, 1), (700, 1), (705, 1), (710, 1), (715, 1), (720, 0), (725, 0), (730, 0), (735, 0), (740, 0), (745, 0), (750, 0), (755, 0), (760, 0), (765, 0), (770, 1), (775, 1), (780, 1), (785, 1), (790, 1), (795, 1), (800, 1), (805, 1), (810, 0), (815, 0), (820, 0), (825, 0), (830, 0), (835, 0), (840, 1), (845, 1), (850, 1), (855, 0), (860, 0), (865, 1), (870, 0), (875, 0), (880, 0), (885, 0), (890, 0), (895, 0), (900, 0), (905, 0), (910, 0), (915, 1), (920, 1), (925, 1), (930, 1), (935, 1), (940, 1), (945, 1), (950, 1), (955, 1), (960, 1), (965, 0), (970, 0), (975, 0), (980, 0), (985, 0), (990, 0), (995, 0), (1000, 0), (1005, 0), (1010, 0), (1015, 0), (1020, 1), (1025, 1)]
Vdin0_7  din0_7  0 PWL (0n 0.0v 4.745n 0.0v 4.755n 0.0v 9.745n 0.0v 9.755n 0.0v 14.745n 0.0v 14.755n 0.0v 19.745n 0.0v 19.755n 0.0v 24.745n 0.0v 24.755n 0.0v 29.745n 0.0v 29.755n 0.0v 34.745n 0.0v 34.755n 0.0v 39.745n 0.0v 39.755n 1.0v 44.745n 1.0v 44.755n 1.0v 49.745n 1.0v 49.755n 0.0v 54.745n 0.0v 54.755n 0.0v 59.745n 0.0v 59.755n 0.0v 64.745n 0.0v 64.755n 1.0v 69.745n 1.0v 69.755n 1.0v 74.745n 1.0v 74.755n 1.0v 79.745n 1.0v 79.755n 1.0v 84.745n 1.0v 84.755n 1.0v 89.745n 1.0v 89.755n 1.0v 94.745n 1.0v 94.755n 1.0v 99.745n 1.0v 99.755n 0.0v 104.745n 0.0v 104.755n 1.0v 109.745n 1.0v 109.755n 1.0v 114.745n 1.0v 114.755n 0.0v 119.745n 0.0v 119.755n 0.0v 124.745n 0.0v 124.755n 0.0v 129.745n 0.0v 129.755n 0.0v 134.745n 0.0v 134.755n 0.0v 139.745n 0.0v 139.755n 0.0v 144.745n 0.0v 144.755n 0.0v 149.745n 0.0v 149.755n 0.0v 154.745n 0.0v 154.755n 1.0v 159.745n 1.0v 159.755n 1.0v 164.745n 1.0v 164.755n 1.0v 169.745n 1.0v 169.755n 1.0v 174.745n 1.0v 174.755n 0.0v 179.745n 0.0v 179.755n 0.0v 184.745n 0.0v 184.755n 0.0v 189.745n 0.0v 189.755n 0.0v 194.745n 0.0v 194.755n 1.0v 199.745n 1.0v 199.755n 1.0v 204.745n 1.0v 204.755n 1.0v 209.745n 1.0v 209.755n 1.0v 214.745n 1.0v 214.755n 1.0v 219.745n 1.0v 219.755n 1.0v 224.745n 1.0v 224.755n 1.0v 229.745n 1.0v 229.755n 1.0v 234.745n 1.0v 234.755n 1.0v 239.745n 1.0v 239.755n 1.0v 244.745n 1.0v 244.755n 1.0v 249.745n 1.0v 249.755n 1.0v 254.745n 1.0v 254.755n 1.0v 259.745n 1.0v 259.755n 1.0v 264.745n 1.0v 264.755n 1.0v 269.745n 1.0v 269.755n 1.0v 274.745n 1.0v 274.755n 1.0v 279.745n 1.0v 279.755n 1.0v 284.745n 1.0v 284.755n 1.0v 289.745n 1.0v 289.755n 0.0v 294.745n 0.0v 294.755n 0.0v 299.745n 0.0v 299.755n 0.0v 304.745n 0.0v 304.755n 0.0v 309.745n 0.0v 309.755n 0.0v 314.745n 0.0v 314.755n 0.0v 319.745n 0.0v 319.755n 0.0v 324.745n 0.0v 324.755n 0.0v 329.745n 0.0v 329.755n 0.0v 334.745n 0.0v 334.755n 0.0v 339.745n 0.0v 339.755n 0.0v 344.745n 0.0v 344.755n 0.0v 349.745n 0.0v 349.755n 1.0v 354.745n 1.0v 354.755n 1.0v 359.745n 1.0v 359.755n 1.0v 364.745n 1.0v 364.755n 1.0v 369.745n 1.0v 369.755n 1.0v 374.745n 1.0v 374.755n 1.0v 379.745n 1.0v 379.755n 1.0v 384.745n 1.0v 384.755n 1.0v 389.745n 1.0v 389.755n 1.0v 394.745n 1.0v 394.755n 1.0v 399.745n 1.0v 399.755n 1.0v 404.745n 1.0v 404.755n 1.0v 409.745n 1.0v 409.755n 0.0v 414.745n 0.0v 414.755n 0.0v 419.745n 0.0v 419.755n 0.0v 424.745n 0.0v 424.755n 0.0v 429.745n 0.0v 429.755n 0.0v 434.745n 0.0v 434.755n 0.0v 439.745n 0.0v 439.755n 0.0v 444.745n 0.0v 444.755n 0.0v 449.745n 0.0v 449.755n 0.0v 454.745n 0.0v 454.755n 0.0v 459.745n 0.0v 459.755n 0.0v 464.745n 0.0v 464.755n 0.0v 469.745n 0.0v 469.755n 0.0v 474.745n 0.0v 474.755n 0.0v 479.745n 0.0v 479.755n 0.0v 484.745n 0.0v 484.755n 1.0v 489.745n 1.0v 489.755n 0.0v 494.745n 0.0v 494.755n 0.0v 499.745n 0.0v 499.755n 0.0v 504.745n 0.0v 504.755n 0.0v 509.745n 0.0v 509.755n 0.0v 514.745n 0.0v 514.755n 0.0v 519.745n 0.0v 519.755n 0.0v 524.745n 0.0v 524.755n 0.0v 529.745n 0.0v 529.755n 0.0v 534.745n 0.0v 534.755n 0.0v 539.745n 0.0v 539.755n 0.0v 544.745n 0.0v 544.755n 0.0v 549.745n 0.0v 549.755n 1.0v 554.745n 1.0v 554.755n 1.0v 559.745n 1.0v 559.755n 0.0v 564.745n 0.0v 564.755n 0.0v 569.745n 0.0v 569.755n 0.0v 574.745n 0.0v 574.755n 0.0v 579.745n 0.0v 579.755n 0.0v 584.745n 0.0v 584.755n 0.0v 589.745n 0.0v 589.755n 0.0v 594.745n 0.0v 594.755n 0.0v 599.745n 0.0v 599.755n 1.0v 604.745n 1.0v 604.755n 1.0v 609.745n 1.0v 609.755n 1.0v 614.745n 1.0v 614.755n 1.0v 619.745n 1.0v 619.755n 1.0v 624.745n 1.0v 624.755n 1.0v 629.745n 1.0v 629.755n 1.0v 634.745n 1.0v 634.755n 1.0v 639.745n 1.0v 639.755n 1.0v 644.745n 1.0v 644.755n 1.0v 649.745n 1.0v 649.755n 1.0v 654.745n 1.0v 654.755n 1.0v 659.745n 1.0v 659.755n 1.0v 664.745n 1.0v 664.755n 1.0v 669.745n 1.0v 669.755n 1.0v 674.745n 1.0v 674.755n 1.0v 679.745n 1.0v 679.755n 1.0v 684.745n 1.0v 684.755n 1.0v 689.745n 1.0v 689.755n 1.0v 694.745n 1.0v 694.755n 1.0v 699.745n 1.0v 699.755n 1.0v 704.745n 1.0v 704.755n 1.0v 709.745n 1.0v 709.755n 1.0v 714.745n 1.0v 714.755n 1.0v 719.745n 1.0v 719.755n 0.0v 724.745n 0.0v 724.755n 0.0v 729.745n 0.0v 729.755n 0.0v 734.745n 0.0v 734.755n 0.0v 739.745n 0.0v 739.755n 0.0v 744.745n 0.0v 744.755n 0.0v 749.745n 0.0v 749.755n 0.0v 754.745n 0.0v 754.755n 0.0v 759.745n 0.0v 759.755n 0.0v 764.745n 0.0v 764.755n 0.0v 769.745n 0.0v 769.755n 1.0v 774.745n 1.0v 774.755n 1.0v 779.745n 1.0v 779.755n 1.0v 784.745n 1.0v 784.755n 1.0v 789.745n 1.0v 789.755n 1.0v 794.745n 1.0v 794.755n 1.0v 799.745n 1.0v 799.755n 1.0v 804.745n 1.0v 804.755n 1.0v 809.745n 1.0v 809.755n 0.0v 814.745n 0.0v 814.755n 0.0v 819.745n 0.0v 819.755n 0.0v 824.745n 0.0v 824.755n 0.0v 829.745n 0.0v 829.755n 0.0v 834.745n 0.0v 834.755n 0.0v 839.745n 0.0v 839.755n 1.0v 844.745n 1.0v 844.755n 1.0v 849.745n 1.0v 849.755n 1.0v 854.745n 1.0v 854.755n 0.0v 859.745n 0.0v 859.755n 0.0v 864.745n 0.0v 864.755n 1.0v 869.745n 1.0v 869.755n 0.0v 874.745n 0.0v 874.755n 0.0v 879.745n 0.0v 879.755n 0.0v 884.745n 0.0v 884.755n 0.0v 889.745n 0.0v 889.755n 0.0v 894.745n 0.0v 894.755n 0.0v 899.745n 0.0v 899.755n 0.0v 904.745n 0.0v 904.755n 0.0v 909.745n 0.0v 909.755n 0.0v 914.745n 0.0v 914.755n 1.0v 919.745n 1.0v 919.755n 1.0v 924.745n 1.0v 924.755n 1.0v 929.745n 1.0v 929.755n 1.0v 934.745n 1.0v 934.755n 1.0v 939.745n 1.0v 939.755n 1.0v 944.745n 1.0v 944.755n 1.0v 949.745n 1.0v 949.755n 1.0v 954.745n 1.0v 954.755n 1.0v 959.745n 1.0v 959.755n 1.0v 964.745n 1.0v 964.755n 0.0v 969.745n 0.0v 969.755n 0.0v 974.745n 0.0v 974.755n 0.0v 979.745n 0.0v 979.755n 0.0v 984.745n 0.0v 984.755n 0.0v 989.745n 0.0v 989.755n 0.0v 994.745n 0.0v 994.755n 0.0v 999.745n 0.0v 999.755n 0.0v 1004.745n 0.0v 1004.755n 0.0v 1009.745n 0.0v 1009.755n 0.0v 1014.745n 0.0v 1014.755n 0.0v 1019.745n 0.0v 1019.755n 1.0v 1024.745n 1.0v 1024.755n 1.0v )
* (time, data): [(0, 0), (5, 0), (10, 0), (15, 1), (20, 1), (25, 1), (30, 0), (35, 0), (40, 0), (45, 0), (50, 1), (55, 1), (60, 1), (65, 0), (70, 0), (75, 0), (80, 0), (85, 0), (90, 0), (95, 0), (100, 1), (105, 0), (110, 0), (115, 1), (120, 1), (125, 1), (130, 1), (135, 1), (140, 1), (145, 1), (150, 1), (155, 0), (160, 0), (165, 0), (170, 0), (175, 0), (180, 0), (185, 0), (190, 0), (195, 0), (200, 0), (205, 0), (210, 0), (215, 0), (220, 0), (225, 0), (230, 0), (235, 0), (240, 0), (245, 0), (250, 0), (255, 0), (260, 0), (265, 0), (270, 0), (275, 0), (280, 0), (285, 0), (290, 0), (295, 0), (300, 0), (305, 0), (310, 0), (315, 0), (320, 0), (325, 0), (330, 0), (335, 1), (340, 1), (345, 1), (350, 1), (355, 1), (360, 1), (365, 1), (370, 1), (375, 1), (380, 1), (385, 1), (390, 1), (395, 1), (400, 1), (405, 1), (410, 0), (415, 0), (420, 0), (425, 0), (430, 0), (435, 1), (440, 1), (445, 0), (450, 0), (455, 0), (460, 0), (465, 0), (470, 0), (475, 0), (480, 0), (485, 0), (490, 1), (495, 1), (500, 1), (505, 1), (510, 1), (515, 0), (520, 0), (525, 0), (530, 0), (535, 1), (540, 0), (545, 1), (550, 1), (555, 1), (560, 0), (565, 0), (570, 0), (575, 0), (580, 0), (585, 0), (590, 0), (595, 0), (600, 1), (605, 1), (610, 0), (615, 0), (620, 1), (625, 1), (630, 1), (635, 0), (640, 0), (645, 1), (650, 0), (655, 1), (660, 1), (665, 1), (670, 0), (675, 0), (680, 0), (685, 0), (690, 0), (695, 0), (700, 0), (705, 0), (710, 0), (715, 0), (720, 1), (725, 1), (730, 1), (735, 1), (740, 1), (745, 1), (750, 1), (755, 1), (760, 1), (765, 1), (770, 0), (775, 0), (780, 0), (785, 0), (790, 0), (795, 0), (800, 0), (805, 1), (810, 1), (815, 1), (820, 1), (825, 1), (830, 1), (835, 1), (840, 1), (845, 1), (850, 0), (855, 0), (860, 0), (865, 0), (870, 0), (875, 0), (880, 0), (885, 0), (890, 0), (895, 0), (900, 0), (905, 0), (910, 0), (915, 1), (920, 1), (925, 1), (930, 0), (935, 0), (940, 0), (945, 0), (950, 0), (955, 0), (960, 0), (965, 1), (970, 1), (975, 1), (980, 1), (985, 1), (990, 1), (995, 1), (1000, 1), (1005, 1), (1010, 1), (1015, 1), (1020, 1), (1025, 1)]
Vdin0_8  din0_8  0 PWL (0n 0.0v 4.745n 0.0v 4.755n 0.0v 9.745n 0.0v 9.755n 0.0v 14.745n 0.0v 14.755n 1.0v 19.745n 1.0v 19.755n 1.0v 24.745n 1.0v 24.755n 1.0v 29.745n 1.0v 29.755n 0.0v 34.745n 0.0v 34.755n 0.0v 39.745n 0.0v 39.755n 0.0v 44.745n 0.0v 44.755n 0.0v 49.745n 0.0v 49.755n 1.0v 54.745n 1.0v 54.755n 1.0v 59.745n 1.0v 59.755n 1.0v 64.745n 1.0v 64.755n 0.0v 69.745n 0.0v 69.755n 0.0v 74.745n 0.0v 74.755n 0.0v 79.745n 0.0v 79.755n 0.0v 84.745n 0.0v 84.755n 0.0v 89.745n 0.0v 89.755n 0.0v 94.745n 0.0v 94.755n 0.0v 99.745n 0.0v 99.755n 1.0v 104.745n 1.0v 104.755n 0.0v 109.745n 0.0v 109.755n 0.0v 114.745n 0.0v 114.755n 1.0v 119.745n 1.0v 119.755n 1.0v 124.745n 1.0v 124.755n 1.0v 129.745n 1.0v 129.755n 1.0v 134.745n 1.0v 134.755n 1.0v 139.745n 1.0v 139.755n 1.0v 144.745n 1.0v 144.755n 1.0v 149.745n 1.0v 149.755n 1.0v 154.745n 1.0v 154.755n 0.0v 159.745n 0.0v 159.755n 0.0v 164.745n 0.0v 164.755n 0.0v 169.745n 0.0v 169.755n 0.0v 174.745n 0.0v 174.755n 0.0v 179.745n 0.0v 179.755n 0.0v 184.745n 0.0v 184.755n 0.0v 189.745n 0.0v 189.755n 0.0v 194.745n 0.0v 194.755n 0.0v 199.745n 0.0v 199.755n 0.0v 204.745n 0.0v 204.755n 0.0v 209.745n 0.0v 209.755n 0.0v 214.745n 0.0v 214.755n 0.0v 219.745n 0.0v 219.755n 0.0v 224.745n 0.0v 224.755n 0.0v 229.745n 0.0v 229.755n 0.0v 234.745n 0.0v 234.755n 0.0v 239.745n 0.0v 239.755n 0.0v 244.745n 0.0v 244.755n 0.0v 249.745n 0.0v 249.755n 0.0v 254.745n 0.0v 254.755n 0.0v 259.745n 0.0v 259.755n 0.0v 264.745n 0.0v 264.755n 0.0v 269.745n 0.0v 269.755n 0.0v 274.745n 0.0v 274.755n 0.0v 279.745n 0.0v 279.755n 0.0v 284.745n 0.0v 284.755n 0.0v 289.745n 0.0v 289.755n 0.0v 294.745n 0.0v 294.755n 0.0v 299.745n 0.0v 299.755n 0.0v 304.745n 0.0v 304.755n 0.0v 309.745n 0.0v 309.755n 0.0v 314.745n 0.0v 314.755n 0.0v 319.745n 0.0v 319.755n 0.0v 324.745n 0.0v 324.755n 0.0v 329.745n 0.0v 329.755n 0.0v 334.745n 0.0v 334.755n 1.0v 339.745n 1.0v 339.755n 1.0v 344.745n 1.0v 344.755n 1.0v 349.745n 1.0v 349.755n 1.0v 354.745n 1.0v 354.755n 1.0v 359.745n 1.0v 359.755n 1.0v 364.745n 1.0v 364.755n 1.0v 369.745n 1.0v 369.755n 1.0v 374.745n 1.0v 374.755n 1.0v 379.745n 1.0v 379.755n 1.0v 384.745n 1.0v 384.755n 1.0v 389.745n 1.0v 389.755n 1.0v 394.745n 1.0v 394.755n 1.0v 399.745n 1.0v 399.755n 1.0v 404.745n 1.0v 404.755n 1.0v 409.745n 1.0v 409.755n 0.0v 414.745n 0.0v 414.755n 0.0v 419.745n 0.0v 419.755n 0.0v 424.745n 0.0v 424.755n 0.0v 429.745n 0.0v 429.755n 0.0v 434.745n 0.0v 434.755n 1.0v 439.745n 1.0v 439.755n 1.0v 444.745n 1.0v 444.755n 0.0v 449.745n 0.0v 449.755n 0.0v 454.745n 0.0v 454.755n 0.0v 459.745n 0.0v 459.755n 0.0v 464.745n 0.0v 464.755n 0.0v 469.745n 0.0v 469.755n 0.0v 474.745n 0.0v 474.755n 0.0v 479.745n 0.0v 479.755n 0.0v 484.745n 0.0v 484.755n 0.0v 489.745n 0.0v 489.755n 1.0v 494.745n 1.0v 494.755n 1.0v 499.745n 1.0v 499.755n 1.0v 504.745n 1.0v 504.755n 1.0v 509.745n 1.0v 509.755n 1.0v 514.745n 1.0v 514.755n 0.0v 519.745n 0.0v 519.755n 0.0v 524.745n 0.0v 524.755n 0.0v 529.745n 0.0v 529.755n 0.0v 534.745n 0.0v 534.755n 1.0v 539.745n 1.0v 539.755n 0.0v 544.745n 0.0v 544.755n 1.0v 549.745n 1.0v 549.755n 1.0v 554.745n 1.0v 554.755n 1.0v 559.745n 1.0v 559.755n 0.0v 564.745n 0.0v 564.755n 0.0v 569.745n 0.0v 569.755n 0.0v 574.745n 0.0v 574.755n 0.0v 579.745n 0.0v 579.755n 0.0v 584.745n 0.0v 584.755n 0.0v 589.745n 0.0v 589.755n 0.0v 594.745n 0.0v 594.755n 0.0v 599.745n 0.0v 599.755n 1.0v 604.745n 1.0v 604.755n 1.0v 609.745n 1.0v 609.755n 0.0v 614.745n 0.0v 614.755n 0.0v 619.745n 0.0v 619.755n 1.0v 624.745n 1.0v 624.755n 1.0v 629.745n 1.0v 629.755n 1.0v 634.745n 1.0v 634.755n 0.0v 639.745n 0.0v 639.755n 0.0v 644.745n 0.0v 644.755n 1.0v 649.745n 1.0v 649.755n 0.0v 654.745n 0.0v 654.755n 1.0v 659.745n 1.0v 659.755n 1.0v 664.745n 1.0v 664.755n 1.0v 669.745n 1.0v 669.755n 0.0v 674.745n 0.0v 674.755n 0.0v 679.745n 0.0v 679.755n 0.0v 684.745n 0.0v 684.755n 0.0v 689.745n 0.0v 689.755n 0.0v 694.745n 0.0v 694.755n 0.0v 699.745n 0.0v 699.755n 0.0v 704.745n 0.0v 704.755n 0.0v 709.745n 0.0v 709.755n 0.0v 714.745n 0.0v 714.755n 0.0v 719.745n 0.0v 719.755n 1.0v 724.745n 1.0v 724.755n 1.0v 729.745n 1.0v 729.755n 1.0v 734.745n 1.0v 734.755n 1.0v 739.745n 1.0v 739.755n 1.0v 744.745n 1.0v 744.755n 1.0v 749.745n 1.0v 749.755n 1.0v 754.745n 1.0v 754.755n 1.0v 759.745n 1.0v 759.755n 1.0v 764.745n 1.0v 764.755n 1.0v 769.745n 1.0v 769.755n 0.0v 774.745n 0.0v 774.755n 0.0v 779.745n 0.0v 779.755n 0.0v 784.745n 0.0v 784.755n 0.0v 789.745n 0.0v 789.755n 0.0v 794.745n 0.0v 794.755n 0.0v 799.745n 0.0v 799.755n 0.0v 804.745n 0.0v 804.755n 1.0v 809.745n 1.0v 809.755n 1.0v 814.745n 1.0v 814.755n 1.0v 819.745n 1.0v 819.755n 1.0v 824.745n 1.0v 824.755n 1.0v 829.745n 1.0v 829.755n 1.0v 834.745n 1.0v 834.755n 1.0v 839.745n 1.0v 839.755n 1.0v 844.745n 1.0v 844.755n 1.0v 849.745n 1.0v 849.755n 0.0v 854.745n 0.0v 854.755n 0.0v 859.745n 0.0v 859.755n 0.0v 864.745n 0.0v 864.755n 0.0v 869.745n 0.0v 869.755n 0.0v 874.745n 0.0v 874.755n 0.0v 879.745n 0.0v 879.755n 0.0v 884.745n 0.0v 884.755n 0.0v 889.745n 0.0v 889.755n 0.0v 894.745n 0.0v 894.755n 0.0v 899.745n 0.0v 899.755n 0.0v 904.745n 0.0v 904.755n 0.0v 909.745n 0.0v 909.755n 0.0v 914.745n 0.0v 914.755n 1.0v 919.745n 1.0v 919.755n 1.0v 924.745n 1.0v 924.755n 1.0v 929.745n 1.0v 929.755n 0.0v 934.745n 0.0v 934.755n 0.0v 939.745n 0.0v 939.755n 0.0v 944.745n 0.0v 944.755n 0.0v 949.745n 0.0v 949.755n 0.0v 954.745n 0.0v 954.755n 0.0v 959.745n 0.0v 959.755n 0.0v 964.745n 0.0v 964.755n 1.0v 969.745n 1.0v 969.755n 1.0v 974.745n 1.0v 974.755n 1.0v 979.745n 1.0v 979.755n 1.0v 984.745n 1.0v 984.755n 1.0v 989.745n 1.0v 989.755n 1.0v 994.745n 1.0v 994.755n 1.0v 999.745n 1.0v 999.755n 1.0v 1004.745n 1.0v 1004.755n 1.0v 1009.745n 1.0v 1009.755n 1.0v 1014.745n 1.0v 1014.755n 1.0v 1019.745n 1.0v 1019.755n 1.0v 1024.745n 1.0v 1024.755n 1.0v )
* (time, data): [(0, 0), (5, 1), (10, 1), (15, 0), (20, 0), (25, 0), (30, 1), (35, 1), (40, 0), (45, 0), (50, 1), (55, 1), (60, 1), (65, 1), (70, 1), (75, 1), (80, 1), (85, 1), (90, 1), (95, 1), (100, 1), (105, 1), (110, 1), (115, 1), (120, 1), (125, 1), (130, 1), (135, 1), (140, 1), (145, 1), (150, 1), (155, 1), (160, 1), (165, 1), (170, 1), (175, 1), (180, 1), (185, 1), (190, 1), (195, 1), (200, 1), (205, 1), (210, 1), (215, 1), (220, 1), (225, 1), (230, 1), (235, 1), (240, 1), (245, 1), (250, 1), (255, 1), (260, 1), (265, 1), (270, 1), (275, 1), (280, 1), (285, 1), (290, 1), (295, 1), (300, 1), (305, 1), (310, 1), (315, 1), (320, 1), (325, 1), (330, 1), (335, 0), (340, 0), (345, 0), (350, 1), (355, 1), (360, 1), (365, 1), (370, 1), (375, 1), (380, 1), (385, 1), (390, 1), (395, 1), (400, 1), (405, 1), (410, 1), (415, 1), (420, 1), (425, 1), (430, 1), (435, 0), (440, 0), (445, 0), (450, 0), (455, 0), (460, 0), (465, 0), (470, 0), (475, 0), (480, 0), (485, 0), (490, 1), (495, 1), (500, 0), (505, 0), (510, 0), (515, 0), (520, 0), (525, 0), (530, 0), (535, 1), (540, 1), (545, 0), (550, 1), (555, 1), (560, 0), (565, 0), (570, 0), (575, 0), (580, 0), (585, 0), (590, 0), (595, 0), (600, 0), (605, 0), (610, 1), (615, 1), (620, 0), (625, 0), (630, 0), (635, 1), (640, 1), (645, 0), (650, 1), (655, 1), (660, 1), (665, 1), (670, 1), (675, 1), (680, 1), (685, 1), (690, 1), (695, 1), (700, 1), (705, 1), (710, 1), (715, 1), (720, 1), (725, 1), (730, 1), (735, 1), (740, 1), (745, 1), (750, 1), (755, 1), (760, 1), (765, 1), (770, 1), (775, 1), (780, 1), (785, 1), (790, 1), (795, 1), (800, 1), (805, 1), (810, 0), (815, 0), (820, 0), (825, 0), (830, 0), (835, 0), (840, 0), (845, 0), (850, 0), (855, 0), (860, 0), (865, 1), (870, 0), (875, 0), (880, 0), (885, 0), (890, 0), (895, 0), (900, 0), (905, 0), (910, 0), (915, 0), (920, 0), (925, 0), (930, 0), (935, 0), (940, 0), (945, 0), (950, 0), (955, 0), (960, 0), (965, 1), (970, 1), (975, 1), (980, 1), (985, 1), (990, 1), (995, 1), (1000, 1), (1005, 1), (1010, 1), (1015, 1), (1020, 1), (1025, 1)]
Vdin0_9  din0_9  0 PWL (0n 0.0v 4.745n 0.0v 4.755n 1.0v 9.745n 1.0v 9.755n 1.0v 14.745n 1.0v 14.755n 0.0v 19.745n 0.0v 19.755n 0.0v 24.745n 0.0v 24.755n 0.0v 29.745n 0.0v 29.755n 1.0v 34.745n 1.0v 34.755n 1.0v 39.745n 1.0v 39.755n 0.0v 44.745n 0.0v 44.755n 0.0v 49.745n 0.0v 49.755n 1.0v 54.745n 1.0v 54.755n 1.0v 59.745n 1.0v 59.755n 1.0v 64.745n 1.0v 64.755n 1.0v 69.745n 1.0v 69.755n 1.0v 74.745n 1.0v 74.755n 1.0v 79.745n 1.0v 79.755n 1.0v 84.745n 1.0v 84.755n 1.0v 89.745n 1.0v 89.755n 1.0v 94.745n 1.0v 94.755n 1.0v 99.745n 1.0v 99.755n 1.0v 104.745n 1.0v 104.755n 1.0v 109.745n 1.0v 109.755n 1.0v 114.745n 1.0v 114.755n 1.0v 119.745n 1.0v 119.755n 1.0v 124.745n 1.0v 124.755n 1.0v 129.745n 1.0v 129.755n 1.0v 134.745n 1.0v 134.755n 1.0v 139.745n 1.0v 139.755n 1.0v 144.745n 1.0v 144.755n 1.0v 149.745n 1.0v 149.755n 1.0v 154.745n 1.0v 154.755n 1.0v 159.745n 1.0v 159.755n 1.0v 164.745n 1.0v 164.755n 1.0v 169.745n 1.0v 169.755n 1.0v 174.745n 1.0v 174.755n 1.0v 179.745n 1.0v 179.755n 1.0v 184.745n 1.0v 184.755n 1.0v 189.745n 1.0v 189.755n 1.0v 194.745n 1.0v 194.755n 1.0v 199.745n 1.0v 199.755n 1.0v 204.745n 1.0v 204.755n 1.0v 209.745n 1.0v 209.755n 1.0v 214.745n 1.0v 214.755n 1.0v 219.745n 1.0v 219.755n 1.0v 224.745n 1.0v 224.755n 1.0v 229.745n 1.0v 229.755n 1.0v 234.745n 1.0v 234.755n 1.0v 239.745n 1.0v 239.755n 1.0v 244.745n 1.0v 244.755n 1.0v 249.745n 1.0v 249.755n 1.0v 254.745n 1.0v 254.755n 1.0v 259.745n 1.0v 259.755n 1.0v 264.745n 1.0v 264.755n 1.0v 269.745n 1.0v 269.755n 1.0v 274.745n 1.0v 274.755n 1.0v 279.745n 1.0v 279.755n 1.0v 284.745n 1.0v 284.755n 1.0v 289.745n 1.0v 289.755n 1.0v 294.745n 1.0v 294.755n 1.0v 299.745n 1.0v 299.755n 1.0v 304.745n 1.0v 304.755n 1.0v 309.745n 1.0v 309.755n 1.0v 314.745n 1.0v 314.755n 1.0v 319.745n 1.0v 319.755n 1.0v 324.745n 1.0v 324.755n 1.0v 329.745n 1.0v 329.755n 1.0v 334.745n 1.0v 334.755n 0.0v 339.745n 0.0v 339.755n 0.0v 344.745n 0.0v 344.755n 0.0v 349.745n 0.0v 349.755n 1.0v 354.745n 1.0v 354.755n 1.0v 359.745n 1.0v 359.755n 1.0v 364.745n 1.0v 364.755n 1.0v 369.745n 1.0v 369.755n 1.0v 374.745n 1.0v 374.755n 1.0v 379.745n 1.0v 379.755n 1.0v 384.745n 1.0v 384.755n 1.0v 389.745n 1.0v 389.755n 1.0v 394.745n 1.0v 394.755n 1.0v 399.745n 1.0v 399.755n 1.0v 404.745n 1.0v 404.755n 1.0v 409.745n 1.0v 409.755n 1.0v 414.745n 1.0v 414.755n 1.0v 419.745n 1.0v 419.755n 1.0v 424.745n 1.0v 424.755n 1.0v 429.745n 1.0v 429.755n 1.0v 434.745n 1.0v 434.755n 0.0v 439.745n 0.0v 439.755n 0.0v 444.745n 0.0v 444.755n 0.0v 449.745n 0.0v 449.755n 0.0v 454.745n 0.0v 454.755n 0.0v 459.745n 0.0v 459.755n 0.0v 464.745n 0.0v 464.755n 0.0v 469.745n 0.0v 469.755n 0.0v 474.745n 0.0v 474.755n 0.0v 479.745n 0.0v 479.755n 0.0v 484.745n 0.0v 484.755n 0.0v 489.745n 0.0v 489.755n 1.0v 494.745n 1.0v 494.755n 1.0v 499.745n 1.0v 499.755n 0.0v 504.745n 0.0v 504.755n 0.0v 509.745n 0.0v 509.755n 0.0v 514.745n 0.0v 514.755n 0.0v 519.745n 0.0v 519.755n 0.0v 524.745n 0.0v 524.755n 0.0v 529.745n 0.0v 529.755n 0.0v 534.745n 0.0v 534.755n 1.0v 539.745n 1.0v 539.755n 1.0v 544.745n 1.0v 544.755n 0.0v 549.745n 0.0v 549.755n 1.0v 554.745n 1.0v 554.755n 1.0v 559.745n 1.0v 559.755n 0.0v 564.745n 0.0v 564.755n 0.0v 569.745n 0.0v 569.755n 0.0v 574.745n 0.0v 574.755n 0.0v 579.745n 0.0v 579.755n 0.0v 584.745n 0.0v 584.755n 0.0v 589.745n 0.0v 589.755n 0.0v 594.745n 0.0v 594.755n 0.0v 599.745n 0.0v 599.755n 0.0v 604.745n 0.0v 604.755n 0.0v 609.745n 0.0v 609.755n 1.0v 614.745n 1.0v 614.755n 1.0v 619.745n 1.0v 619.755n 0.0v 624.745n 0.0v 624.755n 0.0v 629.745n 0.0v 629.755n 0.0v 634.745n 0.0v 634.755n 1.0v 639.745n 1.0v 639.755n 1.0v 644.745n 1.0v 644.755n 0.0v 649.745n 0.0v 649.755n 1.0v 654.745n 1.0v 654.755n 1.0v 659.745n 1.0v 659.755n 1.0v 664.745n 1.0v 664.755n 1.0v 669.745n 1.0v 669.755n 1.0v 674.745n 1.0v 674.755n 1.0v 679.745n 1.0v 679.755n 1.0v 684.745n 1.0v 684.755n 1.0v 689.745n 1.0v 689.755n 1.0v 694.745n 1.0v 694.755n 1.0v 699.745n 1.0v 699.755n 1.0v 704.745n 1.0v 704.755n 1.0v 709.745n 1.0v 709.755n 1.0v 714.745n 1.0v 714.755n 1.0v 719.745n 1.0v 719.755n 1.0v 724.745n 1.0v 724.755n 1.0v 729.745n 1.0v 729.755n 1.0v 734.745n 1.0v 734.755n 1.0v 739.745n 1.0v 739.755n 1.0v 744.745n 1.0v 744.755n 1.0v 749.745n 1.0v 749.755n 1.0v 754.745n 1.0v 754.755n 1.0v 759.745n 1.0v 759.755n 1.0v 764.745n 1.0v 764.755n 1.0v 769.745n 1.0v 769.755n 1.0v 774.745n 1.0v 774.755n 1.0v 779.745n 1.0v 779.755n 1.0v 784.745n 1.0v 784.755n 1.0v 789.745n 1.0v 789.755n 1.0v 794.745n 1.0v 794.755n 1.0v 799.745n 1.0v 799.755n 1.0v 804.745n 1.0v 804.755n 1.0v 809.745n 1.0v 809.755n 0.0v 814.745n 0.0v 814.755n 0.0v 819.745n 0.0v 819.755n 0.0v 824.745n 0.0v 824.755n 0.0v 829.745n 0.0v 829.755n 0.0v 834.745n 0.0v 834.755n 0.0v 839.745n 0.0v 839.755n 0.0v 844.745n 0.0v 844.755n 0.0v 849.745n 0.0v 849.755n 0.0v 854.745n 0.0v 854.755n 0.0v 859.745n 0.0v 859.755n 0.0v 864.745n 0.0v 864.755n 1.0v 869.745n 1.0v 869.755n 0.0v 874.745n 0.0v 874.755n 0.0v 879.745n 0.0v 879.755n 0.0v 884.745n 0.0v 884.755n 0.0v 889.745n 0.0v 889.755n 0.0v 894.745n 0.0v 894.755n 0.0v 899.745n 0.0v 899.755n 0.0v 904.745n 0.0v 904.755n 0.0v 909.745n 0.0v 909.755n 0.0v 914.745n 0.0v 914.755n 0.0v 919.745n 0.0v 919.755n 0.0v 924.745n 0.0v 924.755n 0.0v 929.745n 0.0v 929.755n 0.0v 934.745n 0.0v 934.755n 0.0v 939.745n 0.0v 939.755n 0.0v 944.745n 0.0v 944.755n 0.0v 949.745n 0.0v 949.755n 0.0v 954.745n 0.0v 954.755n 0.0v 959.745n 0.0v 959.755n 0.0v 964.745n 0.0v 964.755n 1.0v 969.745n 1.0v 969.755n 1.0v 974.745n 1.0v 974.755n 1.0v 979.745n 1.0v 979.755n 1.0v 984.745n 1.0v 984.755n 1.0v 989.745n 1.0v 989.755n 1.0v 994.745n 1.0v 994.755n 1.0v 999.745n 1.0v 999.755n 1.0v 1004.745n 1.0v 1004.755n 1.0v 1009.745n 1.0v 1009.755n 1.0v 1014.745n 1.0v 1014.755n 1.0v 1019.745n 1.0v 1019.755n 1.0v 1024.745n 1.0v 1024.755n 1.0v )
* (time, data): [(0, 0), (5, 0), (10, 0), (15, 1), (20, 1), (25, 1), (30, 0), (35, 0), (40, 1), (45, 1), (50, 0), (55, 0), (60, 0), (65, 1), (70, 1), (75, 1), (80, 1), (85, 1), (90, 1), (95, 1), (100, 1), (105, 0), (110, 0), (115, 0), (120, 0), (125, 0), (130, 0), (135, 0), (140, 0), (145, 0), (150, 0), (155, 0), (160, 0), (165, 0), (170, 0), (175, 0), (180, 0), (185, 0), (190, 0), (195, 0), (200, 0), (205, 0), (210, 0), (215, 0), (220, 0), (225, 0), (230, 0), (235, 0), (240, 0), (245, 0), (250, 0), (255, 0), (260, 0), (265, 0), (270, 0), (275, 0), (280, 0), (285, 0), (290, 0), (295, 0), (300, 0), (305, 0), (310, 0), (315, 0), (320, 0), (325, 0), (330, 0), (335, 0), (340, 0), (345, 0), (350, 1), (355, 1), (360, 1), (365, 1), (370, 1), (375, 1), (380, 1), (385, 1), (390, 1), (395, 1), (400, 1), (405, 1), (410, 1), (415, 1), (420, 1), (425, 1), (430, 1), (435, 0), (440, 0), (445, 0), (450, 0), (455, 0), (460, 0), (465, 0), (470, 0), (475, 0), (480, 0), (485, 0), (490, 1), (495, 1), (500, 0), (505, 0), (510, 0), (515, 0), (520, 0), (525, 0), (530, 0), (535, 1), (540, 1), (545, 1), (550, 0), (555, 0), (560, 0), (565, 0), (570, 0), (575, 0), (580, 0), (585, 0), (590, 0), (595, 0), (600, 1), (605, 1), (610, 1), (615, 1), (620, 1), (625, 1), (630, 1), (635, 0), (640, 0), (645, 1), (650, 1), (655, 0), (660, 0), (665, 0), (670, 0), (675, 0), (680, 0), (685, 0), (690, 0), (695, 0), (700, 0), (705, 0), (710, 0), (715, 0), (720, 1), (725, 1), (730, 1), (735, 1), (740, 0), (745, 0), (750, 0), (755, 0), (760, 0), (765, 0), (770, 0), (775, 0), (780, 1), (785, 1), (790, 1), (795, 1), (800, 1), (805, 0), (810, 0), (815, 0), (820, 0), (825, 0), (830, 0), (835, 0), (840, 0), (845, 0), (850, 1), (855, 0), (860, 0), (865, 0), (870, 0), (875, 0), (880, 0), (885, 0), (890, 0), (895, 0), (900, 0), (905, 0), (910, 1), (915, 0), (920, 0), (925, 0), (930, 1), (935, 1), (940, 1), (945, 1), (950, 1), (955, 1), (960, 1), (965, 1), (970, 1), (975, 1), (980, 1), (985, 1), (990, 1), (995, 1), (1000, 1), (1005, 1), (1010, 1), (1015, 1), (1020, 0), (1025, 0)]
Vdin0_10  din0_10  0 PWL (0n 0.0v 4.745n 0.0v 4.755n 0.0v 9.745n 0.0v 9.755n 0.0v 14.745n 0.0v 14.755n 1.0v 19.745n 1.0v 19.755n 1.0v 24.745n 1.0v 24.755n 1.0v 29.745n 1.0v 29.755n 0.0v 34.745n 0.0v 34.755n 0.0v 39.745n 0.0v 39.755n 1.0v 44.745n 1.0v 44.755n 1.0v 49.745n 1.0v 49.755n 0.0v 54.745n 0.0v 54.755n 0.0v 59.745n 0.0v 59.755n 0.0v 64.745n 0.0v 64.755n 1.0v 69.745n 1.0v 69.755n 1.0v 74.745n 1.0v 74.755n 1.0v 79.745n 1.0v 79.755n 1.0v 84.745n 1.0v 84.755n 1.0v 89.745n 1.0v 89.755n 1.0v 94.745n 1.0v 94.755n 1.0v 99.745n 1.0v 99.755n 1.0v 104.745n 1.0v 104.755n 0.0v 109.745n 0.0v 109.755n 0.0v 114.745n 0.0v 114.755n 0.0v 119.745n 0.0v 119.755n 0.0v 124.745n 0.0v 124.755n 0.0v 129.745n 0.0v 129.755n 0.0v 134.745n 0.0v 134.755n 0.0v 139.745n 0.0v 139.755n 0.0v 144.745n 0.0v 144.755n 0.0v 149.745n 0.0v 149.755n 0.0v 154.745n 0.0v 154.755n 0.0v 159.745n 0.0v 159.755n 0.0v 164.745n 0.0v 164.755n 0.0v 169.745n 0.0v 169.755n 0.0v 174.745n 0.0v 174.755n 0.0v 179.745n 0.0v 179.755n 0.0v 184.745n 0.0v 184.755n 0.0v 189.745n 0.0v 189.755n 0.0v 194.745n 0.0v 194.755n 0.0v 199.745n 0.0v 199.755n 0.0v 204.745n 0.0v 204.755n 0.0v 209.745n 0.0v 209.755n 0.0v 214.745n 0.0v 214.755n 0.0v 219.745n 0.0v 219.755n 0.0v 224.745n 0.0v 224.755n 0.0v 229.745n 0.0v 229.755n 0.0v 234.745n 0.0v 234.755n 0.0v 239.745n 0.0v 239.755n 0.0v 244.745n 0.0v 244.755n 0.0v 249.745n 0.0v 249.755n 0.0v 254.745n 0.0v 254.755n 0.0v 259.745n 0.0v 259.755n 0.0v 264.745n 0.0v 264.755n 0.0v 269.745n 0.0v 269.755n 0.0v 274.745n 0.0v 274.755n 0.0v 279.745n 0.0v 279.755n 0.0v 284.745n 0.0v 284.755n 0.0v 289.745n 0.0v 289.755n 0.0v 294.745n 0.0v 294.755n 0.0v 299.745n 0.0v 299.755n 0.0v 304.745n 0.0v 304.755n 0.0v 309.745n 0.0v 309.755n 0.0v 314.745n 0.0v 314.755n 0.0v 319.745n 0.0v 319.755n 0.0v 324.745n 0.0v 324.755n 0.0v 329.745n 0.0v 329.755n 0.0v 334.745n 0.0v 334.755n 0.0v 339.745n 0.0v 339.755n 0.0v 344.745n 0.0v 344.755n 0.0v 349.745n 0.0v 349.755n 1.0v 354.745n 1.0v 354.755n 1.0v 359.745n 1.0v 359.755n 1.0v 364.745n 1.0v 364.755n 1.0v 369.745n 1.0v 369.755n 1.0v 374.745n 1.0v 374.755n 1.0v 379.745n 1.0v 379.755n 1.0v 384.745n 1.0v 384.755n 1.0v 389.745n 1.0v 389.755n 1.0v 394.745n 1.0v 394.755n 1.0v 399.745n 1.0v 399.755n 1.0v 404.745n 1.0v 404.755n 1.0v 409.745n 1.0v 409.755n 1.0v 414.745n 1.0v 414.755n 1.0v 419.745n 1.0v 419.755n 1.0v 424.745n 1.0v 424.755n 1.0v 429.745n 1.0v 429.755n 1.0v 434.745n 1.0v 434.755n 0.0v 439.745n 0.0v 439.755n 0.0v 444.745n 0.0v 444.755n 0.0v 449.745n 0.0v 449.755n 0.0v 454.745n 0.0v 454.755n 0.0v 459.745n 0.0v 459.755n 0.0v 464.745n 0.0v 464.755n 0.0v 469.745n 0.0v 469.755n 0.0v 474.745n 0.0v 474.755n 0.0v 479.745n 0.0v 479.755n 0.0v 484.745n 0.0v 484.755n 0.0v 489.745n 0.0v 489.755n 1.0v 494.745n 1.0v 494.755n 1.0v 499.745n 1.0v 499.755n 0.0v 504.745n 0.0v 504.755n 0.0v 509.745n 0.0v 509.755n 0.0v 514.745n 0.0v 514.755n 0.0v 519.745n 0.0v 519.755n 0.0v 524.745n 0.0v 524.755n 0.0v 529.745n 0.0v 529.755n 0.0v 534.745n 0.0v 534.755n 1.0v 539.745n 1.0v 539.755n 1.0v 544.745n 1.0v 544.755n 1.0v 549.745n 1.0v 549.755n 0.0v 554.745n 0.0v 554.755n 0.0v 559.745n 0.0v 559.755n 0.0v 564.745n 0.0v 564.755n 0.0v 569.745n 0.0v 569.755n 0.0v 574.745n 0.0v 574.755n 0.0v 579.745n 0.0v 579.755n 0.0v 584.745n 0.0v 584.755n 0.0v 589.745n 0.0v 589.755n 0.0v 594.745n 0.0v 594.755n 0.0v 599.745n 0.0v 599.755n 1.0v 604.745n 1.0v 604.755n 1.0v 609.745n 1.0v 609.755n 1.0v 614.745n 1.0v 614.755n 1.0v 619.745n 1.0v 619.755n 1.0v 624.745n 1.0v 624.755n 1.0v 629.745n 1.0v 629.755n 1.0v 634.745n 1.0v 634.755n 0.0v 639.745n 0.0v 639.755n 0.0v 644.745n 0.0v 644.755n 1.0v 649.745n 1.0v 649.755n 1.0v 654.745n 1.0v 654.755n 0.0v 659.745n 0.0v 659.755n 0.0v 664.745n 0.0v 664.755n 0.0v 669.745n 0.0v 669.755n 0.0v 674.745n 0.0v 674.755n 0.0v 679.745n 0.0v 679.755n 0.0v 684.745n 0.0v 684.755n 0.0v 689.745n 0.0v 689.755n 0.0v 694.745n 0.0v 694.755n 0.0v 699.745n 0.0v 699.755n 0.0v 704.745n 0.0v 704.755n 0.0v 709.745n 0.0v 709.755n 0.0v 714.745n 0.0v 714.755n 0.0v 719.745n 0.0v 719.755n 1.0v 724.745n 1.0v 724.755n 1.0v 729.745n 1.0v 729.755n 1.0v 734.745n 1.0v 734.755n 1.0v 739.745n 1.0v 739.755n 0.0v 744.745n 0.0v 744.755n 0.0v 749.745n 0.0v 749.755n 0.0v 754.745n 0.0v 754.755n 0.0v 759.745n 0.0v 759.755n 0.0v 764.745n 0.0v 764.755n 0.0v 769.745n 0.0v 769.755n 0.0v 774.745n 0.0v 774.755n 0.0v 779.745n 0.0v 779.755n 1.0v 784.745n 1.0v 784.755n 1.0v 789.745n 1.0v 789.755n 1.0v 794.745n 1.0v 794.755n 1.0v 799.745n 1.0v 799.755n 1.0v 804.745n 1.0v 804.755n 0.0v 809.745n 0.0v 809.755n 0.0v 814.745n 0.0v 814.755n 0.0v 819.745n 0.0v 819.755n 0.0v 824.745n 0.0v 824.755n 0.0v 829.745n 0.0v 829.755n 0.0v 834.745n 0.0v 834.755n 0.0v 839.745n 0.0v 839.755n 0.0v 844.745n 0.0v 844.755n 0.0v 849.745n 0.0v 849.755n 1.0v 854.745n 1.0v 854.755n 0.0v 859.745n 0.0v 859.755n 0.0v 864.745n 0.0v 864.755n 0.0v 869.745n 0.0v 869.755n 0.0v 874.745n 0.0v 874.755n 0.0v 879.745n 0.0v 879.755n 0.0v 884.745n 0.0v 884.755n 0.0v 889.745n 0.0v 889.755n 0.0v 894.745n 0.0v 894.755n 0.0v 899.745n 0.0v 899.755n 0.0v 904.745n 0.0v 904.755n 0.0v 909.745n 0.0v 909.755n 1.0v 914.745n 1.0v 914.755n 0.0v 919.745n 0.0v 919.755n 0.0v 924.745n 0.0v 924.755n 0.0v 929.745n 0.0v 929.755n 1.0v 934.745n 1.0v 934.755n 1.0v 939.745n 1.0v 939.755n 1.0v 944.745n 1.0v 944.755n 1.0v 949.745n 1.0v 949.755n 1.0v 954.745n 1.0v 954.755n 1.0v 959.745n 1.0v 959.755n 1.0v 964.745n 1.0v 964.755n 1.0v 969.745n 1.0v 969.755n 1.0v 974.745n 1.0v 974.755n 1.0v 979.745n 1.0v 979.755n 1.0v 984.745n 1.0v 984.755n 1.0v 989.745n 1.0v 989.755n 1.0v 994.745n 1.0v 994.755n 1.0v 999.745n 1.0v 999.755n 1.0v 1004.745n 1.0v 1004.755n 1.0v 1009.745n 1.0v 1009.755n 1.0v 1014.745n 1.0v 1014.755n 1.0v 1019.745n 1.0v 1019.755n 0.0v 1024.745n 0.0v 1024.755n 0.0v )
* (time, data): [(0, 0), (5, 1), (10, 0), (15, 1), (20, 1), (25, 1), (30, 0), (35, 0), (40, 1), (45, 1), (50, 1), (55, 1), (60, 1), (65, 1), (70, 1), (75, 1), (80, 1), (85, 1), (90, 1), (95, 1), (100, 1), (105, 1), (110, 1), (115, 1), (120, 1), (125, 1), (130, 1), (135, 1), (140, 1), (145, 1), (150, 1), (155, 1), (160, 1), (165, 1), (170, 1), (175, 0), (180, 0), (185, 0), (190, 1), (195, 1), (200, 1), (205, 1), (210, 1), (215, 1), (220, 1), (225, 1), (230, 1), (235, 1), (240, 1), (245, 1), (250, 1), (255, 1), (260, 1), (265, 1), (270, 1), (275, 1), (280, 1), (285, 1), (290, 0), (295, 0), (300, 0), (305, 0), (310, 0), (315, 0), (320, 0), (325, 0), (330, 0), (335, 1), (340, 1), (345, 1), (350, 0), (355, 0), (360, 0), (365, 0), (370, 0), (375, 0), (380, 0), (385, 0), (390, 0), (395, 0), (400, 0), (405, 0), (410, 0), (415, 0), (420, 0), (425, 0), (430, 0), (435, 0), (440, 0), (445, 1), (450, 1), (455, 1), (460, 1), (465, 1), (470, 1), (475, 1), (480, 1), (485, 1), (490, 1), (495, 1), (500, 1), (505, 1), (510, 1), (515, 0), (520, 0), (525, 0), (530, 0), (535, 0), (540, 0), (545, 1), (550, 1), (555, 1), (560, 0), (565, 0), (570, 0), (575, 0), (580, 0), (585, 0), (590, 0), (595, 0), (600, 1), (605, 1), (610, 0), (615, 0), (620, 1), (625, 1), (630, 1), (635, 1), (640, 1), (645, 0), (650, 0), (655, 1), (660, 1), (665, 1), (670, 1), (675, 1), (680, 1), (685, 1), (690, 1), (695, 1), (700, 1), (705, 1), (710, 1), (715, 1), (720, 1), (725, 1), (730, 1), (735, 1), (740, 1), (745, 1), (750, 1), (755, 1), (760, 1), (765, 1), (770, 1), (775, 1), (780, 0), (785, 0), (790, 0), (795, 0), (800, 0), (805, 0), (810, 0), (815, 0), (820, 0), (825, 0), (830, 0), (835, 0), (840, 0), (845, 0), (850, 0), (855, 0), (860, 0), (865, 1), (870, 0), (875, 0), (880, 0), (885, 0), (890, 0), (895, 0), (900, 0), (905, 0), (910, 1), (915, 0), (920, 0), (925, 0), (930, 1), (935, 1), (940, 1), (945, 1), (950, 1), (955, 1), (960, 1), (965, 0), (970, 0), (975, 0), (980, 0), (985, 0), (990, 0), (995, 0), (1000, 0), (1005, 0), (1010, 0), (1015, 0), (1020, 0), (1025, 0)]
Vdin0_11  din0_11  0 PWL (0n 0.0v 4.745n 0.0v 4.755n 1.0v 9.745n 1.0v 9.755n 0.0v 14.745n 0.0v 14.755n 1.0v 19.745n 1.0v 19.755n 1.0v 24.745n 1.0v 24.755n 1.0v 29.745n 1.0v 29.755n 0.0v 34.745n 0.0v 34.755n 0.0v 39.745n 0.0v 39.755n 1.0v 44.745n 1.0v 44.755n 1.0v 49.745n 1.0v 49.755n 1.0v 54.745n 1.0v 54.755n 1.0v 59.745n 1.0v 59.755n 1.0v 64.745n 1.0v 64.755n 1.0v 69.745n 1.0v 69.755n 1.0v 74.745n 1.0v 74.755n 1.0v 79.745n 1.0v 79.755n 1.0v 84.745n 1.0v 84.755n 1.0v 89.745n 1.0v 89.755n 1.0v 94.745n 1.0v 94.755n 1.0v 99.745n 1.0v 99.755n 1.0v 104.745n 1.0v 104.755n 1.0v 109.745n 1.0v 109.755n 1.0v 114.745n 1.0v 114.755n 1.0v 119.745n 1.0v 119.755n 1.0v 124.745n 1.0v 124.755n 1.0v 129.745n 1.0v 129.755n 1.0v 134.745n 1.0v 134.755n 1.0v 139.745n 1.0v 139.755n 1.0v 144.745n 1.0v 144.755n 1.0v 149.745n 1.0v 149.755n 1.0v 154.745n 1.0v 154.755n 1.0v 159.745n 1.0v 159.755n 1.0v 164.745n 1.0v 164.755n 1.0v 169.745n 1.0v 169.755n 1.0v 174.745n 1.0v 174.755n 0.0v 179.745n 0.0v 179.755n 0.0v 184.745n 0.0v 184.755n 0.0v 189.745n 0.0v 189.755n 1.0v 194.745n 1.0v 194.755n 1.0v 199.745n 1.0v 199.755n 1.0v 204.745n 1.0v 204.755n 1.0v 209.745n 1.0v 209.755n 1.0v 214.745n 1.0v 214.755n 1.0v 219.745n 1.0v 219.755n 1.0v 224.745n 1.0v 224.755n 1.0v 229.745n 1.0v 229.755n 1.0v 234.745n 1.0v 234.755n 1.0v 239.745n 1.0v 239.755n 1.0v 244.745n 1.0v 244.755n 1.0v 249.745n 1.0v 249.755n 1.0v 254.745n 1.0v 254.755n 1.0v 259.745n 1.0v 259.755n 1.0v 264.745n 1.0v 264.755n 1.0v 269.745n 1.0v 269.755n 1.0v 274.745n 1.0v 274.755n 1.0v 279.745n 1.0v 279.755n 1.0v 284.745n 1.0v 284.755n 1.0v 289.745n 1.0v 289.755n 0.0v 294.745n 0.0v 294.755n 0.0v 299.745n 0.0v 299.755n 0.0v 304.745n 0.0v 304.755n 0.0v 309.745n 0.0v 309.755n 0.0v 314.745n 0.0v 314.755n 0.0v 319.745n 0.0v 319.755n 0.0v 324.745n 0.0v 324.755n 0.0v 329.745n 0.0v 329.755n 0.0v 334.745n 0.0v 334.755n 1.0v 339.745n 1.0v 339.755n 1.0v 344.745n 1.0v 344.755n 1.0v 349.745n 1.0v 349.755n 0.0v 354.745n 0.0v 354.755n 0.0v 359.745n 0.0v 359.755n 0.0v 364.745n 0.0v 364.755n 0.0v 369.745n 0.0v 369.755n 0.0v 374.745n 0.0v 374.755n 0.0v 379.745n 0.0v 379.755n 0.0v 384.745n 0.0v 384.755n 0.0v 389.745n 0.0v 389.755n 0.0v 394.745n 0.0v 394.755n 0.0v 399.745n 0.0v 399.755n 0.0v 404.745n 0.0v 404.755n 0.0v 409.745n 0.0v 409.755n 0.0v 414.745n 0.0v 414.755n 0.0v 419.745n 0.0v 419.755n 0.0v 424.745n 0.0v 424.755n 0.0v 429.745n 0.0v 429.755n 0.0v 434.745n 0.0v 434.755n 0.0v 439.745n 0.0v 439.755n 0.0v 444.745n 0.0v 444.755n 1.0v 449.745n 1.0v 449.755n 1.0v 454.745n 1.0v 454.755n 1.0v 459.745n 1.0v 459.755n 1.0v 464.745n 1.0v 464.755n 1.0v 469.745n 1.0v 469.755n 1.0v 474.745n 1.0v 474.755n 1.0v 479.745n 1.0v 479.755n 1.0v 484.745n 1.0v 484.755n 1.0v 489.745n 1.0v 489.755n 1.0v 494.745n 1.0v 494.755n 1.0v 499.745n 1.0v 499.755n 1.0v 504.745n 1.0v 504.755n 1.0v 509.745n 1.0v 509.755n 1.0v 514.745n 1.0v 514.755n 0.0v 519.745n 0.0v 519.755n 0.0v 524.745n 0.0v 524.755n 0.0v 529.745n 0.0v 529.755n 0.0v 534.745n 0.0v 534.755n 0.0v 539.745n 0.0v 539.755n 0.0v 544.745n 0.0v 544.755n 1.0v 549.745n 1.0v 549.755n 1.0v 554.745n 1.0v 554.755n 1.0v 559.745n 1.0v 559.755n 0.0v 564.745n 0.0v 564.755n 0.0v 569.745n 0.0v 569.755n 0.0v 574.745n 0.0v 574.755n 0.0v 579.745n 0.0v 579.755n 0.0v 584.745n 0.0v 584.755n 0.0v 589.745n 0.0v 589.755n 0.0v 594.745n 0.0v 594.755n 0.0v 599.745n 0.0v 599.755n 1.0v 604.745n 1.0v 604.755n 1.0v 609.745n 1.0v 609.755n 0.0v 614.745n 0.0v 614.755n 0.0v 619.745n 0.0v 619.755n 1.0v 624.745n 1.0v 624.755n 1.0v 629.745n 1.0v 629.755n 1.0v 634.745n 1.0v 634.755n 1.0v 639.745n 1.0v 639.755n 1.0v 644.745n 1.0v 644.755n 0.0v 649.745n 0.0v 649.755n 0.0v 654.745n 0.0v 654.755n 1.0v 659.745n 1.0v 659.755n 1.0v 664.745n 1.0v 664.755n 1.0v 669.745n 1.0v 669.755n 1.0v 674.745n 1.0v 674.755n 1.0v 679.745n 1.0v 679.755n 1.0v 684.745n 1.0v 684.755n 1.0v 689.745n 1.0v 689.755n 1.0v 694.745n 1.0v 694.755n 1.0v 699.745n 1.0v 699.755n 1.0v 704.745n 1.0v 704.755n 1.0v 709.745n 1.0v 709.755n 1.0v 714.745n 1.0v 714.755n 1.0v 719.745n 1.0v 719.755n 1.0v 724.745n 1.0v 724.755n 1.0v 729.745n 1.0v 729.755n 1.0v 734.745n 1.0v 734.755n 1.0v 739.745n 1.0v 739.755n 1.0v 744.745n 1.0v 744.755n 1.0v 749.745n 1.0v 749.755n 1.0v 754.745n 1.0v 754.755n 1.0v 759.745n 1.0v 759.755n 1.0v 764.745n 1.0v 764.755n 1.0v 769.745n 1.0v 769.755n 1.0v 774.745n 1.0v 774.755n 1.0v 779.745n 1.0v 779.755n 0.0v 784.745n 0.0v 784.755n 0.0v 789.745n 0.0v 789.755n 0.0v 794.745n 0.0v 794.755n 0.0v 799.745n 0.0v 799.755n 0.0v 804.745n 0.0v 804.755n 0.0v 809.745n 0.0v 809.755n 0.0v 814.745n 0.0v 814.755n 0.0v 819.745n 0.0v 819.755n 0.0v 824.745n 0.0v 824.755n 0.0v 829.745n 0.0v 829.755n 0.0v 834.745n 0.0v 834.755n 0.0v 839.745n 0.0v 839.755n 0.0v 844.745n 0.0v 844.755n 0.0v 849.745n 0.0v 849.755n 0.0v 854.745n 0.0v 854.755n 0.0v 859.745n 0.0v 859.755n 0.0v 864.745n 0.0v 864.755n 1.0v 869.745n 1.0v 869.755n 0.0v 874.745n 0.0v 874.755n 0.0v 879.745n 0.0v 879.755n 0.0v 884.745n 0.0v 884.755n 0.0v 889.745n 0.0v 889.755n 0.0v 894.745n 0.0v 894.755n 0.0v 899.745n 0.0v 899.755n 0.0v 904.745n 0.0v 904.755n 0.0v 909.745n 0.0v 909.755n 1.0v 914.745n 1.0v 914.755n 0.0v 919.745n 0.0v 919.755n 0.0v 924.745n 0.0v 924.755n 0.0v 929.745n 0.0v 929.755n 1.0v 934.745n 1.0v 934.755n 1.0v 939.745n 1.0v 939.755n 1.0v 944.745n 1.0v 944.755n 1.0v 949.745n 1.0v 949.755n 1.0v 954.745n 1.0v 954.755n 1.0v 959.745n 1.0v 959.755n 1.0v 964.745n 1.0v 964.755n 0.0v 969.745n 0.0v 969.755n 0.0v 974.745n 0.0v 974.755n 0.0v 979.745n 0.0v 979.755n 0.0v 984.745n 0.0v 984.755n 0.0v 989.745n 0.0v 989.755n 0.0v 994.745n 0.0v 994.755n 0.0v 999.745n 0.0v 999.755n 0.0v 1004.745n 0.0v 1004.755n 0.0v 1009.745n 0.0v 1009.755n 0.0v 1014.745n 0.0v 1014.755n 0.0v 1019.745n 0.0v 1019.755n 0.0v 1024.745n 0.0v 1024.755n 0.0v )
* (time, data): [(0, 0), (5, 1), (10, 1), (15, 1), (20, 1), (25, 1), (30, 1), (35, 1), (40, 1), (45, 1), (50, 1), (55, 1), (60, 1), (65, 1), (70, 1), (75, 1), (80, 1), (85, 0), (90, 0), (95, 0), (100, 0), (105, 1), (110, 1), (115, 1), (120, 1), (125, 1), (130, 1), (135, 1), (140, 1), (145, 1), (150, 1), (155, 0), (160, 0), (165, 0), (170, 0), (175, 1), (180, 1), (185, 1), (190, 0), (195, 0), (200, 0), (205, 0), (210, 0), (215, 0), (220, 0), (225, 0), (230, 0), (235, 0), (240, 0), (245, 0), (250, 0), (255, 0), (260, 0), (265, 0), (270, 0), (275, 0), (280, 0), (285, 0), (290, 0), (295, 0), (300, 0), (305, 0), (310, 0), (315, 0), (320, 0), (325, 0), (330, 0), (335, 0), (340, 0), (345, 0), (350, 1), (355, 1), (360, 1), (365, 1), (370, 1), (375, 1), (380, 1), (385, 1), (390, 1), (395, 1), (400, 1), (405, 1), (410, 1), (415, 1), (420, 1), (425, 1), (430, 1), (435, 0), (440, 0), (445, 0), (450, 0), (455, 0), (460, 0), (465, 0), (470, 0), (475, 0), (480, 0), (485, 0), (490, 1), (495, 1), (500, 1), (505, 1), (510, 1), (515, 1), (520, 1), (525, 1), (530, 1), (535, 1), (540, 0), (545, 0), (550, 0), (555, 0), (560, 0), (565, 0), (570, 0), (575, 0), (580, 0), (585, 0), (590, 0), (595, 0), (600, 0), (605, 0), (610, 1), (615, 1), (620, 0), (625, 0), (630, 0), (635, 0), (640, 0), (645, 1), (650, 0), (655, 1), (660, 1), (665, 1), (670, 1), (675, 1), (680, 1), (685, 1), (690, 1), (695, 1), (700, 1), (705, 1), (710, 1), (715, 1), (720, 1), (725, 1), (730, 1), (735, 1), (740, 1), (745, 1), (750, 1), (755, 1), (760, 1), (765, 1), (770, 0), (775, 0), (780, 1), (785, 1), (790, 1), (795, 1), (800, 1), (805, 1), (810, 1), (815, 1), (820, 1), (825, 1), (830, 1), (835, 1), (840, 1), (845, 1), (850, 1), (855, 1), (860, 1), (865, 0), (870, 0), (875, 0), (880, 0), (885, 0), (890, 0), (895, 0), (900, 0), (905, 0), (910, 0), (915, 1), (920, 1), (925, 1), (930, 1), (935, 1), (940, 1), (945, 1), (950, 1), (955, 1), (960, 1), (965, 1), (970, 1), (975, 1), (980, 1), (985, 1), (990, 1), (995, 1), (1000, 1), (1005, 1), (1010, 1), (1015, 1), (1020, 0), (1025, 0)]
Vdin0_12  din0_12  0 PWL (0n 0.0v 4.745n 0.0v 4.755n 1.0v 9.745n 1.0v 9.755n 1.0v 14.745n 1.0v 14.755n 1.0v 19.745n 1.0v 19.755n 1.0v 24.745n 1.0v 24.755n 1.0v 29.745n 1.0v 29.755n 1.0v 34.745n 1.0v 34.755n 1.0v 39.745n 1.0v 39.755n 1.0v 44.745n 1.0v 44.755n 1.0v 49.745n 1.0v 49.755n 1.0v 54.745n 1.0v 54.755n 1.0v 59.745n 1.0v 59.755n 1.0v 64.745n 1.0v 64.755n 1.0v 69.745n 1.0v 69.755n 1.0v 74.745n 1.0v 74.755n 1.0v 79.745n 1.0v 79.755n 1.0v 84.745n 1.0v 84.755n 0.0v 89.745n 0.0v 89.755n 0.0v 94.745n 0.0v 94.755n 0.0v 99.745n 0.0v 99.755n 0.0v 104.745n 0.0v 104.755n 1.0v 109.745n 1.0v 109.755n 1.0v 114.745n 1.0v 114.755n 1.0v 119.745n 1.0v 119.755n 1.0v 124.745n 1.0v 124.755n 1.0v 129.745n 1.0v 129.755n 1.0v 134.745n 1.0v 134.755n 1.0v 139.745n 1.0v 139.755n 1.0v 144.745n 1.0v 144.755n 1.0v 149.745n 1.0v 149.755n 1.0v 154.745n 1.0v 154.755n 0.0v 159.745n 0.0v 159.755n 0.0v 164.745n 0.0v 164.755n 0.0v 169.745n 0.0v 169.755n 0.0v 174.745n 0.0v 174.755n 1.0v 179.745n 1.0v 179.755n 1.0v 184.745n 1.0v 184.755n 1.0v 189.745n 1.0v 189.755n 0.0v 194.745n 0.0v 194.755n 0.0v 199.745n 0.0v 199.755n 0.0v 204.745n 0.0v 204.755n 0.0v 209.745n 0.0v 209.755n 0.0v 214.745n 0.0v 214.755n 0.0v 219.745n 0.0v 219.755n 0.0v 224.745n 0.0v 224.755n 0.0v 229.745n 0.0v 229.755n 0.0v 234.745n 0.0v 234.755n 0.0v 239.745n 0.0v 239.755n 0.0v 244.745n 0.0v 244.755n 0.0v 249.745n 0.0v 249.755n 0.0v 254.745n 0.0v 254.755n 0.0v 259.745n 0.0v 259.755n 0.0v 264.745n 0.0v 264.755n 0.0v 269.745n 0.0v 269.755n 0.0v 274.745n 0.0v 274.755n 0.0v 279.745n 0.0v 279.755n 0.0v 284.745n 0.0v 284.755n 0.0v 289.745n 0.0v 289.755n 0.0v 294.745n 0.0v 294.755n 0.0v 299.745n 0.0v 299.755n 0.0v 304.745n 0.0v 304.755n 0.0v 309.745n 0.0v 309.755n 0.0v 314.745n 0.0v 314.755n 0.0v 319.745n 0.0v 319.755n 0.0v 324.745n 0.0v 324.755n 0.0v 329.745n 0.0v 329.755n 0.0v 334.745n 0.0v 334.755n 0.0v 339.745n 0.0v 339.755n 0.0v 344.745n 0.0v 344.755n 0.0v 349.745n 0.0v 349.755n 1.0v 354.745n 1.0v 354.755n 1.0v 359.745n 1.0v 359.755n 1.0v 364.745n 1.0v 364.755n 1.0v 369.745n 1.0v 369.755n 1.0v 374.745n 1.0v 374.755n 1.0v 379.745n 1.0v 379.755n 1.0v 384.745n 1.0v 384.755n 1.0v 389.745n 1.0v 389.755n 1.0v 394.745n 1.0v 394.755n 1.0v 399.745n 1.0v 399.755n 1.0v 404.745n 1.0v 404.755n 1.0v 409.745n 1.0v 409.755n 1.0v 414.745n 1.0v 414.755n 1.0v 419.745n 1.0v 419.755n 1.0v 424.745n 1.0v 424.755n 1.0v 429.745n 1.0v 429.755n 1.0v 434.745n 1.0v 434.755n 0.0v 439.745n 0.0v 439.755n 0.0v 444.745n 0.0v 444.755n 0.0v 449.745n 0.0v 449.755n 0.0v 454.745n 0.0v 454.755n 0.0v 459.745n 0.0v 459.755n 0.0v 464.745n 0.0v 464.755n 0.0v 469.745n 0.0v 469.755n 0.0v 474.745n 0.0v 474.755n 0.0v 479.745n 0.0v 479.755n 0.0v 484.745n 0.0v 484.755n 0.0v 489.745n 0.0v 489.755n 1.0v 494.745n 1.0v 494.755n 1.0v 499.745n 1.0v 499.755n 1.0v 504.745n 1.0v 504.755n 1.0v 509.745n 1.0v 509.755n 1.0v 514.745n 1.0v 514.755n 1.0v 519.745n 1.0v 519.755n 1.0v 524.745n 1.0v 524.755n 1.0v 529.745n 1.0v 529.755n 1.0v 534.745n 1.0v 534.755n 1.0v 539.745n 1.0v 539.755n 0.0v 544.745n 0.0v 544.755n 0.0v 549.745n 0.0v 549.755n 0.0v 554.745n 0.0v 554.755n 0.0v 559.745n 0.0v 559.755n 0.0v 564.745n 0.0v 564.755n 0.0v 569.745n 0.0v 569.755n 0.0v 574.745n 0.0v 574.755n 0.0v 579.745n 0.0v 579.755n 0.0v 584.745n 0.0v 584.755n 0.0v 589.745n 0.0v 589.755n 0.0v 594.745n 0.0v 594.755n 0.0v 599.745n 0.0v 599.755n 0.0v 604.745n 0.0v 604.755n 0.0v 609.745n 0.0v 609.755n 1.0v 614.745n 1.0v 614.755n 1.0v 619.745n 1.0v 619.755n 0.0v 624.745n 0.0v 624.755n 0.0v 629.745n 0.0v 629.755n 0.0v 634.745n 0.0v 634.755n 0.0v 639.745n 0.0v 639.755n 0.0v 644.745n 0.0v 644.755n 1.0v 649.745n 1.0v 649.755n 0.0v 654.745n 0.0v 654.755n 1.0v 659.745n 1.0v 659.755n 1.0v 664.745n 1.0v 664.755n 1.0v 669.745n 1.0v 669.755n 1.0v 674.745n 1.0v 674.755n 1.0v 679.745n 1.0v 679.755n 1.0v 684.745n 1.0v 684.755n 1.0v 689.745n 1.0v 689.755n 1.0v 694.745n 1.0v 694.755n 1.0v 699.745n 1.0v 699.755n 1.0v 704.745n 1.0v 704.755n 1.0v 709.745n 1.0v 709.755n 1.0v 714.745n 1.0v 714.755n 1.0v 719.745n 1.0v 719.755n 1.0v 724.745n 1.0v 724.755n 1.0v 729.745n 1.0v 729.755n 1.0v 734.745n 1.0v 734.755n 1.0v 739.745n 1.0v 739.755n 1.0v 744.745n 1.0v 744.755n 1.0v 749.745n 1.0v 749.755n 1.0v 754.745n 1.0v 754.755n 1.0v 759.745n 1.0v 759.755n 1.0v 764.745n 1.0v 764.755n 1.0v 769.745n 1.0v 769.755n 0.0v 774.745n 0.0v 774.755n 0.0v 779.745n 0.0v 779.755n 1.0v 784.745n 1.0v 784.755n 1.0v 789.745n 1.0v 789.755n 1.0v 794.745n 1.0v 794.755n 1.0v 799.745n 1.0v 799.755n 1.0v 804.745n 1.0v 804.755n 1.0v 809.745n 1.0v 809.755n 1.0v 814.745n 1.0v 814.755n 1.0v 819.745n 1.0v 819.755n 1.0v 824.745n 1.0v 824.755n 1.0v 829.745n 1.0v 829.755n 1.0v 834.745n 1.0v 834.755n 1.0v 839.745n 1.0v 839.755n 1.0v 844.745n 1.0v 844.755n 1.0v 849.745n 1.0v 849.755n 1.0v 854.745n 1.0v 854.755n 1.0v 859.745n 1.0v 859.755n 1.0v 864.745n 1.0v 864.755n 0.0v 869.745n 0.0v 869.755n 0.0v 874.745n 0.0v 874.755n 0.0v 879.745n 0.0v 879.755n 0.0v 884.745n 0.0v 884.755n 0.0v 889.745n 0.0v 889.755n 0.0v 894.745n 0.0v 894.755n 0.0v 899.745n 0.0v 899.755n 0.0v 904.745n 0.0v 904.755n 0.0v 909.745n 0.0v 909.755n 0.0v 914.745n 0.0v 914.755n 1.0v 919.745n 1.0v 919.755n 1.0v 924.745n 1.0v 924.755n 1.0v 929.745n 1.0v 929.755n 1.0v 934.745n 1.0v 934.755n 1.0v 939.745n 1.0v 939.755n 1.0v 944.745n 1.0v 944.755n 1.0v 949.745n 1.0v 949.755n 1.0v 954.745n 1.0v 954.755n 1.0v 959.745n 1.0v 959.755n 1.0v 964.745n 1.0v 964.755n 1.0v 969.745n 1.0v 969.755n 1.0v 974.745n 1.0v 974.755n 1.0v 979.745n 1.0v 979.755n 1.0v 984.745n 1.0v 984.755n 1.0v 989.745n 1.0v 989.755n 1.0v 994.745n 1.0v 994.755n 1.0v 999.745n 1.0v 999.755n 1.0v 1004.745n 1.0v 1004.755n 1.0v 1009.745n 1.0v 1009.755n 1.0v 1014.745n 1.0v 1014.755n 1.0v 1019.745n 1.0v 1019.755n 0.0v 1024.745n 0.0v 1024.755n 0.0v )
* (time, data): [(0, 0), (5, 0), (10, 0), (15, 0), (20, 0), (25, 0), (30, 1), (35, 1), (40, 1), (45, 1), (50, 1), (55, 1), (60, 1), (65, 1), (70, 1), (75, 1), (80, 1), (85, 1), (90, 1), (95, 1), (100, 0), (105, 1), (110, 1), (115, 0), (120, 0), (125, 0), (130, 0), (135, 0), (140, 0), (145, 0), (150, 0), (155, 0), (160, 0), (165, 0), (170, 0), (175, 0), (180, 0), (185, 0), (190, 0), (195, 1), (200, 1), (205, 1), (210, 1), (215, 1), (220, 1), (225, 1), (230, 1), (235, 1), (240, 1), (245, 1), (250, 1), (255, 1), (260, 1), (265, 1), (270, 1), (275, 1), (280, 1), (285, 1), (290, 0), (295, 0), (300, 0), (305, 0), (310, 0), (315, 0), (320, 0), (325, 0), (330, 0), (335, 0), (340, 0), (345, 0), (350, 0), (355, 0), (360, 0), (365, 0), (370, 0), (375, 0), (380, 0), (385, 0), (390, 0), (395, 0), (400, 0), (405, 0), (410, 1), (415, 1), (420, 1), (425, 1), (430, 1), (435, 0), (440, 0), (445, 1), (450, 1), (455, 1), (460, 1), (465, 1), (470, 1), (475, 1), (480, 1), (485, 1), (490, 0), (495, 0), (500, 1), (505, 1), (510, 1), (515, 1), (520, 1), (525, 1), (530, 1), (535, 1), (540, 1), (545, 0), (550, 0), (555, 0), (560, 0), (565, 0), (570, 0), (575, 0), (580, 0), (585, 0), (590, 0), (595, 0), (600, 1), (605, 1), (610, 0), (615, 0), (620, 0), (625, 0), (630, 0), (635, 0), (640, 0), (645, 0), (650, 0), (655, 0), (660, 0), (665, 0), (670, 1), (675, 1), (680, 1), (685, 1), (690, 1), (695, 1), (700, 1), (705, 1), (710, 1), (715, 1), (720, 0), (725, 0), (730, 0), (735, 0), (740, 1), (745, 1), (750, 1), (755, 1), (760, 1), (765, 1), (770, 0), (775, 0), (780, 1), (785, 1), (790, 1), (795, 1), (800, 1), (805, 0), (810, 0), (815, 0), (820, 0), (825, 0), (830, 0), (835, 0), (840, 1), (845, 1), (850, 0), (855, 0), (860, 0), (865, 0), (870, 1), (875, 1), (880, 1), (885, 1), (890, 1), (895, 1), (900, 1), (905, 1), (910, 0), (915, 1), (920, 1), (925, 1), (930, 1), (935, 1), (940, 1), (945, 1), (950, 1), (955, 1), (960, 1), (965, 1), (970, 1), (975, 1), (980, 1), (985, 1), (990, 1), (995, 1), (1000, 1), (1005, 1), (1010, 1), (1015, 1), (1020, 1), (1025, 1)]
Vdin0_13  din0_13  0 PWL (0n 0.0v 4.745n 0.0v 4.755n 0.0v 9.745n 0.0v 9.755n 0.0v 14.745n 0.0v 14.755n 0.0v 19.745n 0.0v 19.755n 0.0v 24.745n 0.0v 24.755n 0.0v 29.745n 0.0v 29.755n 1.0v 34.745n 1.0v 34.755n 1.0v 39.745n 1.0v 39.755n 1.0v 44.745n 1.0v 44.755n 1.0v 49.745n 1.0v 49.755n 1.0v 54.745n 1.0v 54.755n 1.0v 59.745n 1.0v 59.755n 1.0v 64.745n 1.0v 64.755n 1.0v 69.745n 1.0v 69.755n 1.0v 74.745n 1.0v 74.755n 1.0v 79.745n 1.0v 79.755n 1.0v 84.745n 1.0v 84.755n 1.0v 89.745n 1.0v 89.755n 1.0v 94.745n 1.0v 94.755n 1.0v 99.745n 1.0v 99.755n 0.0v 104.745n 0.0v 104.755n 1.0v 109.745n 1.0v 109.755n 1.0v 114.745n 1.0v 114.755n 0.0v 119.745n 0.0v 119.755n 0.0v 124.745n 0.0v 124.755n 0.0v 129.745n 0.0v 129.755n 0.0v 134.745n 0.0v 134.755n 0.0v 139.745n 0.0v 139.755n 0.0v 144.745n 0.0v 144.755n 0.0v 149.745n 0.0v 149.755n 0.0v 154.745n 0.0v 154.755n 0.0v 159.745n 0.0v 159.755n 0.0v 164.745n 0.0v 164.755n 0.0v 169.745n 0.0v 169.755n 0.0v 174.745n 0.0v 174.755n 0.0v 179.745n 0.0v 179.755n 0.0v 184.745n 0.0v 184.755n 0.0v 189.745n 0.0v 189.755n 0.0v 194.745n 0.0v 194.755n 1.0v 199.745n 1.0v 199.755n 1.0v 204.745n 1.0v 204.755n 1.0v 209.745n 1.0v 209.755n 1.0v 214.745n 1.0v 214.755n 1.0v 219.745n 1.0v 219.755n 1.0v 224.745n 1.0v 224.755n 1.0v 229.745n 1.0v 229.755n 1.0v 234.745n 1.0v 234.755n 1.0v 239.745n 1.0v 239.755n 1.0v 244.745n 1.0v 244.755n 1.0v 249.745n 1.0v 249.755n 1.0v 254.745n 1.0v 254.755n 1.0v 259.745n 1.0v 259.755n 1.0v 264.745n 1.0v 264.755n 1.0v 269.745n 1.0v 269.755n 1.0v 274.745n 1.0v 274.755n 1.0v 279.745n 1.0v 279.755n 1.0v 284.745n 1.0v 284.755n 1.0v 289.745n 1.0v 289.755n 0.0v 294.745n 0.0v 294.755n 0.0v 299.745n 0.0v 299.755n 0.0v 304.745n 0.0v 304.755n 0.0v 309.745n 0.0v 309.755n 0.0v 314.745n 0.0v 314.755n 0.0v 319.745n 0.0v 319.755n 0.0v 324.745n 0.0v 324.755n 0.0v 329.745n 0.0v 329.755n 0.0v 334.745n 0.0v 334.755n 0.0v 339.745n 0.0v 339.755n 0.0v 344.745n 0.0v 344.755n 0.0v 349.745n 0.0v 349.755n 0.0v 354.745n 0.0v 354.755n 0.0v 359.745n 0.0v 359.755n 0.0v 364.745n 0.0v 364.755n 0.0v 369.745n 0.0v 369.755n 0.0v 374.745n 0.0v 374.755n 0.0v 379.745n 0.0v 379.755n 0.0v 384.745n 0.0v 384.755n 0.0v 389.745n 0.0v 389.755n 0.0v 394.745n 0.0v 394.755n 0.0v 399.745n 0.0v 399.755n 0.0v 404.745n 0.0v 404.755n 0.0v 409.745n 0.0v 409.755n 1.0v 414.745n 1.0v 414.755n 1.0v 419.745n 1.0v 419.755n 1.0v 424.745n 1.0v 424.755n 1.0v 429.745n 1.0v 429.755n 1.0v 434.745n 1.0v 434.755n 0.0v 439.745n 0.0v 439.755n 0.0v 444.745n 0.0v 444.755n 1.0v 449.745n 1.0v 449.755n 1.0v 454.745n 1.0v 454.755n 1.0v 459.745n 1.0v 459.755n 1.0v 464.745n 1.0v 464.755n 1.0v 469.745n 1.0v 469.755n 1.0v 474.745n 1.0v 474.755n 1.0v 479.745n 1.0v 479.755n 1.0v 484.745n 1.0v 484.755n 1.0v 489.745n 1.0v 489.755n 0.0v 494.745n 0.0v 494.755n 0.0v 499.745n 0.0v 499.755n 1.0v 504.745n 1.0v 504.755n 1.0v 509.745n 1.0v 509.755n 1.0v 514.745n 1.0v 514.755n 1.0v 519.745n 1.0v 519.755n 1.0v 524.745n 1.0v 524.755n 1.0v 529.745n 1.0v 529.755n 1.0v 534.745n 1.0v 534.755n 1.0v 539.745n 1.0v 539.755n 1.0v 544.745n 1.0v 544.755n 0.0v 549.745n 0.0v 549.755n 0.0v 554.745n 0.0v 554.755n 0.0v 559.745n 0.0v 559.755n 0.0v 564.745n 0.0v 564.755n 0.0v 569.745n 0.0v 569.755n 0.0v 574.745n 0.0v 574.755n 0.0v 579.745n 0.0v 579.755n 0.0v 584.745n 0.0v 584.755n 0.0v 589.745n 0.0v 589.755n 0.0v 594.745n 0.0v 594.755n 0.0v 599.745n 0.0v 599.755n 1.0v 604.745n 1.0v 604.755n 1.0v 609.745n 1.0v 609.755n 0.0v 614.745n 0.0v 614.755n 0.0v 619.745n 0.0v 619.755n 0.0v 624.745n 0.0v 624.755n 0.0v 629.745n 0.0v 629.755n 0.0v 634.745n 0.0v 634.755n 0.0v 639.745n 0.0v 639.755n 0.0v 644.745n 0.0v 644.755n 0.0v 649.745n 0.0v 649.755n 0.0v 654.745n 0.0v 654.755n 0.0v 659.745n 0.0v 659.755n 0.0v 664.745n 0.0v 664.755n 0.0v 669.745n 0.0v 669.755n 1.0v 674.745n 1.0v 674.755n 1.0v 679.745n 1.0v 679.755n 1.0v 684.745n 1.0v 684.755n 1.0v 689.745n 1.0v 689.755n 1.0v 694.745n 1.0v 694.755n 1.0v 699.745n 1.0v 699.755n 1.0v 704.745n 1.0v 704.755n 1.0v 709.745n 1.0v 709.755n 1.0v 714.745n 1.0v 714.755n 1.0v 719.745n 1.0v 719.755n 0.0v 724.745n 0.0v 724.755n 0.0v 729.745n 0.0v 729.755n 0.0v 734.745n 0.0v 734.755n 0.0v 739.745n 0.0v 739.755n 1.0v 744.745n 1.0v 744.755n 1.0v 749.745n 1.0v 749.755n 1.0v 754.745n 1.0v 754.755n 1.0v 759.745n 1.0v 759.755n 1.0v 764.745n 1.0v 764.755n 1.0v 769.745n 1.0v 769.755n 0.0v 774.745n 0.0v 774.755n 0.0v 779.745n 0.0v 779.755n 1.0v 784.745n 1.0v 784.755n 1.0v 789.745n 1.0v 789.755n 1.0v 794.745n 1.0v 794.755n 1.0v 799.745n 1.0v 799.755n 1.0v 804.745n 1.0v 804.755n 0.0v 809.745n 0.0v 809.755n 0.0v 814.745n 0.0v 814.755n 0.0v 819.745n 0.0v 819.755n 0.0v 824.745n 0.0v 824.755n 0.0v 829.745n 0.0v 829.755n 0.0v 834.745n 0.0v 834.755n 0.0v 839.745n 0.0v 839.755n 1.0v 844.745n 1.0v 844.755n 1.0v 849.745n 1.0v 849.755n 0.0v 854.745n 0.0v 854.755n 0.0v 859.745n 0.0v 859.755n 0.0v 864.745n 0.0v 864.755n 0.0v 869.745n 0.0v 869.755n 1.0v 874.745n 1.0v 874.755n 1.0v 879.745n 1.0v 879.755n 1.0v 884.745n 1.0v 884.755n 1.0v 889.745n 1.0v 889.755n 1.0v 894.745n 1.0v 894.755n 1.0v 899.745n 1.0v 899.755n 1.0v 904.745n 1.0v 904.755n 1.0v 909.745n 1.0v 909.755n 0.0v 914.745n 0.0v 914.755n 1.0v 919.745n 1.0v 919.755n 1.0v 924.745n 1.0v 924.755n 1.0v 929.745n 1.0v 929.755n 1.0v 934.745n 1.0v 934.755n 1.0v 939.745n 1.0v 939.755n 1.0v 944.745n 1.0v 944.755n 1.0v 949.745n 1.0v 949.755n 1.0v 954.745n 1.0v 954.755n 1.0v 959.745n 1.0v 959.755n 1.0v 964.745n 1.0v 964.755n 1.0v 969.745n 1.0v 969.755n 1.0v 974.745n 1.0v 974.755n 1.0v 979.745n 1.0v 979.755n 1.0v 984.745n 1.0v 984.755n 1.0v 989.745n 1.0v 989.755n 1.0v 994.745n 1.0v 994.755n 1.0v 999.745n 1.0v 999.755n 1.0v 1004.745n 1.0v 1004.755n 1.0v 1009.745n 1.0v 1009.755n 1.0v 1014.745n 1.0v 1014.755n 1.0v 1019.745n 1.0v 1019.755n 1.0v 1024.745n 1.0v 1024.755n 1.0v )
* (time, data): [(0, 0), (5, 1), (10, 1), (15, 1), (20, 1), (25, 1), (30, 1), (35, 1), (40, 0), (45, 0), (50, 0), (55, 0), (60, 0), (65, 1), (70, 1), (75, 1), (80, 1), (85, 0), (90, 0), (95, 0), (100, 1), (105, 0), (110, 0), (115, 0), (120, 0), (125, 0), (130, 0), (135, 0), (140, 0), (145, 0), (150, 0), (155, 0), (160, 0), (165, 0), (170, 0), (175, 1), (180, 1), (185, 1), (190, 1), (195, 1), (200, 1), (205, 1), (210, 1), (215, 1), (220, 1), (225, 1), (230, 1), (235, 1), (240, 1), (245, 0), (250, 0), (255, 0), (260, 0), (265, 0), (270, 0), (275, 0), (280, 0), (285, 0), (290, 0), (295, 0), (300, 0), (305, 0), (310, 0), (315, 0), (320, 0), (325, 0), (330, 0), (335, 0), (340, 0), (345, 0), (350, 1), (355, 1), (360, 1), (365, 1), (370, 1), (375, 1), (380, 1), (385, 1), (390, 1), (395, 1), (400, 1), (405, 1), (410, 1), (415, 1), (420, 1), (425, 1), (430, 1), (435, 1), (440, 1), (445, 1), (450, 1), (455, 1), (460, 1), (465, 1), (470, 1), (475, 1), (480, 1), (485, 1), (490, 1), (495, 1), (500, 1), (505, 1), (510, 1), (515, 1), (520, 1), (525, 1), (530, 1), (535, 0), (540, 0), (545, 0), (550, 0), (555, 0), (560, 1), (565, 1), (570, 1), (575, 1), (580, 1), (585, 1), (590, 1), (595, 1), (600, 0), (605, 0), (610, 0), (615, 0), (620, 0), (625, 0), (630, 0), (635, 0), (640, 0), (645, 1), (650, 1), (655, 0), (660, 0), (665, 0), (670, 1), (675, 1), (680, 1), (685, 1), (690, 1), (695, 1), (700, 1), (705, 1), (710, 1), (715, 1), (720, 0), (725, 0), (730, 0), (735, 0), (740, 1), (745, 1), (750, 1), (755, 1), (760, 1), (765, 1), (770, 1), (775, 1), (780, 0), (785, 0), (790, 0), (795, 0), (800, 0), (805, 1), (810, 1), (815, 1), (820, 1), (825, 1), (830, 1), (835, 1), (840, 0), (845, 0), (850, 0), (855, 1), (860, 1), (865, 0), (870, 0), (875, 0), (880, 0), (885, 0), (890, 0), (895, 0), (900, 0), (905, 0), (910, 1), (915, 1), (920, 1), (925, 1), (930, 1), (935, 1), (940, 1), (945, 1), (950, 1), (955, 1), (960, 1), (965, 1), (970, 1), (975, 1), (980, 1), (985, 1), (990, 1), (995, 1), (1000, 1), (1005, 1), (1010, 1), (1015, 1), (1020, 1), (1025, 1)]
Vdin0_14  din0_14  0 PWL (0n 0.0v 4.745n 0.0v 4.755n 1.0v 9.745n 1.0v 9.755n 1.0v 14.745n 1.0v 14.755n 1.0v 19.745n 1.0v 19.755n 1.0v 24.745n 1.0v 24.755n 1.0v 29.745n 1.0v 29.755n 1.0v 34.745n 1.0v 34.755n 1.0v 39.745n 1.0v 39.755n 0.0v 44.745n 0.0v 44.755n 0.0v 49.745n 0.0v 49.755n 0.0v 54.745n 0.0v 54.755n 0.0v 59.745n 0.0v 59.755n 0.0v 64.745n 0.0v 64.755n 1.0v 69.745n 1.0v 69.755n 1.0v 74.745n 1.0v 74.755n 1.0v 79.745n 1.0v 79.755n 1.0v 84.745n 1.0v 84.755n 0.0v 89.745n 0.0v 89.755n 0.0v 94.745n 0.0v 94.755n 0.0v 99.745n 0.0v 99.755n 1.0v 104.745n 1.0v 104.755n 0.0v 109.745n 0.0v 109.755n 0.0v 114.745n 0.0v 114.755n 0.0v 119.745n 0.0v 119.755n 0.0v 124.745n 0.0v 124.755n 0.0v 129.745n 0.0v 129.755n 0.0v 134.745n 0.0v 134.755n 0.0v 139.745n 0.0v 139.755n 0.0v 144.745n 0.0v 144.755n 0.0v 149.745n 0.0v 149.755n 0.0v 154.745n 0.0v 154.755n 0.0v 159.745n 0.0v 159.755n 0.0v 164.745n 0.0v 164.755n 0.0v 169.745n 0.0v 169.755n 0.0v 174.745n 0.0v 174.755n 1.0v 179.745n 1.0v 179.755n 1.0v 184.745n 1.0v 184.755n 1.0v 189.745n 1.0v 189.755n 1.0v 194.745n 1.0v 194.755n 1.0v 199.745n 1.0v 199.755n 1.0v 204.745n 1.0v 204.755n 1.0v 209.745n 1.0v 209.755n 1.0v 214.745n 1.0v 214.755n 1.0v 219.745n 1.0v 219.755n 1.0v 224.745n 1.0v 224.755n 1.0v 229.745n 1.0v 229.755n 1.0v 234.745n 1.0v 234.755n 1.0v 239.745n 1.0v 239.755n 1.0v 244.745n 1.0v 244.755n 0.0v 249.745n 0.0v 249.755n 0.0v 254.745n 0.0v 254.755n 0.0v 259.745n 0.0v 259.755n 0.0v 264.745n 0.0v 264.755n 0.0v 269.745n 0.0v 269.755n 0.0v 274.745n 0.0v 274.755n 0.0v 279.745n 0.0v 279.755n 0.0v 284.745n 0.0v 284.755n 0.0v 289.745n 0.0v 289.755n 0.0v 294.745n 0.0v 294.755n 0.0v 299.745n 0.0v 299.755n 0.0v 304.745n 0.0v 304.755n 0.0v 309.745n 0.0v 309.755n 0.0v 314.745n 0.0v 314.755n 0.0v 319.745n 0.0v 319.755n 0.0v 324.745n 0.0v 324.755n 0.0v 329.745n 0.0v 329.755n 0.0v 334.745n 0.0v 334.755n 0.0v 339.745n 0.0v 339.755n 0.0v 344.745n 0.0v 344.755n 0.0v 349.745n 0.0v 349.755n 1.0v 354.745n 1.0v 354.755n 1.0v 359.745n 1.0v 359.755n 1.0v 364.745n 1.0v 364.755n 1.0v 369.745n 1.0v 369.755n 1.0v 374.745n 1.0v 374.755n 1.0v 379.745n 1.0v 379.755n 1.0v 384.745n 1.0v 384.755n 1.0v 389.745n 1.0v 389.755n 1.0v 394.745n 1.0v 394.755n 1.0v 399.745n 1.0v 399.755n 1.0v 404.745n 1.0v 404.755n 1.0v 409.745n 1.0v 409.755n 1.0v 414.745n 1.0v 414.755n 1.0v 419.745n 1.0v 419.755n 1.0v 424.745n 1.0v 424.755n 1.0v 429.745n 1.0v 429.755n 1.0v 434.745n 1.0v 434.755n 1.0v 439.745n 1.0v 439.755n 1.0v 444.745n 1.0v 444.755n 1.0v 449.745n 1.0v 449.755n 1.0v 454.745n 1.0v 454.755n 1.0v 459.745n 1.0v 459.755n 1.0v 464.745n 1.0v 464.755n 1.0v 469.745n 1.0v 469.755n 1.0v 474.745n 1.0v 474.755n 1.0v 479.745n 1.0v 479.755n 1.0v 484.745n 1.0v 484.755n 1.0v 489.745n 1.0v 489.755n 1.0v 494.745n 1.0v 494.755n 1.0v 499.745n 1.0v 499.755n 1.0v 504.745n 1.0v 504.755n 1.0v 509.745n 1.0v 509.755n 1.0v 514.745n 1.0v 514.755n 1.0v 519.745n 1.0v 519.755n 1.0v 524.745n 1.0v 524.755n 1.0v 529.745n 1.0v 529.755n 1.0v 534.745n 1.0v 534.755n 0.0v 539.745n 0.0v 539.755n 0.0v 544.745n 0.0v 544.755n 0.0v 549.745n 0.0v 549.755n 0.0v 554.745n 0.0v 554.755n 0.0v 559.745n 0.0v 559.755n 1.0v 564.745n 1.0v 564.755n 1.0v 569.745n 1.0v 569.755n 1.0v 574.745n 1.0v 574.755n 1.0v 579.745n 1.0v 579.755n 1.0v 584.745n 1.0v 584.755n 1.0v 589.745n 1.0v 589.755n 1.0v 594.745n 1.0v 594.755n 1.0v 599.745n 1.0v 599.755n 0.0v 604.745n 0.0v 604.755n 0.0v 609.745n 0.0v 609.755n 0.0v 614.745n 0.0v 614.755n 0.0v 619.745n 0.0v 619.755n 0.0v 624.745n 0.0v 624.755n 0.0v 629.745n 0.0v 629.755n 0.0v 634.745n 0.0v 634.755n 0.0v 639.745n 0.0v 639.755n 0.0v 644.745n 0.0v 644.755n 1.0v 649.745n 1.0v 649.755n 1.0v 654.745n 1.0v 654.755n 0.0v 659.745n 0.0v 659.755n 0.0v 664.745n 0.0v 664.755n 0.0v 669.745n 0.0v 669.755n 1.0v 674.745n 1.0v 674.755n 1.0v 679.745n 1.0v 679.755n 1.0v 684.745n 1.0v 684.755n 1.0v 689.745n 1.0v 689.755n 1.0v 694.745n 1.0v 694.755n 1.0v 699.745n 1.0v 699.755n 1.0v 704.745n 1.0v 704.755n 1.0v 709.745n 1.0v 709.755n 1.0v 714.745n 1.0v 714.755n 1.0v 719.745n 1.0v 719.755n 0.0v 724.745n 0.0v 724.755n 0.0v 729.745n 0.0v 729.755n 0.0v 734.745n 0.0v 734.755n 0.0v 739.745n 0.0v 739.755n 1.0v 744.745n 1.0v 744.755n 1.0v 749.745n 1.0v 749.755n 1.0v 754.745n 1.0v 754.755n 1.0v 759.745n 1.0v 759.755n 1.0v 764.745n 1.0v 764.755n 1.0v 769.745n 1.0v 769.755n 1.0v 774.745n 1.0v 774.755n 1.0v 779.745n 1.0v 779.755n 0.0v 784.745n 0.0v 784.755n 0.0v 789.745n 0.0v 789.755n 0.0v 794.745n 0.0v 794.755n 0.0v 799.745n 0.0v 799.755n 0.0v 804.745n 0.0v 804.755n 1.0v 809.745n 1.0v 809.755n 1.0v 814.745n 1.0v 814.755n 1.0v 819.745n 1.0v 819.755n 1.0v 824.745n 1.0v 824.755n 1.0v 829.745n 1.0v 829.755n 1.0v 834.745n 1.0v 834.755n 1.0v 839.745n 1.0v 839.755n 0.0v 844.745n 0.0v 844.755n 0.0v 849.745n 0.0v 849.755n 0.0v 854.745n 0.0v 854.755n 1.0v 859.745n 1.0v 859.755n 1.0v 864.745n 1.0v 864.755n 0.0v 869.745n 0.0v 869.755n 0.0v 874.745n 0.0v 874.755n 0.0v 879.745n 0.0v 879.755n 0.0v 884.745n 0.0v 884.755n 0.0v 889.745n 0.0v 889.755n 0.0v 894.745n 0.0v 894.755n 0.0v 899.745n 0.0v 899.755n 0.0v 904.745n 0.0v 904.755n 0.0v 909.745n 0.0v 909.755n 1.0v 914.745n 1.0v 914.755n 1.0v 919.745n 1.0v 919.755n 1.0v 924.745n 1.0v 924.755n 1.0v 929.745n 1.0v 929.755n 1.0v 934.745n 1.0v 934.755n 1.0v 939.745n 1.0v 939.755n 1.0v 944.745n 1.0v 944.755n 1.0v 949.745n 1.0v 949.755n 1.0v 954.745n 1.0v 954.755n 1.0v 959.745n 1.0v 959.755n 1.0v 964.745n 1.0v 964.755n 1.0v 969.745n 1.0v 969.755n 1.0v 974.745n 1.0v 974.755n 1.0v 979.745n 1.0v 979.755n 1.0v 984.745n 1.0v 984.755n 1.0v 989.745n 1.0v 989.755n 1.0v 994.745n 1.0v 994.755n 1.0v 999.745n 1.0v 999.755n 1.0v 1004.745n 1.0v 1004.755n 1.0v 1009.745n 1.0v 1009.755n 1.0v 1014.745n 1.0v 1014.755n 1.0v 1019.745n 1.0v 1019.755n 1.0v 1024.745n 1.0v 1024.755n 1.0v )
* (time, data): [(0, 0), (5, 1), (10, 0), (15, 1), (20, 1), (25, 1), (30, 0), (35, 0), (40, 0), (45, 0), (50, 0), (55, 0), (60, 0), (65, 0), (70, 0), (75, 0), (80, 0), (85, 1), (90, 1), (95, 1), (100, 0), (105, 0), (110, 0), (115, 0), (120, 0), (125, 0), (130, 0), (135, 0), (140, 0), (145, 0), (150, 0), (155, 0), (160, 0), (165, 0), (170, 0), (175, 1), (180, 1), (185, 1), (190, 1), (195, 1), (200, 1), (205, 1), (210, 1), (215, 1), (220, 1), (225, 1), (230, 1), (235, 1), (240, 1), (245, 1), (250, 1), (255, 1), (260, 1), (265, 1), (270, 1), (275, 1), (280, 1), (285, 1), (290, 0), (295, 0), (300, 0), (305, 0), (310, 0), (315, 0), (320, 0), (325, 0), (330, 0), (335, 1), (340, 1), (345, 1), (350, 1), (355, 1), (360, 1), (365, 1), (370, 1), (375, 1), (380, 1), (385, 1), (390, 1), (395, 1), (400, 1), (405, 1), (410, 0), (415, 0), (420, 0), (425, 0), (430, 0), (435, 1), (440, 1), (445, 1), (450, 1), (455, 1), (460, 1), (465, 1), (470, 1), (475, 1), (480, 1), (485, 1), (490, 0), (495, 0), (500, 1), (505, 1), (510, 1), (515, 0), (520, 0), (525, 0), (530, 0), (535, 1), (540, 1), (545, 0), (550, 0), (555, 0), (560, 1), (565, 1), (570, 1), (575, 1), (580, 1), (585, 1), (590, 1), (595, 1), (600, 0), (605, 0), (610, 0), (615, 0), (620, 0), (625, 0), (630, 0), (635, 1), (640, 1), (645, 1), (650, 1), (655, 0), (660, 0), (665, 0), (670, 0), (675, 0), (680, 0), (685, 0), (690, 0), (695, 0), (700, 0), (705, 0), (710, 0), (715, 0), (720, 1), (725, 1), (730, 1), (735, 1), (740, 0), (745, 0), (750, 0), (755, 0), (760, 0), (765, 0), (770, 0), (775, 0), (780, 1), (785, 1), (790, 1), (795, 1), (800, 1), (805, 1), (810, 0), (815, 0), (820, 0), (825, 0), (830, 0), (835, 0), (840, 0), (845, 0), (850, 1), (855, 1), (860, 1), (865, 1), (870, 0), (875, 0), (880, 0), (885, 0), (890, 0), (895, 0), (900, 0), (905, 0), (910, 1), (915, 1), (920, 1), (925, 1), (930, 0), (935, 0), (940, 0), (945, 0), (950, 0), (955, 0), (960, 0), (965, 0), (970, 0), (975, 0), (980, 0), (985, 0), (990, 0), (995, 0), (1000, 0), (1005, 0), (1010, 0), (1015, 0), (1020, 1), (1025, 1)]
Vdin0_15  din0_15  0 PWL (0n 0.0v 4.745n 0.0v 4.755n 1.0v 9.745n 1.0v 9.755n 0.0v 14.745n 0.0v 14.755n 1.0v 19.745n 1.0v 19.755n 1.0v 24.745n 1.0v 24.755n 1.0v 29.745n 1.0v 29.755n 0.0v 34.745n 0.0v 34.755n 0.0v 39.745n 0.0v 39.755n 0.0v 44.745n 0.0v 44.755n 0.0v 49.745n 0.0v 49.755n 0.0v 54.745n 0.0v 54.755n 0.0v 59.745n 0.0v 59.755n 0.0v 64.745n 0.0v 64.755n 0.0v 69.745n 0.0v 69.755n 0.0v 74.745n 0.0v 74.755n 0.0v 79.745n 0.0v 79.755n 0.0v 84.745n 0.0v 84.755n 1.0v 89.745n 1.0v 89.755n 1.0v 94.745n 1.0v 94.755n 1.0v 99.745n 1.0v 99.755n 0.0v 104.745n 0.0v 104.755n 0.0v 109.745n 0.0v 109.755n 0.0v 114.745n 0.0v 114.755n 0.0v 119.745n 0.0v 119.755n 0.0v 124.745n 0.0v 124.755n 0.0v 129.745n 0.0v 129.755n 0.0v 134.745n 0.0v 134.755n 0.0v 139.745n 0.0v 139.755n 0.0v 144.745n 0.0v 144.755n 0.0v 149.745n 0.0v 149.755n 0.0v 154.745n 0.0v 154.755n 0.0v 159.745n 0.0v 159.755n 0.0v 164.745n 0.0v 164.755n 0.0v 169.745n 0.0v 169.755n 0.0v 174.745n 0.0v 174.755n 1.0v 179.745n 1.0v 179.755n 1.0v 184.745n 1.0v 184.755n 1.0v 189.745n 1.0v 189.755n 1.0v 194.745n 1.0v 194.755n 1.0v 199.745n 1.0v 199.755n 1.0v 204.745n 1.0v 204.755n 1.0v 209.745n 1.0v 209.755n 1.0v 214.745n 1.0v 214.755n 1.0v 219.745n 1.0v 219.755n 1.0v 224.745n 1.0v 224.755n 1.0v 229.745n 1.0v 229.755n 1.0v 234.745n 1.0v 234.755n 1.0v 239.745n 1.0v 239.755n 1.0v 244.745n 1.0v 244.755n 1.0v 249.745n 1.0v 249.755n 1.0v 254.745n 1.0v 254.755n 1.0v 259.745n 1.0v 259.755n 1.0v 264.745n 1.0v 264.755n 1.0v 269.745n 1.0v 269.755n 1.0v 274.745n 1.0v 274.755n 1.0v 279.745n 1.0v 279.755n 1.0v 284.745n 1.0v 284.755n 1.0v 289.745n 1.0v 289.755n 0.0v 294.745n 0.0v 294.755n 0.0v 299.745n 0.0v 299.755n 0.0v 304.745n 0.0v 304.755n 0.0v 309.745n 0.0v 309.755n 0.0v 314.745n 0.0v 314.755n 0.0v 319.745n 0.0v 319.755n 0.0v 324.745n 0.0v 324.755n 0.0v 329.745n 0.0v 329.755n 0.0v 334.745n 0.0v 334.755n 1.0v 339.745n 1.0v 339.755n 1.0v 344.745n 1.0v 344.755n 1.0v 349.745n 1.0v 349.755n 1.0v 354.745n 1.0v 354.755n 1.0v 359.745n 1.0v 359.755n 1.0v 364.745n 1.0v 364.755n 1.0v 369.745n 1.0v 369.755n 1.0v 374.745n 1.0v 374.755n 1.0v 379.745n 1.0v 379.755n 1.0v 384.745n 1.0v 384.755n 1.0v 389.745n 1.0v 389.755n 1.0v 394.745n 1.0v 394.755n 1.0v 399.745n 1.0v 399.755n 1.0v 404.745n 1.0v 404.755n 1.0v 409.745n 1.0v 409.755n 0.0v 414.745n 0.0v 414.755n 0.0v 419.745n 0.0v 419.755n 0.0v 424.745n 0.0v 424.755n 0.0v 429.745n 0.0v 429.755n 0.0v 434.745n 0.0v 434.755n 1.0v 439.745n 1.0v 439.755n 1.0v 444.745n 1.0v 444.755n 1.0v 449.745n 1.0v 449.755n 1.0v 454.745n 1.0v 454.755n 1.0v 459.745n 1.0v 459.755n 1.0v 464.745n 1.0v 464.755n 1.0v 469.745n 1.0v 469.755n 1.0v 474.745n 1.0v 474.755n 1.0v 479.745n 1.0v 479.755n 1.0v 484.745n 1.0v 484.755n 1.0v 489.745n 1.0v 489.755n 0.0v 494.745n 0.0v 494.755n 0.0v 499.745n 0.0v 499.755n 1.0v 504.745n 1.0v 504.755n 1.0v 509.745n 1.0v 509.755n 1.0v 514.745n 1.0v 514.755n 0.0v 519.745n 0.0v 519.755n 0.0v 524.745n 0.0v 524.755n 0.0v 529.745n 0.0v 529.755n 0.0v 534.745n 0.0v 534.755n 1.0v 539.745n 1.0v 539.755n 1.0v 544.745n 1.0v 544.755n 0.0v 549.745n 0.0v 549.755n 0.0v 554.745n 0.0v 554.755n 0.0v 559.745n 0.0v 559.755n 1.0v 564.745n 1.0v 564.755n 1.0v 569.745n 1.0v 569.755n 1.0v 574.745n 1.0v 574.755n 1.0v 579.745n 1.0v 579.755n 1.0v 584.745n 1.0v 584.755n 1.0v 589.745n 1.0v 589.755n 1.0v 594.745n 1.0v 594.755n 1.0v 599.745n 1.0v 599.755n 0.0v 604.745n 0.0v 604.755n 0.0v 609.745n 0.0v 609.755n 0.0v 614.745n 0.0v 614.755n 0.0v 619.745n 0.0v 619.755n 0.0v 624.745n 0.0v 624.755n 0.0v 629.745n 0.0v 629.755n 0.0v 634.745n 0.0v 634.755n 1.0v 639.745n 1.0v 639.755n 1.0v 644.745n 1.0v 644.755n 1.0v 649.745n 1.0v 649.755n 1.0v 654.745n 1.0v 654.755n 0.0v 659.745n 0.0v 659.755n 0.0v 664.745n 0.0v 664.755n 0.0v 669.745n 0.0v 669.755n 0.0v 674.745n 0.0v 674.755n 0.0v 679.745n 0.0v 679.755n 0.0v 684.745n 0.0v 684.755n 0.0v 689.745n 0.0v 689.755n 0.0v 694.745n 0.0v 694.755n 0.0v 699.745n 0.0v 699.755n 0.0v 704.745n 0.0v 704.755n 0.0v 709.745n 0.0v 709.755n 0.0v 714.745n 0.0v 714.755n 0.0v 719.745n 0.0v 719.755n 1.0v 724.745n 1.0v 724.755n 1.0v 729.745n 1.0v 729.755n 1.0v 734.745n 1.0v 734.755n 1.0v 739.745n 1.0v 739.755n 0.0v 744.745n 0.0v 744.755n 0.0v 749.745n 0.0v 749.755n 0.0v 754.745n 0.0v 754.755n 0.0v 759.745n 0.0v 759.755n 0.0v 764.745n 0.0v 764.755n 0.0v 769.745n 0.0v 769.755n 0.0v 774.745n 0.0v 774.755n 0.0v 779.745n 0.0v 779.755n 1.0v 784.745n 1.0v 784.755n 1.0v 789.745n 1.0v 789.755n 1.0v 794.745n 1.0v 794.755n 1.0v 799.745n 1.0v 799.755n 1.0v 804.745n 1.0v 804.755n 1.0v 809.745n 1.0v 809.755n 0.0v 814.745n 0.0v 814.755n 0.0v 819.745n 0.0v 819.755n 0.0v 824.745n 0.0v 824.755n 0.0v 829.745n 0.0v 829.755n 0.0v 834.745n 0.0v 834.755n 0.0v 839.745n 0.0v 839.755n 0.0v 844.745n 0.0v 844.755n 0.0v 849.745n 0.0v 849.755n 1.0v 854.745n 1.0v 854.755n 1.0v 859.745n 1.0v 859.755n 1.0v 864.745n 1.0v 864.755n 1.0v 869.745n 1.0v 869.755n 0.0v 874.745n 0.0v 874.755n 0.0v 879.745n 0.0v 879.755n 0.0v 884.745n 0.0v 884.755n 0.0v 889.745n 0.0v 889.755n 0.0v 894.745n 0.0v 894.755n 0.0v 899.745n 0.0v 899.755n 0.0v 904.745n 0.0v 904.755n 0.0v 909.745n 0.0v 909.755n 1.0v 914.745n 1.0v 914.755n 1.0v 919.745n 1.0v 919.755n 1.0v 924.745n 1.0v 924.755n 1.0v 929.745n 1.0v 929.755n 0.0v 934.745n 0.0v 934.755n 0.0v 939.745n 0.0v 939.755n 0.0v 944.745n 0.0v 944.755n 0.0v 949.745n 0.0v 949.755n 0.0v 954.745n 0.0v 954.755n 0.0v 959.745n 0.0v 959.755n 0.0v 964.745n 0.0v 964.755n 0.0v 969.745n 0.0v 969.755n 0.0v 974.745n 0.0v 974.755n 0.0v 979.745n 0.0v 979.755n 0.0v 984.745n 0.0v 984.755n 0.0v 989.745n 0.0v 989.755n 0.0v 994.745n 0.0v 994.755n 0.0v 999.745n 0.0v 999.755n 0.0v 1004.745n 0.0v 1004.755n 0.0v 1009.745n 0.0v 1009.755n 0.0v 1014.745n 0.0v 1014.755n 0.0v 1019.745n 0.0v 1019.755n 1.0v 1024.745n 1.0v 1024.755n 1.0v )
* (time, data): [(0, 0), (5, 1), (10, 1), (15, 1), (20, 1), (25, 1), (30, 0), (35, 0), (40, 1), (45, 1), (50, 0), (55, 0), (60, 0), (65, 0), (70, 0), (75, 0), (80, 0), (85, 1), (90, 1), (95, 1), (100, 0), (105, 0), (110, 0), (115, 0), (120, 0), (125, 0), (130, 0), (135, 0), (140, 0), (145, 0), (150, 0), (155, 0), (160, 0), (165, 0), (170, 0), (175, 1), (180, 1), (185, 1), (190, 1), (195, 1), (200, 1), (205, 1), (210, 1), (215, 1), (220, 1), (225, 1), (230, 1), (235, 1), (240, 1), (245, 1), (250, 1), (255, 1), (260, 1), (265, 1), (270, 1), (275, 1), (280, 1), (285, 1), (290, 1), (295, 1), (300, 1), (305, 1), (310, 1), (315, 1), (320, 1), (325, 1), (330, 1), (335, 0), (340, 0), (345, 0), (350, 1), (355, 1), (360, 1), (365, 1), (370, 1), (375, 1), (380, 1), (385, 1), (390, 1), (395, 1), (400, 1), (405, 1), (410, 0), (415, 0), (420, 0), (425, 0), (430, 0), (435, 1), (440, 1), (445, 0), (450, 0), (455, 0), (460, 0), (465, 0), (470, 0), (475, 0), (480, 0), (485, 1), (490, 1), (495, 1), (500, 0), (505, 0), (510, 0), (515, 1), (520, 1), (525, 1), (530, 1), (535, 0), (540, 0), (545, 0), (550, 0), (555, 0), (560, 1), (565, 1), (570, 1), (575, 1), (580, 1), (585, 1), (590, 1), (595, 1), (600, 0), (605, 0), (610, 1), (615, 1), (620, 0), (625, 0), (630, 0), (635, 1), (640, 1), (645, 0), (650, 0), (655, 0), (660, 0), (665, 0), (670, 0), (675, 0), (680, 0), (685, 0), (690, 0), (695, 0), (700, 0), (705, 0), (710, 0), (715, 0), (720, 0), (725, 0), (730, 0), (735, 0), (740, 1), (745, 1), (750, 1), (755, 1), (760, 1), (765, 1), (770, 1), (775, 1), (780, 1), (785, 1), (790, 1), (795, 1), (800, 1), (805, 0), (810, 1), (815, 1), (820, 1), (825, 1), (830, 1), (835, 1), (840, 1), (845, 1), (850, 1), (855, 0), (860, 0), (865, 0), (870, 0), (875, 0), (880, 0), (885, 0), (890, 0), (895, 0), (900, 0), (905, 0), (910, 0), (915, 0), (920, 0), (925, 0), (930, 0), (935, 0), (940, 0), (945, 0), (950, 0), (955, 0), (960, 0), (965, 0), (970, 0), (975, 0), (980, 0), (985, 0), (990, 0), (995, 0), (1000, 0), (1005, 0), (1010, 0), (1015, 0), (1020, 1), (1025, 1)]
Vdin0_16  din0_16  0 PWL (0n 0.0v 4.745n 0.0v 4.755n 1.0v 9.745n 1.0v 9.755n 1.0v 14.745n 1.0v 14.755n 1.0v 19.745n 1.0v 19.755n 1.0v 24.745n 1.0v 24.755n 1.0v 29.745n 1.0v 29.755n 0.0v 34.745n 0.0v 34.755n 0.0v 39.745n 0.0v 39.755n 1.0v 44.745n 1.0v 44.755n 1.0v 49.745n 1.0v 49.755n 0.0v 54.745n 0.0v 54.755n 0.0v 59.745n 0.0v 59.755n 0.0v 64.745n 0.0v 64.755n 0.0v 69.745n 0.0v 69.755n 0.0v 74.745n 0.0v 74.755n 0.0v 79.745n 0.0v 79.755n 0.0v 84.745n 0.0v 84.755n 1.0v 89.745n 1.0v 89.755n 1.0v 94.745n 1.0v 94.755n 1.0v 99.745n 1.0v 99.755n 0.0v 104.745n 0.0v 104.755n 0.0v 109.745n 0.0v 109.755n 0.0v 114.745n 0.0v 114.755n 0.0v 119.745n 0.0v 119.755n 0.0v 124.745n 0.0v 124.755n 0.0v 129.745n 0.0v 129.755n 0.0v 134.745n 0.0v 134.755n 0.0v 139.745n 0.0v 139.755n 0.0v 144.745n 0.0v 144.755n 0.0v 149.745n 0.0v 149.755n 0.0v 154.745n 0.0v 154.755n 0.0v 159.745n 0.0v 159.755n 0.0v 164.745n 0.0v 164.755n 0.0v 169.745n 0.0v 169.755n 0.0v 174.745n 0.0v 174.755n 1.0v 179.745n 1.0v 179.755n 1.0v 184.745n 1.0v 184.755n 1.0v 189.745n 1.0v 189.755n 1.0v 194.745n 1.0v 194.755n 1.0v 199.745n 1.0v 199.755n 1.0v 204.745n 1.0v 204.755n 1.0v 209.745n 1.0v 209.755n 1.0v 214.745n 1.0v 214.755n 1.0v 219.745n 1.0v 219.755n 1.0v 224.745n 1.0v 224.755n 1.0v 229.745n 1.0v 229.755n 1.0v 234.745n 1.0v 234.755n 1.0v 239.745n 1.0v 239.755n 1.0v 244.745n 1.0v 244.755n 1.0v 249.745n 1.0v 249.755n 1.0v 254.745n 1.0v 254.755n 1.0v 259.745n 1.0v 259.755n 1.0v 264.745n 1.0v 264.755n 1.0v 269.745n 1.0v 269.755n 1.0v 274.745n 1.0v 274.755n 1.0v 279.745n 1.0v 279.755n 1.0v 284.745n 1.0v 284.755n 1.0v 289.745n 1.0v 289.755n 1.0v 294.745n 1.0v 294.755n 1.0v 299.745n 1.0v 299.755n 1.0v 304.745n 1.0v 304.755n 1.0v 309.745n 1.0v 309.755n 1.0v 314.745n 1.0v 314.755n 1.0v 319.745n 1.0v 319.755n 1.0v 324.745n 1.0v 324.755n 1.0v 329.745n 1.0v 329.755n 1.0v 334.745n 1.0v 334.755n 0.0v 339.745n 0.0v 339.755n 0.0v 344.745n 0.0v 344.755n 0.0v 349.745n 0.0v 349.755n 1.0v 354.745n 1.0v 354.755n 1.0v 359.745n 1.0v 359.755n 1.0v 364.745n 1.0v 364.755n 1.0v 369.745n 1.0v 369.755n 1.0v 374.745n 1.0v 374.755n 1.0v 379.745n 1.0v 379.755n 1.0v 384.745n 1.0v 384.755n 1.0v 389.745n 1.0v 389.755n 1.0v 394.745n 1.0v 394.755n 1.0v 399.745n 1.0v 399.755n 1.0v 404.745n 1.0v 404.755n 1.0v 409.745n 1.0v 409.755n 0.0v 414.745n 0.0v 414.755n 0.0v 419.745n 0.0v 419.755n 0.0v 424.745n 0.0v 424.755n 0.0v 429.745n 0.0v 429.755n 0.0v 434.745n 0.0v 434.755n 1.0v 439.745n 1.0v 439.755n 1.0v 444.745n 1.0v 444.755n 0.0v 449.745n 0.0v 449.755n 0.0v 454.745n 0.0v 454.755n 0.0v 459.745n 0.0v 459.755n 0.0v 464.745n 0.0v 464.755n 0.0v 469.745n 0.0v 469.755n 0.0v 474.745n 0.0v 474.755n 0.0v 479.745n 0.0v 479.755n 0.0v 484.745n 0.0v 484.755n 1.0v 489.745n 1.0v 489.755n 1.0v 494.745n 1.0v 494.755n 1.0v 499.745n 1.0v 499.755n 0.0v 504.745n 0.0v 504.755n 0.0v 509.745n 0.0v 509.755n 0.0v 514.745n 0.0v 514.755n 1.0v 519.745n 1.0v 519.755n 1.0v 524.745n 1.0v 524.755n 1.0v 529.745n 1.0v 529.755n 1.0v 534.745n 1.0v 534.755n 0.0v 539.745n 0.0v 539.755n 0.0v 544.745n 0.0v 544.755n 0.0v 549.745n 0.0v 549.755n 0.0v 554.745n 0.0v 554.755n 0.0v 559.745n 0.0v 559.755n 1.0v 564.745n 1.0v 564.755n 1.0v 569.745n 1.0v 569.755n 1.0v 574.745n 1.0v 574.755n 1.0v 579.745n 1.0v 579.755n 1.0v 584.745n 1.0v 584.755n 1.0v 589.745n 1.0v 589.755n 1.0v 594.745n 1.0v 594.755n 1.0v 599.745n 1.0v 599.755n 0.0v 604.745n 0.0v 604.755n 0.0v 609.745n 0.0v 609.755n 1.0v 614.745n 1.0v 614.755n 1.0v 619.745n 1.0v 619.755n 0.0v 624.745n 0.0v 624.755n 0.0v 629.745n 0.0v 629.755n 0.0v 634.745n 0.0v 634.755n 1.0v 639.745n 1.0v 639.755n 1.0v 644.745n 1.0v 644.755n 0.0v 649.745n 0.0v 649.755n 0.0v 654.745n 0.0v 654.755n 0.0v 659.745n 0.0v 659.755n 0.0v 664.745n 0.0v 664.755n 0.0v 669.745n 0.0v 669.755n 0.0v 674.745n 0.0v 674.755n 0.0v 679.745n 0.0v 679.755n 0.0v 684.745n 0.0v 684.755n 0.0v 689.745n 0.0v 689.755n 0.0v 694.745n 0.0v 694.755n 0.0v 699.745n 0.0v 699.755n 0.0v 704.745n 0.0v 704.755n 0.0v 709.745n 0.0v 709.755n 0.0v 714.745n 0.0v 714.755n 0.0v 719.745n 0.0v 719.755n 0.0v 724.745n 0.0v 724.755n 0.0v 729.745n 0.0v 729.755n 0.0v 734.745n 0.0v 734.755n 0.0v 739.745n 0.0v 739.755n 1.0v 744.745n 1.0v 744.755n 1.0v 749.745n 1.0v 749.755n 1.0v 754.745n 1.0v 754.755n 1.0v 759.745n 1.0v 759.755n 1.0v 764.745n 1.0v 764.755n 1.0v 769.745n 1.0v 769.755n 1.0v 774.745n 1.0v 774.755n 1.0v 779.745n 1.0v 779.755n 1.0v 784.745n 1.0v 784.755n 1.0v 789.745n 1.0v 789.755n 1.0v 794.745n 1.0v 794.755n 1.0v 799.745n 1.0v 799.755n 1.0v 804.745n 1.0v 804.755n 0.0v 809.745n 0.0v 809.755n 1.0v 814.745n 1.0v 814.755n 1.0v 819.745n 1.0v 819.755n 1.0v 824.745n 1.0v 824.755n 1.0v 829.745n 1.0v 829.755n 1.0v 834.745n 1.0v 834.755n 1.0v 839.745n 1.0v 839.755n 1.0v 844.745n 1.0v 844.755n 1.0v 849.745n 1.0v 849.755n 1.0v 854.745n 1.0v 854.755n 0.0v 859.745n 0.0v 859.755n 0.0v 864.745n 0.0v 864.755n 0.0v 869.745n 0.0v 869.755n 0.0v 874.745n 0.0v 874.755n 0.0v 879.745n 0.0v 879.755n 0.0v 884.745n 0.0v 884.755n 0.0v 889.745n 0.0v 889.755n 0.0v 894.745n 0.0v 894.755n 0.0v 899.745n 0.0v 899.755n 0.0v 904.745n 0.0v 904.755n 0.0v 909.745n 0.0v 909.755n 0.0v 914.745n 0.0v 914.755n 0.0v 919.745n 0.0v 919.755n 0.0v 924.745n 0.0v 924.755n 0.0v 929.745n 0.0v 929.755n 0.0v 934.745n 0.0v 934.755n 0.0v 939.745n 0.0v 939.755n 0.0v 944.745n 0.0v 944.755n 0.0v 949.745n 0.0v 949.755n 0.0v 954.745n 0.0v 954.755n 0.0v 959.745n 0.0v 959.755n 0.0v 964.745n 0.0v 964.755n 0.0v 969.745n 0.0v 969.755n 0.0v 974.745n 0.0v 974.755n 0.0v 979.745n 0.0v 979.755n 0.0v 984.745n 0.0v 984.755n 0.0v 989.745n 0.0v 989.755n 0.0v 994.745n 0.0v 994.755n 0.0v 999.745n 0.0v 999.755n 0.0v 1004.745n 0.0v 1004.755n 0.0v 1009.745n 0.0v 1009.755n 0.0v 1014.745n 0.0v 1014.755n 0.0v 1019.745n 0.0v 1019.755n 1.0v 1024.745n 1.0v 1024.755n 1.0v )
* (time, data): [(0, 0), (5, 1), (10, 0), (15, 0), (20, 0), (25, 0), (30, 0), (35, 0), (40, 1), (45, 1), (50, 0), (55, 0), (60, 0), (65, 1), (70, 1), (75, 1), (80, 1), (85, 1), (90, 1), (95, 1), (100, 0), (105, 0), (110, 0), (115, 0), (120, 0), (125, 0), (130, 0), (135, 0), (140, 0), (145, 0), (150, 0), (155, 1), (160, 1), (165, 1), (170, 1), (175, 0), (180, 0), (185, 0), (190, 0), (195, 1), (200, 1), (205, 1), (210, 1), (215, 1), (220, 1), (225, 1), (230, 1), (235, 1), (240, 1), (245, 0), (250, 0), (255, 0), (260, 0), (265, 0), (270, 0), (275, 0), (280, 0), (285, 0), (290, 0), (295, 0), (300, 0), (305, 0), (310, 0), (315, 0), (320, 0), (325, 0), (330, 0), (335, 1), (340, 1), (345, 1), (350, 1), (355, 1), (360, 1), (365, 1), (370, 1), (375, 1), (380, 1), (385, 1), (390, 1), (395, 1), (400, 1), (405, 1), (410, 0), (415, 0), (420, 0), (425, 0), (430, 0), (435, 1), (440, 1), (445, 0), (450, 0), (455, 0), (460, 0), (465, 0), (470, 0), (475, 0), (480, 0), (485, 0), (490, 0), (495, 0), (500, 0), (505, 0), (510, 0), (515, 1), (520, 1), (525, 1), (530, 1), (535, 0), (540, 1), (545, 1), (550, 1), (555, 1), (560, 1), (565, 1), (570, 1), (575, 1), (580, 1), (585, 1), (590, 1), (595, 1), (600, 1), (605, 1), (610, 1), (615, 1), (620, 0), (625, 0), (630, 0), (635, 1), (640, 1), (645, 1), (650, 1), (655, 1), (660, 1), (665, 1), (670, 0), (675, 0), (680, 0), (685, 0), (690, 0), (695, 0), (700, 0), (705, 0), (710, 0), (715, 0), (720, 1), (725, 1), (730, 1), (735, 1), (740, 0), (745, 0), (750, 0), (755, 0), (760, 0), (765, 0), (770, 1), (775, 1), (780, 1), (785, 1), (790, 1), (795, 1), (800, 1), (805, 1), (810, 1), (815, 1), (820, 1), (825, 1), (830, 1), (835, 1), (840, 1), (845, 1), (850, 0), (855, 1), (860, 1), (865, 0), (870, 0), (875, 0), (880, 0), (885, 0), (890, 0), (895, 0), (900, 0), (905, 0), (910, 1), (915, 0), (920, 0), (925, 0), (930, 1), (935, 1), (940, 1), (945, 1), (950, 1), (955, 1), (960, 1), (965, 0), (970, 0), (975, 0), (980, 0), (985, 0), (990, 0), (995, 0), (1000, 0), (1005, 0), (1010, 0), (1015, 0), (1020, 1), (1025, 1)]
Vdin0_17  din0_17  0 PWL (0n 0.0v 4.745n 0.0v 4.755n 1.0v 9.745n 1.0v 9.755n 0.0v 14.745n 0.0v 14.755n 0.0v 19.745n 0.0v 19.755n 0.0v 24.745n 0.0v 24.755n 0.0v 29.745n 0.0v 29.755n 0.0v 34.745n 0.0v 34.755n 0.0v 39.745n 0.0v 39.755n 1.0v 44.745n 1.0v 44.755n 1.0v 49.745n 1.0v 49.755n 0.0v 54.745n 0.0v 54.755n 0.0v 59.745n 0.0v 59.755n 0.0v 64.745n 0.0v 64.755n 1.0v 69.745n 1.0v 69.755n 1.0v 74.745n 1.0v 74.755n 1.0v 79.745n 1.0v 79.755n 1.0v 84.745n 1.0v 84.755n 1.0v 89.745n 1.0v 89.755n 1.0v 94.745n 1.0v 94.755n 1.0v 99.745n 1.0v 99.755n 0.0v 104.745n 0.0v 104.755n 0.0v 109.745n 0.0v 109.755n 0.0v 114.745n 0.0v 114.755n 0.0v 119.745n 0.0v 119.755n 0.0v 124.745n 0.0v 124.755n 0.0v 129.745n 0.0v 129.755n 0.0v 134.745n 0.0v 134.755n 0.0v 139.745n 0.0v 139.755n 0.0v 144.745n 0.0v 144.755n 0.0v 149.745n 0.0v 149.755n 0.0v 154.745n 0.0v 154.755n 1.0v 159.745n 1.0v 159.755n 1.0v 164.745n 1.0v 164.755n 1.0v 169.745n 1.0v 169.755n 1.0v 174.745n 1.0v 174.755n 0.0v 179.745n 0.0v 179.755n 0.0v 184.745n 0.0v 184.755n 0.0v 189.745n 0.0v 189.755n 0.0v 194.745n 0.0v 194.755n 1.0v 199.745n 1.0v 199.755n 1.0v 204.745n 1.0v 204.755n 1.0v 209.745n 1.0v 209.755n 1.0v 214.745n 1.0v 214.755n 1.0v 219.745n 1.0v 219.755n 1.0v 224.745n 1.0v 224.755n 1.0v 229.745n 1.0v 229.755n 1.0v 234.745n 1.0v 234.755n 1.0v 239.745n 1.0v 239.755n 1.0v 244.745n 1.0v 244.755n 0.0v 249.745n 0.0v 249.755n 0.0v 254.745n 0.0v 254.755n 0.0v 259.745n 0.0v 259.755n 0.0v 264.745n 0.0v 264.755n 0.0v 269.745n 0.0v 269.755n 0.0v 274.745n 0.0v 274.755n 0.0v 279.745n 0.0v 279.755n 0.0v 284.745n 0.0v 284.755n 0.0v 289.745n 0.0v 289.755n 0.0v 294.745n 0.0v 294.755n 0.0v 299.745n 0.0v 299.755n 0.0v 304.745n 0.0v 304.755n 0.0v 309.745n 0.0v 309.755n 0.0v 314.745n 0.0v 314.755n 0.0v 319.745n 0.0v 319.755n 0.0v 324.745n 0.0v 324.755n 0.0v 329.745n 0.0v 329.755n 0.0v 334.745n 0.0v 334.755n 1.0v 339.745n 1.0v 339.755n 1.0v 344.745n 1.0v 344.755n 1.0v 349.745n 1.0v 349.755n 1.0v 354.745n 1.0v 354.755n 1.0v 359.745n 1.0v 359.755n 1.0v 364.745n 1.0v 364.755n 1.0v 369.745n 1.0v 369.755n 1.0v 374.745n 1.0v 374.755n 1.0v 379.745n 1.0v 379.755n 1.0v 384.745n 1.0v 384.755n 1.0v 389.745n 1.0v 389.755n 1.0v 394.745n 1.0v 394.755n 1.0v 399.745n 1.0v 399.755n 1.0v 404.745n 1.0v 404.755n 1.0v 409.745n 1.0v 409.755n 0.0v 414.745n 0.0v 414.755n 0.0v 419.745n 0.0v 419.755n 0.0v 424.745n 0.0v 424.755n 0.0v 429.745n 0.0v 429.755n 0.0v 434.745n 0.0v 434.755n 1.0v 439.745n 1.0v 439.755n 1.0v 444.745n 1.0v 444.755n 0.0v 449.745n 0.0v 449.755n 0.0v 454.745n 0.0v 454.755n 0.0v 459.745n 0.0v 459.755n 0.0v 464.745n 0.0v 464.755n 0.0v 469.745n 0.0v 469.755n 0.0v 474.745n 0.0v 474.755n 0.0v 479.745n 0.0v 479.755n 0.0v 484.745n 0.0v 484.755n 0.0v 489.745n 0.0v 489.755n 0.0v 494.745n 0.0v 494.755n 0.0v 499.745n 0.0v 499.755n 0.0v 504.745n 0.0v 504.755n 0.0v 509.745n 0.0v 509.755n 0.0v 514.745n 0.0v 514.755n 1.0v 519.745n 1.0v 519.755n 1.0v 524.745n 1.0v 524.755n 1.0v 529.745n 1.0v 529.755n 1.0v 534.745n 1.0v 534.755n 0.0v 539.745n 0.0v 539.755n 1.0v 544.745n 1.0v 544.755n 1.0v 549.745n 1.0v 549.755n 1.0v 554.745n 1.0v 554.755n 1.0v 559.745n 1.0v 559.755n 1.0v 564.745n 1.0v 564.755n 1.0v 569.745n 1.0v 569.755n 1.0v 574.745n 1.0v 574.755n 1.0v 579.745n 1.0v 579.755n 1.0v 584.745n 1.0v 584.755n 1.0v 589.745n 1.0v 589.755n 1.0v 594.745n 1.0v 594.755n 1.0v 599.745n 1.0v 599.755n 1.0v 604.745n 1.0v 604.755n 1.0v 609.745n 1.0v 609.755n 1.0v 614.745n 1.0v 614.755n 1.0v 619.745n 1.0v 619.755n 0.0v 624.745n 0.0v 624.755n 0.0v 629.745n 0.0v 629.755n 0.0v 634.745n 0.0v 634.755n 1.0v 639.745n 1.0v 639.755n 1.0v 644.745n 1.0v 644.755n 1.0v 649.745n 1.0v 649.755n 1.0v 654.745n 1.0v 654.755n 1.0v 659.745n 1.0v 659.755n 1.0v 664.745n 1.0v 664.755n 1.0v 669.745n 1.0v 669.755n 0.0v 674.745n 0.0v 674.755n 0.0v 679.745n 0.0v 679.755n 0.0v 684.745n 0.0v 684.755n 0.0v 689.745n 0.0v 689.755n 0.0v 694.745n 0.0v 694.755n 0.0v 699.745n 0.0v 699.755n 0.0v 704.745n 0.0v 704.755n 0.0v 709.745n 0.0v 709.755n 0.0v 714.745n 0.0v 714.755n 0.0v 719.745n 0.0v 719.755n 1.0v 724.745n 1.0v 724.755n 1.0v 729.745n 1.0v 729.755n 1.0v 734.745n 1.0v 734.755n 1.0v 739.745n 1.0v 739.755n 0.0v 744.745n 0.0v 744.755n 0.0v 749.745n 0.0v 749.755n 0.0v 754.745n 0.0v 754.755n 0.0v 759.745n 0.0v 759.755n 0.0v 764.745n 0.0v 764.755n 0.0v 769.745n 0.0v 769.755n 1.0v 774.745n 1.0v 774.755n 1.0v 779.745n 1.0v 779.755n 1.0v 784.745n 1.0v 784.755n 1.0v 789.745n 1.0v 789.755n 1.0v 794.745n 1.0v 794.755n 1.0v 799.745n 1.0v 799.755n 1.0v 804.745n 1.0v 804.755n 1.0v 809.745n 1.0v 809.755n 1.0v 814.745n 1.0v 814.755n 1.0v 819.745n 1.0v 819.755n 1.0v 824.745n 1.0v 824.755n 1.0v 829.745n 1.0v 829.755n 1.0v 834.745n 1.0v 834.755n 1.0v 839.745n 1.0v 839.755n 1.0v 844.745n 1.0v 844.755n 1.0v 849.745n 1.0v 849.755n 0.0v 854.745n 0.0v 854.755n 1.0v 859.745n 1.0v 859.755n 1.0v 864.745n 1.0v 864.755n 0.0v 869.745n 0.0v 869.755n 0.0v 874.745n 0.0v 874.755n 0.0v 879.745n 0.0v 879.755n 0.0v 884.745n 0.0v 884.755n 0.0v 889.745n 0.0v 889.755n 0.0v 894.745n 0.0v 894.755n 0.0v 899.745n 0.0v 899.755n 0.0v 904.745n 0.0v 904.755n 0.0v 909.745n 0.0v 909.755n 1.0v 914.745n 1.0v 914.755n 0.0v 919.745n 0.0v 919.755n 0.0v 924.745n 0.0v 924.755n 0.0v 929.745n 0.0v 929.755n 1.0v 934.745n 1.0v 934.755n 1.0v 939.745n 1.0v 939.755n 1.0v 944.745n 1.0v 944.755n 1.0v 949.745n 1.0v 949.755n 1.0v 954.745n 1.0v 954.755n 1.0v 959.745n 1.0v 959.755n 1.0v 964.745n 1.0v 964.755n 0.0v 969.745n 0.0v 969.755n 0.0v 974.745n 0.0v 974.755n 0.0v 979.745n 0.0v 979.755n 0.0v 984.745n 0.0v 984.755n 0.0v 989.745n 0.0v 989.755n 0.0v 994.745n 0.0v 994.755n 0.0v 999.745n 0.0v 999.755n 0.0v 1004.745n 0.0v 1004.755n 0.0v 1009.745n 0.0v 1009.755n 0.0v 1014.745n 0.0v 1014.755n 0.0v 1019.745n 0.0v 1019.755n 1.0v 1024.745n 1.0v 1024.755n 1.0v )
* (time, data): [(0, 0), (5, 1), (10, 0), (15, 1), (20, 1), (25, 1), (30, 1), (35, 1), (40, 0), (45, 0), (50, 0), (55, 0), (60, 0), (65, 1), (70, 1), (75, 1), (80, 1), (85, 1), (90, 1), (95, 1), (100, 1), (105, 0), (110, 0), (115, 1), (120, 1), (125, 1), (130, 1), (135, 1), (140, 1), (145, 1), (150, 1), (155, 0), (160, 0), (165, 0), (170, 0), (175, 1), (180, 1), (185, 1), (190, 0), (195, 1), (200, 1), (205, 1), (210, 1), (215, 1), (220, 1), (225, 1), (230, 1), (235, 1), (240, 1), (245, 0), (250, 0), (255, 0), (260, 0), (265, 0), (270, 0), (275, 0), (280, 0), (285, 0), (290, 0), (295, 0), (300, 0), (305, 0), (310, 0), (315, 0), (320, 0), (325, 0), (330, 0), (335, 0), (340, 0), (345, 0), (350, 1), (355, 1), (360, 1), (365, 1), (370, 1), (375, 1), (380, 1), (385, 1), (390, 1), (395, 1), (400, 1), (405, 1), (410, 0), (415, 0), (420, 0), (425, 0), (430, 0), (435, 0), (440, 0), (445, 1), (450, 1), (455, 1), (460, 1), (465, 1), (470, 1), (475, 1), (480, 1), (485, 1), (490, 1), (495, 1), (500, 1), (505, 1), (510, 1), (515, 1), (520, 1), (525, 1), (530, 1), (535, 0), (540, 0), (545, 1), (550, 1), (555, 1), (560, 0), (565, 0), (570, 0), (575, 0), (580, 0), (585, 0), (590, 0), (595, 0), (600, 1), (605, 1), (610, 0), (615, 0), (620, 0), (625, 0), (630, 0), (635, 0), (640, 0), (645, 1), (650, 0), (655, 1), (660, 1), (665, 1), (670, 1), (675, 1), (680, 1), (685, 1), (690, 1), (695, 1), (700, 1), (705, 1), (710, 1), (715, 1), (720, 1), (725, 1), (730, 1), (735, 1), (740, 1), (745, 1), (750, 1), (755, 1), (760, 1), (765, 1), (770, 0), (775, 0), (780, 1), (785, 1), (790, 1), (795, 1), (800, 1), (805, 1), (810, 1), (815, 1), (820, 1), (825, 1), (830, 1), (835, 1), (840, 0), (845, 0), (850, 1), (855, 0), (860, 0), (865, 1), (870, 1), (875, 1), (880, 1), (885, 1), (890, 1), (895, 1), (900, 1), (905, 1), (910, 0), (915, 0), (920, 0), (925, 0), (930, 1), (935, 1), (940, 1), (945, 1), (950, 1), (955, 1), (960, 1), (965, 0), (970, 0), (975, 0), (980, 0), (985, 0), (990, 0), (995, 0), (1000, 0), (1005, 0), (1010, 0), (1015, 0), (1020, 1), (1025, 1)]
Vdin0_18  din0_18  0 PWL (0n 0.0v 4.745n 0.0v 4.755n 1.0v 9.745n 1.0v 9.755n 0.0v 14.745n 0.0v 14.755n 1.0v 19.745n 1.0v 19.755n 1.0v 24.745n 1.0v 24.755n 1.0v 29.745n 1.0v 29.755n 1.0v 34.745n 1.0v 34.755n 1.0v 39.745n 1.0v 39.755n 0.0v 44.745n 0.0v 44.755n 0.0v 49.745n 0.0v 49.755n 0.0v 54.745n 0.0v 54.755n 0.0v 59.745n 0.0v 59.755n 0.0v 64.745n 0.0v 64.755n 1.0v 69.745n 1.0v 69.755n 1.0v 74.745n 1.0v 74.755n 1.0v 79.745n 1.0v 79.755n 1.0v 84.745n 1.0v 84.755n 1.0v 89.745n 1.0v 89.755n 1.0v 94.745n 1.0v 94.755n 1.0v 99.745n 1.0v 99.755n 1.0v 104.745n 1.0v 104.755n 0.0v 109.745n 0.0v 109.755n 0.0v 114.745n 0.0v 114.755n 1.0v 119.745n 1.0v 119.755n 1.0v 124.745n 1.0v 124.755n 1.0v 129.745n 1.0v 129.755n 1.0v 134.745n 1.0v 134.755n 1.0v 139.745n 1.0v 139.755n 1.0v 144.745n 1.0v 144.755n 1.0v 149.745n 1.0v 149.755n 1.0v 154.745n 1.0v 154.755n 0.0v 159.745n 0.0v 159.755n 0.0v 164.745n 0.0v 164.755n 0.0v 169.745n 0.0v 169.755n 0.0v 174.745n 0.0v 174.755n 1.0v 179.745n 1.0v 179.755n 1.0v 184.745n 1.0v 184.755n 1.0v 189.745n 1.0v 189.755n 0.0v 194.745n 0.0v 194.755n 1.0v 199.745n 1.0v 199.755n 1.0v 204.745n 1.0v 204.755n 1.0v 209.745n 1.0v 209.755n 1.0v 214.745n 1.0v 214.755n 1.0v 219.745n 1.0v 219.755n 1.0v 224.745n 1.0v 224.755n 1.0v 229.745n 1.0v 229.755n 1.0v 234.745n 1.0v 234.755n 1.0v 239.745n 1.0v 239.755n 1.0v 244.745n 1.0v 244.755n 0.0v 249.745n 0.0v 249.755n 0.0v 254.745n 0.0v 254.755n 0.0v 259.745n 0.0v 259.755n 0.0v 264.745n 0.0v 264.755n 0.0v 269.745n 0.0v 269.755n 0.0v 274.745n 0.0v 274.755n 0.0v 279.745n 0.0v 279.755n 0.0v 284.745n 0.0v 284.755n 0.0v 289.745n 0.0v 289.755n 0.0v 294.745n 0.0v 294.755n 0.0v 299.745n 0.0v 299.755n 0.0v 304.745n 0.0v 304.755n 0.0v 309.745n 0.0v 309.755n 0.0v 314.745n 0.0v 314.755n 0.0v 319.745n 0.0v 319.755n 0.0v 324.745n 0.0v 324.755n 0.0v 329.745n 0.0v 329.755n 0.0v 334.745n 0.0v 334.755n 0.0v 339.745n 0.0v 339.755n 0.0v 344.745n 0.0v 344.755n 0.0v 349.745n 0.0v 349.755n 1.0v 354.745n 1.0v 354.755n 1.0v 359.745n 1.0v 359.755n 1.0v 364.745n 1.0v 364.755n 1.0v 369.745n 1.0v 369.755n 1.0v 374.745n 1.0v 374.755n 1.0v 379.745n 1.0v 379.755n 1.0v 384.745n 1.0v 384.755n 1.0v 389.745n 1.0v 389.755n 1.0v 394.745n 1.0v 394.755n 1.0v 399.745n 1.0v 399.755n 1.0v 404.745n 1.0v 404.755n 1.0v 409.745n 1.0v 409.755n 0.0v 414.745n 0.0v 414.755n 0.0v 419.745n 0.0v 419.755n 0.0v 424.745n 0.0v 424.755n 0.0v 429.745n 0.0v 429.755n 0.0v 434.745n 0.0v 434.755n 0.0v 439.745n 0.0v 439.755n 0.0v 444.745n 0.0v 444.755n 1.0v 449.745n 1.0v 449.755n 1.0v 454.745n 1.0v 454.755n 1.0v 459.745n 1.0v 459.755n 1.0v 464.745n 1.0v 464.755n 1.0v 469.745n 1.0v 469.755n 1.0v 474.745n 1.0v 474.755n 1.0v 479.745n 1.0v 479.755n 1.0v 484.745n 1.0v 484.755n 1.0v 489.745n 1.0v 489.755n 1.0v 494.745n 1.0v 494.755n 1.0v 499.745n 1.0v 499.755n 1.0v 504.745n 1.0v 504.755n 1.0v 509.745n 1.0v 509.755n 1.0v 514.745n 1.0v 514.755n 1.0v 519.745n 1.0v 519.755n 1.0v 524.745n 1.0v 524.755n 1.0v 529.745n 1.0v 529.755n 1.0v 534.745n 1.0v 534.755n 0.0v 539.745n 0.0v 539.755n 0.0v 544.745n 0.0v 544.755n 1.0v 549.745n 1.0v 549.755n 1.0v 554.745n 1.0v 554.755n 1.0v 559.745n 1.0v 559.755n 0.0v 564.745n 0.0v 564.755n 0.0v 569.745n 0.0v 569.755n 0.0v 574.745n 0.0v 574.755n 0.0v 579.745n 0.0v 579.755n 0.0v 584.745n 0.0v 584.755n 0.0v 589.745n 0.0v 589.755n 0.0v 594.745n 0.0v 594.755n 0.0v 599.745n 0.0v 599.755n 1.0v 604.745n 1.0v 604.755n 1.0v 609.745n 1.0v 609.755n 0.0v 614.745n 0.0v 614.755n 0.0v 619.745n 0.0v 619.755n 0.0v 624.745n 0.0v 624.755n 0.0v 629.745n 0.0v 629.755n 0.0v 634.745n 0.0v 634.755n 0.0v 639.745n 0.0v 639.755n 0.0v 644.745n 0.0v 644.755n 1.0v 649.745n 1.0v 649.755n 0.0v 654.745n 0.0v 654.755n 1.0v 659.745n 1.0v 659.755n 1.0v 664.745n 1.0v 664.755n 1.0v 669.745n 1.0v 669.755n 1.0v 674.745n 1.0v 674.755n 1.0v 679.745n 1.0v 679.755n 1.0v 684.745n 1.0v 684.755n 1.0v 689.745n 1.0v 689.755n 1.0v 694.745n 1.0v 694.755n 1.0v 699.745n 1.0v 699.755n 1.0v 704.745n 1.0v 704.755n 1.0v 709.745n 1.0v 709.755n 1.0v 714.745n 1.0v 714.755n 1.0v 719.745n 1.0v 719.755n 1.0v 724.745n 1.0v 724.755n 1.0v 729.745n 1.0v 729.755n 1.0v 734.745n 1.0v 734.755n 1.0v 739.745n 1.0v 739.755n 1.0v 744.745n 1.0v 744.755n 1.0v 749.745n 1.0v 749.755n 1.0v 754.745n 1.0v 754.755n 1.0v 759.745n 1.0v 759.755n 1.0v 764.745n 1.0v 764.755n 1.0v 769.745n 1.0v 769.755n 0.0v 774.745n 0.0v 774.755n 0.0v 779.745n 0.0v 779.755n 1.0v 784.745n 1.0v 784.755n 1.0v 789.745n 1.0v 789.755n 1.0v 794.745n 1.0v 794.755n 1.0v 799.745n 1.0v 799.755n 1.0v 804.745n 1.0v 804.755n 1.0v 809.745n 1.0v 809.755n 1.0v 814.745n 1.0v 814.755n 1.0v 819.745n 1.0v 819.755n 1.0v 824.745n 1.0v 824.755n 1.0v 829.745n 1.0v 829.755n 1.0v 834.745n 1.0v 834.755n 1.0v 839.745n 1.0v 839.755n 0.0v 844.745n 0.0v 844.755n 0.0v 849.745n 0.0v 849.755n 1.0v 854.745n 1.0v 854.755n 0.0v 859.745n 0.0v 859.755n 0.0v 864.745n 0.0v 864.755n 1.0v 869.745n 1.0v 869.755n 1.0v 874.745n 1.0v 874.755n 1.0v 879.745n 1.0v 879.755n 1.0v 884.745n 1.0v 884.755n 1.0v 889.745n 1.0v 889.755n 1.0v 894.745n 1.0v 894.755n 1.0v 899.745n 1.0v 899.755n 1.0v 904.745n 1.0v 904.755n 1.0v 909.745n 1.0v 909.755n 0.0v 914.745n 0.0v 914.755n 0.0v 919.745n 0.0v 919.755n 0.0v 924.745n 0.0v 924.755n 0.0v 929.745n 0.0v 929.755n 1.0v 934.745n 1.0v 934.755n 1.0v 939.745n 1.0v 939.755n 1.0v 944.745n 1.0v 944.755n 1.0v 949.745n 1.0v 949.755n 1.0v 954.745n 1.0v 954.755n 1.0v 959.745n 1.0v 959.755n 1.0v 964.745n 1.0v 964.755n 0.0v 969.745n 0.0v 969.755n 0.0v 974.745n 0.0v 974.755n 0.0v 979.745n 0.0v 979.755n 0.0v 984.745n 0.0v 984.755n 0.0v 989.745n 0.0v 989.755n 0.0v 994.745n 0.0v 994.755n 0.0v 999.745n 0.0v 999.755n 0.0v 1004.745n 0.0v 1004.755n 0.0v 1009.745n 0.0v 1009.755n 0.0v 1014.745n 0.0v 1014.755n 0.0v 1019.745n 0.0v 1019.755n 1.0v 1024.745n 1.0v 1024.755n 1.0v )
* (time, data): [(0, 0), (5, 0), (10, 0), (15, 1), (20, 1), (25, 1), (30, 1), (35, 1), (40, 0), (45, 0), (50, 0), (55, 0), (60, 0), (65, 0), (70, 0), (75, 0), (80, 0), (85, 1), (90, 1), (95, 1), (100, 0), (105, 1), (110, 1), (115, 1), (120, 1), (125, 1), (130, 1), (135, 1), (140, 1), (145, 1), (150, 1), (155, 0), (160, 0), (165, 0), (170, 0), (175, 1), (180, 1), (185, 1), (190, 0), (195, 1), (200, 1), (205, 1), (210, 1), (215, 1), (220, 1), (225, 1), (230, 1), (235, 1), (240, 1), (245, 1), (250, 1), (255, 1), (260, 1), (265, 1), (270, 1), (275, 1), (280, 1), (285, 1), (290, 0), (295, 0), (300, 0), (305, 0), (310, 0), (315, 0), (320, 0), (325, 0), (330, 0), (335, 0), (340, 0), (345, 0), (350, 1), (355, 1), (360, 1), (365, 1), (370, 1), (375, 1), (380, 1), (385, 1), (390, 1), (395, 1), (400, 1), (405, 1), (410, 0), (415, 0), (420, 0), (425, 0), (430, 0), (435, 0), (440, 0), (445, 0), (450, 0), (455, 0), (460, 0), (465, 0), (470, 0), (475, 0), (480, 0), (485, 1), (490, 0), (495, 0), (500, 1), (505, 1), (510, 1), (515, 1), (520, 1), (525, 1), (530, 1), (535, 0), (540, 1), (545, 1), (550, 1), (555, 1), (560, 1), (565, 1), (570, 1), (575, 1), (580, 1), (585, 1), (590, 1), (595, 1), (600, 1), (605, 1), (610, 0), (615, 0), (620, 1), (625, 1), (630, 1), (635, 1), (640, 1), (645, 1), (650, 1), (655, 0), (660, 0), (665, 0), (670, 1), (675, 1), (680, 1), (685, 1), (690, 1), (695, 1), (700, 1), (705, 1), (710, 1), (715, 1), (720, 1), (725, 1), (730, 1), (735, 1), (740, 1), (745, 1), (750, 1), (755, 1), (760, 1), (765, 1), (770, 0), (775, 0), (780, 0), (785, 0), (790, 0), (795, 0), (800, 0), (805, 1), (810, 1), (815, 1), (820, 1), (825, 1), (830, 1), (835, 1), (840, 0), (845, 0), (850, 0), (855, 1), (860, 1), (865, 1), (870, 0), (875, 0), (880, 0), (885, 0), (890, 0), (895, 0), (900, 0), (905, 0), (910, 1), (915, 0), (920, 0), (925, 0), (930, 0), (935, 0), (940, 0), (945, 0), (950, 0), (955, 0), (960, 0), (965, 0), (970, 0), (975, 0), (980, 0), (985, 0), (990, 0), (995, 0), (1000, 0), (1005, 0), (1010, 0), (1015, 0), (1020, 1), (1025, 1)]
Vdin0_19  din0_19  0 PWL (0n 0.0v 4.745n 0.0v 4.755n 0.0v 9.745n 0.0v 9.755n 0.0v 14.745n 0.0v 14.755n 1.0v 19.745n 1.0v 19.755n 1.0v 24.745n 1.0v 24.755n 1.0v 29.745n 1.0v 29.755n 1.0v 34.745n 1.0v 34.755n 1.0v 39.745n 1.0v 39.755n 0.0v 44.745n 0.0v 44.755n 0.0v 49.745n 0.0v 49.755n 0.0v 54.745n 0.0v 54.755n 0.0v 59.745n 0.0v 59.755n 0.0v 64.745n 0.0v 64.755n 0.0v 69.745n 0.0v 69.755n 0.0v 74.745n 0.0v 74.755n 0.0v 79.745n 0.0v 79.755n 0.0v 84.745n 0.0v 84.755n 1.0v 89.745n 1.0v 89.755n 1.0v 94.745n 1.0v 94.755n 1.0v 99.745n 1.0v 99.755n 0.0v 104.745n 0.0v 104.755n 1.0v 109.745n 1.0v 109.755n 1.0v 114.745n 1.0v 114.755n 1.0v 119.745n 1.0v 119.755n 1.0v 124.745n 1.0v 124.755n 1.0v 129.745n 1.0v 129.755n 1.0v 134.745n 1.0v 134.755n 1.0v 139.745n 1.0v 139.755n 1.0v 144.745n 1.0v 144.755n 1.0v 149.745n 1.0v 149.755n 1.0v 154.745n 1.0v 154.755n 0.0v 159.745n 0.0v 159.755n 0.0v 164.745n 0.0v 164.755n 0.0v 169.745n 0.0v 169.755n 0.0v 174.745n 0.0v 174.755n 1.0v 179.745n 1.0v 179.755n 1.0v 184.745n 1.0v 184.755n 1.0v 189.745n 1.0v 189.755n 0.0v 194.745n 0.0v 194.755n 1.0v 199.745n 1.0v 199.755n 1.0v 204.745n 1.0v 204.755n 1.0v 209.745n 1.0v 209.755n 1.0v 214.745n 1.0v 214.755n 1.0v 219.745n 1.0v 219.755n 1.0v 224.745n 1.0v 224.755n 1.0v 229.745n 1.0v 229.755n 1.0v 234.745n 1.0v 234.755n 1.0v 239.745n 1.0v 239.755n 1.0v 244.745n 1.0v 244.755n 1.0v 249.745n 1.0v 249.755n 1.0v 254.745n 1.0v 254.755n 1.0v 259.745n 1.0v 259.755n 1.0v 264.745n 1.0v 264.755n 1.0v 269.745n 1.0v 269.755n 1.0v 274.745n 1.0v 274.755n 1.0v 279.745n 1.0v 279.755n 1.0v 284.745n 1.0v 284.755n 1.0v 289.745n 1.0v 289.755n 0.0v 294.745n 0.0v 294.755n 0.0v 299.745n 0.0v 299.755n 0.0v 304.745n 0.0v 304.755n 0.0v 309.745n 0.0v 309.755n 0.0v 314.745n 0.0v 314.755n 0.0v 319.745n 0.0v 319.755n 0.0v 324.745n 0.0v 324.755n 0.0v 329.745n 0.0v 329.755n 0.0v 334.745n 0.0v 334.755n 0.0v 339.745n 0.0v 339.755n 0.0v 344.745n 0.0v 344.755n 0.0v 349.745n 0.0v 349.755n 1.0v 354.745n 1.0v 354.755n 1.0v 359.745n 1.0v 359.755n 1.0v 364.745n 1.0v 364.755n 1.0v 369.745n 1.0v 369.755n 1.0v 374.745n 1.0v 374.755n 1.0v 379.745n 1.0v 379.755n 1.0v 384.745n 1.0v 384.755n 1.0v 389.745n 1.0v 389.755n 1.0v 394.745n 1.0v 394.755n 1.0v 399.745n 1.0v 399.755n 1.0v 404.745n 1.0v 404.755n 1.0v 409.745n 1.0v 409.755n 0.0v 414.745n 0.0v 414.755n 0.0v 419.745n 0.0v 419.755n 0.0v 424.745n 0.0v 424.755n 0.0v 429.745n 0.0v 429.755n 0.0v 434.745n 0.0v 434.755n 0.0v 439.745n 0.0v 439.755n 0.0v 444.745n 0.0v 444.755n 0.0v 449.745n 0.0v 449.755n 0.0v 454.745n 0.0v 454.755n 0.0v 459.745n 0.0v 459.755n 0.0v 464.745n 0.0v 464.755n 0.0v 469.745n 0.0v 469.755n 0.0v 474.745n 0.0v 474.755n 0.0v 479.745n 0.0v 479.755n 0.0v 484.745n 0.0v 484.755n 1.0v 489.745n 1.0v 489.755n 0.0v 494.745n 0.0v 494.755n 0.0v 499.745n 0.0v 499.755n 1.0v 504.745n 1.0v 504.755n 1.0v 509.745n 1.0v 509.755n 1.0v 514.745n 1.0v 514.755n 1.0v 519.745n 1.0v 519.755n 1.0v 524.745n 1.0v 524.755n 1.0v 529.745n 1.0v 529.755n 1.0v 534.745n 1.0v 534.755n 0.0v 539.745n 0.0v 539.755n 1.0v 544.745n 1.0v 544.755n 1.0v 549.745n 1.0v 549.755n 1.0v 554.745n 1.0v 554.755n 1.0v 559.745n 1.0v 559.755n 1.0v 564.745n 1.0v 564.755n 1.0v 569.745n 1.0v 569.755n 1.0v 574.745n 1.0v 574.755n 1.0v 579.745n 1.0v 579.755n 1.0v 584.745n 1.0v 584.755n 1.0v 589.745n 1.0v 589.755n 1.0v 594.745n 1.0v 594.755n 1.0v 599.745n 1.0v 599.755n 1.0v 604.745n 1.0v 604.755n 1.0v 609.745n 1.0v 609.755n 0.0v 614.745n 0.0v 614.755n 0.0v 619.745n 0.0v 619.755n 1.0v 624.745n 1.0v 624.755n 1.0v 629.745n 1.0v 629.755n 1.0v 634.745n 1.0v 634.755n 1.0v 639.745n 1.0v 639.755n 1.0v 644.745n 1.0v 644.755n 1.0v 649.745n 1.0v 649.755n 1.0v 654.745n 1.0v 654.755n 0.0v 659.745n 0.0v 659.755n 0.0v 664.745n 0.0v 664.755n 0.0v 669.745n 0.0v 669.755n 1.0v 674.745n 1.0v 674.755n 1.0v 679.745n 1.0v 679.755n 1.0v 684.745n 1.0v 684.755n 1.0v 689.745n 1.0v 689.755n 1.0v 694.745n 1.0v 694.755n 1.0v 699.745n 1.0v 699.755n 1.0v 704.745n 1.0v 704.755n 1.0v 709.745n 1.0v 709.755n 1.0v 714.745n 1.0v 714.755n 1.0v 719.745n 1.0v 719.755n 1.0v 724.745n 1.0v 724.755n 1.0v 729.745n 1.0v 729.755n 1.0v 734.745n 1.0v 734.755n 1.0v 739.745n 1.0v 739.755n 1.0v 744.745n 1.0v 744.755n 1.0v 749.745n 1.0v 749.755n 1.0v 754.745n 1.0v 754.755n 1.0v 759.745n 1.0v 759.755n 1.0v 764.745n 1.0v 764.755n 1.0v 769.745n 1.0v 769.755n 0.0v 774.745n 0.0v 774.755n 0.0v 779.745n 0.0v 779.755n 0.0v 784.745n 0.0v 784.755n 0.0v 789.745n 0.0v 789.755n 0.0v 794.745n 0.0v 794.755n 0.0v 799.745n 0.0v 799.755n 0.0v 804.745n 0.0v 804.755n 1.0v 809.745n 1.0v 809.755n 1.0v 814.745n 1.0v 814.755n 1.0v 819.745n 1.0v 819.755n 1.0v 824.745n 1.0v 824.755n 1.0v 829.745n 1.0v 829.755n 1.0v 834.745n 1.0v 834.755n 1.0v 839.745n 1.0v 839.755n 0.0v 844.745n 0.0v 844.755n 0.0v 849.745n 0.0v 849.755n 0.0v 854.745n 0.0v 854.755n 1.0v 859.745n 1.0v 859.755n 1.0v 864.745n 1.0v 864.755n 1.0v 869.745n 1.0v 869.755n 0.0v 874.745n 0.0v 874.755n 0.0v 879.745n 0.0v 879.755n 0.0v 884.745n 0.0v 884.755n 0.0v 889.745n 0.0v 889.755n 0.0v 894.745n 0.0v 894.755n 0.0v 899.745n 0.0v 899.755n 0.0v 904.745n 0.0v 904.755n 0.0v 909.745n 0.0v 909.755n 1.0v 914.745n 1.0v 914.755n 0.0v 919.745n 0.0v 919.755n 0.0v 924.745n 0.0v 924.755n 0.0v 929.745n 0.0v 929.755n 0.0v 934.745n 0.0v 934.755n 0.0v 939.745n 0.0v 939.755n 0.0v 944.745n 0.0v 944.755n 0.0v 949.745n 0.0v 949.755n 0.0v 954.745n 0.0v 954.755n 0.0v 959.745n 0.0v 959.755n 0.0v 964.745n 0.0v 964.755n 0.0v 969.745n 0.0v 969.755n 0.0v 974.745n 0.0v 974.755n 0.0v 979.745n 0.0v 979.755n 0.0v 984.745n 0.0v 984.755n 0.0v 989.745n 0.0v 989.755n 0.0v 994.745n 0.0v 994.755n 0.0v 999.745n 0.0v 999.755n 0.0v 1004.745n 0.0v 1004.755n 0.0v 1009.745n 0.0v 1009.755n 0.0v 1014.745n 0.0v 1014.755n 0.0v 1019.745n 0.0v 1019.755n 1.0v 1024.745n 1.0v 1024.755n 1.0v )
* (time, data): [(0, 0), (5, 1), (10, 0), (15, 1), (20, 1), (25, 1), (30, 0), (35, 0), (40, 0), (45, 0), (50, 0), (55, 0), (60, 0), (65, 0), (70, 0), (75, 0), (80, 0), (85, 1), (90, 1), (95, 1), (100, 1), (105, 0), (110, 0), (115, 0), (120, 0), (125, 0), (130, 0), (135, 0), (140, 0), (145, 0), (150, 0), (155, 1), (160, 1), (165, 1), (170, 1), (175, 1), (180, 1), (185, 1), (190, 0), (195, 0), (200, 0), (205, 0), (210, 0), (215, 0), (220, 0), (225, 0), (230, 0), (235, 0), (240, 0), (245, 1), (250, 1), (255, 1), (260, 1), (265, 1), (270, 1), (275, 1), (280, 1), (285, 1), (290, 1), (295, 1), (300, 1), (305, 1), (310, 1), (315, 1), (320, 1), (325, 1), (330, 1), (335, 1), (340, 1), (345, 1), (350, 1), (355, 1), (360, 1), (365, 1), (370, 1), (375, 1), (380, 1), (385, 1), (390, 1), (395, 1), (400, 1), (405, 1), (410, 1), (415, 1), (420, 1), (425, 1), (430, 1), (435, 0), (440, 0), (445, 0), (450, 0), (455, 0), (460, 0), (465, 0), (470, 0), (475, 0), (480, 0), (485, 0), (490, 1), (495, 1), (500, 1), (505, 1), (510, 1), (515, 0), (520, 0), (525, 0), (530, 0), (535, 1), (540, 0), (545, 0), (550, 1), (555, 1), (560, 0), (565, 0), (570, 0), (575, 0), (580, 0), (585, 0), (590, 0), (595, 0), (600, 1), (605, 1), (610, 1), (615, 1), (620, 0), (625, 0), (630, 0), (635, 1), (640, 1), (645, 1), (650, 0), (655, 0), (660, 0), (665, 0), (670, 1), (675, 1), (680, 1), (685, 1), (690, 1), (695, 1), (700, 1), (705, 1), (710, 1), (715, 1), (720, 1), (725, 1), (730, 1), (735, 1), (740, 0), (745, 0), (750, 0), (755, 0), (760, 0), (765, 0), (770, 0), (775, 0), (780, 0), (785, 0), (790, 0), (795, 0), (800, 0), (805, 0), (810, 1), (815, 1), (820, 1), (825, 1), (830, 1), (835, 1), (840, 1), (845, 1), (850, 0), (855, 1), (860, 1), (865, 1), (870, 0), (875, 0), (880, 0), (885, 0), (890, 0), (895, 0), (900, 0), (905, 0), (910, 0), (915, 1), (920, 1), (925, 1), (930, 1), (935, 1), (940, 1), (945, 1), (950, 1), (955, 1), (960, 1), (965, 0), (970, 0), (975, 0), (980, 0), (985, 0), (990, 0), (995, 0), (1000, 0), (1005, 0), (1010, 0), (1015, 0), (1020, 1), (1025, 1)]
Vdin0_20  din0_20  0 PWL (0n 0.0v 4.745n 0.0v 4.755n 1.0v 9.745n 1.0v 9.755n 0.0v 14.745n 0.0v 14.755n 1.0v 19.745n 1.0v 19.755n 1.0v 24.745n 1.0v 24.755n 1.0v 29.745n 1.0v 29.755n 0.0v 34.745n 0.0v 34.755n 0.0v 39.745n 0.0v 39.755n 0.0v 44.745n 0.0v 44.755n 0.0v 49.745n 0.0v 49.755n 0.0v 54.745n 0.0v 54.755n 0.0v 59.745n 0.0v 59.755n 0.0v 64.745n 0.0v 64.755n 0.0v 69.745n 0.0v 69.755n 0.0v 74.745n 0.0v 74.755n 0.0v 79.745n 0.0v 79.755n 0.0v 84.745n 0.0v 84.755n 1.0v 89.745n 1.0v 89.755n 1.0v 94.745n 1.0v 94.755n 1.0v 99.745n 1.0v 99.755n 1.0v 104.745n 1.0v 104.755n 0.0v 109.745n 0.0v 109.755n 0.0v 114.745n 0.0v 114.755n 0.0v 119.745n 0.0v 119.755n 0.0v 124.745n 0.0v 124.755n 0.0v 129.745n 0.0v 129.755n 0.0v 134.745n 0.0v 134.755n 0.0v 139.745n 0.0v 139.755n 0.0v 144.745n 0.0v 144.755n 0.0v 149.745n 0.0v 149.755n 0.0v 154.745n 0.0v 154.755n 1.0v 159.745n 1.0v 159.755n 1.0v 164.745n 1.0v 164.755n 1.0v 169.745n 1.0v 169.755n 1.0v 174.745n 1.0v 174.755n 1.0v 179.745n 1.0v 179.755n 1.0v 184.745n 1.0v 184.755n 1.0v 189.745n 1.0v 189.755n 0.0v 194.745n 0.0v 194.755n 0.0v 199.745n 0.0v 199.755n 0.0v 204.745n 0.0v 204.755n 0.0v 209.745n 0.0v 209.755n 0.0v 214.745n 0.0v 214.755n 0.0v 219.745n 0.0v 219.755n 0.0v 224.745n 0.0v 224.755n 0.0v 229.745n 0.0v 229.755n 0.0v 234.745n 0.0v 234.755n 0.0v 239.745n 0.0v 239.755n 0.0v 244.745n 0.0v 244.755n 1.0v 249.745n 1.0v 249.755n 1.0v 254.745n 1.0v 254.755n 1.0v 259.745n 1.0v 259.755n 1.0v 264.745n 1.0v 264.755n 1.0v 269.745n 1.0v 269.755n 1.0v 274.745n 1.0v 274.755n 1.0v 279.745n 1.0v 279.755n 1.0v 284.745n 1.0v 284.755n 1.0v 289.745n 1.0v 289.755n 1.0v 294.745n 1.0v 294.755n 1.0v 299.745n 1.0v 299.755n 1.0v 304.745n 1.0v 304.755n 1.0v 309.745n 1.0v 309.755n 1.0v 314.745n 1.0v 314.755n 1.0v 319.745n 1.0v 319.755n 1.0v 324.745n 1.0v 324.755n 1.0v 329.745n 1.0v 329.755n 1.0v 334.745n 1.0v 334.755n 1.0v 339.745n 1.0v 339.755n 1.0v 344.745n 1.0v 344.755n 1.0v 349.745n 1.0v 349.755n 1.0v 354.745n 1.0v 354.755n 1.0v 359.745n 1.0v 359.755n 1.0v 364.745n 1.0v 364.755n 1.0v 369.745n 1.0v 369.755n 1.0v 374.745n 1.0v 374.755n 1.0v 379.745n 1.0v 379.755n 1.0v 384.745n 1.0v 384.755n 1.0v 389.745n 1.0v 389.755n 1.0v 394.745n 1.0v 394.755n 1.0v 399.745n 1.0v 399.755n 1.0v 404.745n 1.0v 404.755n 1.0v 409.745n 1.0v 409.755n 1.0v 414.745n 1.0v 414.755n 1.0v 419.745n 1.0v 419.755n 1.0v 424.745n 1.0v 424.755n 1.0v 429.745n 1.0v 429.755n 1.0v 434.745n 1.0v 434.755n 0.0v 439.745n 0.0v 439.755n 0.0v 444.745n 0.0v 444.755n 0.0v 449.745n 0.0v 449.755n 0.0v 454.745n 0.0v 454.755n 0.0v 459.745n 0.0v 459.755n 0.0v 464.745n 0.0v 464.755n 0.0v 469.745n 0.0v 469.755n 0.0v 474.745n 0.0v 474.755n 0.0v 479.745n 0.0v 479.755n 0.0v 484.745n 0.0v 484.755n 0.0v 489.745n 0.0v 489.755n 1.0v 494.745n 1.0v 494.755n 1.0v 499.745n 1.0v 499.755n 1.0v 504.745n 1.0v 504.755n 1.0v 509.745n 1.0v 509.755n 1.0v 514.745n 1.0v 514.755n 0.0v 519.745n 0.0v 519.755n 0.0v 524.745n 0.0v 524.755n 0.0v 529.745n 0.0v 529.755n 0.0v 534.745n 0.0v 534.755n 1.0v 539.745n 1.0v 539.755n 0.0v 544.745n 0.0v 544.755n 0.0v 549.745n 0.0v 549.755n 1.0v 554.745n 1.0v 554.755n 1.0v 559.745n 1.0v 559.755n 0.0v 564.745n 0.0v 564.755n 0.0v 569.745n 0.0v 569.755n 0.0v 574.745n 0.0v 574.755n 0.0v 579.745n 0.0v 579.755n 0.0v 584.745n 0.0v 584.755n 0.0v 589.745n 0.0v 589.755n 0.0v 594.745n 0.0v 594.755n 0.0v 599.745n 0.0v 599.755n 1.0v 604.745n 1.0v 604.755n 1.0v 609.745n 1.0v 609.755n 1.0v 614.745n 1.0v 614.755n 1.0v 619.745n 1.0v 619.755n 0.0v 624.745n 0.0v 624.755n 0.0v 629.745n 0.0v 629.755n 0.0v 634.745n 0.0v 634.755n 1.0v 639.745n 1.0v 639.755n 1.0v 644.745n 1.0v 644.755n 1.0v 649.745n 1.0v 649.755n 0.0v 654.745n 0.0v 654.755n 0.0v 659.745n 0.0v 659.755n 0.0v 664.745n 0.0v 664.755n 0.0v 669.745n 0.0v 669.755n 1.0v 674.745n 1.0v 674.755n 1.0v 679.745n 1.0v 679.755n 1.0v 684.745n 1.0v 684.755n 1.0v 689.745n 1.0v 689.755n 1.0v 694.745n 1.0v 694.755n 1.0v 699.745n 1.0v 699.755n 1.0v 704.745n 1.0v 704.755n 1.0v 709.745n 1.0v 709.755n 1.0v 714.745n 1.0v 714.755n 1.0v 719.745n 1.0v 719.755n 1.0v 724.745n 1.0v 724.755n 1.0v 729.745n 1.0v 729.755n 1.0v 734.745n 1.0v 734.755n 1.0v 739.745n 1.0v 739.755n 0.0v 744.745n 0.0v 744.755n 0.0v 749.745n 0.0v 749.755n 0.0v 754.745n 0.0v 754.755n 0.0v 759.745n 0.0v 759.755n 0.0v 764.745n 0.0v 764.755n 0.0v 769.745n 0.0v 769.755n 0.0v 774.745n 0.0v 774.755n 0.0v 779.745n 0.0v 779.755n 0.0v 784.745n 0.0v 784.755n 0.0v 789.745n 0.0v 789.755n 0.0v 794.745n 0.0v 794.755n 0.0v 799.745n 0.0v 799.755n 0.0v 804.745n 0.0v 804.755n 0.0v 809.745n 0.0v 809.755n 1.0v 814.745n 1.0v 814.755n 1.0v 819.745n 1.0v 819.755n 1.0v 824.745n 1.0v 824.755n 1.0v 829.745n 1.0v 829.755n 1.0v 834.745n 1.0v 834.755n 1.0v 839.745n 1.0v 839.755n 1.0v 844.745n 1.0v 844.755n 1.0v 849.745n 1.0v 849.755n 0.0v 854.745n 0.0v 854.755n 1.0v 859.745n 1.0v 859.755n 1.0v 864.745n 1.0v 864.755n 1.0v 869.745n 1.0v 869.755n 0.0v 874.745n 0.0v 874.755n 0.0v 879.745n 0.0v 879.755n 0.0v 884.745n 0.0v 884.755n 0.0v 889.745n 0.0v 889.755n 0.0v 894.745n 0.0v 894.755n 0.0v 899.745n 0.0v 899.755n 0.0v 904.745n 0.0v 904.755n 0.0v 909.745n 0.0v 909.755n 0.0v 914.745n 0.0v 914.755n 1.0v 919.745n 1.0v 919.755n 1.0v 924.745n 1.0v 924.755n 1.0v 929.745n 1.0v 929.755n 1.0v 934.745n 1.0v 934.755n 1.0v 939.745n 1.0v 939.755n 1.0v 944.745n 1.0v 944.755n 1.0v 949.745n 1.0v 949.755n 1.0v 954.745n 1.0v 954.755n 1.0v 959.745n 1.0v 959.755n 1.0v 964.745n 1.0v 964.755n 0.0v 969.745n 0.0v 969.755n 0.0v 974.745n 0.0v 974.755n 0.0v 979.745n 0.0v 979.755n 0.0v 984.745n 0.0v 984.755n 0.0v 989.745n 0.0v 989.755n 0.0v 994.745n 0.0v 994.755n 0.0v 999.745n 0.0v 999.755n 0.0v 1004.745n 0.0v 1004.755n 0.0v 1009.745n 0.0v 1009.755n 0.0v 1014.745n 0.0v 1014.755n 0.0v 1019.745n 0.0v 1019.755n 1.0v 1024.745n 1.0v 1024.755n 1.0v )
* (time, data): [(0, 0), (5, 0), (10, 1), (15, 1), (20, 1), (25, 1), (30, 1), (35, 1), (40, 0), (45, 0), (50, 1), (55, 1), (60, 1), (65, 0), (70, 0), (75, 0), (80, 0), (85, 0), (90, 0), (95, 0), (100, 1), (105, 1), (110, 1), (115, 1), (120, 1), (125, 1), (130, 1), (135, 1), (140, 1), (145, 1), (150, 1), (155, 0), (160, 0), (165, 0), (170, 0), (175, 0), (180, 0), (185, 0), (190, 0), (195, 0), (200, 0), (205, 0), (210, 0), (215, 0), (220, 0), (225, 0), (230, 0), (235, 0), (240, 0), (245, 0), (250, 0), (255, 0), (260, 0), (265, 0), (270, 0), (275, 0), (280, 0), (285, 0), (290, 0), (295, 0), (300, 0), (305, 0), (310, 0), (315, 0), (320, 0), (325, 0), (330, 0), (335, 0), (340, 0), (345, 0), (350, 1), (355, 1), (360, 1), (365, 1), (370, 1), (375, 1), (380, 1), (385, 1), (390, 1), (395, 1), (400, 1), (405, 1), (410, 1), (415, 1), (420, 1), (425, 1), (430, 1), (435, 1), (440, 1), (445, 1), (450, 1), (455, 1), (460, 1), (465, 1), (470, 1), (475, 1), (480, 1), (485, 0), (490, 0), (495, 0), (500, 1), (505, 1), (510, 1), (515, 0), (520, 0), (525, 0), (530, 0), (535, 0), (540, 1), (545, 0), (550, 0), (555, 0), (560, 0), (565, 0), (570, 0), (575, 0), (580, 0), (585, 0), (590, 0), (595, 0), (600, 1), (605, 1), (610, 0), (615, 0), (620, 1), (625, 1), (630, 1), (635, 0), (640, 0), (645, 0), (650, 0), (655, 0), (660, 0), (665, 0), (670, 1), (675, 1), (680, 1), (685, 1), (690, 1), (695, 1), (700, 1), (705, 1), (710, 1), (715, 1), (720, 0), (725, 0), (730, 0), (735, 0), (740, 0), (745, 0), (750, 0), (755, 0), (760, 0), (765, 0), (770, 0), (775, 0), (780, 0), (785, 0), (790, 0), (795, 0), (800, 0), (805, 0), (810, 1), (815, 1), (820, 1), (825, 1), (830, 1), (835, 1), (840, 1), (845, 1), (850, 0), (855, 0), (860, 0), (865, 0), (870, 0), (875, 0), (880, 0), (885, 0), (890, 0), (895, 0), (900, 0), (905, 0), (910, 1), (915, 0), (920, 0), (925, 0), (930, 0), (935, 0), (940, 0), (945, 0), (950, 0), (955, 0), (960, 0), (965, 0), (970, 0), (975, 0), (980, 0), (985, 0), (990, 0), (995, 0), (1000, 0), (1005, 0), (1010, 0), (1015, 0), (1020, 1), (1025, 1)]
Vdin0_21  din0_21  0 PWL (0n 0.0v 4.745n 0.0v 4.755n 0.0v 9.745n 0.0v 9.755n 1.0v 14.745n 1.0v 14.755n 1.0v 19.745n 1.0v 19.755n 1.0v 24.745n 1.0v 24.755n 1.0v 29.745n 1.0v 29.755n 1.0v 34.745n 1.0v 34.755n 1.0v 39.745n 1.0v 39.755n 0.0v 44.745n 0.0v 44.755n 0.0v 49.745n 0.0v 49.755n 1.0v 54.745n 1.0v 54.755n 1.0v 59.745n 1.0v 59.755n 1.0v 64.745n 1.0v 64.755n 0.0v 69.745n 0.0v 69.755n 0.0v 74.745n 0.0v 74.755n 0.0v 79.745n 0.0v 79.755n 0.0v 84.745n 0.0v 84.755n 0.0v 89.745n 0.0v 89.755n 0.0v 94.745n 0.0v 94.755n 0.0v 99.745n 0.0v 99.755n 1.0v 104.745n 1.0v 104.755n 1.0v 109.745n 1.0v 109.755n 1.0v 114.745n 1.0v 114.755n 1.0v 119.745n 1.0v 119.755n 1.0v 124.745n 1.0v 124.755n 1.0v 129.745n 1.0v 129.755n 1.0v 134.745n 1.0v 134.755n 1.0v 139.745n 1.0v 139.755n 1.0v 144.745n 1.0v 144.755n 1.0v 149.745n 1.0v 149.755n 1.0v 154.745n 1.0v 154.755n 0.0v 159.745n 0.0v 159.755n 0.0v 164.745n 0.0v 164.755n 0.0v 169.745n 0.0v 169.755n 0.0v 174.745n 0.0v 174.755n 0.0v 179.745n 0.0v 179.755n 0.0v 184.745n 0.0v 184.755n 0.0v 189.745n 0.0v 189.755n 0.0v 194.745n 0.0v 194.755n 0.0v 199.745n 0.0v 199.755n 0.0v 204.745n 0.0v 204.755n 0.0v 209.745n 0.0v 209.755n 0.0v 214.745n 0.0v 214.755n 0.0v 219.745n 0.0v 219.755n 0.0v 224.745n 0.0v 224.755n 0.0v 229.745n 0.0v 229.755n 0.0v 234.745n 0.0v 234.755n 0.0v 239.745n 0.0v 239.755n 0.0v 244.745n 0.0v 244.755n 0.0v 249.745n 0.0v 249.755n 0.0v 254.745n 0.0v 254.755n 0.0v 259.745n 0.0v 259.755n 0.0v 264.745n 0.0v 264.755n 0.0v 269.745n 0.0v 269.755n 0.0v 274.745n 0.0v 274.755n 0.0v 279.745n 0.0v 279.755n 0.0v 284.745n 0.0v 284.755n 0.0v 289.745n 0.0v 289.755n 0.0v 294.745n 0.0v 294.755n 0.0v 299.745n 0.0v 299.755n 0.0v 304.745n 0.0v 304.755n 0.0v 309.745n 0.0v 309.755n 0.0v 314.745n 0.0v 314.755n 0.0v 319.745n 0.0v 319.755n 0.0v 324.745n 0.0v 324.755n 0.0v 329.745n 0.0v 329.755n 0.0v 334.745n 0.0v 334.755n 0.0v 339.745n 0.0v 339.755n 0.0v 344.745n 0.0v 344.755n 0.0v 349.745n 0.0v 349.755n 1.0v 354.745n 1.0v 354.755n 1.0v 359.745n 1.0v 359.755n 1.0v 364.745n 1.0v 364.755n 1.0v 369.745n 1.0v 369.755n 1.0v 374.745n 1.0v 374.755n 1.0v 379.745n 1.0v 379.755n 1.0v 384.745n 1.0v 384.755n 1.0v 389.745n 1.0v 389.755n 1.0v 394.745n 1.0v 394.755n 1.0v 399.745n 1.0v 399.755n 1.0v 404.745n 1.0v 404.755n 1.0v 409.745n 1.0v 409.755n 1.0v 414.745n 1.0v 414.755n 1.0v 419.745n 1.0v 419.755n 1.0v 424.745n 1.0v 424.755n 1.0v 429.745n 1.0v 429.755n 1.0v 434.745n 1.0v 434.755n 1.0v 439.745n 1.0v 439.755n 1.0v 444.745n 1.0v 444.755n 1.0v 449.745n 1.0v 449.755n 1.0v 454.745n 1.0v 454.755n 1.0v 459.745n 1.0v 459.755n 1.0v 464.745n 1.0v 464.755n 1.0v 469.745n 1.0v 469.755n 1.0v 474.745n 1.0v 474.755n 1.0v 479.745n 1.0v 479.755n 1.0v 484.745n 1.0v 484.755n 0.0v 489.745n 0.0v 489.755n 0.0v 494.745n 0.0v 494.755n 0.0v 499.745n 0.0v 499.755n 1.0v 504.745n 1.0v 504.755n 1.0v 509.745n 1.0v 509.755n 1.0v 514.745n 1.0v 514.755n 0.0v 519.745n 0.0v 519.755n 0.0v 524.745n 0.0v 524.755n 0.0v 529.745n 0.0v 529.755n 0.0v 534.745n 0.0v 534.755n 0.0v 539.745n 0.0v 539.755n 1.0v 544.745n 1.0v 544.755n 0.0v 549.745n 0.0v 549.755n 0.0v 554.745n 0.0v 554.755n 0.0v 559.745n 0.0v 559.755n 0.0v 564.745n 0.0v 564.755n 0.0v 569.745n 0.0v 569.755n 0.0v 574.745n 0.0v 574.755n 0.0v 579.745n 0.0v 579.755n 0.0v 584.745n 0.0v 584.755n 0.0v 589.745n 0.0v 589.755n 0.0v 594.745n 0.0v 594.755n 0.0v 599.745n 0.0v 599.755n 1.0v 604.745n 1.0v 604.755n 1.0v 609.745n 1.0v 609.755n 0.0v 614.745n 0.0v 614.755n 0.0v 619.745n 0.0v 619.755n 1.0v 624.745n 1.0v 624.755n 1.0v 629.745n 1.0v 629.755n 1.0v 634.745n 1.0v 634.755n 0.0v 639.745n 0.0v 639.755n 0.0v 644.745n 0.0v 644.755n 0.0v 649.745n 0.0v 649.755n 0.0v 654.745n 0.0v 654.755n 0.0v 659.745n 0.0v 659.755n 0.0v 664.745n 0.0v 664.755n 0.0v 669.745n 0.0v 669.755n 1.0v 674.745n 1.0v 674.755n 1.0v 679.745n 1.0v 679.755n 1.0v 684.745n 1.0v 684.755n 1.0v 689.745n 1.0v 689.755n 1.0v 694.745n 1.0v 694.755n 1.0v 699.745n 1.0v 699.755n 1.0v 704.745n 1.0v 704.755n 1.0v 709.745n 1.0v 709.755n 1.0v 714.745n 1.0v 714.755n 1.0v 719.745n 1.0v 719.755n 0.0v 724.745n 0.0v 724.755n 0.0v 729.745n 0.0v 729.755n 0.0v 734.745n 0.0v 734.755n 0.0v 739.745n 0.0v 739.755n 0.0v 744.745n 0.0v 744.755n 0.0v 749.745n 0.0v 749.755n 0.0v 754.745n 0.0v 754.755n 0.0v 759.745n 0.0v 759.755n 0.0v 764.745n 0.0v 764.755n 0.0v 769.745n 0.0v 769.755n 0.0v 774.745n 0.0v 774.755n 0.0v 779.745n 0.0v 779.755n 0.0v 784.745n 0.0v 784.755n 0.0v 789.745n 0.0v 789.755n 0.0v 794.745n 0.0v 794.755n 0.0v 799.745n 0.0v 799.755n 0.0v 804.745n 0.0v 804.755n 0.0v 809.745n 0.0v 809.755n 1.0v 814.745n 1.0v 814.755n 1.0v 819.745n 1.0v 819.755n 1.0v 824.745n 1.0v 824.755n 1.0v 829.745n 1.0v 829.755n 1.0v 834.745n 1.0v 834.755n 1.0v 839.745n 1.0v 839.755n 1.0v 844.745n 1.0v 844.755n 1.0v 849.745n 1.0v 849.755n 0.0v 854.745n 0.0v 854.755n 0.0v 859.745n 0.0v 859.755n 0.0v 864.745n 0.0v 864.755n 0.0v 869.745n 0.0v 869.755n 0.0v 874.745n 0.0v 874.755n 0.0v 879.745n 0.0v 879.755n 0.0v 884.745n 0.0v 884.755n 0.0v 889.745n 0.0v 889.755n 0.0v 894.745n 0.0v 894.755n 0.0v 899.745n 0.0v 899.755n 0.0v 904.745n 0.0v 904.755n 0.0v 909.745n 0.0v 909.755n 1.0v 914.745n 1.0v 914.755n 0.0v 919.745n 0.0v 919.755n 0.0v 924.745n 0.0v 924.755n 0.0v 929.745n 0.0v 929.755n 0.0v 934.745n 0.0v 934.755n 0.0v 939.745n 0.0v 939.755n 0.0v 944.745n 0.0v 944.755n 0.0v 949.745n 0.0v 949.755n 0.0v 954.745n 0.0v 954.755n 0.0v 959.745n 0.0v 959.755n 0.0v 964.745n 0.0v 964.755n 0.0v 969.745n 0.0v 969.755n 0.0v 974.745n 0.0v 974.755n 0.0v 979.745n 0.0v 979.755n 0.0v 984.745n 0.0v 984.755n 0.0v 989.745n 0.0v 989.755n 0.0v 994.745n 0.0v 994.755n 0.0v 999.745n 0.0v 999.755n 0.0v 1004.745n 0.0v 1004.755n 0.0v 1009.745n 0.0v 1009.755n 0.0v 1014.745n 0.0v 1014.755n 0.0v 1019.745n 0.0v 1019.755n 1.0v 1024.745n 1.0v 1024.755n 1.0v )
* (time, data): [(0, 0), (5, 0), (10, 0), (15, 0), (20, 0), (25, 0), (30, 1), (35, 1), (40, 1), (45, 1), (50, 1), (55, 1), (60, 1), (65, 0), (70, 0), (75, 0), (80, 0), (85, 0), (90, 0), (95, 0), (100, 0), (105, 0), (110, 0), (115, 0), (120, 0), (125, 0), (130, 0), (135, 0), (140, 0), (145, 0), (150, 0), (155, 0), (160, 0), (165, 0), (170, 0), (175, 0), (180, 0), (185, 0), (190, 1), (195, 1), (200, 1), (205, 1), (210, 1), (215, 1), (220, 1), (225, 1), (230, 1), (235, 1), (240, 1), (245, 1), (250, 1), (255, 1), (260, 1), (265, 1), (270, 1), (275, 1), (280, 1), (285, 1), (290, 0), (295, 0), (300, 0), (305, 0), (310, 0), (315, 0), (320, 0), (325, 0), (330, 0), (335, 1), (340, 1), (345, 1), (350, 1), (355, 1), (360, 1), (365, 1), (370, 1), (375, 1), (380, 1), (385, 1), (390, 1), (395, 1), (400, 1), (405, 1), (410, 1), (415, 1), (420, 1), (425, 1), (430, 1), (435, 0), (440, 0), (445, 1), (450, 1), (455, 1), (460, 1), (465, 1), (470, 1), (475, 1), (480, 1), (485, 1), (490, 0), (495, 0), (500, 0), (505, 0), (510, 0), (515, 1), (520, 1), (525, 1), (530, 1), (535, 1), (540, 1), (545, 0), (550, 0), (555, 0), (560, 1), (565, 1), (570, 1), (575, 1), (580, 1), (585, 1), (590, 1), (595, 1), (600, 0), (605, 0), (610, 0), (615, 0), (620, 1), (625, 1), (630, 1), (635, 1), (640, 1), (645, 1), (650, 0), (655, 0), (660, 0), (665, 0), (670, 0), (675, 0), (680, 0), (685, 0), (690, 0), (695, 0), (700, 0), (705, 0), (710, 0), (715, 0), (720, 1), (725, 1), (730, 1), (735, 1), (740, 0), (745, 0), (750, 0), (755, 0), (760, 0), (765, 0), (770, 1), (775, 1), (780, 1), (785, 1), (790, 1), (795, 1), (800, 1), (805, 1), (810, 1), (815, 1), (820, 1), (825, 1), (830, 1), (835, 1), (840, 1), (845, 1), (850, 1), (855, 1), (860, 1), (865, 0), (870, 0), (875, 0), (880, 0), (885, 0), (890, 0), (895, 0), (900, 0), (905, 0), (910, 1), (915, 0), (920, 0), (925, 0), (930, 1), (935, 1), (940, 1), (945, 1), (950, 1), (955, 1), (960, 1), (965, 1), (970, 1), (975, 1), (980, 1), (985, 1), (990, 1), (995, 1), (1000, 1), (1005, 1), (1010, 1), (1015, 1), (1020, 0), (1025, 0)]
Vdin0_22  din0_22  0 PWL (0n 0.0v 4.745n 0.0v 4.755n 0.0v 9.745n 0.0v 9.755n 0.0v 14.745n 0.0v 14.755n 0.0v 19.745n 0.0v 19.755n 0.0v 24.745n 0.0v 24.755n 0.0v 29.745n 0.0v 29.755n 1.0v 34.745n 1.0v 34.755n 1.0v 39.745n 1.0v 39.755n 1.0v 44.745n 1.0v 44.755n 1.0v 49.745n 1.0v 49.755n 1.0v 54.745n 1.0v 54.755n 1.0v 59.745n 1.0v 59.755n 1.0v 64.745n 1.0v 64.755n 0.0v 69.745n 0.0v 69.755n 0.0v 74.745n 0.0v 74.755n 0.0v 79.745n 0.0v 79.755n 0.0v 84.745n 0.0v 84.755n 0.0v 89.745n 0.0v 89.755n 0.0v 94.745n 0.0v 94.755n 0.0v 99.745n 0.0v 99.755n 0.0v 104.745n 0.0v 104.755n 0.0v 109.745n 0.0v 109.755n 0.0v 114.745n 0.0v 114.755n 0.0v 119.745n 0.0v 119.755n 0.0v 124.745n 0.0v 124.755n 0.0v 129.745n 0.0v 129.755n 0.0v 134.745n 0.0v 134.755n 0.0v 139.745n 0.0v 139.755n 0.0v 144.745n 0.0v 144.755n 0.0v 149.745n 0.0v 149.755n 0.0v 154.745n 0.0v 154.755n 0.0v 159.745n 0.0v 159.755n 0.0v 164.745n 0.0v 164.755n 0.0v 169.745n 0.0v 169.755n 0.0v 174.745n 0.0v 174.755n 0.0v 179.745n 0.0v 179.755n 0.0v 184.745n 0.0v 184.755n 0.0v 189.745n 0.0v 189.755n 1.0v 194.745n 1.0v 194.755n 1.0v 199.745n 1.0v 199.755n 1.0v 204.745n 1.0v 204.755n 1.0v 209.745n 1.0v 209.755n 1.0v 214.745n 1.0v 214.755n 1.0v 219.745n 1.0v 219.755n 1.0v 224.745n 1.0v 224.755n 1.0v 229.745n 1.0v 229.755n 1.0v 234.745n 1.0v 234.755n 1.0v 239.745n 1.0v 239.755n 1.0v 244.745n 1.0v 244.755n 1.0v 249.745n 1.0v 249.755n 1.0v 254.745n 1.0v 254.755n 1.0v 259.745n 1.0v 259.755n 1.0v 264.745n 1.0v 264.755n 1.0v 269.745n 1.0v 269.755n 1.0v 274.745n 1.0v 274.755n 1.0v 279.745n 1.0v 279.755n 1.0v 284.745n 1.0v 284.755n 1.0v 289.745n 1.0v 289.755n 0.0v 294.745n 0.0v 294.755n 0.0v 299.745n 0.0v 299.755n 0.0v 304.745n 0.0v 304.755n 0.0v 309.745n 0.0v 309.755n 0.0v 314.745n 0.0v 314.755n 0.0v 319.745n 0.0v 319.755n 0.0v 324.745n 0.0v 324.755n 0.0v 329.745n 0.0v 329.755n 0.0v 334.745n 0.0v 334.755n 1.0v 339.745n 1.0v 339.755n 1.0v 344.745n 1.0v 344.755n 1.0v 349.745n 1.0v 349.755n 1.0v 354.745n 1.0v 354.755n 1.0v 359.745n 1.0v 359.755n 1.0v 364.745n 1.0v 364.755n 1.0v 369.745n 1.0v 369.755n 1.0v 374.745n 1.0v 374.755n 1.0v 379.745n 1.0v 379.755n 1.0v 384.745n 1.0v 384.755n 1.0v 389.745n 1.0v 389.755n 1.0v 394.745n 1.0v 394.755n 1.0v 399.745n 1.0v 399.755n 1.0v 404.745n 1.0v 404.755n 1.0v 409.745n 1.0v 409.755n 1.0v 414.745n 1.0v 414.755n 1.0v 419.745n 1.0v 419.755n 1.0v 424.745n 1.0v 424.755n 1.0v 429.745n 1.0v 429.755n 1.0v 434.745n 1.0v 434.755n 0.0v 439.745n 0.0v 439.755n 0.0v 444.745n 0.0v 444.755n 1.0v 449.745n 1.0v 449.755n 1.0v 454.745n 1.0v 454.755n 1.0v 459.745n 1.0v 459.755n 1.0v 464.745n 1.0v 464.755n 1.0v 469.745n 1.0v 469.755n 1.0v 474.745n 1.0v 474.755n 1.0v 479.745n 1.0v 479.755n 1.0v 484.745n 1.0v 484.755n 1.0v 489.745n 1.0v 489.755n 0.0v 494.745n 0.0v 494.755n 0.0v 499.745n 0.0v 499.755n 0.0v 504.745n 0.0v 504.755n 0.0v 509.745n 0.0v 509.755n 0.0v 514.745n 0.0v 514.755n 1.0v 519.745n 1.0v 519.755n 1.0v 524.745n 1.0v 524.755n 1.0v 529.745n 1.0v 529.755n 1.0v 534.745n 1.0v 534.755n 1.0v 539.745n 1.0v 539.755n 1.0v 544.745n 1.0v 544.755n 0.0v 549.745n 0.0v 549.755n 0.0v 554.745n 0.0v 554.755n 0.0v 559.745n 0.0v 559.755n 1.0v 564.745n 1.0v 564.755n 1.0v 569.745n 1.0v 569.755n 1.0v 574.745n 1.0v 574.755n 1.0v 579.745n 1.0v 579.755n 1.0v 584.745n 1.0v 584.755n 1.0v 589.745n 1.0v 589.755n 1.0v 594.745n 1.0v 594.755n 1.0v 599.745n 1.0v 599.755n 0.0v 604.745n 0.0v 604.755n 0.0v 609.745n 0.0v 609.755n 0.0v 614.745n 0.0v 614.755n 0.0v 619.745n 0.0v 619.755n 1.0v 624.745n 1.0v 624.755n 1.0v 629.745n 1.0v 629.755n 1.0v 634.745n 1.0v 634.755n 1.0v 639.745n 1.0v 639.755n 1.0v 644.745n 1.0v 644.755n 1.0v 649.745n 1.0v 649.755n 0.0v 654.745n 0.0v 654.755n 0.0v 659.745n 0.0v 659.755n 0.0v 664.745n 0.0v 664.755n 0.0v 669.745n 0.0v 669.755n 0.0v 674.745n 0.0v 674.755n 0.0v 679.745n 0.0v 679.755n 0.0v 684.745n 0.0v 684.755n 0.0v 689.745n 0.0v 689.755n 0.0v 694.745n 0.0v 694.755n 0.0v 699.745n 0.0v 699.755n 0.0v 704.745n 0.0v 704.755n 0.0v 709.745n 0.0v 709.755n 0.0v 714.745n 0.0v 714.755n 0.0v 719.745n 0.0v 719.755n 1.0v 724.745n 1.0v 724.755n 1.0v 729.745n 1.0v 729.755n 1.0v 734.745n 1.0v 734.755n 1.0v 739.745n 1.0v 739.755n 0.0v 744.745n 0.0v 744.755n 0.0v 749.745n 0.0v 749.755n 0.0v 754.745n 0.0v 754.755n 0.0v 759.745n 0.0v 759.755n 0.0v 764.745n 0.0v 764.755n 0.0v 769.745n 0.0v 769.755n 1.0v 774.745n 1.0v 774.755n 1.0v 779.745n 1.0v 779.755n 1.0v 784.745n 1.0v 784.755n 1.0v 789.745n 1.0v 789.755n 1.0v 794.745n 1.0v 794.755n 1.0v 799.745n 1.0v 799.755n 1.0v 804.745n 1.0v 804.755n 1.0v 809.745n 1.0v 809.755n 1.0v 814.745n 1.0v 814.755n 1.0v 819.745n 1.0v 819.755n 1.0v 824.745n 1.0v 824.755n 1.0v 829.745n 1.0v 829.755n 1.0v 834.745n 1.0v 834.755n 1.0v 839.745n 1.0v 839.755n 1.0v 844.745n 1.0v 844.755n 1.0v 849.745n 1.0v 849.755n 1.0v 854.745n 1.0v 854.755n 1.0v 859.745n 1.0v 859.755n 1.0v 864.745n 1.0v 864.755n 0.0v 869.745n 0.0v 869.755n 0.0v 874.745n 0.0v 874.755n 0.0v 879.745n 0.0v 879.755n 0.0v 884.745n 0.0v 884.755n 0.0v 889.745n 0.0v 889.755n 0.0v 894.745n 0.0v 894.755n 0.0v 899.745n 0.0v 899.755n 0.0v 904.745n 0.0v 904.755n 0.0v 909.745n 0.0v 909.755n 1.0v 914.745n 1.0v 914.755n 0.0v 919.745n 0.0v 919.755n 0.0v 924.745n 0.0v 924.755n 0.0v 929.745n 0.0v 929.755n 1.0v 934.745n 1.0v 934.755n 1.0v 939.745n 1.0v 939.755n 1.0v 944.745n 1.0v 944.755n 1.0v 949.745n 1.0v 949.755n 1.0v 954.745n 1.0v 954.755n 1.0v 959.745n 1.0v 959.755n 1.0v 964.745n 1.0v 964.755n 1.0v 969.745n 1.0v 969.755n 1.0v 974.745n 1.0v 974.755n 1.0v 979.745n 1.0v 979.755n 1.0v 984.745n 1.0v 984.755n 1.0v 989.745n 1.0v 989.755n 1.0v 994.745n 1.0v 994.755n 1.0v 999.745n 1.0v 999.755n 1.0v 1004.745n 1.0v 1004.755n 1.0v 1009.745n 1.0v 1009.755n 1.0v 1014.745n 1.0v 1014.755n 1.0v 1019.745n 1.0v 1019.755n 0.0v 1024.745n 0.0v 1024.755n 0.0v )
* (time, data): [(0, 0), (5, 1), (10, 0), (15, 1), (20, 1), (25, 1), (30, 0), (35, 0), (40, 0), (45, 0), (50, 1), (55, 1), (60, 1), (65, 1), (70, 1), (75, 1), (80, 1), (85, 0), (90, 0), (95, 0), (100, 1), (105, 0), (110, 0), (115, 0), (120, 0), (125, 0), (130, 0), (135, 0), (140, 0), (145, 0), (150, 0), (155, 0), (160, 0), (165, 0), (170, 0), (175, 1), (180, 1), (185, 1), (190, 1), (195, 0), (200, 0), (205, 0), (210, 0), (215, 0), (220, 0), (225, 0), (230, 0), (235, 0), (240, 0), (245, 1), (250, 1), (255, 1), (260, 1), (265, 1), (270, 1), (275, 1), (280, 1), (285, 1), (290, 1), (295, 1), (300, 1), (305, 1), (310, 1), (315, 1), (320, 1), (325, 1), (330, 1), (335, 0), (340, 0), (345, 0), (350, 1), (355, 1), (360, 1), (365, 1), (370, 1), (375, 1), (380, 1), (385, 1), (390, 1), (395, 1), (400, 1), (405, 1), (410, 0), (415, 0), (420, 0), (425, 0), (430, 0), (435, 0), (440, 0), (445, 0), (450, 0), (455, 0), (460, 0), (465, 0), (470, 0), (475, 0), (480, 0), (485, 1), (490, 1), (495, 1), (500, 1), (505, 1), (510, 1), (515, 0), (520, 0), (525, 0), (530, 0), (535, 0), (540, 0), (545, 1), (550, 0), (555, 0), (560, 0), (565, 0), (570, 0), (575, 0), (580, 0), (585, 0), (590, 0), (595, 0), (600, 1), (605, 1), (610, 0), (615, 0), (620, 0), (625, 0), (630, 0), (635, 1), (640, 1), (645, 1), (650, 1), (655, 0), (660, 0), (665, 0), (670, 1), (675, 1), (680, 1), (685, 1), (690, 1), (695, 1), (700, 1), (705, 1), (710, 1), (715, 1), (720, 0), (725, 0), (730, 0), (735, 0), (740, 0), (745, 0), (750, 0), (755, 0), (760, 0), (765, 0), (770, 1), (775, 1), (780, 0), (785, 0), (790, 0), (795, 0), (800, 0), (805, 1), (810, 0), (815, 0), (820, 0), (825, 0), (830, 0), (835, 0), (840, 0), (845, 0), (850, 1), (855, 1), (860, 1), (865, 0), (870, 0), (875, 0), (880, 0), (885, 0), (890, 0), (895, 0), (900, 0), (905, 0), (910, 1), (915, 1), (920, 1), (925, 1), (930, 0), (935, 0), (940, 0), (945, 0), (950, 0), (955, 0), (960, 0), (965, 0), (970, 0), (975, 0), (980, 0), (985, 0), (990, 0), (995, 0), (1000, 0), (1005, 0), (1010, 0), (1015, 0), (1020, 0), (1025, 0)]
Vdin0_23  din0_23  0 PWL (0n 0.0v 4.745n 0.0v 4.755n 1.0v 9.745n 1.0v 9.755n 0.0v 14.745n 0.0v 14.755n 1.0v 19.745n 1.0v 19.755n 1.0v 24.745n 1.0v 24.755n 1.0v 29.745n 1.0v 29.755n 0.0v 34.745n 0.0v 34.755n 0.0v 39.745n 0.0v 39.755n 0.0v 44.745n 0.0v 44.755n 0.0v 49.745n 0.0v 49.755n 1.0v 54.745n 1.0v 54.755n 1.0v 59.745n 1.0v 59.755n 1.0v 64.745n 1.0v 64.755n 1.0v 69.745n 1.0v 69.755n 1.0v 74.745n 1.0v 74.755n 1.0v 79.745n 1.0v 79.755n 1.0v 84.745n 1.0v 84.755n 0.0v 89.745n 0.0v 89.755n 0.0v 94.745n 0.0v 94.755n 0.0v 99.745n 0.0v 99.755n 1.0v 104.745n 1.0v 104.755n 0.0v 109.745n 0.0v 109.755n 0.0v 114.745n 0.0v 114.755n 0.0v 119.745n 0.0v 119.755n 0.0v 124.745n 0.0v 124.755n 0.0v 129.745n 0.0v 129.755n 0.0v 134.745n 0.0v 134.755n 0.0v 139.745n 0.0v 139.755n 0.0v 144.745n 0.0v 144.755n 0.0v 149.745n 0.0v 149.755n 0.0v 154.745n 0.0v 154.755n 0.0v 159.745n 0.0v 159.755n 0.0v 164.745n 0.0v 164.755n 0.0v 169.745n 0.0v 169.755n 0.0v 174.745n 0.0v 174.755n 1.0v 179.745n 1.0v 179.755n 1.0v 184.745n 1.0v 184.755n 1.0v 189.745n 1.0v 189.755n 1.0v 194.745n 1.0v 194.755n 0.0v 199.745n 0.0v 199.755n 0.0v 204.745n 0.0v 204.755n 0.0v 209.745n 0.0v 209.755n 0.0v 214.745n 0.0v 214.755n 0.0v 219.745n 0.0v 219.755n 0.0v 224.745n 0.0v 224.755n 0.0v 229.745n 0.0v 229.755n 0.0v 234.745n 0.0v 234.755n 0.0v 239.745n 0.0v 239.755n 0.0v 244.745n 0.0v 244.755n 1.0v 249.745n 1.0v 249.755n 1.0v 254.745n 1.0v 254.755n 1.0v 259.745n 1.0v 259.755n 1.0v 264.745n 1.0v 264.755n 1.0v 269.745n 1.0v 269.755n 1.0v 274.745n 1.0v 274.755n 1.0v 279.745n 1.0v 279.755n 1.0v 284.745n 1.0v 284.755n 1.0v 289.745n 1.0v 289.755n 1.0v 294.745n 1.0v 294.755n 1.0v 299.745n 1.0v 299.755n 1.0v 304.745n 1.0v 304.755n 1.0v 309.745n 1.0v 309.755n 1.0v 314.745n 1.0v 314.755n 1.0v 319.745n 1.0v 319.755n 1.0v 324.745n 1.0v 324.755n 1.0v 329.745n 1.0v 329.755n 1.0v 334.745n 1.0v 334.755n 0.0v 339.745n 0.0v 339.755n 0.0v 344.745n 0.0v 344.755n 0.0v 349.745n 0.0v 349.755n 1.0v 354.745n 1.0v 354.755n 1.0v 359.745n 1.0v 359.755n 1.0v 364.745n 1.0v 364.755n 1.0v 369.745n 1.0v 369.755n 1.0v 374.745n 1.0v 374.755n 1.0v 379.745n 1.0v 379.755n 1.0v 384.745n 1.0v 384.755n 1.0v 389.745n 1.0v 389.755n 1.0v 394.745n 1.0v 394.755n 1.0v 399.745n 1.0v 399.755n 1.0v 404.745n 1.0v 404.755n 1.0v 409.745n 1.0v 409.755n 0.0v 414.745n 0.0v 414.755n 0.0v 419.745n 0.0v 419.755n 0.0v 424.745n 0.0v 424.755n 0.0v 429.745n 0.0v 429.755n 0.0v 434.745n 0.0v 434.755n 0.0v 439.745n 0.0v 439.755n 0.0v 444.745n 0.0v 444.755n 0.0v 449.745n 0.0v 449.755n 0.0v 454.745n 0.0v 454.755n 0.0v 459.745n 0.0v 459.755n 0.0v 464.745n 0.0v 464.755n 0.0v 469.745n 0.0v 469.755n 0.0v 474.745n 0.0v 474.755n 0.0v 479.745n 0.0v 479.755n 0.0v 484.745n 0.0v 484.755n 1.0v 489.745n 1.0v 489.755n 1.0v 494.745n 1.0v 494.755n 1.0v 499.745n 1.0v 499.755n 1.0v 504.745n 1.0v 504.755n 1.0v 509.745n 1.0v 509.755n 1.0v 514.745n 1.0v 514.755n 0.0v 519.745n 0.0v 519.755n 0.0v 524.745n 0.0v 524.755n 0.0v 529.745n 0.0v 529.755n 0.0v 534.745n 0.0v 534.755n 0.0v 539.745n 0.0v 539.755n 0.0v 544.745n 0.0v 544.755n 1.0v 549.745n 1.0v 549.755n 0.0v 554.745n 0.0v 554.755n 0.0v 559.745n 0.0v 559.755n 0.0v 564.745n 0.0v 564.755n 0.0v 569.745n 0.0v 569.755n 0.0v 574.745n 0.0v 574.755n 0.0v 579.745n 0.0v 579.755n 0.0v 584.745n 0.0v 584.755n 0.0v 589.745n 0.0v 589.755n 0.0v 594.745n 0.0v 594.755n 0.0v 599.745n 0.0v 599.755n 1.0v 604.745n 1.0v 604.755n 1.0v 609.745n 1.0v 609.755n 0.0v 614.745n 0.0v 614.755n 0.0v 619.745n 0.0v 619.755n 0.0v 624.745n 0.0v 624.755n 0.0v 629.745n 0.0v 629.755n 0.0v 634.745n 0.0v 634.755n 1.0v 639.745n 1.0v 639.755n 1.0v 644.745n 1.0v 644.755n 1.0v 649.745n 1.0v 649.755n 1.0v 654.745n 1.0v 654.755n 0.0v 659.745n 0.0v 659.755n 0.0v 664.745n 0.0v 664.755n 0.0v 669.745n 0.0v 669.755n 1.0v 674.745n 1.0v 674.755n 1.0v 679.745n 1.0v 679.755n 1.0v 684.745n 1.0v 684.755n 1.0v 689.745n 1.0v 689.755n 1.0v 694.745n 1.0v 694.755n 1.0v 699.745n 1.0v 699.755n 1.0v 704.745n 1.0v 704.755n 1.0v 709.745n 1.0v 709.755n 1.0v 714.745n 1.0v 714.755n 1.0v 719.745n 1.0v 719.755n 0.0v 724.745n 0.0v 724.755n 0.0v 729.745n 0.0v 729.755n 0.0v 734.745n 0.0v 734.755n 0.0v 739.745n 0.0v 739.755n 0.0v 744.745n 0.0v 744.755n 0.0v 749.745n 0.0v 749.755n 0.0v 754.745n 0.0v 754.755n 0.0v 759.745n 0.0v 759.755n 0.0v 764.745n 0.0v 764.755n 0.0v 769.745n 0.0v 769.755n 1.0v 774.745n 1.0v 774.755n 1.0v 779.745n 1.0v 779.755n 0.0v 784.745n 0.0v 784.755n 0.0v 789.745n 0.0v 789.755n 0.0v 794.745n 0.0v 794.755n 0.0v 799.745n 0.0v 799.755n 0.0v 804.745n 0.0v 804.755n 1.0v 809.745n 1.0v 809.755n 0.0v 814.745n 0.0v 814.755n 0.0v 819.745n 0.0v 819.755n 0.0v 824.745n 0.0v 824.755n 0.0v 829.745n 0.0v 829.755n 0.0v 834.745n 0.0v 834.755n 0.0v 839.745n 0.0v 839.755n 0.0v 844.745n 0.0v 844.755n 0.0v 849.745n 0.0v 849.755n 1.0v 854.745n 1.0v 854.755n 1.0v 859.745n 1.0v 859.755n 1.0v 864.745n 1.0v 864.755n 0.0v 869.745n 0.0v 869.755n 0.0v 874.745n 0.0v 874.755n 0.0v 879.745n 0.0v 879.755n 0.0v 884.745n 0.0v 884.755n 0.0v 889.745n 0.0v 889.755n 0.0v 894.745n 0.0v 894.755n 0.0v 899.745n 0.0v 899.755n 0.0v 904.745n 0.0v 904.755n 0.0v 909.745n 0.0v 909.755n 1.0v 914.745n 1.0v 914.755n 1.0v 919.745n 1.0v 919.755n 1.0v 924.745n 1.0v 924.755n 1.0v 929.745n 1.0v 929.755n 0.0v 934.745n 0.0v 934.755n 0.0v 939.745n 0.0v 939.755n 0.0v 944.745n 0.0v 944.755n 0.0v 949.745n 0.0v 949.755n 0.0v 954.745n 0.0v 954.755n 0.0v 959.745n 0.0v 959.755n 0.0v 964.745n 0.0v 964.755n 0.0v 969.745n 0.0v 969.755n 0.0v 974.745n 0.0v 974.755n 0.0v 979.745n 0.0v 979.755n 0.0v 984.745n 0.0v 984.755n 0.0v 989.745n 0.0v 989.755n 0.0v 994.745n 0.0v 994.755n 0.0v 999.745n 0.0v 999.755n 0.0v 1004.745n 0.0v 1004.755n 0.0v 1009.745n 0.0v 1009.755n 0.0v 1014.745n 0.0v 1014.755n 0.0v 1019.745n 0.0v 1019.755n 0.0v 1024.745n 0.0v 1024.755n 0.0v )
* (time, data): [(0, 0), (5, 1), (10, 1), (15, 1), (20, 1), (25, 1), (30, 0), (35, 0), (40, 0), (45, 0), (50, 0), (55, 0), (60, 0), (65, 0), (70, 0), (75, 0), (80, 0), (85, 1), (90, 1), (95, 1), (100, 1), (105, 0), (110, 0), (115, 1), (120, 1), (125, 1), (130, 1), (135, 1), (140, 1), (145, 1), (150, 1), (155, 0), (160, 0), (165, 0), (170, 0), (175, 0), (180, 0), (185, 0), (190, 1), (195, 1), (200, 1), (205, 1), (210, 1), (215, 1), (220, 1), (225, 1), (230, 1), (235, 1), (240, 1), (245, 0), (250, 0), (255, 0), (260, 0), (265, 0), (270, 0), (275, 0), (280, 0), (285, 0), (290, 1), (295, 1), (300, 1), (305, 1), (310, 1), (315, 1), (320, 1), (325, 1), (330, 1), (335, 1), (340, 1), (345, 1), (350, 1), (355, 1), (360, 1), (365, 1), (370, 1), (375, 1), (380, 1), (385, 1), (390, 1), (395, 1), (400, 1), (405, 1), (410, 0), (415, 0), (420, 0), (425, 0), (430, 0), (435, 1), (440, 1), (445, 0), (450, 0), (455, 0), (460, 0), (465, 0), (470, 0), (475, 0), (480, 0), (485, 1), (490, 1), (495, 1), (500, 1), (505, 1), (510, 1), (515, 1), (520, 1), (525, 1), (530, 1), (535, 1), (540, 0), (545, 0), (550, 0), (555, 0), (560, 0), (565, 0), (570, 0), (575, 0), (580, 0), (585, 0), (590, 0), (595, 0), (600, 0), (605, 0), (610, 0), (615, 0), (620, 0), (625, 0), (630, 0), (635, 1), (640, 1), (645, 0), (650, 1), (655, 0), (660, 0), (665, 0), (670, 1), (675, 1), (680, 1), (685, 1), (690, 1), (695, 1), (700, 1), (705, 1), (710, 1), (715, 1), (720, 0), (725, 0), (730, 0), (735, 0), (740, 1), (745, 1), (750, 1), (755, 1), (760, 1), (765, 1), (770, 1), (775, 1), (780, 0), (785, 0), (790, 0), (795, 0), (800, 0), (805, 0), (810, 0), (815, 0), (820, 0), (825, 0), (830, 0), (835, 0), (840, 1), (845, 1), (850, 1), (855, 0), (860, 0), (865, 1), (870, 0), (875, 0), (880, 0), (885, 0), (890, 0), (895, 0), (900, 0), (905, 0), (910, 0), (915, 0), (920, 0), (925, 0), (930, 0), (935, 0), (940, 0), (945, 0), (950, 0), (955, 0), (960, 0), (965, 0), (970, 0), (975, 0), (980, 0), (985, 0), (990, 0), (995, 0), (1000, 0), (1005, 0), (1010, 0), (1015, 0), (1020, 1), (1025, 1)]
Vdin0_24  din0_24  0 PWL (0n 0.0v 4.745n 0.0v 4.755n 1.0v 9.745n 1.0v 9.755n 1.0v 14.745n 1.0v 14.755n 1.0v 19.745n 1.0v 19.755n 1.0v 24.745n 1.0v 24.755n 1.0v 29.745n 1.0v 29.755n 0.0v 34.745n 0.0v 34.755n 0.0v 39.745n 0.0v 39.755n 0.0v 44.745n 0.0v 44.755n 0.0v 49.745n 0.0v 49.755n 0.0v 54.745n 0.0v 54.755n 0.0v 59.745n 0.0v 59.755n 0.0v 64.745n 0.0v 64.755n 0.0v 69.745n 0.0v 69.755n 0.0v 74.745n 0.0v 74.755n 0.0v 79.745n 0.0v 79.755n 0.0v 84.745n 0.0v 84.755n 1.0v 89.745n 1.0v 89.755n 1.0v 94.745n 1.0v 94.755n 1.0v 99.745n 1.0v 99.755n 1.0v 104.745n 1.0v 104.755n 0.0v 109.745n 0.0v 109.755n 0.0v 114.745n 0.0v 114.755n 1.0v 119.745n 1.0v 119.755n 1.0v 124.745n 1.0v 124.755n 1.0v 129.745n 1.0v 129.755n 1.0v 134.745n 1.0v 134.755n 1.0v 139.745n 1.0v 139.755n 1.0v 144.745n 1.0v 144.755n 1.0v 149.745n 1.0v 149.755n 1.0v 154.745n 1.0v 154.755n 0.0v 159.745n 0.0v 159.755n 0.0v 164.745n 0.0v 164.755n 0.0v 169.745n 0.0v 169.755n 0.0v 174.745n 0.0v 174.755n 0.0v 179.745n 0.0v 179.755n 0.0v 184.745n 0.0v 184.755n 0.0v 189.745n 0.0v 189.755n 1.0v 194.745n 1.0v 194.755n 1.0v 199.745n 1.0v 199.755n 1.0v 204.745n 1.0v 204.755n 1.0v 209.745n 1.0v 209.755n 1.0v 214.745n 1.0v 214.755n 1.0v 219.745n 1.0v 219.755n 1.0v 224.745n 1.0v 224.755n 1.0v 229.745n 1.0v 229.755n 1.0v 234.745n 1.0v 234.755n 1.0v 239.745n 1.0v 239.755n 1.0v 244.745n 1.0v 244.755n 0.0v 249.745n 0.0v 249.755n 0.0v 254.745n 0.0v 254.755n 0.0v 259.745n 0.0v 259.755n 0.0v 264.745n 0.0v 264.755n 0.0v 269.745n 0.0v 269.755n 0.0v 274.745n 0.0v 274.755n 0.0v 279.745n 0.0v 279.755n 0.0v 284.745n 0.0v 284.755n 0.0v 289.745n 0.0v 289.755n 1.0v 294.745n 1.0v 294.755n 1.0v 299.745n 1.0v 299.755n 1.0v 304.745n 1.0v 304.755n 1.0v 309.745n 1.0v 309.755n 1.0v 314.745n 1.0v 314.755n 1.0v 319.745n 1.0v 319.755n 1.0v 324.745n 1.0v 324.755n 1.0v 329.745n 1.0v 329.755n 1.0v 334.745n 1.0v 334.755n 1.0v 339.745n 1.0v 339.755n 1.0v 344.745n 1.0v 344.755n 1.0v 349.745n 1.0v 349.755n 1.0v 354.745n 1.0v 354.755n 1.0v 359.745n 1.0v 359.755n 1.0v 364.745n 1.0v 364.755n 1.0v 369.745n 1.0v 369.755n 1.0v 374.745n 1.0v 374.755n 1.0v 379.745n 1.0v 379.755n 1.0v 384.745n 1.0v 384.755n 1.0v 389.745n 1.0v 389.755n 1.0v 394.745n 1.0v 394.755n 1.0v 399.745n 1.0v 399.755n 1.0v 404.745n 1.0v 404.755n 1.0v 409.745n 1.0v 409.755n 0.0v 414.745n 0.0v 414.755n 0.0v 419.745n 0.0v 419.755n 0.0v 424.745n 0.0v 424.755n 0.0v 429.745n 0.0v 429.755n 0.0v 434.745n 0.0v 434.755n 1.0v 439.745n 1.0v 439.755n 1.0v 444.745n 1.0v 444.755n 0.0v 449.745n 0.0v 449.755n 0.0v 454.745n 0.0v 454.755n 0.0v 459.745n 0.0v 459.755n 0.0v 464.745n 0.0v 464.755n 0.0v 469.745n 0.0v 469.755n 0.0v 474.745n 0.0v 474.755n 0.0v 479.745n 0.0v 479.755n 0.0v 484.745n 0.0v 484.755n 1.0v 489.745n 1.0v 489.755n 1.0v 494.745n 1.0v 494.755n 1.0v 499.745n 1.0v 499.755n 1.0v 504.745n 1.0v 504.755n 1.0v 509.745n 1.0v 509.755n 1.0v 514.745n 1.0v 514.755n 1.0v 519.745n 1.0v 519.755n 1.0v 524.745n 1.0v 524.755n 1.0v 529.745n 1.0v 529.755n 1.0v 534.745n 1.0v 534.755n 1.0v 539.745n 1.0v 539.755n 0.0v 544.745n 0.0v 544.755n 0.0v 549.745n 0.0v 549.755n 0.0v 554.745n 0.0v 554.755n 0.0v 559.745n 0.0v 559.755n 0.0v 564.745n 0.0v 564.755n 0.0v 569.745n 0.0v 569.755n 0.0v 574.745n 0.0v 574.755n 0.0v 579.745n 0.0v 579.755n 0.0v 584.745n 0.0v 584.755n 0.0v 589.745n 0.0v 589.755n 0.0v 594.745n 0.0v 594.755n 0.0v 599.745n 0.0v 599.755n 0.0v 604.745n 0.0v 604.755n 0.0v 609.745n 0.0v 609.755n 0.0v 614.745n 0.0v 614.755n 0.0v 619.745n 0.0v 619.755n 0.0v 624.745n 0.0v 624.755n 0.0v 629.745n 0.0v 629.755n 0.0v 634.745n 0.0v 634.755n 1.0v 639.745n 1.0v 639.755n 1.0v 644.745n 1.0v 644.755n 0.0v 649.745n 0.0v 649.755n 1.0v 654.745n 1.0v 654.755n 0.0v 659.745n 0.0v 659.755n 0.0v 664.745n 0.0v 664.755n 0.0v 669.745n 0.0v 669.755n 1.0v 674.745n 1.0v 674.755n 1.0v 679.745n 1.0v 679.755n 1.0v 684.745n 1.0v 684.755n 1.0v 689.745n 1.0v 689.755n 1.0v 694.745n 1.0v 694.755n 1.0v 699.745n 1.0v 699.755n 1.0v 704.745n 1.0v 704.755n 1.0v 709.745n 1.0v 709.755n 1.0v 714.745n 1.0v 714.755n 1.0v 719.745n 1.0v 719.755n 0.0v 724.745n 0.0v 724.755n 0.0v 729.745n 0.0v 729.755n 0.0v 734.745n 0.0v 734.755n 0.0v 739.745n 0.0v 739.755n 1.0v 744.745n 1.0v 744.755n 1.0v 749.745n 1.0v 749.755n 1.0v 754.745n 1.0v 754.755n 1.0v 759.745n 1.0v 759.755n 1.0v 764.745n 1.0v 764.755n 1.0v 769.745n 1.0v 769.755n 1.0v 774.745n 1.0v 774.755n 1.0v 779.745n 1.0v 779.755n 0.0v 784.745n 0.0v 784.755n 0.0v 789.745n 0.0v 789.755n 0.0v 794.745n 0.0v 794.755n 0.0v 799.745n 0.0v 799.755n 0.0v 804.745n 0.0v 804.755n 0.0v 809.745n 0.0v 809.755n 0.0v 814.745n 0.0v 814.755n 0.0v 819.745n 0.0v 819.755n 0.0v 824.745n 0.0v 824.755n 0.0v 829.745n 0.0v 829.755n 0.0v 834.745n 0.0v 834.755n 0.0v 839.745n 0.0v 839.755n 1.0v 844.745n 1.0v 844.755n 1.0v 849.745n 1.0v 849.755n 1.0v 854.745n 1.0v 854.755n 0.0v 859.745n 0.0v 859.755n 0.0v 864.745n 0.0v 864.755n 1.0v 869.745n 1.0v 869.755n 0.0v 874.745n 0.0v 874.755n 0.0v 879.745n 0.0v 879.755n 0.0v 884.745n 0.0v 884.755n 0.0v 889.745n 0.0v 889.755n 0.0v 894.745n 0.0v 894.755n 0.0v 899.745n 0.0v 899.755n 0.0v 904.745n 0.0v 904.755n 0.0v 909.745n 0.0v 909.755n 0.0v 914.745n 0.0v 914.755n 0.0v 919.745n 0.0v 919.755n 0.0v 924.745n 0.0v 924.755n 0.0v 929.745n 0.0v 929.755n 0.0v 934.745n 0.0v 934.755n 0.0v 939.745n 0.0v 939.755n 0.0v 944.745n 0.0v 944.755n 0.0v 949.745n 0.0v 949.755n 0.0v 954.745n 0.0v 954.755n 0.0v 959.745n 0.0v 959.755n 0.0v 964.745n 0.0v 964.755n 0.0v 969.745n 0.0v 969.755n 0.0v 974.745n 0.0v 974.755n 0.0v 979.745n 0.0v 979.755n 0.0v 984.745n 0.0v 984.755n 0.0v 989.745n 0.0v 989.755n 0.0v 994.745n 0.0v 994.755n 0.0v 999.745n 0.0v 999.755n 0.0v 1004.745n 0.0v 1004.755n 0.0v 1009.745n 0.0v 1009.755n 0.0v 1014.745n 0.0v 1014.755n 0.0v 1019.745n 0.0v 1019.755n 1.0v 1024.745n 1.0v 1024.755n 1.0v )
* (time, data): [(0, 0), (5, 0), (10, 1), (15, 0), (20, 0), (25, 0), (30, 0), (35, 0), (40, 1), (45, 1), (50, 0), (55, 0), (60, 0), (65, 1), (70, 1), (75, 1), (80, 1), (85, 1), (90, 1), (95, 1), (100, 0), (105, 1), (110, 1), (115, 1), (120, 1), (125, 1), (130, 1), (135, 1), (140, 1), (145, 1), (150, 1), (155, 0), (160, 0), (165, 0), (170, 0), (175, 1), (180, 1), (185, 1), (190, 0), (195, 1), (200, 1), (205, 1), (210, 1), (215, 1), (220, 1), (225, 1), (230, 1), (235, 1), (240, 1), (245, 0), (250, 0), (255, 0), (260, 0), (265, 0), (270, 0), (275, 0), (280, 0), (285, 0), (290, 1), (295, 1), (300, 1), (305, 1), (310, 1), (315, 1), (320, 1), (325, 1), (330, 1), (335, 1), (340, 1), (345, 1), (350, 0), (355, 0), (360, 0), (365, 0), (370, 0), (375, 0), (380, 0), (385, 0), (390, 0), (395, 0), (400, 0), (405, 0), (410, 1), (415, 1), (420, 1), (425, 1), (430, 1), (435, 0), (440, 0), (445, 0), (450, 0), (455, 0), (460, 0), (465, 0), (470, 0), (475, 0), (480, 0), (485, 0), (490, 0), (495, 0), (500, 1), (505, 1), (510, 1), (515, 0), (520, 0), (525, 0), (530, 0), (535, 1), (540, 0), (545, 0), (550, 0), (555, 0), (560, 0), (565, 0), (570, 0), (575, 0), (580, 0), (585, 0), (590, 0), (595, 0), (600, 0), (605, 0), (610, 1), (615, 1), (620, 0), (625, 0), (630, 0), (635, 0), (640, 0), (645, 1), (650, 1), (655, 0), (660, 0), (665, 0), (670, 1), (675, 1), (680, 1), (685, 1), (690, 1), (695, 1), (700, 1), (705, 1), (710, 1), (715, 1), (720, 0), (725, 0), (730, 0), (735, 0), (740, 1), (745, 1), (750, 1), (755, 1), (760, 1), (765, 1), (770, 1), (775, 1), (780, 0), (785, 0), (790, 0), (795, 0), (800, 0), (805, 0), (810, 1), (815, 1), (820, 1), (825, 1), (830, 1), (835, 1), (840, 0), (845, 0), (850, 1), (855, 1), (860, 1), (865, 0), (870, 1), (875, 1), (880, 1), (885, 1), (890, 1), (895, 1), (900, 1), (905, 1), (910, 0), (915, 1), (920, 1), (925, 1), (930, 1), (935, 1), (940, 1), (945, 1), (950, 1), (955, 1), (960, 1), (965, 0), (970, 0), (975, 0), (980, 0), (985, 0), (990, 0), (995, 0), (1000, 0), (1005, 0), (1010, 0), (1015, 0), (1020, 1), (1025, 1)]
Vdin0_25  din0_25  0 PWL (0n 0.0v 4.745n 0.0v 4.755n 0.0v 9.745n 0.0v 9.755n 1.0v 14.745n 1.0v 14.755n 0.0v 19.745n 0.0v 19.755n 0.0v 24.745n 0.0v 24.755n 0.0v 29.745n 0.0v 29.755n 0.0v 34.745n 0.0v 34.755n 0.0v 39.745n 0.0v 39.755n 1.0v 44.745n 1.0v 44.755n 1.0v 49.745n 1.0v 49.755n 0.0v 54.745n 0.0v 54.755n 0.0v 59.745n 0.0v 59.755n 0.0v 64.745n 0.0v 64.755n 1.0v 69.745n 1.0v 69.755n 1.0v 74.745n 1.0v 74.755n 1.0v 79.745n 1.0v 79.755n 1.0v 84.745n 1.0v 84.755n 1.0v 89.745n 1.0v 89.755n 1.0v 94.745n 1.0v 94.755n 1.0v 99.745n 1.0v 99.755n 0.0v 104.745n 0.0v 104.755n 1.0v 109.745n 1.0v 109.755n 1.0v 114.745n 1.0v 114.755n 1.0v 119.745n 1.0v 119.755n 1.0v 124.745n 1.0v 124.755n 1.0v 129.745n 1.0v 129.755n 1.0v 134.745n 1.0v 134.755n 1.0v 139.745n 1.0v 139.755n 1.0v 144.745n 1.0v 144.755n 1.0v 149.745n 1.0v 149.755n 1.0v 154.745n 1.0v 154.755n 0.0v 159.745n 0.0v 159.755n 0.0v 164.745n 0.0v 164.755n 0.0v 169.745n 0.0v 169.755n 0.0v 174.745n 0.0v 174.755n 1.0v 179.745n 1.0v 179.755n 1.0v 184.745n 1.0v 184.755n 1.0v 189.745n 1.0v 189.755n 0.0v 194.745n 0.0v 194.755n 1.0v 199.745n 1.0v 199.755n 1.0v 204.745n 1.0v 204.755n 1.0v 209.745n 1.0v 209.755n 1.0v 214.745n 1.0v 214.755n 1.0v 219.745n 1.0v 219.755n 1.0v 224.745n 1.0v 224.755n 1.0v 229.745n 1.0v 229.755n 1.0v 234.745n 1.0v 234.755n 1.0v 239.745n 1.0v 239.755n 1.0v 244.745n 1.0v 244.755n 0.0v 249.745n 0.0v 249.755n 0.0v 254.745n 0.0v 254.755n 0.0v 259.745n 0.0v 259.755n 0.0v 264.745n 0.0v 264.755n 0.0v 269.745n 0.0v 269.755n 0.0v 274.745n 0.0v 274.755n 0.0v 279.745n 0.0v 279.755n 0.0v 284.745n 0.0v 284.755n 0.0v 289.745n 0.0v 289.755n 1.0v 294.745n 1.0v 294.755n 1.0v 299.745n 1.0v 299.755n 1.0v 304.745n 1.0v 304.755n 1.0v 309.745n 1.0v 309.755n 1.0v 314.745n 1.0v 314.755n 1.0v 319.745n 1.0v 319.755n 1.0v 324.745n 1.0v 324.755n 1.0v 329.745n 1.0v 329.755n 1.0v 334.745n 1.0v 334.755n 1.0v 339.745n 1.0v 339.755n 1.0v 344.745n 1.0v 344.755n 1.0v 349.745n 1.0v 349.755n 0.0v 354.745n 0.0v 354.755n 0.0v 359.745n 0.0v 359.755n 0.0v 364.745n 0.0v 364.755n 0.0v 369.745n 0.0v 369.755n 0.0v 374.745n 0.0v 374.755n 0.0v 379.745n 0.0v 379.755n 0.0v 384.745n 0.0v 384.755n 0.0v 389.745n 0.0v 389.755n 0.0v 394.745n 0.0v 394.755n 0.0v 399.745n 0.0v 399.755n 0.0v 404.745n 0.0v 404.755n 0.0v 409.745n 0.0v 409.755n 1.0v 414.745n 1.0v 414.755n 1.0v 419.745n 1.0v 419.755n 1.0v 424.745n 1.0v 424.755n 1.0v 429.745n 1.0v 429.755n 1.0v 434.745n 1.0v 434.755n 0.0v 439.745n 0.0v 439.755n 0.0v 444.745n 0.0v 444.755n 0.0v 449.745n 0.0v 449.755n 0.0v 454.745n 0.0v 454.755n 0.0v 459.745n 0.0v 459.755n 0.0v 464.745n 0.0v 464.755n 0.0v 469.745n 0.0v 469.755n 0.0v 474.745n 0.0v 474.755n 0.0v 479.745n 0.0v 479.755n 0.0v 484.745n 0.0v 484.755n 0.0v 489.745n 0.0v 489.755n 0.0v 494.745n 0.0v 494.755n 0.0v 499.745n 0.0v 499.755n 1.0v 504.745n 1.0v 504.755n 1.0v 509.745n 1.0v 509.755n 1.0v 514.745n 1.0v 514.755n 0.0v 519.745n 0.0v 519.755n 0.0v 524.745n 0.0v 524.755n 0.0v 529.745n 0.0v 529.755n 0.0v 534.745n 0.0v 534.755n 1.0v 539.745n 1.0v 539.755n 0.0v 544.745n 0.0v 544.755n 0.0v 549.745n 0.0v 549.755n 0.0v 554.745n 0.0v 554.755n 0.0v 559.745n 0.0v 559.755n 0.0v 564.745n 0.0v 564.755n 0.0v 569.745n 0.0v 569.755n 0.0v 574.745n 0.0v 574.755n 0.0v 579.745n 0.0v 579.755n 0.0v 584.745n 0.0v 584.755n 0.0v 589.745n 0.0v 589.755n 0.0v 594.745n 0.0v 594.755n 0.0v 599.745n 0.0v 599.755n 0.0v 604.745n 0.0v 604.755n 0.0v 609.745n 0.0v 609.755n 1.0v 614.745n 1.0v 614.755n 1.0v 619.745n 1.0v 619.755n 0.0v 624.745n 0.0v 624.755n 0.0v 629.745n 0.0v 629.755n 0.0v 634.745n 0.0v 634.755n 0.0v 639.745n 0.0v 639.755n 0.0v 644.745n 0.0v 644.755n 1.0v 649.745n 1.0v 649.755n 1.0v 654.745n 1.0v 654.755n 0.0v 659.745n 0.0v 659.755n 0.0v 664.745n 0.0v 664.755n 0.0v 669.745n 0.0v 669.755n 1.0v 674.745n 1.0v 674.755n 1.0v 679.745n 1.0v 679.755n 1.0v 684.745n 1.0v 684.755n 1.0v 689.745n 1.0v 689.755n 1.0v 694.745n 1.0v 694.755n 1.0v 699.745n 1.0v 699.755n 1.0v 704.745n 1.0v 704.755n 1.0v 709.745n 1.0v 709.755n 1.0v 714.745n 1.0v 714.755n 1.0v 719.745n 1.0v 719.755n 0.0v 724.745n 0.0v 724.755n 0.0v 729.745n 0.0v 729.755n 0.0v 734.745n 0.0v 734.755n 0.0v 739.745n 0.0v 739.755n 1.0v 744.745n 1.0v 744.755n 1.0v 749.745n 1.0v 749.755n 1.0v 754.745n 1.0v 754.755n 1.0v 759.745n 1.0v 759.755n 1.0v 764.745n 1.0v 764.755n 1.0v 769.745n 1.0v 769.755n 1.0v 774.745n 1.0v 774.755n 1.0v 779.745n 1.0v 779.755n 0.0v 784.745n 0.0v 784.755n 0.0v 789.745n 0.0v 789.755n 0.0v 794.745n 0.0v 794.755n 0.0v 799.745n 0.0v 799.755n 0.0v 804.745n 0.0v 804.755n 0.0v 809.745n 0.0v 809.755n 1.0v 814.745n 1.0v 814.755n 1.0v 819.745n 1.0v 819.755n 1.0v 824.745n 1.0v 824.755n 1.0v 829.745n 1.0v 829.755n 1.0v 834.745n 1.0v 834.755n 1.0v 839.745n 1.0v 839.755n 0.0v 844.745n 0.0v 844.755n 0.0v 849.745n 0.0v 849.755n 1.0v 854.745n 1.0v 854.755n 1.0v 859.745n 1.0v 859.755n 1.0v 864.745n 1.0v 864.755n 0.0v 869.745n 0.0v 869.755n 1.0v 874.745n 1.0v 874.755n 1.0v 879.745n 1.0v 879.755n 1.0v 884.745n 1.0v 884.755n 1.0v 889.745n 1.0v 889.755n 1.0v 894.745n 1.0v 894.755n 1.0v 899.745n 1.0v 899.755n 1.0v 904.745n 1.0v 904.755n 1.0v 909.745n 1.0v 909.755n 0.0v 914.745n 0.0v 914.755n 1.0v 919.745n 1.0v 919.755n 1.0v 924.745n 1.0v 924.755n 1.0v 929.745n 1.0v 929.755n 1.0v 934.745n 1.0v 934.755n 1.0v 939.745n 1.0v 939.755n 1.0v 944.745n 1.0v 944.755n 1.0v 949.745n 1.0v 949.755n 1.0v 954.745n 1.0v 954.755n 1.0v 959.745n 1.0v 959.755n 1.0v 964.745n 1.0v 964.755n 0.0v 969.745n 0.0v 969.755n 0.0v 974.745n 0.0v 974.755n 0.0v 979.745n 0.0v 979.755n 0.0v 984.745n 0.0v 984.755n 0.0v 989.745n 0.0v 989.755n 0.0v 994.745n 0.0v 994.755n 0.0v 999.745n 0.0v 999.755n 0.0v 1004.745n 0.0v 1004.755n 0.0v 1009.745n 0.0v 1009.755n 0.0v 1014.745n 0.0v 1014.755n 0.0v 1019.745n 0.0v 1019.755n 1.0v 1024.745n 1.0v 1024.755n 1.0v )
* (time, data): [(0, 0), (5, 0), (10, 1), (15, 1), (20, 1), (25, 1), (30, 1), (35, 1), (40, 0), (45, 0), (50, 0), (55, 0), (60, 0), (65, 1), (70, 1), (75, 1), (80, 1), (85, 0), (90, 0), (95, 0), (100, 0), (105, 0), (110, 0), (115, 1), (120, 1), (125, 1), (130, 1), (135, 1), (140, 1), (145, 1), (150, 1), (155, 0), (160, 0), (165, 0), (170, 0), (175, 1), (180, 1), (185, 1), (190, 0), (195, 1), (200, 1), (205, 1), (210, 1), (215, 1), (220, 1), (225, 1), (230, 1), (235, 1), (240, 1), (245, 0), (250, 0), (255, 0), (260, 0), (265, 0), (270, 0), (275, 0), (280, 0), (285, 0), (290, 1), (295, 1), (300, 1), (305, 1), (310, 1), (315, 1), (320, 1), (325, 1), (330, 1), (335, 0), (340, 0), (345, 0), (350, 0), (355, 0), (360, 0), (365, 0), (370, 0), (375, 0), (380, 0), (385, 0), (390, 0), (395, 0), (400, 0), (405, 0), (410, 0), (415, 0), (420, 0), (425, 0), (430, 0), (435, 1), (440, 1), (445, 1), (450, 1), (455, 1), (460, 1), (465, 1), (470, 1), (475, 1), (480, 1), (485, 0), (490, 1), (495, 1), (500, 0), (505, 0), (510, 0), (515, 1), (520, 1), (525, 1), (530, 1), (535, 1), (540, 1), (545, 1), (550, 0), (555, 0), (560, 1), (565, 1), (570, 1), (575, 1), (580, 1), (585, 1), (590, 1), (595, 1), (600, 0), (605, 0), (610, 1), (615, 1), (620, 1), (625, 1), (630, 1), (635, 0), (640, 0), (645, 1), (650, 1), (655, 0), (660, 0), (665, 0), (670, 1), (675, 1), (680, 1), (685, 1), (690, 1), (695, 1), (700, 1), (705, 1), (710, 1), (715, 1), (720, 1), (725, 1), (730, 1), (735, 1), (740, 0), (745, 0), (750, 0), (755, 0), (760, 0), (765, 0), (770, 1), (775, 1), (780, 0), (785, 0), (790, 0), (795, 0), (800, 0), (805, 1), (810, 1), (815, 1), (820, 1), (825, 1), (830, 1), (835, 1), (840, 0), (845, 0), (850, 0), (855, 1), (860, 1), (865, 0), (870, 0), (875, 0), (880, 0), (885, 0), (890, 0), (895, 0), (900, 0), (905, 0), (910, 0), (915, 1), (920, 1), (925, 1), (930, 1), (935, 1), (940, 1), (945, 1), (950, 1), (955, 1), (960, 1), (965, 0), (970, 0), (975, 0), (980, 0), (985, 0), (990, 0), (995, 0), (1000, 0), (1005, 0), (1010, 0), (1015, 0), (1020, 0), (1025, 0)]
Vdin0_26  din0_26  0 PWL (0n 0.0v 4.745n 0.0v 4.755n 0.0v 9.745n 0.0v 9.755n 1.0v 14.745n 1.0v 14.755n 1.0v 19.745n 1.0v 19.755n 1.0v 24.745n 1.0v 24.755n 1.0v 29.745n 1.0v 29.755n 1.0v 34.745n 1.0v 34.755n 1.0v 39.745n 1.0v 39.755n 0.0v 44.745n 0.0v 44.755n 0.0v 49.745n 0.0v 49.755n 0.0v 54.745n 0.0v 54.755n 0.0v 59.745n 0.0v 59.755n 0.0v 64.745n 0.0v 64.755n 1.0v 69.745n 1.0v 69.755n 1.0v 74.745n 1.0v 74.755n 1.0v 79.745n 1.0v 79.755n 1.0v 84.745n 1.0v 84.755n 0.0v 89.745n 0.0v 89.755n 0.0v 94.745n 0.0v 94.755n 0.0v 99.745n 0.0v 99.755n 0.0v 104.745n 0.0v 104.755n 0.0v 109.745n 0.0v 109.755n 0.0v 114.745n 0.0v 114.755n 1.0v 119.745n 1.0v 119.755n 1.0v 124.745n 1.0v 124.755n 1.0v 129.745n 1.0v 129.755n 1.0v 134.745n 1.0v 134.755n 1.0v 139.745n 1.0v 139.755n 1.0v 144.745n 1.0v 144.755n 1.0v 149.745n 1.0v 149.755n 1.0v 154.745n 1.0v 154.755n 0.0v 159.745n 0.0v 159.755n 0.0v 164.745n 0.0v 164.755n 0.0v 169.745n 0.0v 169.755n 0.0v 174.745n 0.0v 174.755n 1.0v 179.745n 1.0v 179.755n 1.0v 184.745n 1.0v 184.755n 1.0v 189.745n 1.0v 189.755n 0.0v 194.745n 0.0v 194.755n 1.0v 199.745n 1.0v 199.755n 1.0v 204.745n 1.0v 204.755n 1.0v 209.745n 1.0v 209.755n 1.0v 214.745n 1.0v 214.755n 1.0v 219.745n 1.0v 219.755n 1.0v 224.745n 1.0v 224.755n 1.0v 229.745n 1.0v 229.755n 1.0v 234.745n 1.0v 234.755n 1.0v 239.745n 1.0v 239.755n 1.0v 244.745n 1.0v 244.755n 0.0v 249.745n 0.0v 249.755n 0.0v 254.745n 0.0v 254.755n 0.0v 259.745n 0.0v 259.755n 0.0v 264.745n 0.0v 264.755n 0.0v 269.745n 0.0v 269.755n 0.0v 274.745n 0.0v 274.755n 0.0v 279.745n 0.0v 279.755n 0.0v 284.745n 0.0v 284.755n 0.0v 289.745n 0.0v 289.755n 1.0v 294.745n 1.0v 294.755n 1.0v 299.745n 1.0v 299.755n 1.0v 304.745n 1.0v 304.755n 1.0v 309.745n 1.0v 309.755n 1.0v 314.745n 1.0v 314.755n 1.0v 319.745n 1.0v 319.755n 1.0v 324.745n 1.0v 324.755n 1.0v 329.745n 1.0v 329.755n 1.0v 334.745n 1.0v 334.755n 0.0v 339.745n 0.0v 339.755n 0.0v 344.745n 0.0v 344.755n 0.0v 349.745n 0.0v 349.755n 0.0v 354.745n 0.0v 354.755n 0.0v 359.745n 0.0v 359.755n 0.0v 364.745n 0.0v 364.755n 0.0v 369.745n 0.0v 369.755n 0.0v 374.745n 0.0v 374.755n 0.0v 379.745n 0.0v 379.755n 0.0v 384.745n 0.0v 384.755n 0.0v 389.745n 0.0v 389.755n 0.0v 394.745n 0.0v 394.755n 0.0v 399.745n 0.0v 399.755n 0.0v 404.745n 0.0v 404.755n 0.0v 409.745n 0.0v 409.755n 0.0v 414.745n 0.0v 414.755n 0.0v 419.745n 0.0v 419.755n 0.0v 424.745n 0.0v 424.755n 0.0v 429.745n 0.0v 429.755n 0.0v 434.745n 0.0v 434.755n 1.0v 439.745n 1.0v 439.755n 1.0v 444.745n 1.0v 444.755n 1.0v 449.745n 1.0v 449.755n 1.0v 454.745n 1.0v 454.755n 1.0v 459.745n 1.0v 459.755n 1.0v 464.745n 1.0v 464.755n 1.0v 469.745n 1.0v 469.755n 1.0v 474.745n 1.0v 474.755n 1.0v 479.745n 1.0v 479.755n 1.0v 484.745n 1.0v 484.755n 0.0v 489.745n 0.0v 489.755n 1.0v 494.745n 1.0v 494.755n 1.0v 499.745n 1.0v 499.755n 0.0v 504.745n 0.0v 504.755n 0.0v 509.745n 0.0v 509.755n 0.0v 514.745n 0.0v 514.755n 1.0v 519.745n 1.0v 519.755n 1.0v 524.745n 1.0v 524.755n 1.0v 529.745n 1.0v 529.755n 1.0v 534.745n 1.0v 534.755n 1.0v 539.745n 1.0v 539.755n 1.0v 544.745n 1.0v 544.755n 1.0v 549.745n 1.0v 549.755n 0.0v 554.745n 0.0v 554.755n 0.0v 559.745n 0.0v 559.755n 1.0v 564.745n 1.0v 564.755n 1.0v 569.745n 1.0v 569.755n 1.0v 574.745n 1.0v 574.755n 1.0v 579.745n 1.0v 579.755n 1.0v 584.745n 1.0v 584.755n 1.0v 589.745n 1.0v 589.755n 1.0v 594.745n 1.0v 594.755n 1.0v 599.745n 1.0v 599.755n 0.0v 604.745n 0.0v 604.755n 0.0v 609.745n 0.0v 609.755n 1.0v 614.745n 1.0v 614.755n 1.0v 619.745n 1.0v 619.755n 1.0v 624.745n 1.0v 624.755n 1.0v 629.745n 1.0v 629.755n 1.0v 634.745n 1.0v 634.755n 0.0v 639.745n 0.0v 639.755n 0.0v 644.745n 0.0v 644.755n 1.0v 649.745n 1.0v 649.755n 1.0v 654.745n 1.0v 654.755n 0.0v 659.745n 0.0v 659.755n 0.0v 664.745n 0.0v 664.755n 0.0v 669.745n 0.0v 669.755n 1.0v 674.745n 1.0v 674.755n 1.0v 679.745n 1.0v 679.755n 1.0v 684.745n 1.0v 684.755n 1.0v 689.745n 1.0v 689.755n 1.0v 694.745n 1.0v 694.755n 1.0v 699.745n 1.0v 699.755n 1.0v 704.745n 1.0v 704.755n 1.0v 709.745n 1.0v 709.755n 1.0v 714.745n 1.0v 714.755n 1.0v 719.745n 1.0v 719.755n 1.0v 724.745n 1.0v 724.755n 1.0v 729.745n 1.0v 729.755n 1.0v 734.745n 1.0v 734.755n 1.0v 739.745n 1.0v 739.755n 0.0v 744.745n 0.0v 744.755n 0.0v 749.745n 0.0v 749.755n 0.0v 754.745n 0.0v 754.755n 0.0v 759.745n 0.0v 759.755n 0.0v 764.745n 0.0v 764.755n 0.0v 769.745n 0.0v 769.755n 1.0v 774.745n 1.0v 774.755n 1.0v 779.745n 1.0v 779.755n 0.0v 784.745n 0.0v 784.755n 0.0v 789.745n 0.0v 789.755n 0.0v 794.745n 0.0v 794.755n 0.0v 799.745n 0.0v 799.755n 0.0v 804.745n 0.0v 804.755n 1.0v 809.745n 1.0v 809.755n 1.0v 814.745n 1.0v 814.755n 1.0v 819.745n 1.0v 819.755n 1.0v 824.745n 1.0v 824.755n 1.0v 829.745n 1.0v 829.755n 1.0v 834.745n 1.0v 834.755n 1.0v 839.745n 1.0v 839.755n 0.0v 844.745n 0.0v 844.755n 0.0v 849.745n 0.0v 849.755n 0.0v 854.745n 0.0v 854.755n 1.0v 859.745n 1.0v 859.755n 1.0v 864.745n 1.0v 864.755n 0.0v 869.745n 0.0v 869.755n 0.0v 874.745n 0.0v 874.755n 0.0v 879.745n 0.0v 879.755n 0.0v 884.745n 0.0v 884.755n 0.0v 889.745n 0.0v 889.755n 0.0v 894.745n 0.0v 894.755n 0.0v 899.745n 0.0v 899.755n 0.0v 904.745n 0.0v 904.755n 0.0v 909.745n 0.0v 909.755n 0.0v 914.745n 0.0v 914.755n 1.0v 919.745n 1.0v 919.755n 1.0v 924.745n 1.0v 924.755n 1.0v 929.745n 1.0v 929.755n 1.0v 934.745n 1.0v 934.755n 1.0v 939.745n 1.0v 939.755n 1.0v 944.745n 1.0v 944.755n 1.0v 949.745n 1.0v 949.755n 1.0v 954.745n 1.0v 954.755n 1.0v 959.745n 1.0v 959.755n 1.0v 964.745n 1.0v 964.755n 0.0v 969.745n 0.0v 969.755n 0.0v 974.745n 0.0v 974.755n 0.0v 979.745n 0.0v 979.755n 0.0v 984.745n 0.0v 984.755n 0.0v 989.745n 0.0v 989.755n 0.0v 994.745n 0.0v 994.755n 0.0v 999.745n 0.0v 999.755n 0.0v 1004.745n 0.0v 1004.755n 0.0v 1009.745n 0.0v 1009.755n 0.0v 1014.745n 0.0v 1014.755n 0.0v 1019.745n 0.0v 1019.755n 0.0v 1024.745n 0.0v 1024.755n 0.0v )
* (time, data): [(0, 0), (5, 1), (10, 1), (15, 1), (20, 1), (25, 1), (30, 0), (35, 0), (40, 1), (45, 1), (50, 1), (55, 1), (60, 1), (65, 1), (70, 1), (75, 1), (80, 1), (85, 1), (90, 1), (95, 1), (100, 0), (105, 1), (110, 1), (115, 1), (120, 1), (125, 1), (130, 1), (135, 1), (140, 1), (145, 1), (150, 1), (155, 1), (160, 1), (165, 1), (170, 1), (175, 0), (180, 0), (185, 0), (190, 1), (195, 0), (200, 0), (205, 0), (210, 0), (215, 0), (220, 0), (225, 0), (230, 0), (235, 0), (240, 0), (245, 1), (250, 1), (255, 1), (260, 1), (265, 1), (270, 1), (275, 1), (280, 1), (285, 1), (290, 1), (295, 1), (300, 1), (305, 1), (310, 1), (315, 1), (320, 1), (325, 1), (330, 1), (335, 0), (340, 0), (345, 0), (350, 0), (355, 0), (360, 0), (365, 0), (370, 0), (375, 0), (380, 0), (385, 0), (390, 0), (395, 0), (400, 0), (405, 0), (410, 0), (415, 0), (420, 0), (425, 0), (430, 0), (435, 1), (440, 1), (445, 1), (450, 1), (455, 1), (460, 1), (465, 1), (470, 1), (475, 1), (480, 1), (485, 0), (490, 0), (495, 0), (500, 0), (505, 0), (510, 0), (515, 0), (520, 0), (525, 0), (530, 0), (535, 0), (540, 0), (545, 0), (550, 0), (555, 0), (560, 0), (565, 0), (570, 0), (575, 0), (580, 0), (585, 0), (590, 0), (595, 0), (600, 0), (605, 0), (610, 1), (615, 1), (620, 0), (625, 0), (630, 0), (635, 0), (640, 0), (645, 1), (650, 1), (655, 0), (660, 0), (665, 0), (670, 1), (675, 1), (680, 1), (685, 1), (690, 1), (695, 1), (700, 1), (705, 1), (710, 1), (715, 1), (720, 1), (725, 1), (730, 1), (735, 1), (740, 0), (745, 0), (750, 0), (755, 0), (760, 0), (765, 0), (770, 0), (775, 0), (780, 0), (785, 0), (790, 0), (795, 0), (800, 0), (805, 1), (810, 0), (815, 0), (820, 0), (825, 0), (830, 0), (835, 0), (840, 1), (845, 1), (850, 0), (855, 1), (860, 1), (865, 1), (870, 0), (875, 0), (880, 0), (885, 0), (890, 0), (895, 0), (900, 0), (905, 0), (910, 0), (915, 1), (920, 1), (925, 1), (930, 1), (935, 1), (940, 1), (945, 1), (950, 1), (955, 1), (960, 1), (965, 1), (970, 1), (975, 1), (980, 1), (985, 1), (990, 1), (995, 1), (1000, 1), (1005, 1), (1010, 1), (1015, 1), (1020, 1), (1025, 1)]
Vdin0_27  din0_27  0 PWL (0n 0.0v 4.745n 0.0v 4.755n 1.0v 9.745n 1.0v 9.755n 1.0v 14.745n 1.0v 14.755n 1.0v 19.745n 1.0v 19.755n 1.0v 24.745n 1.0v 24.755n 1.0v 29.745n 1.0v 29.755n 0.0v 34.745n 0.0v 34.755n 0.0v 39.745n 0.0v 39.755n 1.0v 44.745n 1.0v 44.755n 1.0v 49.745n 1.0v 49.755n 1.0v 54.745n 1.0v 54.755n 1.0v 59.745n 1.0v 59.755n 1.0v 64.745n 1.0v 64.755n 1.0v 69.745n 1.0v 69.755n 1.0v 74.745n 1.0v 74.755n 1.0v 79.745n 1.0v 79.755n 1.0v 84.745n 1.0v 84.755n 1.0v 89.745n 1.0v 89.755n 1.0v 94.745n 1.0v 94.755n 1.0v 99.745n 1.0v 99.755n 0.0v 104.745n 0.0v 104.755n 1.0v 109.745n 1.0v 109.755n 1.0v 114.745n 1.0v 114.755n 1.0v 119.745n 1.0v 119.755n 1.0v 124.745n 1.0v 124.755n 1.0v 129.745n 1.0v 129.755n 1.0v 134.745n 1.0v 134.755n 1.0v 139.745n 1.0v 139.755n 1.0v 144.745n 1.0v 144.755n 1.0v 149.745n 1.0v 149.755n 1.0v 154.745n 1.0v 154.755n 1.0v 159.745n 1.0v 159.755n 1.0v 164.745n 1.0v 164.755n 1.0v 169.745n 1.0v 169.755n 1.0v 174.745n 1.0v 174.755n 0.0v 179.745n 0.0v 179.755n 0.0v 184.745n 0.0v 184.755n 0.0v 189.745n 0.0v 189.755n 1.0v 194.745n 1.0v 194.755n 0.0v 199.745n 0.0v 199.755n 0.0v 204.745n 0.0v 204.755n 0.0v 209.745n 0.0v 209.755n 0.0v 214.745n 0.0v 214.755n 0.0v 219.745n 0.0v 219.755n 0.0v 224.745n 0.0v 224.755n 0.0v 229.745n 0.0v 229.755n 0.0v 234.745n 0.0v 234.755n 0.0v 239.745n 0.0v 239.755n 0.0v 244.745n 0.0v 244.755n 1.0v 249.745n 1.0v 249.755n 1.0v 254.745n 1.0v 254.755n 1.0v 259.745n 1.0v 259.755n 1.0v 264.745n 1.0v 264.755n 1.0v 269.745n 1.0v 269.755n 1.0v 274.745n 1.0v 274.755n 1.0v 279.745n 1.0v 279.755n 1.0v 284.745n 1.0v 284.755n 1.0v 289.745n 1.0v 289.755n 1.0v 294.745n 1.0v 294.755n 1.0v 299.745n 1.0v 299.755n 1.0v 304.745n 1.0v 304.755n 1.0v 309.745n 1.0v 309.755n 1.0v 314.745n 1.0v 314.755n 1.0v 319.745n 1.0v 319.755n 1.0v 324.745n 1.0v 324.755n 1.0v 329.745n 1.0v 329.755n 1.0v 334.745n 1.0v 334.755n 0.0v 339.745n 0.0v 339.755n 0.0v 344.745n 0.0v 344.755n 0.0v 349.745n 0.0v 349.755n 0.0v 354.745n 0.0v 354.755n 0.0v 359.745n 0.0v 359.755n 0.0v 364.745n 0.0v 364.755n 0.0v 369.745n 0.0v 369.755n 0.0v 374.745n 0.0v 374.755n 0.0v 379.745n 0.0v 379.755n 0.0v 384.745n 0.0v 384.755n 0.0v 389.745n 0.0v 389.755n 0.0v 394.745n 0.0v 394.755n 0.0v 399.745n 0.0v 399.755n 0.0v 404.745n 0.0v 404.755n 0.0v 409.745n 0.0v 409.755n 0.0v 414.745n 0.0v 414.755n 0.0v 419.745n 0.0v 419.755n 0.0v 424.745n 0.0v 424.755n 0.0v 429.745n 0.0v 429.755n 0.0v 434.745n 0.0v 434.755n 1.0v 439.745n 1.0v 439.755n 1.0v 444.745n 1.0v 444.755n 1.0v 449.745n 1.0v 449.755n 1.0v 454.745n 1.0v 454.755n 1.0v 459.745n 1.0v 459.755n 1.0v 464.745n 1.0v 464.755n 1.0v 469.745n 1.0v 469.755n 1.0v 474.745n 1.0v 474.755n 1.0v 479.745n 1.0v 479.755n 1.0v 484.745n 1.0v 484.755n 0.0v 489.745n 0.0v 489.755n 0.0v 494.745n 0.0v 494.755n 0.0v 499.745n 0.0v 499.755n 0.0v 504.745n 0.0v 504.755n 0.0v 509.745n 0.0v 509.755n 0.0v 514.745n 0.0v 514.755n 0.0v 519.745n 0.0v 519.755n 0.0v 524.745n 0.0v 524.755n 0.0v 529.745n 0.0v 529.755n 0.0v 534.745n 0.0v 534.755n 0.0v 539.745n 0.0v 539.755n 0.0v 544.745n 0.0v 544.755n 0.0v 549.745n 0.0v 549.755n 0.0v 554.745n 0.0v 554.755n 0.0v 559.745n 0.0v 559.755n 0.0v 564.745n 0.0v 564.755n 0.0v 569.745n 0.0v 569.755n 0.0v 574.745n 0.0v 574.755n 0.0v 579.745n 0.0v 579.755n 0.0v 584.745n 0.0v 584.755n 0.0v 589.745n 0.0v 589.755n 0.0v 594.745n 0.0v 594.755n 0.0v 599.745n 0.0v 599.755n 0.0v 604.745n 0.0v 604.755n 0.0v 609.745n 0.0v 609.755n 1.0v 614.745n 1.0v 614.755n 1.0v 619.745n 1.0v 619.755n 0.0v 624.745n 0.0v 624.755n 0.0v 629.745n 0.0v 629.755n 0.0v 634.745n 0.0v 634.755n 0.0v 639.745n 0.0v 639.755n 0.0v 644.745n 0.0v 644.755n 1.0v 649.745n 1.0v 649.755n 1.0v 654.745n 1.0v 654.755n 0.0v 659.745n 0.0v 659.755n 0.0v 664.745n 0.0v 664.755n 0.0v 669.745n 0.0v 669.755n 1.0v 674.745n 1.0v 674.755n 1.0v 679.745n 1.0v 679.755n 1.0v 684.745n 1.0v 684.755n 1.0v 689.745n 1.0v 689.755n 1.0v 694.745n 1.0v 694.755n 1.0v 699.745n 1.0v 699.755n 1.0v 704.745n 1.0v 704.755n 1.0v 709.745n 1.0v 709.755n 1.0v 714.745n 1.0v 714.755n 1.0v 719.745n 1.0v 719.755n 1.0v 724.745n 1.0v 724.755n 1.0v 729.745n 1.0v 729.755n 1.0v 734.745n 1.0v 734.755n 1.0v 739.745n 1.0v 739.755n 0.0v 744.745n 0.0v 744.755n 0.0v 749.745n 0.0v 749.755n 0.0v 754.745n 0.0v 754.755n 0.0v 759.745n 0.0v 759.755n 0.0v 764.745n 0.0v 764.755n 0.0v 769.745n 0.0v 769.755n 0.0v 774.745n 0.0v 774.755n 0.0v 779.745n 0.0v 779.755n 0.0v 784.745n 0.0v 784.755n 0.0v 789.745n 0.0v 789.755n 0.0v 794.745n 0.0v 794.755n 0.0v 799.745n 0.0v 799.755n 0.0v 804.745n 0.0v 804.755n 1.0v 809.745n 1.0v 809.755n 0.0v 814.745n 0.0v 814.755n 0.0v 819.745n 0.0v 819.755n 0.0v 824.745n 0.0v 824.755n 0.0v 829.745n 0.0v 829.755n 0.0v 834.745n 0.0v 834.755n 0.0v 839.745n 0.0v 839.755n 1.0v 844.745n 1.0v 844.755n 1.0v 849.745n 1.0v 849.755n 0.0v 854.745n 0.0v 854.755n 1.0v 859.745n 1.0v 859.755n 1.0v 864.745n 1.0v 864.755n 1.0v 869.745n 1.0v 869.755n 0.0v 874.745n 0.0v 874.755n 0.0v 879.745n 0.0v 879.755n 0.0v 884.745n 0.0v 884.755n 0.0v 889.745n 0.0v 889.755n 0.0v 894.745n 0.0v 894.755n 0.0v 899.745n 0.0v 899.755n 0.0v 904.745n 0.0v 904.755n 0.0v 909.745n 0.0v 909.755n 0.0v 914.745n 0.0v 914.755n 1.0v 919.745n 1.0v 919.755n 1.0v 924.745n 1.0v 924.755n 1.0v 929.745n 1.0v 929.755n 1.0v 934.745n 1.0v 934.755n 1.0v 939.745n 1.0v 939.755n 1.0v 944.745n 1.0v 944.755n 1.0v 949.745n 1.0v 949.755n 1.0v 954.745n 1.0v 954.755n 1.0v 959.745n 1.0v 959.755n 1.0v 964.745n 1.0v 964.755n 1.0v 969.745n 1.0v 969.755n 1.0v 974.745n 1.0v 974.755n 1.0v 979.745n 1.0v 979.755n 1.0v 984.745n 1.0v 984.755n 1.0v 989.745n 1.0v 989.755n 1.0v 994.745n 1.0v 994.755n 1.0v 999.745n 1.0v 999.755n 1.0v 1004.745n 1.0v 1004.755n 1.0v 1009.745n 1.0v 1009.755n 1.0v 1014.745n 1.0v 1014.755n 1.0v 1019.745n 1.0v 1019.755n 1.0v 1024.745n 1.0v 1024.755n 1.0v )
* (time, data): [(0, 0), (5, 1), (10, 1), (15, 1), (20, 1), (25, 1), (30, 0), (35, 0), (40, 0), (45, 0), (50, 0), (55, 0), (60, 0), (65, 0), (70, 0), (75, 0), (80, 0), (85, 0), (90, 0), (95, 0), (100, 1), (105, 0), (110, 0), (115, 0), (120, 0), (125, 0), (130, 0), (135, 0), (140, 0), (145, 0), (150, 0), (155, 0), (160, 0), (165, 0), (170, 0), (175, 1), (180, 1), (185, 1), (190, 0), (195, 0), (200, 0), (205, 0), (210, 0), (215, 0), (220, 0), (225, 0), (230, 0), (235, 0), (240, 0), (245, 0), (250, 0), (255, 0), (260, 0), (265, 0), (270, 0), (275, 0), (280, 0), (285, 0), (290, 1), (295, 1), (300, 1), (305, 1), (310, 1), (315, 1), (320, 1), (325, 1), (330, 1), (335, 1), (340, 1), (345, 1), (350, 1), (355, 1), (360, 1), (365, 1), (370, 1), (375, 1), (380, 1), (385, 1), (390, 1), (395, 1), (400, 1), (405, 1), (410, 1), (415, 1), (420, 1), (425, 1), (430, 1), (435, 1), (440, 1), (445, 0), (450, 0), (455, 0), (460, 0), (465, 0), (470, 0), (475, 0), (480, 0), (485, 1), (490, 1), (495, 1), (500, 0), (505, 0), (510, 0), (515, 0), (520, 0), (525, 0), (530, 0), (535, 1), (540, 0), (545, 1), (550, 1), (555, 1), (560, 1), (565, 1), (570, 1), (575, 1), (580, 1), (585, 1), (590, 1), (595, 1), (600, 0), (605, 0), (610, 1), (615, 1), (620, 0), (625, 0), (630, 0), (635, 0), (640, 0), (645, 1), (650, 1), (655, 1), (660, 1), (665, 1), (670, 1), (675, 1), (680, 1), (685, 1), (690, 1), (695, 1), (700, 1), (705, 1), (710, 1), (715, 1), (720, 1), (725, 1), (730, 1), (735, 1), (740, 0), (745, 0), (750, 0), (755, 0), (760, 0), (765, 0), (770, 1), (775, 1), (780, 1), (785, 1), (790, 1), (795, 1), (800, 1), (805, 0), (810, 1), (815, 1), (820, 1), (825, 1), (830, 1), (835, 1), (840, 0), (845, 0), (850, 0), (855, 0), (860, 0), (865, 1), (870, 1), (875, 1), (880, 1), (885, 1), (890, 1), (895, 1), (900, 1), (905, 1), (910, 1), (915, 0), (920, 0), (925, 0), (930, 1), (935, 1), (940, 1), (945, 1), (950, 1), (955, 1), (960, 1), (965, 0), (970, 0), (975, 0), (980, 0), (985, 0), (990, 0), (995, 0), (1000, 0), (1005, 0), (1010, 0), (1015, 0), (1020, 1), (1025, 1)]
Vdin0_28  din0_28  0 PWL (0n 0.0v 4.745n 0.0v 4.755n 1.0v 9.745n 1.0v 9.755n 1.0v 14.745n 1.0v 14.755n 1.0v 19.745n 1.0v 19.755n 1.0v 24.745n 1.0v 24.755n 1.0v 29.745n 1.0v 29.755n 0.0v 34.745n 0.0v 34.755n 0.0v 39.745n 0.0v 39.755n 0.0v 44.745n 0.0v 44.755n 0.0v 49.745n 0.0v 49.755n 0.0v 54.745n 0.0v 54.755n 0.0v 59.745n 0.0v 59.755n 0.0v 64.745n 0.0v 64.755n 0.0v 69.745n 0.0v 69.755n 0.0v 74.745n 0.0v 74.755n 0.0v 79.745n 0.0v 79.755n 0.0v 84.745n 0.0v 84.755n 0.0v 89.745n 0.0v 89.755n 0.0v 94.745n 0.0v 94.755n 0.0v 99.745n 0.0v 99.755n 1.0v 104.745n 1.0v 104.755n 0.0v 109.745n 0.0v 109.755n 0.0v 114.745n 0.0v 114.755n 0.0v 119.745n 0.0v 119.755n 0.0v 124.745n 0.0v 124.755n 0.0v 129.745n 0.0v 129.755n 0.0v 134.745n 0.0v 134.755n 0.0v 139.745n 0.0v 139.755n 0.0v 144.745n 0.0v 144.755n 0.0v 149.745n 0.0v 149.755n 0.0v 154.745n 0.0v 154.755n 0.0v 159.745n 0.0v 159.755n 0.0v 164.745n 0.0v 164.755n 0.0v 169.745n 0.0v 169.755n 0.0v 174.745n 0.0v 174.755n 1.0v 179.745n 1.0v 179.755n 1.0v 184.745n 1.0v 184.755n 1.0v 189.745n 1.0v 189.755n 0.0v 194.745n 0.0v 194.755n 0.0v 199.745n 0.0v 199.755n 0.0v 204.745n 0.0v 204.755n 0.0v 209.745n 0.0v 209.755n 0.0v 214.745n 0.0v 214.755n 0.0v 219.745n 0.0v 219.755n 0.0v 224.745n 0.0v 224.755n 0.0v 229.745n 0.0v 229.755n 0.0v 234.745n 0.0v 234.755n 0.0v 239.745n 0.0v 239.755n 0.0v 244.745n 0.0v 244.755n 0.0v 249.745n 0.0v 249.755n 0.0v 254.745n 0.0v 254.755n 0.0v 259.745n 0.0v 259.755n 0.0v 264.745n 0.0v 264.755n 0.0v 269.745n 0.0v 269.755n 0.0v 274.745n 0.0v 274.755n 0.0v 279.745n 0.0v 279.755n 0.0v 284.745n 0.0v 284.755n 0.0v 289.745n 0.0v 289.755n 1.0v 294.745n 1.0v 294.755n 1.0v 299.745n 1.0v 299.755n 1.0v 304.745n 1.0v 304.755n 1.0v 309.745n 1.0v 309.755n 1.0v 314.745n 1.0v 314.755n 1.0v 319.745n 1.0v 319.755n 1.0v 324.745n 1.0v 324.755n 1.0v 329.745n 1.0v 329.755n 1.0v 334.745n 1.0v 334.755n 1.0v 339.745n 1.0v 339.755n 1.0v 344.745n 1.0v 344.755n 1.0v 349.745n 1.0v 349.755n 1.0v 354.745n 1.0v 354.755n 1.0v 359.745n 1.0v 359.755n 1.0v 364.745n 1.0v 364.755n 1.0v 369.745n 1.0v 369.755n 1.0v 374.745n 1.0v 374.755n 1.0v 379.745n 1.0v 379.755n 1.0v 384.745n 1.0v 384.755n 1.0v 389.745n 1.0v 389.755n 1.0v 394.745n 1.0v 394.755n 1.0v 399.745n 1.0v 399.755n 1.0v 404.745n 1.0v 404.755n 1.0v 409.745n 1.0v 409.755n 1.0v 414.745n 1.0v 414.755n 1.0v 419.745n 1.0v 419.755n 1.0v 424.745n 1.0v 424.755n 1.0v 429.745n 1.0v 429.755n 1.0v 434.745n 1.0v 434.755n 1.0v 439.745n 1.0v 439.755n 1.0v 444.745n 1.0v 444.755n 0.0v 449.745n 0.0v 449.755n 0.0v 454.745n 0.0v 454.755n 0.0v 459.745n 0.0v 459.755n 0.0v 464.745n 0.0v 464.755n 0.0v 469.745n 0.0v 469.755n 0.0v 474.745n 0.0v 474.755n 0.0v 479.745n 0.0v 479.755n 0.0v 484.745n 0.0v 484.755n 1.0v 489.745n 1.0v 489.755n 1.0v 494.745n 1.0v 494.755n 1.0v 499.745n 1.0v 499.755n 0.0v 504.745n 0.0v 504.755n 0.0v 509.745n 0.0v 509.755n 0.0v 514.745n 0.0v 514.755n 0.0v 519.745n 0.0v 519.755n 0.0v 524.745n 0.0v 524.755n 0.0v 529.745n 0.0v 529.755n 0.0v 534.745n 0.0v 534.755n 1.0v 539.745n 1.0v 539.755n 0.0v 544.745n 0.0v 544.755n 1.0v 549.745n 1.0v 549.755n 1.0v 554.745n 1.0v 554.755n 1.0v 559.745n 1.0v 559.755n 1.0v 564.745n 1.0v 564.755n 1.0v 569.745n 1.0v 569.755n 1.0v 574.745n 1.0v 574.755n 1.0v 579.745n 1.0v 579.755n 1.0v 584.745n 1.0v 584.755n 1.0v 589.745n 1.0v 589.755n 1.0v 594.745n 1.0v 594.755n 1.0v 599.745n 1.0v 599.755n 0.0v 604.745n 0.0v 604.755n 0.0v 609.745n 0.0v 609.755n 1.0v 614.745n 1.0v 614.755n 1.0v 619.745n 1.0v 619.755n 0.0v 624.745n 0.0v 624.755n 0.0v 629.745n 0.0v 629.755n 0.0v 634.745n 0.0v 634.755n 0.0v 639.745n 0.0v 639.755n 0.0v 644.745n 0.0v 644.755n 1.0v 649.745n 1.0v 649.755n 1.0v 654.745n 1.0v 654.755n 1.0v 659.745n 1.0v 659.755n 1.0v 664.745n 1.0v 664.755n 1.0v 669.745n 1.0v 669.755n 1.0v 674.745n 1.0v 674.755n 1.0v 679.745n 1.0v 679.755n 1.0v 684.745n 1.0v 684.755n 1.0v 689.745n 1.0v 689.755n 1.0v 694.745n 1.0v 694.755n 1.0v 699.745n 1.0v 699.755n 1.0v 704.745n 1.0v 704.755n 1.0v 709.745n 1.0v 709.755n 1.0v 714.745n 1.0v 714.755n 1.0v 719.745n 1.0v 719.755n 1.0v 724.745n 1.0v 724.755n 1.0v 729.745n 1.0v 729.755n 1.0v 734.745n 1.0v 734.755n 1.0v 739.745n 1.0v 739.755n 0.0v 744.745n 0.0v 744.755n 0.0v 749.745n 0.0v 749.755n 0.0v 754.745n 0.0v 754.755n 0.0v 759.745n 0.0v 759.755n 0.0v 764.745n 0.0v 764.755n 0.0v 769.745n 0.0v 769.755n 1.0v 774.745n 1.0v 774.755n 1.0v 779.745n 1.0v 779.755n 1.0v 784.745n 1.0v 784.755n 1.0v 789.745n 1.0v 789.755n 1.0v 794.745n 1.0v 794.755n 1.0v 799.745n 1.0v 799.755n 1.0v 804.745n 1.0v 804.755n 0.0v 809.745n 0.0v 809.755n 1.0v 814.745n 1.0v 814.755n 1.0v 819.745n 1.0v 819.755n 1.0v 824.745n 1.0v 824.755n 1.0v 829.745n 1.0v 829.755n 1.0v 834.745n 1.0v 834.755n 1.0v 839.745n 1.0v 839.755n 0.0v 844.745n 0.0v 844.755n 0.0v 849.745n 0.0v 849.755n 0.0v 854.745n 0.0v 854.755n 0.0v 859.745n 0.0v 859.755n 0.0v 864.745n 0.0v 864.755n 1.0v 869.745n 1.0v 869.755n 1.0v 874.745n 1.0v 874.755n 1.0v 879.745n 1.0v 879.755n 1.0v 884.745n 1.0v 884.755n 1.0v 889.745n 1.0v 889.755n 1.0v 894.745n 1.0v 894.755n 1.0v 899.745n 1.0v 899.755n 1.0v 904.745n 1.0v 904.755n 1.0v 909.745n 1.0v 909.755n 1.0v 914.745n 1.0v 914.755n 0.0v 919.745n 0.0v 919.755n 0.0v 924.745n 0.0v 924.755n 0.0v 929.745n 0.0v 929.755n 1.0v 934.745n 1.0v 934.755n 1.0v 939.745n 1.0v 939.755n 1.0v 944.745n 1.0v 944.755n 1.0v 949.745n 1.0v 949.755n 1.0v 954.745n 1.0v 954.755n 1.0v 959.745n 1.0v 959.755n 1.0v 964.745n 1.0v 964.755n 0.0v 969.745n 0.0v 969.755n 0.0v 974.745n 0.0v 974.755n 0.0v 979.745n 0.0v 979.755n 0.0v 984.745n 0.0v 984.755n 0.0v 989.745n 0.0v 989.755n 0.0v 994.745n 0.0v 994.755n 0.0v 999.745n 0.0v 999.755n 0.0v 1004.745n 0.0v 1004.755n 0.0v 1009.745n 0.0v 1009.755n 0.0v 1014.745n 0.0v 1014.755n 0.0v 1019.745n 0.0v 1019.755n 1.0v 1024.745n 1.0v 1024.755n 1.0v )
* (time, data): [(0, 0), (5, 1), (10, 1), (15, 0), (20, 0), (25, 0), (30, 1), (35, 1), (40, 1), (45, 1), (50, 1), (55, 1), (60, 1), (65, 0), (70, 0), (75, 0), (80, 0), (85, 1), (90, 1), (95, 1), (100, 1), (105, 0), (110, 0), (115, 0), (120, 0), (125, 0), (130, 0), (135, 0), (140, 0), (145, 0), (150, 0), (155, 1), (160, 1), (165, 1), (170, 1), (175, 1), (180, 1), (185, 1), (190, 1), (195, 1), (200, 1), (205, 1), (210, 1), (215, 1), (220, 1), (225, 1), (230, 1), (235, 1), (240, 1), (245, 0), (250, 0), (255, 0), (260, 0), (265, 0), (270, 0), (275, 0), (280, 0), (285, 0), (290, 0), (295, 0), (300, 0), (305, 0), (310, 0), (315, 0), (320, 0), (325, 0), (330, 0), (335, 1), (340, 1), (345, 1), (350, 0), (355, 0), (360, 0), (365, 0), (370, 0), (375, 0), (380, 0), (385, 0), (390, 0), (395, 0), (400, 0), (405, 0), (410, 0), (415, 0), (420, 0), (425, 0), (430, 0), (435, 1), (440, 1), (445, 0), (450, 0), (455, 0), (460, 0), (465, 0), (470, 0), (475, 0), (480, 0), (485, 1), (490, 0), (495, 0), (500, 1), (505, 1), (510, 1), (515, 1), (520, 1), (525, 1), (530, 1), (535, 1), (540, 1), (545, 1), (550, 0), (555, 0), (560, 0), (565, 0), (570, 0), (575, 0), (580, 0), (585, 0), (590, 0), (595, 0), (600, 0), (605, 0), (610, 0), (615, 0), (620, 1), (625, 1), (630, 1), (635, 0), (640, 0), (645, 0), (650, 0), (655, 0), (660, 0), (665, 0), (670, 1), (675, 1), (680, 1), (685, 1), (690, 1), (695, 1), (700, 1), (705, 1), (710, 1), (715, 1), (720, 0), (725, 0), (730, 0), (735, 0), (740, 1), (745, 1), (750, 1), (755, 1), (760, 1), (765, 1), (770, 1), (775, 1), (780, 1), (785, 1), (790, 1), (795, 1), (800, 1), (805, 1), (810, 1), (815, 1), (820, 1), (825, 1), (830, 1), (835, 1), (840, 0), (845, 0), (850, 0), (855, 0), (860, 0), (865, 1), (870, 1), (875, 1), (880, 1), (885, 1), (890, 1), (895, 1), (900, 1), (905, 1), (910, 0), (915, 0), (920, 0), (925, 0), (930, 1), (935, 1), (940, 1), (945, 1), (950, 1), (955, 1), (960, 1), (965, 0), (970, 0), (975, 0), (980, 0), (985, 0), (990, 0), (995, 0), (1000, 0), (1005, 0), (1010, 0), (1015, 0), (1020, 0), (1025, 0)]
Vdin0_29  din0_29  0 PWL (0n 0.0v 4.745n 0.0v 4.755n 1.0v 9.745n 1.0v 9.755n 1.0v 14.745n 1.0v 14.755n 0.0v 19.745n 0.0v 19.755n 0.0v 24.745n 0.0v 24.755n 0.0v 29.745n 0.0v 29.755n 1.0v 34.745n 1.0v 34.755n 1.0v 39.745n 1.0v 39.755n 1.0v 44.745n 1.0v 44.755n 1.0v 49.745n 1.0v 49.755n 1.0v 54.745n 1.0v 54.755n 1.0v 59.745n 1.0v 59.755n 1.0v 64.745n 1.0v 64.755n 0.0v 69.745n 0.0v 69.755n 0.0v 74.745n 0.0v 74.755n 0.0v 79.745n 0.0v 79.755n 0.0v 84.745n 0.0v 84.755n 1.0v 89.745n 1.0v 89.755n 1.0v 94.745n 1.0v 94.755n 1.0v 99.745n 1.0v 99.755n 1.0v 104.745n 1.0v 104.755n 0.0v 109.745n 0.0v 109.755n 0.0v 114.745n 0.0v 114.755n 0.0v 119.745n 0.0v 119.755n 0.0v 124.745n 0.0v 124.755n 0.0v 129.745n 0.0v 129.755n 0.0v 134.745n 0.0v 134.755n 0.0v 139.745n 0.0v 139.755n 0.0v 144.745n 0.0v 144.755n 0.0v 149.745n 0.0v 149.755n 0.0v 154.745n 0.0v 154.755n 1.0v 159.745n 1.0v 159.755n 1.0v 164.745n 1.0v 164.755n 1.0v 169.745n 1.0v 169.755n 1.0v 174.745n 1.0v 174.755n 1.0v 179.745n 1.0v 179.755n 1.0v 184.745n 1.0v 184.755n 1.0v 189.745n 1.0v 189.755n 1.0v 194.745n 1.0v 194.755n 1.0v 199.745n 1.0v 199.755n 1.0v 204.745n 1.0v 204.755n 1.0v 209.745n 1.0v 209.755n 1.0v 214.745n 1.0v 214.755n 1.0v 219.745n 1.0v 219.755n 1.0v 224.745n 1.0v 224.755n 1.0v 229.745n 1.0v 229.755n 1.0v 234.745n 1.0v 234.755n 1.0v 239.745n 1.0v 239.755n 1.0v 244.745n 1.0v 244.755n 0.0v 249.745n 0.0v 249.755n 0.0v 254.745n 0.0v 254.755n 0.0v 259.745n 0.0v 259.755n 0.0v 264.745n 0.0v 264.755n 0.0v 269.745n 0.0v 269.755n 0.0v 274.745n 0.0v 274.755n 0.0v 279.745n 0.0v 279.755n 0.0v 284.745n 0.0v 284.755n 0.0v 289.745n 0.0v 289.755n 0.0v 294.745n 0.0v 294.755n 0.0v 299.745n 0.0v 299.755n 0.0v 304.745n 0.0v 304.755n 0.0v 309.745n 0.0v 309.755n 0.0v 314.745n 0.0v 314.755n 0.0v 319.745n 0.0v 319.755n 0.0v 324.745n 0.0v 324.755n 0.0v 329.745n 0.0v 329.755n 0.0v 334.745n 0.0v 334.755n 1.0v 339.745n 1.0v 339.755n 1.0v 344.745n 1.0v 344.755n 1.0v 349.745n 1.0v 349.755n 0.0v 354.745n 0.0v 354.755n 0.0v 359.745n 0.0v 359.755n 0.0v 364.745n 0.0v 364.755n 0.0v 369.745n 0.0v 369.755n 0.0v 374.745n 0.0v 374.755n 0.0v 379.745n 0.0v 379.755n 0.0v 384.745n 0.0v 384.755n 0.0v 389.745n 0.0v 389.755n 0.0v 394.745n 0.0v 394.755n 0.0v 399.745n 0.0v 399.755n 0.0v 404.745n 0.0v 404.755n 0.0v 409.745n 0.0v 409.755n 0.0v 414.745n 0.0v 414.755n 0.0v 419.745n 0.0v 419.755n 0.0v 424.745n 0.0v 424.755n 0.0v 429.745n 0.0v 429.755n 0.0v 434.745n 0.0v 434.755n 1.0v 439.745n 1.0v 439.755n 1.0v 444.745n 1.0v 444.755n 0.0v 449.745n 0.0v 449.755n 0.0v 454.745n 0.0v 454.755n 0.0v 459.745n 0.0v 459.755n 0.0v 464.745n 0.0v 464.755n 0.0v 469.745n 0.0v 469.755n 0.0v 474.745n 0.0v 474.755n 0.0v 479.745n 0.0v 479.755n 0.0v 484.745n 0.0v 484.755n 1.0v 489.745n 1.0v 489.755n 0.0v 494.745n 0.0v 494.755n 0.0v 499.745n 0.0v 499.755n 1.0v 504.745n 1.0v 504.755n 1.0v 509.745n 1.0v 509.755n 1.0v 514.745n 1.0v 514.755n 1.0v 519.745n 1.0v 519.755n 1.0v 524.745n 1.0v 524.755n 1.0v 529.745n 1.0v 529.755n 1.0v 534.745n 1.0v 534.755n 1.0v 539.745n 1.0v 539.755n 1.0v 544.745n 1.0v 544.755n 1.0v 549.745n 1.0v 549.755n 0.0v 554.745n 0.0v 554.755n 0.0v 559.745n 0.0v 559.755n 0.0v 564.745n 0.0v 564.755n 0.0v 569.745n 0.0v 569.755n 0.0v 574.745n 0.0v 574.755n 0.0v 579.745n 0.0v 579.755n 0.0v 584.745n 0.0v 584.755n 0.0v 589.745n 0.0v 589.755n 0.0v 594.745n 0.0v 594.755n 0.0v 599.745n 0.0v 599.755n 0.0v 604.745n 0.0v 604.755n 0.0v 609.745n 0.0v 609.755n 0.0v 614.745n 0.0v 614.755n 0.0v 619.745n 0.0v 619.755n 1.0v 624.745n 1.0v 624.755n 1.0v 629.745n 1.0v 629.755n 1.0v 634.745n 1.0v 634.755n 0.0v 639.745n 0.0v 639.755n 0.0v 644.745n 0.0v 644.755n 0.0v 649.745n 0.0v 649.755n 0.0v 654.745n 0.0v 654.755n 0.0v 659.745n 0.0v 659.755n 0.0v 664.745n 0.0v 664.755n 0.0v 669.745n 0.0v 669.755n 1.0v 674.745n 1.0v 674.755n 1.0v 679.745n 1.0v 679.755n 1.0v 684.745n 1.0v 684.755n 1.0v 689.745n 1.0v 689.755n 1.0v 694.745n 1.0v 694.755n 1.0v 699.745n 1.0v 699.755n 1.0v 704.745n 1.0v 704.755n 1.0v 709.745n 1.0v 709.755n 1.0v 714.745n 1.0v 714.755n 1.0v 719.745n 1.0v 719.755n 0.0v 724.745n 0.0v 724.755n 0.0v 729.745n 0.0v 729.755n 0.0v 734.745n 0.0v 734.755n 0.0v 739.745n 0.0v 739.755n 1.0v 744.745n 1.0v 744.755n 1.0v 749.745n 1.0v 749.755n 1.0v 754.745n 1.0v 754.755n 1.0v 759.745n 1.0v 759.755n 1.0v 764.745n 1.0v 764.755n 1.0v 769.745n 1.0v 769.755n 1.0v 774.745n 1.0v 774.755n 1.0v 779.745n 1.0v 779.755n 1.0v 784.745n 1.0v 784.755n 1.0v 789.745n 1.0v 789.755n 1.0v 794.745n 1.0v 794.755n 1.0v 799.745n 1.0v 799.755n 1.0v 804.745n 1.0v 804.755n 1.0v 809.745n 1.0v 809.755n 1.0v 814.745n 1.0v 814.755n 1.0v 819.745n 1.0v 819.755n 1.0v 824.745n 1.0v 824.755n 1.0v 829.745n 1.0v 829.755n 1.0v 834.745n 1.0v 834.755n 1.0v 839.745n 1.0v 839.755n 0.0v 844.745n 0.0v 844.755n 0.0v 849.745n 0.0v 849.755n 0.0v 854.745n 0.0v 854.755n 0.0v 859.745n 0.0v 859.755n 0.0v 864.745n 0.0v 864.755n 1.0v 869.745n 1.0v 869.755n 1.0v 874.745n 1.0v 874.755n 1.0v 879.745n 1.0v 879.755n 1.0v 884.745n 1.0v 884.755n 1.0v 889.745n 1.0v 889.755n 1.0v 894.745n 1.0v 894.755n 1.0v 899.745n 1.0v 899.755n 1.0v 904.745n 1.0v 904.755n 1.0v 909.745n 1.0v 909.755n 0.0v 914.745n 0.0v 914.755n 0.0v 919.745n 0.0v 919.755n 0.0v 924.745n 0.0v 924.755n 0.0v 929.745n 0.0v 929.755n 1.0v 934.745n 1.0v 934.755n 1.0v 939.745n 1.0v 939.755n 1.0v 944.745n 1.0v 944.755n 1.0v 949.745n 1.0v 949.755n 1.0v 954.745n 1.0v 954.755n 1.0v 959.745n 1.0v 959.755n 1.0v 964.745n 1.0v 964.755n 0.0v 969.745n 0.0v 969.755n 0.0v 974.745n 0.0v 974.755n 0.0v 979.745n 0.0v 979.755n 0.0v 984.745n 0.0v 984.755n 0.0v 989.745n 0.0v 989.755n 0.0v 994.745n 0.0v 994.755n 0.0v 999.745n 0.0v 999.755n 0.0v 1004.745n 0.0v 1004.755n 0.0v 1009.745n 0.0v 1009.755n 0.0v 1014.745n 0.0v 1014.755n 0.0v 1019.745n 0.0v 1019.755n 0.0v 1024.745n 0.0v 1024.755n 0.0v )
* (time, data): [(0, 0), (5, 1), (10, 1), (15, 1), (20, 1), (25, 1), (30, 1), (35, 1), (40, 1), (45, 1), (50, 1), (55, 1), (60, 1), (65, 1), (70, 1), (75, 1), (80, 1), (85, 1), (90, 1), (95, 1), (100, 1), (105, 0), (110, 0), (115, 1), (120, 1), (125, 1), (130, 1), (135, 1), (140, 1), (145, 1), (150, 1), (155, 0), (160, 0), (165, 0), (170, 0), (175, 1), (180, 1), (185, 1), (190, 1), (195, 1), (200, 1), (205, 1), (210, 1), (215, 1), (220, 1), (225, 1), (230, 1), (235, 1), (240, 1), (245, 1), (250, 1), (255, 1), (260, 1), (265, 1), (270, 1), (275, 1), (280, 1), (285, 1), (290, 0), (295, 0), (300, 0), (305, 0), (310, 0), (315, 0), (320, 0), (325, 0), (330, 0), (335, 0), (340, 0), (345, 0), (350, 0), (355, 0), (360, 0), (365, 0), (370, 0), (375, 0), (380, 0), (385, 0), (390, 0), (395, 0), (400, 0), (405, 0), (410, 0), (415, 0), (420, 0), (425, 0), (430, 0), (435, 0), (440, 0), (445, 1), (450, 1), (455, 1), (460, 1), (465, 1), (470, 1), (475, 1), (480, 1), (485, 0), (490, 1), (495, 1), (500, 0), (505, 0), (510, 0), (515, 0), (520, 0), (525, 0), (530, 0), (535, 1), (540, 1), (545, 0), (550, 0), (555, 0), (560, 1), (565, 1), (570, 1), (575, 1), (580, 1), (585, 1), (590, 1), (595, 1), (600, 1), (605, 1), (610, 1), (615, 1), (620, 1), (625, 1), (630, 1), (635, 0), (640, 0), (645, 1), (650, 0), (655, 0), (660, 0), (665, 0), (670, 1), (675, 1), (680, 1), (685, 1), (690, 1), (695, 1), (700, 1), (705, 1), (710, 1), (715, 1), (720, 1), (725, 1), (730, 1), (735, 1), (740, 1), (745, 1), (750, 1), (755, 1), (760, 1), (765, 1), (770, 1), (775, 1), (780, 1), (785, 1), (790, 1), (795, 1), (800, 1), (805, 1), (810, 0), (815, 0), (820, 0), (825, 0), (830, 0), (835, 0), (840, 1), (845, 1), (850, 0), (855, 0), (860, 0), (865, 1), (870, 1), (875, 1), (880, 1), (885, 1), (890, 1), (895, 1), (900, 1), (905, 1), (910, 1), (915, 0), (920, 0), (925, 0), (930, 0), (935, 0), (940, 0), (945, 0), (950, 0), (955, 0), (960, 0), (965, 1), (970, 1), (975, 1), (980, 1), (985, 1), (990, 1), (995, 1), (1000, 1), (1005, 1), (1010, 1), (1015, 1), (1020, 0), (1025, 0)]
Vdin0_30  din0_30  0 PWL (0n 0.0v 4.745n 0.0v 4.755n 1.0v 9.745n 1.0v 9.755n 1.0v 14.745n 1.0v 14.755n 1.0v 19.745n 1.0v 19.755n 1.0v 24.745n 1.0v 24.755n 1.0v 29.745n 1.0v 29.755n 1.0v 34.745n 1.0v 34.755n 1.0v 39.745n 1.0v 39.755n 1.0v 44.745n 1.0v 44.755n 1.0v 49.745n 1.0v 49.755n 1.0v 54.745n 1.0v 54.755n 1.0v 59.745n 1.0v 59.755n 1.0v 64.745n 1.0v 64.755n 1.0v 69.745n 1.0v 69.755n 1.0v 74.745n 1.0v 74.755n 1.0v 79.745n 1.0v 79.755n 1.0v 84.745n 1.0v 84.755n 1.0v 89.745n 1.0v 89.755n 1.0v 94.745n 1.0v 94.755n 1.0v 99.745n 1.0v 99.755n 1.0v 104.745n 1.0v 104.755n 0.0v 109.745n 0.0v 109.755n 0.0v 114.745n 0.0v 114.755n 1.0v 119.745n 1.0v 119.755n 1.0v 124.745n 1.0v 124.755n 1.0v 129.745n 1.0v 129.755n 1.0v 134.745n 1.0v 134.755n 1.0v 139.745n 1.0v 139.755n 1.0v 144.745n 1.0v 144.755n 1.0v 149.745n 1.0v 149.755n 1.0v 154.745n 1.0v 154.755n 0.0v 159.745n 0.0v 159.755n 0.0v 164.745n 0.0v 164.755n 0.0v 169.745n 0.0v 169.755n 0.0v 174.745n 0.0v 174.755n 1.0v 179.745n 1.0v 179.755n 1.0v 184.745n 1.0v 184.755n 1.0v 189.745n 1.0v 189.755n 1.0v 194.745n 1.0v 194.755n 1.0v 199.745n 1.0v 199.755n 1.0v 204.745n 1.0v 204.755n 1.0v 209.745n 1.0v 209.755n 1.0v 214.745n 1.0v 214.755n 1.0v 219.745n 1.0v 219.755n 1.0v 224.745n 1.0v 224.755n 1.0v 229.745n 1.0v 229.755n 1.0v 234.745n 1.0v 234.755n 1.0v 239.745n 1.0v 239.755n 1.0v 244.745n 1.0v 244.755n 1.0v 249.745n 1.0v 249.755n 1.0v 254.745n 1.0v 254.755n 1.0v 259.745n 1.0v 259.755n 1.0v 264.745n 1.0v 264.755n 1.0v 269.745n 1.0v 269.755n 1.0v 274.745n 1.0v 274.755n 1.0v 279.745n 1.0v 279.755n 1.0v 284.745n 1.0v 284.755n 1.0v 289.745n 1.0v 289.755n 0.0v 294.745n 0.0v 294.755n 0.0v 299.745n 0.0v 299.755n 0.0v 304.745n 0.0v 304.755n 0.0v 309.745n 0.0v 309.755n 0.0v 314.745n 0.0v 314.755n 0.0v 319.745n 0.0v 319.755n 0.0v 324.745n 0.0v 324.755n 0.0v 329.745n 0.0v 329.755n 0.0v 334.745n 0.0v 334.755n 0.0v 339.745n 0.0v 339.755n 0.0v 344.745n 0.0v 344.755n 0.0v 349.745n 0.0v 349.755n 0.0v 354.745n 0.0v 354.755n 0.0v 359.745n 0.0v 359.755n 0.0v 364.745n 0.0v 364.755n 0.0v 369.745n 0.0v 369.755n 0.0v 374.745n 0.0v 374.755n 0.0v 379.745n 0.0v 379.755n 0.0v 384.745n 0.0v 384.755n 0.0v 389.745n 0.0v 389.755n 0.0v 394.745n 0.0v 394.755n 0.0v 399.745n 0.0v 399.755n 0.0v 404.745n 0.0v 404.755n 0.0v 409.745n 0.0v 409.755n 0.0v 414.745n 0.0v 414.755n 0.0v 419.745n 0.0v 419.755n 0.0v 424.745n 0.0v 424.755n 0.0v 429.745n 0.0v 429.755n 0.0v 434.745n 0.0v 434.755n 0.0v 439.745n 0.0v 439.755n 0.0v 444.745n 0.0v 444.755n 1.0v 449.745n 1.0v 449.755n 1.0v 454.745n 1.0v 454.755n 1.0v 459.745n 1.0v 459.755n 1.0v 464.745n 1.0v 464.755n 1.0v 469.745n 1.0v 469.755n 1.0v 474.745n 1.0v 474.755n 1.0v 479.745n 1.0v 479.755n 1.0v 484.745n 1.0v 484.755n 0.0v 489.745n 0.0v 489.755n 1.0v 494.745n 1.0v 494.755n 1.0v 499.745n 1.0v 499.755n 0.0v 504.745n 0.0v 504.755n 0.0v 509.745n 0.0v 509.755n 0.0v 514.745n 0.0v 514.755n 0.0v 519.745n 0.0v 519.755n 0.0v 524.745n 0.0v 524.755n 0.0v 529.745n 0.0v 529.755n 0.0v 534.745n 0.0v 534.755n 1.0v 539.745n 1.0v 539.755n 1.0v 544.745n 1.0v 544.755n 0.0v 549.745n 0.0v 549.755n 0.0v 554.745n 0.0v 554.755n 0.0v 559.745n 0.0v 559.755n 1.0v 564.745n 1.0v 564.755n 1.0v 569.745n 1.0v 569.755n 1.0v 574.745n 1.0v 574.755n 1.0v 579.745n 1.0v 579.755n 1.0v 584.745n 1.0v 584.755n 1.0v 589.745n 1.0v 589.755n 1.0v 594.745n 1.0v 594.755n 1.0v 599.745n 1.0v 599.755n 1.0v 604.745n 1.0v 604.755n 1.0v 609.745n 1.0v 609.755n 1.0v 614.745n 1.0v 614.755n 1.0v 619.745n 1.0v 619.755n 1.0v 624.745n 1.0v 624.755n 1.0v 629.745n 1.0v 629.755n 1.0v 634.745n 1.0v 634.755n 0.0v 639.745n 0.0v 639.755n 0.0v 644.745n 0.0v 644.755n 1.0v 649.745n 1.0v 649.755n 0.0v 654.745n 0.0v 654.755n 0.0v 659.745n 0.0v 659.755n 0.0v 664.745n 0.0v 664.755n 0.0v 669.745n 0.0v 669.755n 1.0v 674.745n 1.0v 674.755n 1.0v 679.745n 1.0v 679.755n 1.0v 684.745n 1.0v 684.755n 1.0v 689.745n 1.0v 689.755n 1.0v 694.745n 1.0v 694.755n 1.0v 699.745n 1.0v 699.755n 1.0v 704.745n 1.0v 704.755n 1.0v 709.745n 1.0v 709.755n 1.0v 714.745n 1.0v 714.755n 1.0v 719.745n 1.0v 719.755n 1.0v 724.745n 1.0v 724.755n 1.0v 729.745n 1.0v 729.755n 1.0v 734.745n 1.0v 734.755n 1.0v 739.745n 1.0v 739.755n 1.0v 744.745n 1.0v 744.755n 1.0v 749.745n 1.0v 749.755n 1.0v 754.745n 1.0v 754.755n 1.0v 759.745n 1.0v 759.755n 1.0v 764.745n 1.0v 764.755n 1.0v 769.745n 1.0v 769.755n 1.0v 774.745n 1.0v 774.755n 1.0v 779.745n 1.0v 779.755n 1.0v 784.745n 1.0v 784.755n 1.0v 789.745n 1.0v 789.755n 1.0v 794.745n 1.0v 794.755n 1.0v 799.745n 1.0v 799.755n 1.0v 804.745n 1.0v 804.755n 1.0v 809.745n 1.0v 809.755n 0.0v 814.745n 0.0v 814.755n 0.0v 819.745n 0.0v 819.755n 0.0v 824.745n 0.0v 824.755n 0.0v 829.745n 0.0v 829.755n 0.0v 834.745n 0.0v 834.755n 0.0v 839.745n 0.0v 839.755n 1.0v 844.745n 1.0v 844.755n 1.0v 849.745n 1.0v 849.755n 0.0v 854.745n 0.0v 854.755n 0.0v 859.745n 0.0v 859.755n 0.0v 864.745n 0.0v 864.755n 1.0v 869.745n 1.0v 869.755n 1.0v 874.745n 1.0v 874.755n 1.0v 879.745n 1.0v 879.755n 1.0v 884.745n 1.0v 884.755n 1.0v 889.745n 1.0v 889.755n 1.0v 894.745n 1.0v 894.755n 1.0v 899.745n 1.0v 899.755n 1.0v 904.745n 1.0v 904.755n 1.0v 909.745n 1.0v 909.755n 1.0v 914.745n 1.0v 914.755n 0.0v 919.745n 0.0v 919.755n 0.0v 924.745n 0.0v 924.755n 0.0v 929.745n 0.0v 929.755n 0.0v 934.745n 0.0v 934.755n 0.0v 939.745n 0.0v 939.755n 0.0v 944.745n 0.0v 944.755n 0.0v 949.745n 0.0v 949.755n 0.0v 954.745n 0.0v 954.755n 0.0v 959.745n 0.0v 959.755n 0.0v 964.745n 0.0v 964.755n 1.0v 969.745n 1.0v 969.755n 1.0v 974.745n 1.0v 974.755n 1.0v 979.745n 1.0v 979.755n 1.0v 984.745n 1.0v 984.755n 1.0v 989.745n 1.0v 989.755n 1.0v 994.745n 1.0v 994.755n 1.0v 999.745n 1.0v 999.755n 1.0v 1004.745n 1.0v 1004.755n 1.0v 1009.745n 1.0v 1009.755n 1.0v 1014.745n 1.0v 1014.755n 1.0v 1019.745n 1.0v 1019.755n 0.0v 1024.745n 0.0v 1024.755n 0.0v )
* (time, data): [(0, 0), (5, 1), (10, 1), (15, 1), (20, 1), (25, 1), (30, 0), (35, 0), (40, 0), (45, 0), (50, 1), (55, 1), (60, 1), (65, 1), (70, 1), (75, 1), (80, 1), (85, 0), (90, 0), (95, 0), (100, 0), (105, 1), (110, 1), (115, 0), (120, 0), (125, 0), (130, 0), (135, 0), (140, 0), (145, 0), (150, 0), (155, 0), (160, 0), (165, 0), (170, 0), (175, 1), (180, 1), (185, 1), (190, 0), (195, 1), (200, 1), (205, 1), (210, 1), (215, 1), (220, 1), (225, 1), (230, 1), (235, 1), (240, 1), (245, 0), (250, 0), (255, 0), (260, 0), (265, 0), (270, 0), (275, 0), (280, 0), (285, 0), (290, 0), (295, 0), (300, 0), (305, 0), (310, 0), (315, 0), (320, 0), (325, 0), (330, 0), (335, 1), (340, 1), (345, 1), (350, 0), (355, 0), (360, 0), (365, 0), (370, 0), (375, 0), (380, 0), (385, 0), (390, 0), (395, 0), (400, 0), (405, 0), (410, 0), (415, 0), (420, 0), (425, 0), (430, 0), (435, 1), (440, 1), (445, 1), (450, 1), (455, 1), (460, 1), (465, 1), (470, 1), (475, 1), (480, 1), (485, 0), (490, 1), (495, 1), (500, 0), (505, 0), (510, 0), (515, 1), (520, 1), (525, 1), (530, 1), (535, 0), (540, 0), (545, 1), (550, 0), (555, 0), (560, 0), (565, 0), (570, 0), (575, 0), (580, 0), (585, 0), (590, 0), (595, 0), (600, 1), (605, 1), (610, 0), (615, 0), (620, 1), (625, 1), (630, 1), (635, 0), (640, 0), (645, 0), (650, 0), (655, 0), (660, 0), (665, 0), (670, 0), (675, 0), (680, 0), (685, 0), (690, 0), (695, 0), (700, 0), (705, 0), (710, 0), (715, 0), (720, 0), (725, 0), (730, 0), (735, 0), (740, 1), (745, 1), (750, 1), (755, 1), (760, 1), (765, 1), (770, 0), (775, 0), (780, 0), (785, 0), (790, 0), (795, 0), (800, 0), (805, 1), (810, 1), (815, 1), (820, 1), (825, 1), (830, 1), (835, 1), (840, 0), (845, 0), (850, 1), (855, 1), (860, 1), (865, 1), (870, 1), (875, 1), (880, 1), (885, 1), (890, 1), (895, 1), (900, 1), (905, 1), (910, 1), (915, 1), (920, 1), (925, 1), (930, 1), (935, 1), (940, 1), (945, 1), (950, 1), (955, 1), (960, 1), (965, 0), (970, 0), (975, 0), (980, 0), (985, 0), (990, 0), (995, 0), (1000, 0), (1005, 0), (1010, 0), (1015, 0), (1020, 0), (1025, 0)]
Vdin0_31  din0_31  0 PWL (0n 0.0v 4.745n 0.0v 4.755n 1.0v 9.745n 1.0v 9.755n 1.0v 14.745n 1.0v 14.755n 1.0v 19.745n 1.0v 19.755n 1.0v 24.745n 1.0v 24.755n 1.0v 29.745n 1.0v 29.755n 0.0v 34.745n 0.0v 34.755n 0.0v 39.745n 0.0v 39.755n 0.0v 44.745n 0.0v 44.755n 0.0v 49.745n 0.0v 49.755n 1.0v 54.745n 1.0v 54.755n 1.0v 59.745n 1.0v 59.755n 1.0v 64.745n 1.0v 64.755n 1.0v 69.745n 1.0v 69.755n 1.0v 74.745n 1.0v 74.755n 1.0v 79.745n 1.0v 79.755n 1.0v 84.745n 1.0v 84.755n 0.0v 89.745n 0.0v 89.755n 0.0v 94.745n 0.0v 94.755n 0.0v 99.745n 0.0v 99.755n 0.0v 104.745n 0.0v 104.755n 1.0v 109.745n 1.0v 109.755n 1.0v 114.745n 1.0v 114.755n 0.0v 119.745n 0.0v 119.755n 0.0v 124.745n 0.0v 124.755n 0.0v 129.745n 0.0v 129.755n 0.0v 134.745n 0.0v 134.755n 0.0v 139.745n 0.0v 139.755n 0.0v 144.745n 0.0v 144.755n 0.0v 149.745n 0.0v 149.755n 0.0v 154.745n 0.0v 154.755n 0.0v 159.745n 0.0v 159.755n 0.0v 164.745n 0.0v 164.755n 0.0v 169.745n 0.0v 169.755n 0.0v 174.745n 0.0v 174.755n 1.0v 179.745n 1.0v 179.755n 1.0v 184.745n 1.0v 184.755n 1.0v 189.745n 1.0v 189.755n 0.0v 194.745n 0.0v 194.755n 1.0v 199.745n 1.0v 199.755n 1.0v 204.745n 1.0v 204.755n 1.0v 209.745n 1.0v 209.755n 1.0v 214.745n 1.0v 214.755n 1.0v 219.745n 1.0v 219.755n 1.0v 224.745n 1.0v 224.755n 1.0v 229.745n 1.0v 229.755n 1.0v 234.745n 1.0v 234.755n 1.0v 239.745n 1.0v 239.755n 1.0v 244.745n 1.0v 244.755n 0.0v 249.745n 0.0v 249.755n 0.0v 254.745n 0.0v 254.755n 0.0v 259.745n 0.0v 259.755n 0.0v 264.745n 0.0v 264.755n 0.0v 269.745n 0.0v 269.755n 0.0v 274.745n 0.0v 274.755n 0.0v 279.745n 0.0v 279.755n 0.0v 284.745n 0.0v 284.755n 0.0v 289.745n 0.0v 289.755n 0.0v 294.745n 0.0v 294.755n 0.0v 299.745n 0.0v 299.755n 0.0v 304.745n 0.0v 304.755n 0.0v 309.745n 0.0v 309.755n 0.0v 314.745n 0.0v 314.755n 0.0v 319.745n 0.0v 319.755n 0.0v 324.745n 0.0v 324.755n 0.0v 329.745n 0.0v 329.755n 0.0v 334.745n 0.0v 334.755n 1.0v 339.745n 1.0v 339.755n 1.0v 344.745n 1.0v 344.755n 1.0v 349.745n 1.0v 349.755n 0.0v 354.745n 0.0v 354.755n 0.0v 359.745n 0.0v 359.755n 0.0v 364.745n 0.0v 364.755n 0.0v 369.745n 0.0v 369.755n 0.0v 374.745n 0.0v 374.755n 0.0v 379.745n 0.0v 379.755n 0.0v 384.745n 0.0v 384.755n 0.0v 389.745n 0.0v 389.755n 0.0v 394.745n 0.0v 394.755n 0.0v 399.745n 0.0v 399.755n 0.0v 404.745n 0.0v 404.755n 0.0v 409.745n 0.0v 409.755n 0.0v 414.745n 0.0v 414.755n 0.0v 419.745n 0.0v 419.755n 0.0v 424.745n 0.0v 424.755n 0.0v 429.745n 0.0v 429.755n 0.0v 434.745n 0.0v 434.755n 1.0v 439.745n 1.0v 439.755n 1.0v 444.745n 1.0v 444.755n 1.0v 449.745n 1.0v 449.755n 1.0v 454.745n 1.0v 454.755n 1.0v 459.745n 1.0v 459.755n 1.0v 464.745n 1.0v 464.755n 1.0v 469.745n 1.0v 469.755n 1.0v 474.745n 1.0v 474.755n 1.0v 479.745n 1.0v 479.755n 1.0v 484.745n 1.0v 484.755n 0.0v 489.745n 0.0v 489.755n 1.0v 494.745n 1.0v 494.755n 1.0v 499.745n 1.0v 499.755n 0.0v 504.745n 0.0v 504.755n 0.0v 509.745n 0.0v 509.755n 0.0v 514.745n 0.0v 514.755n 1.0v 519.745n 1.0v 519.755n 1.0v 524.745n 1.0v 524.755n 1.0v 529.745n 1.0v 529.755n 1.0v 534.745n 1.0v 534.755n 0.0v 539.745n 0.0v 539.755n 0.0v 544.745n 0.0v 544.755n 1.0v 549.745n 1.0v 549.755n 0.0v 554.745n 0.0v 554.755n 0.0v 559.745n 0.0v 559.755n 0.0v 564.745n 0.0v 564.755n 0.0v 569.745n 0.0v 569.755n 0.0v 574.745n 0.0v 574.755n 0.0v 579.745n 0.0v 579.755n 0.0v 584.745n 0.0v 584.755n 0.0v 589.745n 0.0v 589.755n 0.0v 594.745n 0.0v 594.755n 0.0v 599.745n 0.0v 599.755n 1.0v 604.745n 1.0v 604.755n 1.0v 609.745n 1.0v 609.755n 0.0v 614.745n 0.0v 614.755n 0.0v 619.745n 0.0v 619.755n 1.0v 624.745n 1.0v 624.755n 1.0v 629.745n 1.0v 629.755n 1.0v 634.745n 1.0v 634.755n 0.0v 639.745n 0.0v 639.755n 0.0v 644.745n 0.0v 644.755n 0.0v 649.745n 0.0v 649.755n 0.0v 654.745n 0.0v 654.755n 0.0v 659.745n 0.0v 659.755n 0.0v 664.745n 0.0v 664.755n 0.0v 669.745n 0.0v 669.755n 0.0v 674.745n 0.0v 674.755n 0.0v 679.745n 0.0v 679.755n 0.0v 684.745n 0.0v 684.755n 0.0v 689.745n 0.0v 689.755n 0.0v 694.745n 0.0v 694.755n 0.0v 699.745n 0.0v 699.755n 0.0v 704.745n 0.0v 704.755n 0.0v 709.745n 0.0v 709.755n 0.0v 714.745n 0.0v 714.755n 0.0v 719.745n 0.0v 719.755n 0.0v 724.745n 0.0v 724.755n 0.0v 729.745n 0.0v 729.755n 0.0v 734.745n 0.0v 734.755n 0.0v 739.745n 0.0v 739.755n 1.0v 744.745n 1.0v 744.755n 1.0v 749.745n 1.0v 749.755n 1.0v 754.745n 1.0v 754.755n 1.0v 759.745n 1.0v 759.755n 1.0v 764.745n 1.0v 764.755n 1.0v 769.745n 1.0v 769.755n 0.0v 774.745n 0.0v 774.755n 0.0v 779.745n 0.0v 779.755n 0.0v 784.745n 0.0v 784.755n 0.0v 789.745n 0.0v 789.755n 0.0v 794.745n 0.0v 794.755n 0.0v 799.745n 0.0v 799.755n 0.0v 804.745n 0.0v 804.755n 1.0v 809.745n 1.0v 809.755n 1.0v 814.745n 1.0v 814.755n 1.0v 819.745n 1.0v 819.755n 1.0v 824.745n 1.0v 824.755n 1.0v 829.745n 1.0v 829.755n 1.0v 834.745n 1.0v 834.755n 1.0v 839.745n 1.0v 839.755n 0.0v 844.745n 0.0v 844.755n 0.0v 849.745n 0.0v 849.755n 1.0v 854.745n 1.0v 854.755n 1.0v 859.745n 1.0v 859.755n 1.0v 864.745n 1.0v 864.755n 1.0v 869.745n 1.0v 869.755n 1.0v 874.745n 1.0v 874.755n 1.0v 879.745n 1.0v 879.755n 1.0v 884.745n 1.0v 884.755n 1.0v 889.745n 1.0v 889.755n 1.0v 894.745n 1.0v 894.755n 1.0v 899.745n 1.0v 899.755n 1.0v 904.745n 1.0v 904.755n 1.0v 909.745n 1.0v 909.755n 1.0v 914.745n 1.0v 914.755n 1.0v 919.745n 1.0v 919.755n 1.0v 924.745n 1.0v 924.755n 1.0v 929.745n 1.0v 929.755n 1.0v 934.745n 1.0v 934.755n 1.0v 939.745n 1.0v 939.755n 1.0v 944.745n 1.0v 944.755n 1.0v 949.745n 1.0v 949.755n 1.0v 954.745n 1.0v 954.755n 1.0v 959.745n 1.0v 959.755n 1.0v 964.745n 1.0v 964.755n 0.0v 969.745n 0.0v 969.755n 0.0v 974.745n 0.0v 974.755n 0.0v 979.745n 0.0v 979.755n 0.0v 984.745n 0.0v 984.755n 0.0v 989.745n 0.0v 989.755n 0.0v 994.745n 0.0v 994.755n 0.0v 999.745n 0.0v 999.755n 0.0v 1004.745n 0.0v 1004.755n 0.0v 1009.745n 0.0v 1009.755n 0.0v 1014.745n 0.0v 1014.755n 0.0v 1019.745n 0.0v 1019.755n 0.0v 1024.745n 0.0v 1024.755n 0.0v )
* (time, data): [(0, 0), (5, 1), (10, 1), (15, 0), (20, 0), (25, 0), (30, 1), (35, 1), (40, 0), (45, 0), (50, 1), (55, 1), (60, 1), (65, 1), (70, 1), (75, 1), (80, 1), (85, 0), (90, 0), (95, 0), (100, 1), (105, 1), (110, 1), (115, 0), (120, 0), (125, 0), (130, 0), (135, 0), (140, 0), (145, 0), (150, 0), (155, 0), (160, 0), (165, 0), (170, 0), (175, 0), (180, 0), (185, 0), (190, 0), (195, 1), (200, 1), (205, 1), (210, 1), (215, 1), (220, 1), (225, 1), (230, 1), (235, 1), (240, 1), (245, 1), (250, 1), (255, 1), (260, 1), (265, 1), (270, 1), (275, 1), (280, 1), (285, 1), (290, 0), (295, 0), (300, 0), (305, 0), (310, 0), (315, 0), (320, 0), (325, 0), (330, 0), (335, 1), (340, 1), (345, 1), (350, 0), (355, 0), (360, 0), (365, 0), (370, 0), (375, 0), (380, 0), (385, 0), (390, 0), (395, 0), (400, 0), (405, 0), (410, 0), (415, 0), (420, 0), (425, 0), (430, 0), (435, 1), (440, 1), (445, 0), (450, 0), (455, 0), (460, 0), (465, 0), (470, 0), (475, 0), (480, 0), (485, 1), (490, 1), (495, 1), (500, 1), (505, 1), (510, 1), (515, 1), (520, 1), (525, 1), (530, 1), (535, 0), (540, 1), (545, 0), (550, 1), (555, 1), (560, 0), (565, 0), (570, 0), (575, 0), (580, 0), (585, 0), (590, 0), (595, 0), (600, 1), (605, 1), (610, 0), (615, 0), (620, 0), (625, 0), (630, 0), (635, 0), (640, 0), (645, 0), (650, 1), (655, 1), (660, 1), (665, 1), (670, 0), (675, 0), (680, 0), (685, 0), (690, 0), (695, 0), (700, 0), (705, 0), (710, 0), (715, 0), (720, 0), (725, 0), (730, 0), (735, 0), (740, 1), (745, 1), (750, 1), (755, 1), (760, 1), (765, 1), (770, 1), (775, 1), (780, 0), (785, 0), (790, 0), (795, 0), (800, 0), (805, 0), (810, 0), (815, 0), (820, 0), (825, 0), (830, 0), (835, 0), (840, 0), (845, 0), (850, 0), (855, 0), (860, 0), (865, 0), (870, 0), (875, 0), (880, 0), (885, 0), (890, 0), (895, 0), (900, 0), (905, 0), (910, 1), (915, 0), (920, 0), (925, 0), (930, 0), (935, 0), (940, 0), (945, 0), (950, 0), (955, 0), (960, 0), (965, 0), (970, 0), (975, 0), (980, 0), (985, 0), (990, 0), (995, 0), (1000, 0), (1005, 0), (1010, 0), (1015, 0), (1020, 0), (1025, 0)]
Vdin0_32  din0_32  0 PWL (0n 0.0v 4.745n 0.0v 4.755n 1.0v 9.745n 1.0v 9.755n 1.0v 14.745n 1.0v 14.755n 0.0v 19.745n 0.0v 19.755n 0.0v 24.745n 0.0v 24.755n 0.0v 29.745n 0.0v 29.755n 1.0v 34.745n 1.0v 34.755n 1.0v 39.745n 1.0v 39.755n 0.0v 44.745n 0.0v 44.755n 0.0v 49.745n 0.0v 49.755n 1.0v 54.745n 1.0v 54.755n 1.0v 59.745n 1.0v 59.755n 1.0v 64.745n 1.0v 64.755n 1.0v 69.745n 1.0v 69.755n 1.0v 74.745n 1.0v 74.755n 1.0v 79.745n 1.0v 79.755n 1.0v 84.745n 1.0v 84.755n 0.0v 89.745n 0.0v 89.755n 0.0v 94.745n 0.0v 94.755n 0.0v 99.745n 0.0v 99.755n 1.0v 104.745n 1.0v 104.755n 1.0v 109.745n 1.0v 109.755n 1.0v 114.745n 1.0v 114.755n 0.0v 119.745n 0.0v 119.755n 0.0v 124.745n 0.0v 124.755n 0.0v 129.745n 0.0v 129.755n 0.0v 134.745n 0.0v 134.755n 0.0v 139.745n 0.0v 139.755n 0.0v 144.745n 0.0v 144.755n 0.0v 149.745n 0.0v 149.755n 0.0v 154.745n 0.0v 154.755n 0.0v 159.745n 0.0v 159.755n 0.0v 164.745n 0.0v 164.755n 0.0v 169.745n 0.0v 169.755n 0.0v 174.745n 0.0v 174.755n 0.0v 179.745n 0.0v 179.755n 0.0v 184.745n 0.0v 184.755n 0.0v 189.745n 0.0v 189.755n 0.0v 194.745n 0.0v 194.755n 1.0v 199.745n 1.0v 199.755n 1.0v 204.745n 1.0v 204.755n 1.0v 209.745n 1.0v 209.755n 1.0v 214.745n 1.0v 214.755n 1.0v 219.745n 1.0v 219.755n 1.0v 224.745n 1.0v 224.755n 1.0v 229.745n 1.0v 229.755n 1.0v 234.745n 1.0v 234.755n 1.0v 239.745n 1.0v 239.755n 1.0v 244.745n 1.0v 244.755n 1.0v 249.745n 1.0v 249.755n 1.0v 254.745n 1.0v 254.755n 1.0v 259.745n 1.0v 259.755n 1.0v 264.745n 1.0v 264.755n 1.0v 269.745n 1.0v 269.755n 1.0v 274.745n 1.0v 274.755n 1.0v 279.745n 1.0v 279.755n 1.0v 284.745n 1.0v 284.755n 1.0v 289.745n 1.0v 289.755n 0.0v 294.745n 0.0v 294.755n 0.0v 299.745n 0.0v 299.755n 0.0v 304.745n 0.0v 304.755n 0.0v 309.745n 0.0v 309.755n 0.0v 314.745n 0.0v 314.755n 0.0v 319.745n 0.0v 319.755n 0.0v 324.745n 0.0v 324.755n 0.0v 329.745n 0.0v 329.755n 0.0v 334.745n 0.0v 334.755n 1.0v 339.745n 1.0v 339.755n 1.0v 344.745n 1.0v 344.755n 1.0v 349.745n 1.0v 349.755n 0.0v 354.745n 0.0v 354.755n 0.0v 359.745n 0.0v 359.755n 0.0v 364.745n 0.0v 364.755n 0.0v 369.745n 0.0v 369.755n 0.0v 374.745n 0.0v 374.755n 0.0v 379.745n 0.0v 379.755n 0.0v 384.745n 0.0v 384.755n 0.0v 389.745n 0.0v 389.755n 0.0v 394.745n 0.0v 394.755n 0.0v 399.745n 0.0v 399.755n 0.0v 404.745n 0.0v 404.755n 0.0v 409.745n 0.0v 409.755n 0.0v 414.745n 0.0v 414.755n 0.0v 419.745n 0.0v 419.755n 0.0v 424.745n 0.0v 424.755n 0.0v 429.745n 0.0v 429.755n 0.0v 434.745n 0.0v 434.755n 1.0v 439.745n 1.0v 439.755n 1.0v 444.745n 1.0v 444.755n 0.0v 449.745n 0.0v 449.755n 0.0v 454.745n 0.0v 454.755n 0.0v 459.745n 0.0v 459.755n 0.0v 464.745n 0.0v 464.755n 0.0v 469.745n 0.0v 469.755n 0.0v 474.745n 0.0v 474.755n 0.0v 479.745n 0.0v 479.755n 0.0v 484.745n 0.0v 484.755n 1.0v 489.745n 1.0v 489.755n 1.0v 494.745n 1.0v 494.755n 1.0v 499.745n 1.0v 499.755n 1.0v 504.745n 1.0v 504.755n 1.0v 509.745n 1.0v 509.755n 1.0v 514.745n 1.0v 514.755n 1.0v 519.745n 1.0v 519.755n 1.0v 524.745n 1.0v 524.755n 1.0v 529.745n 1.0v 529.755n 1.0v 534.745n 1.0v 534.755n 0.0v 539.745n 0.0v 539.755n 1.0v 544.745n 1.0v 544.755n 0.0v 549.745n 0.0v 549.755n 1.0v 554.745n 1.0v 554.755n 1.0v 559.745n 1.0v 559.755n 0.0v 564.745n 0.0v 564.755n 0.0v 569.745n 0.0v 569.755n 0.0v 574.745n 0.0v 574.755n 0.0v 579.745n 0.0v 579.755n 0.0v 584.745n 0.0v 584.755n 0.0v 589.745n 0.0v 589.755n 0.0v 594.745n 0.0v 594.755n 0.0v 599.745n 0.0v 599.755n 1.0v 604.745n 1.0v 604.755n 1.0v 609.745n 1.0v 609.755n 0.0v 614.745n 0.0v 614.755n 0.0v 619.745n 0.0v 619.755n 0.0v 624.745n 0.0v 624.755n 0.0v 629.745n 0.0v 629.755n 0.0v 634.745n 0.0v 634.755n 0.0v 639.745n 0.0v 639.755n 0.0v 644.745n 0.0v 644.755n 0.0v 649.745n 0.0v 649.755n 1.0v 654.745n 1.0v 654.755n 1.0v 659.745n 1.0v 659.755n 1.0v 664.745n 1.0v 664.755n 1.0v 669.745n 1.0v 669.755n 0.0v 674.745n 0.0v 674.755n 0.0v 679.745n 0.0v 679.755n 0.0v 684.745n 0.0v 684.755n 0.0v 689.745n 0.0v 689.755n 0.0v 694.745n 0.0v 694.755n 0.0v 699.745n 0.0v 699.755n 0.0v 704.745n 0.0v 704.755n 0.0v 709.745n 0.0v 709.755n 0.0v 714.745n 0.0v 714.755n 0.0v 719.745n 0.0v 719.755n 0.0v 724.745n 0.0v 724.755n 0.0v 729.745n 0.0v 729.755n 0.0v 734.745n 0.0v 734.755n 0.0v 739.745n 0.0v 739.755n 1.0v 744.745n 1.0v 744.755n 1.0v 749.745n 1.0v 749.755n 1.0v 754.745n 1.0v 754.755n 1.0v 759.745n 1.0v 759.755n 1.0v 764.745n 1.0v 764.755n 1.0v 769.745n 1.0v 769.755n 1.0v 774.745n 1.0v 774.755n 1.0v 779.745n 1.0v 779.755n 0.0v 784.745n 0.0v 784.755n 0.0v 789.745n 0.0v 789.755n 0.0v 794.745n 0.0v 794.755n 0.0v 799.745n 0.0v 799.755n 0.0v 804.745n 0.0v 804.755n 0.0v 809.745n 0.0v 809.755n 0.0v 814.745n 0.0v 814.755n 0.0v 819.745n 0.0v 819.755n 0.0v 824.745n 0.0v 824.755n 0.0v 829.745n 0.0v 829.755n 0.0v 834.745n 0.0v 834.755n 0.0v 839.745n 0.0v 839.755n 0.0v 844.745n 0.0v 844.755n 0.0v 849.745n 0.0v 849.755n 0.0v 854.745n 0.0v 854.755n 0.0v 859.745n 0.0v 859.755n 0.0v 864.745n 0.0v 864.755n 0.0v 869.745n 0.0v 869.755n 0.0v 874.745n 0.0v 874.755n 0.0v 879.745n 0.0v 879.755n 0.0v 884.745n 0.0v 884.755n 0.0v 889.745n 0.0v 889.755n 0.0v 894.745n 0.0v 894.755n 0.0v 899.745n 0.0v 899.755n 0.0v 904.745n 0.0v 904.755n 0.0v 909.745n 0.0v 909.755n 1.0v 914.745n 1.0v 914.755n 0.0v 919.745n 0.0v 919.755n 0.0v 924.745n 0.0v 924.755n 0.0v 929.745n 0.0v 929.755n 0.0v 934.745n 0.0v 934.755n 0.0v 939.745n 0.0v 939.755n 0.0v 944.745n 0.0v 944.755n 0.0v 949.745n 0.0v 949.755n 0.0v 954.745n 0.0v 954.755n 0.0v 959.745n 0.0v 959.755n 0.0v 964.745n 0.0v 964.755n 0.0v 969.745n 0.0v 969.755n 0.0v 974.745n 0.0v 974.755n 0.0v 979.745n 0.0v 979.755n 0.0v 984.745n 0.0v 984.755n 0.0v 989.745n 0.0v 989.755n 0.0v 994.745n 0.0v 994.755n 0.0v 999.745n 0.0v 999.755n 0.0v 1004.745n 0.0v 1004.755n 0.0v 1009.745n 0.0v 1009.755n 0.0v 1014.745n 0.0v 1014.755n 0.0v 1019.745n 0.0v 1019.755n 0.0v 1024.745n 0.0v 1024.755n 0.0v )
* (time, data): [(0, 0), (5, 1), (10, 0), (15, 1), (20, 1), (25, 1), (30, 1), (35, 1), (40, 0), (45, 0), (50, 0), (55, 0), (60, 0), (65, 0), (70, 0), (75, 0), (80, 0), (85, 0), (90, 0), (95, 0), (100, 1), (105, 1), (110, 1), (115, 0), (120, 0), (125, 0), (130, 0), (135, 0), (140, 0), (145, 0), (150, 0), (155, 0), (160, 0), (165, 0), (170, 0), (175, 1), (180, 1), (185, 1), (190, 1), (195, 0), (200, 0), (205, 0), (210, 0), (215, 0), (220, 0), (225, 0), (230, 0), (235, 0), (240, 0), (245, 0), (250, 0), (255, 0), (260, 0), (265, 0), (270, 0), (275, 0), (280, 0), (285, 0), (290, 0), (295, 0), (300, 0), (305, 0), (310, 0), (315, 0), (320, 0), (325, 0), (330, 0), (335, 1), (340, 1), (345, 1), (350, 1), (355, 1), (360, 1), (365, 1), (370, 1), (375, 1), (380, 1), (385, 1), (390, 1), (395, 1), (400, 1), (405, 1), (410, 0), (415, 0), (420, 0), (425, 0), (430, 0), (435, 1), (440, 1), (445, 0), (450, 0), (455, 0), (460, 0), (465, 0), (470, 0), (475, 0), (480, 0), (485, 1), (490, 1), (495, 1), (500, 1), (505, 1), (510, 1), (515, 0), (520, 0), (525, 0), (530, 0), (535, 1), (540, 1), (545, 1), (550, 1), (555, 1), (560, 0), (565, 0), (570, 0), (575, 0), (580, 0), (585, 0), (590, 0), (595, 0), (600, 0), (605, 0), (610, 1), (615, 1), (620, 0), (625, 0), (630, 0), (635, 1), (640, 1), (645, 1), (650, 1), (655, 0), (660, 0), (665, 0), (670, 1), (675, 1), (680, 1), (685, 1), (690, 1), (695, 1), (700, 1), (705, 1), (710, 1), (715, 1), (720, 1), (725, 1), (730, 1), (735, 1), (740, 0), (745, 0), (750, 0), (755, 0), (760, 0), (765, 0), (770, 1), (775, 1), (780, 0), (785, 0), (790, 0), (795, 0), (800, 0), (805, 1), (810, 1), (815, 1), (820, 1), (825, 1), (830, 1), (835, 1), (840, 0), (845, 0), (850, 1), (855, 1), (860, 1), (865, 1), (870, 0), (875, 0), (880, 0), (885, 0), (890, 0), (895, 0), (900, 0), (905, 0), (910, 0), (915, 0), (920, 0), (925, 0), (930, 0), (935, 0), (940, 0), (945, 0), (950, 0), (955, 0), (960, 0), (965, 0), (970, 0), (975, 0), (980, 0), (985, 0), (990, 0), (995, 0), (1000, 0), (1005, 0), (1010, 0), (1015, 0), (1020, 1), (1025, 1)]
Vdin0_33  din0_33  0 PWL (0n 0.0v 4.745n 0.0v 4.755n 1.0v 9.745n 1.0v 9.755n 0.0v 14.745n 0.0v 14.755n 1.0v 19.745n 1.0v 19.755n 1.0v 24.745n 1.0v 24.755n 1.0v 29.745n 1.0v 29.755n 1.0v 34.745n 1.0v 34.755n 1.0v 39.745n 1.0v 39.755n 0.0v 44.745n 0.0v 44.755n 0.0v 49.745n 0.0v 49.755n 0.0v 54.745n 0.0v 54.755n 0.0v 59.745n 0.0v 59.755n 0.0v 64.745n 0.0v 64.755n 0.0v 69.745n 0.0v 69.755n 0.0v 74.745n 0.0v 74.755n 0.0v 79.745n 0.0v 79.755n 0.0v 84.745n 0.0v 84.755n 0.0v 89.745n 0.0v 89.755n 0.0v 94.745n 0.0v 94.755n 0.0v 99.745n 0.0v 99.755n 1.0v 104.745n 1.0v 104.755n 1.0v 109.745n 1.0v 109.755n 1.0v 114.745n 1.0v 114.755n 0.0v 119.745n 0.0v 119.755n 0.0v 124.745n 0.0v 124.755n 0.0v 129.745n 0.0v 129.755n 0.0v 134.745n 0.0v 134.755n 0.0v 139.745n 0.0v 139.755n 0.0v 144.745n 0.0v 144.755n 0.0v 149.745n 0.0v 149.755n 0.0v 154.745n 0.0v 154.755n 0.0v 159.745n 0.0v 159.755n 0.0v 164.745n 0.0v 164.755n 0.0v 169.745n 0.0v 169.755n 0.0v 174.745n 0.0v 174.755n 1.0v 179.745n 1.0v 179.755n 1.0v 184.745n 1.0v 184.755n 1.0v 189.745n 1.0v 189.755n 1.0v 194.745n 1.0v 194.755n 0.0v 199.745n 0.0v 199.755n 0.0v 204.745n 0.0v 204.755n 0.0v 209.745n 0.0v 209.755n 0.0v 214.745n 0.0v 214.755n 0.0v 219.745n 0.0v 219.755n 0.0v 224.745n 0.0v 224.755n 0.0v 229.745n 0.0v 229.755n 0.0v 234.745n 0.0v 234.755n 0.0v 239.745n 0.0v 239.755n 0.0v 244.745n 0.0v 244.755n 0.0v 249.745n 0.0v 249.755n 0.0v 254.745n 0.0v 254.755n 0.0v 259.745n 0.0v 259.755n 0.0v 264.745n 0.0v 264.755n 0.0v 269.745n 0.0v 269.755n 0.0v 274.745n 0.0v 274.755n 0.0v 279.745n 0.0v 279.755n 0.0v 284.745n 0.0v 284.755n 0.0v 289.745n 0.0v 289.755n 0.0v 294.745n 0.0v 294.755n 0.0v 299.745n 0.0v 299.755n 0.0v 304.745n 0.0v 304.755n 0.0v 309.745n 0.0v 309.755n 0.0v 314.745n 0.0v 314.755n 0.0v 319.745n 0.0v 319.755n 0.0v 324.745n 0.0v 324.755n 0.0v 329.745n 0.0v 329.755n 0.0v 334.745n 0.0v 334.755n 1.0v 339.745n 1.0v 339.755n 1.0v 344.745n 1.0v 344.755n 1.0v 349.745n 1.0v 349.755n 1.0v 354.745n 1.0v 354.755n 1.0v 359.745n 1.0v 359.755n 1.0v 364.745n 1.0v 364.755n 1.0v 369.745n 1.0v 369.755n 1.0v 374.745n 1.0v 374.755n 1.0v 379.745n 1.0v 379.755n 1.0v 384.745n 1.0v 384.755n 1.0v 389.745n 1.0v 389.755n 1.0v 394.745n 1.0v 394.755n 1.0v 399.745n 1.0v 399.755n 1.0v 404.745n 1.0v 404.755n 1.0v 409.745n 1.0v 409.755n 0.0v 414.745n 0.0v 414.755n 0.0v 419.745n 0.0v 419.755n 0.0v 424.745n 0.0v 424.755n 0.0v 429.745n 0.0v 429.755n 0.0v 434.745n 0.0v 434.755n 1.0v 439.745n 1.0v 439.755n 1.0v 444.745n 1.0v 444.755n 0.0v 449.745n 0.0v 449.755n 0.0v 454.745n 0.0v 454.755n 0.0v 459.745n 0.0v 459.755n 0.0v 464.745n 0.0v 464.755n 0.0v 469.745n 0.0v 469.755n 0.0v 474.745n 0.0v 474.755n 0.0v 479.745n 0.0v 479.755n 0.0v 484.745n 0.0v 484.755n 1.0v 489.745n 1.0v 489.755n 1.0v 494.745n 1.0v 494.755n 1.0v 499.745n 1.0v 499.755n 1.0v 504.745n 1.0v 504.755n 1.0v 509.745n 1.0v 509.755n 1.0v 514.745n 1.0v 514.755n 0.0v 519.745n 0.0v 519.755n 0.0v 524.745n 0.0v 524.755n 0.0v 529.745n 0.0v 529.755n 0.0v 534.745n 0.0v 534.755n 1.0v 539.745n 1.0v 539.755n 1.0v 544.745n 1.0v 544.755n 1.0v 549.745n 1.0v 549.755n 1.0v 554.745n 1.0v 554.755n 1.0v 559.745n 1.0v 559.755n 0.0v 564.745n 0.0v 564.755n 0.0v 569.745n 0.0v 569.755n 0.0v 574.745n 0.0v 574.755n 0.0v 579.745n 0.0v 579.755n 0.0v 584.745n 0.0v 584.755n 0.0v 589.745n 0.0v 589.755n 0.0v 594.745n 0.0v 594.755n 0.0v 599.745n 0.0v 599.755n 0.0v 604.745n 0.0v 604.755n 0.0v 609.745n 0.0v 609.755n 1.0v 614.745n 1.0v 614.755n 1.0v 619.745n 1.0v 619.755n 0.0v 624.745n 0.0v 624.755n 0.0v 629.745n 0.0v 629.755n 0.0v 634.745n 0.0v 634.755n 1.0v 639.745n 1.0v 639.755n 1.0v 644.745n 1.0v 644.755n 1.0v 649.745n 1.0v 649.755n 1.0v 654.745n 1.0v 654.755n 0.0v 659.745n 0.0v 659.755n 0.0v 664.745n 0.0v 664.755n 0.0v 669.745n 0.0v 669.755n 1.0v 674.745n 1.0v 674.755n 1.0v 679.745n 1.0v 679.755n 1.0v 684.745n 1.0v 684.755n 1.0v 689.745n 1.0v 689.755n 1.0v 694.745n 1.0v 694.755n 1.0v 699.745n 1.0v 699.755n 1.0v 704.745n 1.0v 704.755n 1.0v 709.745n 1.0v 709.755n 1.0v 714.745n 1.0v 714.755n 1.0v 719.745n 1.0v 719.755n 1.0v 724.745n 1.0v 724.755n 1.0v 729.745n 1.0v 729.755n 1.0v 734.745n 1.0v 734.755n 1.0v 739.745n 1.0v 739.755n 0.0v 744.745n 0.0v 744.755n 0.0v 749.745n 0.0v 749.755n 0.0v 754.745n 0.0v 754.755n 0.0v 759.745n 0.0v 759.755n 0.0v 764.745n 0.0v 764.755n 0.0v 769.745n 0.0v 769.755n 1.0v 774.745n 1.0v 774.755n 1.0v 779.745n 1.0v 779.755n 0.0v 784.745n 0.0v 784.755n 0.0v 789.745n 0.0v 789.755n 0.0v 794.745n 0.0v 794.755n 0.0v 799.745n 0.0v 799.755n 0.0v 804.745n 0.0v 804.755n 1.0v 809.745n 1.0v 809.755n 1.0v 814.745n 1.0v 814.755n 1.0v 819.745n 1.0v 819.755n 1.0v 824.745n 1.0v 824.755n 1.0v 829.745n 1.0v 829.755n 1.0v 834.745n 1.0v 834.755n 1.0v 839.745n 1.0v 839.755n 0.0v 844.745n 0.0v 844.755n 0.0v 849.745n 0.0v 849.755n 1.0v 854.745n 1.0v 854.755n 1.0v 859.745n 1.0v 859.755n 1.0v 864.745n 1.0v 864.755n 1.0v 869.745n 1.0v 869.755n 0.0v 874.745n 0.0v 874.755n 0.0v 879.745n 0.0v 879.755n 0.0v 884.745n 0.0v 884.755n 0.0v 889.745n 0.0v 889.755n 0.0v 894.745n 0.0v 894.755n 0.0v 899.745n 0.0v 899.755n 0.0v 904.745n 0.0v 904.755n 0.0v 909.745n 0.0v 909.755n 0.0v 914.745n 0.0v 914.755n 0.0v 919.745n 0.0v 919.755n 0.0v 924.745n 0.0v 924.755n 0.0v 929.745n 0.0v 929.755n 0.0v 934.745n 0.0v 934.755n 0.0v 939.745n 0.0v 939.755n 0.0v 944.745n 0.0v 944.755n 0.0v 949.745n 0.0v 949.755n 0.0v 954.745n 0.0v 954.755n 0.0v 959.745n 0.0v 959.755n 0.0v 964.745n 0.0v 964.755n 0.0v 969.745n 0.0v 969.755n 0.0v 974.745n 0.0v 974.755n 0.0v 979.745n 0.0v 979.755n 0.0v 984.745n 0.0v 984.755n 0.0v 989.745n 0.0v 989.755n 0.0v 994.745n 0.0v 994.755n 0.0v 999.745n 0.0v 999.755n 0.0v 1004.745n 0.0v 1004.755n 0.0v 1009.745n 0.0v 1009.755n 0.0v 1014.745n 0.0v 1014.755n 0.0v 1019.745n 0.0v 1019.755n 1.0v 1024.745n 1.0v 1024.755n 1.0v )
* (time, data): [(0, 0), (5, 1), (10, 1), (15, 0), (20, 0), (25, 0), (30, 1), (35, 1), (40, 1), (45, 1), (50, 0), (55, 0), (60, 0), (65, 1), (70, 1), (75, 1), (80, 1), (85, 1), (90, 1), (95, 1), (100, 1), (105, 1), (110, 1), (115, 1), (120, 1), (125, 1), (130, 1), (135, 1), (140, 1), (145, 1), (150, 1), (155, 1), (160, 1), (165, 1), (170, 1), (175, 0), (180, 0), (185, 0), (190, 0), (195, 1), (200, 1), (205, 1), (210, 1), (215, 1), (220, 1), (225, 1), (230, 1), (235, 1), (240, 1), (245, 1), (250, 1), (255, 1), (260, 1), (265, 1), (270, 1), (275, 1), (280, 1), (285, 1), (290, 1), (295, 1), (300, 1), (305, 1), (310, 1), (315, 1), (320, 1), (325, 1), (330, 1), (335, 1), (340, 1), (345, 1), (350, 1), (355, 1), (360, 1), (365, 1), (370, 1), (375, 1), (380, 1), (385, 1), (390, 1), (395, 1), (400, 1), (405, 1), (410, 0), (415, 0), (420, 0), (425, 0), (430, 0), (435, 0), (440, 0), (445, 1), (450, 1), (455, 1), (460, 1), (465, 1), (470, 1), (475, 1), (480, 1), (485, 1), (490, 1), (495, 1), (500, 1), (505, 1), (510, 1), (515, 1), (520, 1), (525, 1), (530, 1), (535, 1), (540, 1), (545, 0), (550, 0), (555, 0), (560, 0), (565, 0), (570, 0), (575, 0), (580, 0), (585, 0), (590, 0), (595, 0), (600, 1), (605, 1), (610, 0), (615, 0), (620, 0), (625, 0), (630, 0), (635, 0), (640, 0), (645, 1), (650, 0), (655, 0), (660, 0), (665, 0), (670, 0), (675, 0), (680, 0), (685, 0), (690, 0), (695, 0), (700, 0), (705, 0), (710, 0), (715, 0), (720, 0), (725, 0), (730, 0), (735, 0), (740, 1), (745, 1), (750, 1), (755, 1), (760, 1), (765, 1), (770, 1), (775, 1), (780, 1), (785, 1), (790, 1), (795, 1), (800, 1), (805, 0), (810, 0), (815, 0), (820, 0), (825, 0), (830, 0), (835, 0), (840, 1), (845, 1), (850, 0), (855, 1), (860, 1), (865, 1), (870, 1), (875, 1), (880, 1), (885, 1), (890, 1), (895, 1), (900, 1), (905, 1), (910, 1), (915, 1), (920, 1), (925, 1), (930, 1), (935, 1), (940, 1), (945, 1), (950, 1), (955, 1), (960, 1), (965, 0), (970, 0), (975, 0), (980, 0), (985, 0), (990, 0), (995, 0), (1000, 0), (1005, 0), (1010, 0), (1015, 0), (1020, 0), (1025, 0)]
Vdin0_34  din0_34  0 PWL (0n 0.0v 4.745n 0.0v 4.755n 1.0v 9.745n 1.0v 9.755n 1.0v 14.745n 1.0v 14.755n 0.0v 19.745n 0.0v 19.755n 0.0v 24.745n 0.0v 24.755n 0.0v 29.745n 0.0v 29.755n 1.0v 34.745n 1.0v 34.755n 1.0v 39.745n 1.0v 39.755n 1.0v 44.745n 1.0v 44.755n 1.0v 49.745n 1.0v 49.755n 0.0v 54.745n 0.0v 54.755n 0.0v 59.745n 0.0v 59.755n 0.0v 64.745n 0.0v 64.755n 1.0v 69.745n 1.0v 69.755n 1.0v 74.745n 1.0v 74.755n 1.0v 79.745n 1.0v 79.755n 1.0v 84.745n 1.0v 84.755n 1.0v 89.745n 1.0v 89.755n 1.0v 94.745n 1.0v 94.755n 1.0v 99.745n 1.0v 99.755n 1.0v 104.745n 1.0v 104.755n 1.0v 109.745n 1.0v 109.755n 1.0v 114.745n 1.0v 114.755n 1.0v 119.745n 1.0v 119.755n 1.0v 124.745n 1.0v 124.755n 1.0v 129.745n 1.0v 129.755n 1.0v 134.745n 1.0v 134.755n 1.0v 139.745n 1.0v 139.755n 1.0v 144.745n 1.0v 144.755n 1.0v 149.745n 1.0v 149.755n 1.0v 154.745n 1.0v 154.755n 1.0v 159.745n 1.0v 159.755n 1.0v 164.745n 1.0v 164.755n 1.0v 169.745n 1.0v 169.755n 1.0v 174.745n 1.0v 174.755n 0.0v 179.745n 0.0v 179.755n 0.0v 184.745n 0.0v 184.755n 0.0v 189.745n 0.0v 189.755n 0.0v 194.745n 0.0v 194.755n 1.0v 199.745n 1.0v 199.755n 1.0v 204.745n 1.0v 204.755n 1.0v 209.745n 1.0v 209.755n 1.0v 214.745n 1.0v 214.755n 1.0v 219.745n 1.0v 219.755n 1.0v 224.745n 1.0v 224.755n 1.0v 229.745n 1.0v 229.755n 1.0v 234.745n 1.0v 234.755n 1.0v 239.745n 1.0v 239.755n 1.0v 244.745n 1.0v 244.755n 1.0v 249.745n 1.0v 249.755n 1.0v 254.745n 1.0v 254.755n 1.0v 259.745n 1.0v 259.755n 1.0v 264.745n 1.0v 264.755n 1.0v 269.745n 1.0v 269.755n 1.0v 274.745n 1.0v 274.755n 1.0v 279.745n 1.0v 279.755n 1.0v 284.745n 1.0v 284.755n 1.0v 289.745n 1.0v 289.755n 1.0v 294.745n 1.0v 294.755n 1.0v 299.745n 1.0v 299.755n 1.0v 304.745n 1.0v 304.755n 1.0v 309.745n 1.0v 309.755n 1.0v 314.745n 1.0v 314.755n 1.0v 319.745n 1.0v 319.755n 1.0v 324.745n 1.0v 324.755n 1.0v 329.745n 1.0v 329.755n 1.0v 334.745n 1.0v 334.755n 1.0v 339.745n 1.0v 339.755n 1.0v 344.745n 1.0v 344.755n 1.0v 349.745n 1.0v 349.755n 1.0v 354.745n 1.0v 354.755n 1.0v 359.745n 1.0v 359.755n 1.0v 364.745n 1.0v 364.755n 1.0v 369.745n 1.0v 369.755n 1.0v 374.745n 1.0v 374.755n 1.0v 379.745n 1.0v 379.755n 1.0v 384.745n 1.0v 384.755n 1.0v 389.745n 1.0v 389.755n 1.0v 394.745n 1.0v 394.755n 1.0v 399.745n 1.0v 399.755n 1.0v 404.745n 1.0v 404.755n 1.0v 409.745n 1.0v 409.755n 0.0v 414.745n 0.0v 414.755n 0.0v 419.745n 0.0v 419.755n 0.0v 424.745n 0.0v 424.755n 0.0v 429.745n 0.0v 429.755n 0.0v 434.745n 0.0v 434.755n 0.0v 439.745n 0.0v 439.755n 0.0v 444.745n 0.0v 444.755n 1.0v 449.745n 1.0v 449.755n 1.0v 454.745n 1.0v 454.755n 1.0v 459.745n 1.0v 459.755n 1.0v 464.745n 1.0v 464.755n 1.0v 469.745n 1.0v 469.755n 1.0v 474.745n 1.0v 474.755n 1.0v 479.745n 1.0v 479.755n 1.0v 484.745n 1.0v 484.755n 1.0v 489.745n 1.0v 489.755n 1.0v 494.745n 1.0v 494.755n 1.0v 499.745n 1.0v 499.755n 1.0v 504.745n 1.0v 504.755n 1.0v 509.745n 1.0v 509.755n 1.0v 514.745n 1.0v 514.755n 1.0v 519.745n 1.0v 519.755n 1.0v 524.745n 1.0v 524.755n 1.0v 529.745n 1.0v 529.755n 1.0v 534.745n 1.0v 534.755n 1.0v 539.745n 1.0v 539.755n 1.0v 544.745n 1.0v 544.755n 0.0v 549.745n 0.0v 549.755n 0.0v 554.745n 0.0v 554.755n 0.0v 559.745n 0.0v 559.755n 0.0v 564.745n 0.0v 564.755n 0.0v 569.745n 0.0v 569.755n 0.0v 574.745n 0.0v 574.755n 0.0v 579.745n 0.0v 579.755n 0.0v 584.745n 0.0v 584.755n 0.0v 589.745n 0.0v 589.755n 0.0v 594.745n 0.0v 594.755n 0.0v 599.745n 0.0v 599.755n 1.0v 604.745n 1.0v 604.755n 1.0v 609.745n 1.0v 609.755n 0.0v 614.745n 0.0v 614.755n 0.0v 619.745n 0.0v 619.755n 0.0v 624.745n 0.0v 624.755n 0.0v 629.745n 0.0v 629.755n 0.0v 634.745n 0.0v 634.755n 0.0v 639.745n 0.0v 639.755n 0.0v 644.745n 0.0v 644.755n 1.0v 649.745n 1.0v 649.755n 0.0v 654.745n 0.0v 654.755n 0.0v 659.745n 0.0v 659.755n 0.0v 664.745n 0.0v 664.755n 0.0v 669.745n 0.0v 669.755n 0.0v 674.745n 0.0v 674.755n 0.0v 679.745n 0.0v 679.755n 0.0v 684.745n 0.0v 684.755n 0.0v 689.745n 0.0v 689.755n 0.0v 694.745n 0.0v 694.755n 0.0v 699.745n 0.0v 699.755n 0.0v 704.745n 0.0v 704.755n 0.0v 709.745n 0.0v 709.755n 0.0v 714.745n 0.0v 714.755n 0.0v 719.745n 0.0v 719.755n 0.0v 724.745n 0.0v 724.755n 0.0v 729.745n 0.0v 729.755n 0.0v 734.745n 0.0v 734.755n 0.0v 739.745n 0.0v 739.755n 1.0v 744.745n 1.0v 744.755n 1.0v 749.745n 1.0v 749.755n 1.0v 754.745n 1.0v 754.755n 1.0v 759.745n 1.0v 759.755n 1.0v 764.745n 1.0v 764.755n 1.0v 769.745n 1.0v 769.755n 1.0v 774.745n 1.0v 774.755n 1.0v 779.745n 1.0v 779.755n 1.0v 784.745n 1.0v 784.755n 1.0v 789.745n 1.0v 789.755n 1.0v 794.745n 1.0v 794.755n 1.0v 799.745n 1.0v 799.755n 1.0v 804.745n 1.0v 804.755n 0.0v 809.745n 0.0v 809.755n 0.0v 814.745n 0.0v 814.755n 0.0v 819.745n 0.0v 819.755n 0.0v 824.745n 0.0v 824.755n 0.0v 829.745n 0.0v 829.755n 0.0v 834.745n 0.0v 834.755n 0.0v 839.745n 0.0v 839.755n 1.0v 844.745n 1.0v 844.755n 1.0v 849.745n 1.0v 849.755n 0.0v 854.745n 0.0v 854.755n 1.0v 859.745n 1.0v 859.755n 1.0v 864.745n 1.0v 864.755n 1.0v 869.745n 1.0v 869.755n 1.0v 874.745n 1.0v 874.755n 1.0v 879.745n 1.0v 879.755n 1.0v 884.745n 1.0v 884.755n 1.0v 889.745n 1.0v 889.755n 1.0v 894.745n 1.0v 894.755n 1.0v 899.745n 1.0v 899.755n 1.0v 904.745n 1.0v 904.755n 1.0v 909.745n 1.0v 909.755n 1.0v 914.745n 1.0v 914.755n 1.0v 919.745n 1.0v 919.755n 1.0v 924.745n 1.0v 924.755n 1.0v 929.745n 1.0v 929.755n 1.0v 934.745n 1.0v 934.755n 1.0v 939.745n 1.0v 939.755n 1.0v 944.745n 1.0v 944.755n 1.0v 949.745n 1.0v 949.755n 1.0v 954.745n 1.0v 954.755n 1.0v 959.745n 1.0v 959.755n 1.0v 964.745n 1.0v 964.755n 0.0v 969.745n 0.0v 969.755n 0.0v 974.745n 0.0v 974.755n 0.0v 979.745n 0.0v 979.755n 0.0v 984.745n 0.0v 984.755n 0.0v 989.745n 0.0v 989.755n 0.0v 994.745n 0.0v 994.755n 0.0v 999.745n 0.0v 999.755n 0.0v 1004.745n 0.0v 1004.755n 0.0v 1009.745n 0.0v 1009.755n 0.0v 1014.745n 0.0v 1014.755n 0.0v 1019.745n 0.0v 1019.755n 0.0v 1024.745n 0.0v 1024.755n 0.0v )
* (time, data): [(0, 0), (5, 0), (10, 1), (15, 1), (20, 1), (25, 1), (30, 0), (35, 0), (40, 0), (45, 0), (50, 1), (55, 1), (60, 1), (65, 0), (70, 0), (75, 0), (80, 0), (85, 0), (90, 0), (95, 0), (100, 1), (105, 1), (110, 1), (115, 0), (120, 0), (125, 0), (130, 0), (135, 0), (140, 0), (145, 0), (150, 0), (155, 1), (160, 1), (165, 1), (170, 1), (175, 1), (180, 1), (185, 1), (190, 1), (195, 0), (200, 0), (205, 0), (210, 0), (215, 0), (220, 0), (225, 0), (230, 0), (235, 0), (240, 0), (245, 1), (250, 1), (255, 1), (260, 1), (265, 1), (270, 1), (275, 1), (280, 1), (285, 1), (290, 0), (295, 0), (300, 0), (305, 0), (310, 0), (315, 0), (320, 0), (325, 0), (330, 0), (335, 0), (340, 0), (345, 0), (350, 0), (355, 0), (360, 0), (365, 0), (370, 0), (375, 0), (380, 0), (385, 0), (390, 0), (395, 0), (400, 0), (405, 0), (410, 0), (415, 0), (420, 0), (425, 0), (430, 0), (435, 1), (440, 1), (445, 0), (450, 0), (455, 0), (460, 0), (465, 0), (470, 0), (475, 0), (480, 0), (485, 0), (490, 0), (495, 0), (500, 1), (505, 1), (510, 1), (515, 1), (520, 1), (525, 1), (530, 1), (535, 1), (540, 1), (545, 1), (550, 1), (555, 1), (560, 0), (565, 0), (570, 0), (575, 0), (580, 0), (585, 0), (590, 0), (595, 0), (600, 1), (605, 1), (610, 0), (615, 0), (620, 0), (625, 0), (630, 0), (635, 1), (640, 1), (645, 0), (650, 0), (655, 0), (660, 0), (665, 0), (670, 1), (675, 1), (680, 1), (685, 1), (690, 1), (695, 1), (700, 1), (705, 1), (710, 1), (715, 1), (720, 0), (725, 0), (730, 0), (735, 0), (740, 0), (745, 0), (750, 0), (755, 0), (760, 0), (765, 0), (770, 0), (775, 0), (780, 1), (785, 1), (790, 1), (795, 1), (800, 1), (805, 1), (810, 1), (815, 1), (820, 1), (825, 1), (830, 1), (835, 1), (840, 1), (845, 1), (850, 1), (855, 0), (860, 0), (865, 0), (870, 1), (875, 1), (880, 1), (885, 1), (890, 1), (895, 1), (900, 1), (905, 1), (910, 0), (915, 1), (920, 1), (925, 1), (930, 0), (935, 0), (940, 0), (945, 0), (950, 0), (955, 0), (960, 0), (965, 0), (970, 0), (975, 0), (980, 0), (985, 0), (990, 0), (995, 0), (1000, 0), (1005, 0), (1010, 0), (1015, 0), (1020, 1), (1025, 1)]
Vdin0_35  din0_35  0 PWL (0n 0.0v 4.745n 0.0v 4.755n 0.0v 9.745n 0.0v 9.755n 1.0v 14.745n 1.0v 14.755n 1.0v 19.745n 1.0v 19.755n 1.0v 24.745n 1.0v 24.755n 1.0v 29.745n 1.0v 29.755n 0.0v 34.745n 0.0v 34.755n 0.0v 39.745n 0.0v 39.755n 0.0v 44.745n 0.0v 44.755n 0.0v 49.745n 0.0v 49.755n 1.0v 54.745n 1.0v 54.755n 1.0v 59.745n 1.0v 59.755n 1.0v 64.745n 1.0v 64.755n 0.0v 69.745n 0.0v 69.755n 0.0v 74.745n 0.0v 74.755n 0.0v 79.745n 0.0v 79.755n 0.0v 84.745n 0.0v 84.755n 0.0v 89.745n 0.0v 89.755n 0.0v 94.745n 0.0v 94.755n 0.0v 99.745n 0.0v 99.755n 1.0v 104.745n 1.0v 104.755n 1.0v 109.745n 1.0v 109.755n 1.0v 114.745n 1.0v 114.755n 0.0v 119.745n 0.0v 119.755n 0.0v 124.745n 0.0v 124.755n 0.0v 129.745n 0.0v 129.755n 0.0v 134.745n 0.0v 134.755n 0.0v 139.745n 0.0v 139.755n 0.0v 144.745n 0.0v 144.755n 0.0v 149.745n 0.0v 149.755n 0.0v 154.745n 0.0v 154.755n 1.0v 159.745n 1.0v 159.755n 1.0v 164.745n 1.0v 164.755n 1.0v 169.745n 1.0v 169.755n 1.0v 174.745n 1.0v 174.755n 1.0v 179.745n 1.0v 179.755n 1.0v 184.745n 1.0v 184.755n 1.0v 189.745n 1.0v 189.755n 1.0v 194.745n 1.0v 194.755n 0.0v 199.745n 0.0v 199.755n 0.0v 204.745n 0.0v 204.755n 0.0v 209.745n 0.0v 209.755n 0.0v 214.745n 0.0v 214.755n 0.0v 219.745n 0.0v 219.755n 0.0v 224.745n 0.0v 224.755n 0.0v 229.745n 0.0v 229.755n 0.0v 234.745n 0.0v 234.755n 0.0v 239.745n 0.0v 239.755n 0.0v 244.745n 0.0v 244.755n 1.0v 249.745n 1.0v 249.755n 1.0v 254.745n 1.0v 254.755n 1.0v 259.745n 1.0v 259.755n 1.0v 264.745n 1.0v 264.755n 1.0v 269.745n 1.0v 269.755n 1.0v 274.745n 1.0v 274.755n 1.0v 279.745n 1.0v 279.755n 1.0v 284.745n 1.0v 284.755n 1.0v 289.745n 1.0v 289.755n 0.0v 294.745n 0.0v 294.755n 0.0v 299.745n 0.0v 299.755n 0.0v 304.745n 0.0v 304.755n 0.0v 309.745n 0.0v 309.755n 0.0v 314.745n 0.0v 314.755n 0.0v 319.745n 0.0v 319.755n 0.0v 324.745n 0.0v 324.755n 0.0v 329.745n 0.0v 329.755n 0.0v 334.745n 0.0v 334.755n 0.0v 339.745n 0.0v 339.755n 0.0v 344.745n 0.0v 344.755n 0.0v 349.745n 0.0v 349.755n 0.0v 354.745n 0.0v 354.755n 0.0v 359.745n 0.0v 359.755n 0.0v 364.745n 0.0v 364.755n 0.0v 369.745n 0.0v 369.755n 0.0v 374.745n 0.0v 374.755n 0.0v 379.745n 0.0v 379.755n 0.0v 384.745n 0.0v 384.755n 0.0v 389.745n 0.0v 389.755n 0.0v 394.745n 0.0v 394.755n 0.0v 399.745n 0.0v 399.755n 0.0v 404.745n 0.0v 404.755n 0.0v 409.745n 0.0v 409.755n 0.0v 414.745n 0.0v 414.755n 0.0v 419.745n 0.0v 419.755n 0.0v 424.745n 0.0v 424.755n 0.0v 429.745n 0.0v 429.755n 0.0v 434.745n 0.0v 434.755n 1.0v 439.745n 1.0v 439.755n 1.0v 444.745n 1.0v 444.755n 0.0v 449.745n 0.0v 449.755n 0.0v 454.745n 0.0v 454.755n 0.0v 459.745n 0.0v 459.755n 0.0v 464.745n 0.0v 464.755n 0.0v 469.745n 0.0v 469.755n 0.0v 474.745n 0.0v 474.755n 0.0v 479.745n 0.0v 479.755n 0.0v 484.745n 0.0v 484.755n 0.0v 489.745n 0.0v 489.755n 0.0v 494.745n 0.0v 494.755n 0.0v 499.745n 0.0v 499.755n 1.0v 504.745n 1.0v 504.755n 1.0v 509.745n 1.0v 509.755n 1.0v 514.745n 1.0v 514.755n 1.0v 519.745n 1.0v 519.755n 1.0v 524.745n 1.0v 524.755n 1.0v 529.745n 1.0v 529.755n 1.0v 534.745n 1.0v 534.755n 1.0v 539.745n 1.0v 539.755n 1.0v 544.745n 1.0v 544.755n 1.0v 549.745n 1.0v 549.755n 1.0v 554.745n 1.0v 554.755n 1.0v 559.745n 1.0v 559.755n 0.0v 564.745n 0.0v 564.755n 0.0v 569.745n 0.0v 569.755n 0.0v 574.745n 0.0v 574.755n 0.0v 579.745n 0.0v 579.755n 0.0v 584.745n 0.0v 584.755n 0.0v 589.745n 0.0v 589.755n 0.0v 594.745n 0.0v 594.755n 0.0v 599.745n 0.0v 599.755n 1.0v 604.745n 1.0v 604.755n 1.0v 609.745n 1.0v 609.755n 0.0v 614.745n 0.0v 614.755n 0.0v 619.745n 0.0v 619.755n 0.0v 624.745n 0.0v 624.755n 0.0v 629.745n 0.0v 629.755n 0.0v 634.745n 0.0v 634.755n 1.0v 639.745n 1.0v 639.755n 1.0v 644.745n 1.0v 644.755n 0.0v 649.745n 0.0v 649.755n 0.0v 654.745n 0.0v 654.755n 0.0v 659.745n 0.0v 659.755n 0.0v 664.745n 0.0v 664.755n 0.0v 669.745n 0.0v 669.755n 1.0v 674.745n 1.0v 674.755n 1.0v 679.745n 1.0v 679.755n 1.0v 684.745n 1.0v 684.755n 1.0v 689.745n 1.0v 689.755n 1.0v 694.745n 1.0v 694.755n 1.0v 699.745n 1.0v 699.755n 1.0v 704.745n 1.0v 704.755n 1.0v 709.745n 1.0v 709.755n 1.0v 714.745n 1.0v 714.755n 1.0v 719.745n 1.0v 719.755n 0.0v 724.745n 0.0v 724.755n 0.0v 729.745n 0.0v 729.755n 0.0v 734.745n 0.0v 734.755n 0.0v 739.745n 0.0v 739.755n 0.0v 744.745n 0.0v 744.755n 0.0v 749.745n 0.0v 749.755n 0.0v 754.745n 0.0v 754.755n 0.0v 759.745n 0.0v 759.755n 0.0v 764.745n 0.0v 764.755n 0.0v 769.745n 0.0v 769.755n 0.0v 774.745n 0.0v 774.755n 0.0v 779.745n 0.0v 779.755n 1.0v 784.745n 1.0v 784.755n 1.0v 789.745n 1.0v 789.755n 1.0v 794.745n 1.0v 794.755n 1.0v 799.745n 1.0v 799.755n 1.0v 804.745n 1.0v 804.755n 1.0v 809.745n 1.0v 809.755n 1.0v 814.745n 1.0v 814.755n 1.0v 819.745n 1.0v 819.755n 1.0v 824.745n 1.0v 824.755n 1.0v 829.745n 1.0v 829.755n 1.0v 834.745n 1.0v 834.755n 1.0v 839.745n 1.0v 839.755n 1.0v 844.745n 1.0v 844.755n 1.0v 849.745n 1.0v 849.755n 1.0v 854.745n 1.0v 854.755n 0.0v 859.745n 0.0v 859.755n 0.0v 864.745n 0.0v 864.755n 0.0v 869.745n 0.0v 869.755n 1.0v 874.745n 1.0v 874.755n 1.0v 879.745n 1.0v 879.755n 1.0v 884.745n 1.0v 884.755n 1.0v 889.745n 1.0v 889.755n 1.0v 894.745n 1.0v 894.755n 1.0v 899.745n 1.0v 899.755n 1.0v 904.745n 1.0v 904.755n 1.0v 909.745n 1.0v 909.755n 0.0v 914.745n 0.0v 914.755n 1.0v 919.745n 1.0v 919.755n 1.0v 924.745n 1.0v 924.755n 1.0v 929.745n 1.0v 929.755n 0.0v 934.745n 0.0v 934.755n 0.0v 939.745n 0.0v 939.755n 0.0v 944.745n 0.0v 944.755n 0.0v 949.745n 0.0v 949.755n 0.0v 954.745n 0.0v 954.755n 0.0v 959.745n 0.0v 959.755n 0.0v 964.745n 0.0v 964.755n 0.0v 969.745n 0.0v 969.755n 0.0v 974.745n 0.0v 974.755n 0.0v 979.745n 0.0v 979.755n 0.0v 984.745n 0.0v 984.755n 0.0v 989.745n 0.0v 989.755n 0.0v 994.745n 0.0v 994.755n 0.0v 999.745n 0.0v 999.755n 0.0v 1004.745n 0.0v 1004.755n 0.0v 1009.745n 0.0v 1009.755n 0.0v 1014.745n 0.0v 1014.755n 0.0v 1019.745n 0.0v 1019.755n 1.0v 1024.745n 1.0v 1024.755n 1.0v )
* (time, data): [(0, 0), (5, 0), (10, 1), (15, 0), (20, 0), (25, 0), (30, 0), (35, 0), (40, 1), (45, 1), (50, 1), (55, 1), (60, 1), (65, 0), (70, 0), (75, 0), (80, 0), (85, 0), (90, 0), (95, 0), (100, 0), (105, 0), (110, 0), (115, 0), (120, 0), (125, 0), (130, 0), (135, 0), (140, 0), (145, 0), (150, 0), (155, 1), (160, 1), (165, 1), (170, 1), (175, 1), (180, 1), (185, 1), (190, 0), (195, 1), (200, 1), (205, 1), (210, 1), (215, 1), (220, 1), (225, 1), (230, 1), (235, 1), (240, 1), (245, 1), (250, 1), (255, 1), (260, 1), (265, 1), (270, 1), (275, 1), (280, 1), (285, 1), (290, 0), (295, 0), (300, 0), (305, 0), (310, 0), (315, 0), (320, 0), (325, 0), (330, 0), (335, 0), (340, 0), (345, 0), (350, 0), (355, 0), (360, 0), (365, 0), (370, 0), (375, 0), (380, 0), (385, 0), (390, 0), (395, 0), (400, 0), (405, 0), (410, 0), (415, 0), (420, 0), (425, 0), (430, 0), (435, 1), (440, 1), (445, 1), (450, 1), (455, 1), (460, 1), (465, 1), (470, 1), (475, 1), (480, 1), (485, 1), (490, 1), (495, 1), (500, 0), (505, 0), (510, 0), (515, 1), (520, 1), (525, 1), (530, 1), (535, 0), (540, 0), (545, 1), (550, 0), (555, 0), (560, 0), (565, 0), (570, 0), (575, 0), (580, 0), (585, 0), (590, 0), (595, 0), (600, 1), (605, 1), (610, 0), (615, 0), (620, 0), (625, 0), (630, 0), (635, 0), (640, 0), (645, 1), (650, 0), (655, 1), (660, 1), (665, 1), (670, 0), (675, 0), (680, 0), (685, 0), (690, 0), (695, 0), (700, 0), (705, 0), (710, 0), (715, 0), (720, 0), (725, 0), (730, 0), (735, 0), (740, 1), (745, 1), (750, 1), (755, 1), (760, 1), (765, 1), (770, 1), (775, 1), (780, 1), (785, 1), (790, 1), (795, 1), (800, 1), (805, 0), (810, 1), (815, 1), (820, 1), (825, 1), (830, 1), (835, 1), (840, 1), (845, 1), (850, 1), (855, 0), (860, 0), (865, 1), (870, 1), (875, 1), (880, 1), (885, 1), (890, 1), (895, 1), (900, 1), (905, 1), (910, 0), (915, 0), (920, 0), (925, 0), (930, 0), (935, 0), (940, 0), (945, 0), (950, 0), (955, 0), (960, 0), (965, 0), (970, 0), (975, 0), (980, 0), (985, 0), (990, 0), (995, 0), (1000, 0), (1005, 0), (1010, 0), (1015, 0), (1020, 0), (1025, 0)]
Vdin0_36  din0_36  0 PWL (0n 0.0v 4.745n 0.0v 4.755n 0.0v 9.745n 0.0v 9.755n 1.0v 14.745n 1.0v 14.755n 0.0v 19.745n 0.0v 19.755n 0.0v 24.745n 0.0v 24.755n 0.0v 29.745n 0.0v 29.755n 0.0v 34.745n 0.0v 34.755n 0.0v 39.745n 0.0v 39.755n 1.0v 44.745n 1.0v 44.755n 1.0v 49.745n 1.0v 49.755n 1.0v 54.745n 1.0v 54.755n 1.0v 59.745n 1.0v 59.755n 1.0v 64.745n 1.0v 64.755n 0.0v 69.745n 0.0v 69.755n 0.0v 74.745n 0.0v 74.755n 0.0v 79.745n 0.0v 79.755n 0.0v 84.745n 0.0v 84.755n 0.0v 89.745n 0.0v 89.755n 0.0v 94.745n 0.0v 94.755n 0.0v 99.745n 0.0v 99.755n 0.0v 104.745n 0.0v 104.755n 0.0v 109.745n 0.0v 109.755n 0.0v 114.745n 0.0v 114.755n 0.0v 119.745n 0.0v 119.755n 0.0v 124.745n 0.0v 124.755n 0.0v 129.745n 0.0v 129.755n 0.0v 134.745n 0.0v 134.755n 0.0v 139.745n 0.0v 139.755n 0.0v 144.745n 0.0v 144.755n 0.0v 149.745n 0.0v 149.755n 0.0v 154.745n 0.0v 154.755n 1.0v 159.745n 1.0v 159.755n 1.0v 164.745n 1.0v 164.755n 1.0v 169.745n 1.0v 169.755n 1.0v 174.745n 1.0v 174.755n 1.0v 179.745n 1.0v 179.755n 1.0v 184.745n 1.0v 184.755n 1.0v 189.745n 1.0v 189.755n 0.0v 194.745n 0.0v 194.755n 1.0v 199.745n 1.0v 199.755n 1.0v 204.745n 1.0v 204.755n 1.0v 209.745n 1.0v 209.755n 1.0v 214.745n 1.0v 214.755n 1.0v 219.745n 1.0v 219.755n 1.0v 224.745n 1.0v 224.755n 1.0v 229.745n 1.0v 229.755n 1.0v 234.745n 1.0v 234.755n 1.0v 239.745n 1.0v 239.755n 1.0v 244.745n 1.0v 244.755n 1.0v 249.745n 1.0v 249.755n 1.0v 254.745n 1.0v 254.755n 1.0v 259.745n 1.0v 259.755n 1.0v 264.745n 1.0v 264.755n 1.0v 269.745n 1.0v 269.755n 1.0v 274.745n 1.0v 274.755n 1.0v 279.745n 1.0v 279.755n 1.0v 284.745n 1.0v 284.755n 1.0v 289.745n 1.0v 289.755n 0.0v 294.745n 0.0v 294.755n 0.0v 299.745n 0.0v 299.755n 0.0v 304.745n 0.0v 304.755n 0.0v 309.745n 0.0v 309.755n 0.0v 314.745n 0.0v 314.755n 0.0v 319.745n 0.0v 319.755n 0.0v 324.745n 0.0v 324.755n 0.0v 329.745n 0.0v 329.755n 0.0v 334.745n 0.0v 334.755n 0.0v 339.745n 0.0v 339.755n 0.0v 344.745n 0.0v 344.755n 0.0v 349.745n 0.0v 349.755n 0.0v 354.745n 0.0v 354.755n 0.0v 359.745n 0.0v 359.755n 0.0v 364.745n 0.0v 364.755n 0.0v 369.745n 0.0v 369.755n 0.0v 374.745n 0.0v 374.755n 0.0v 379.745n 0.0v 379.755n 0.0v 384.745n 0.0v 384.755n 0.0v 389.745n 0.0v 389.755n 0.0v 394.745n 0.0v 394.755n 0.0v 399.745n 0.0v 399.755n 0.0v 404.745n 0.0v 404.755n 0.0v 409.745n 0.0v 409.755n 0.0v 414.745n 0.0v 414.755n 0.0v 419.745n 0.0v 419.755n 0.0v 424.745n 0.0v 424.755n 0.0v 429.745n 0.0v 429.755n 0.0v 434.745n 0.0v 434.755n 1.0v 439.745n 1.0v 439.755n 1.0v 444.745n 1.0v 444.755n 1.0v 449.745n 1.0v 449.755n 1.0v 454.745n 1.0v 454.755n 1.0v 459.745n 1.0v 459.755n 1.0v 464.745n 1.0v 464.755n 1.0v 469.745n 1.0v 469.755n 1.0v 474.745n 1.0v 474.755n 1.0v 479.745n 1.0v 479.755n 1.0v 484.745n 1.0v 484.755n 1.0v 489.745n 1.0v 489.755n 1.0v 494.745n 1.0v 494.755n 1.0v 499.745n 1.0v 499.755n 0.0v 504.745n 0.0v 504.755n 0.0v 509.745n 0.0v 509.755n 0.0v 514.745n 0.0v 514.755n 1.0v 519.745n 1.0v 519.755n 1.0v 524.745n 1.0v 524.755n 1.0v 529.745n 1.0v 529.755n 1.0v 534.745n 1.0v 534.755n 0.0v 539.745n 0.0v 539.755n 0.0v 544.745n 0.0v 544.755n 1.0v 549.745n 1.0v 549.755n 0.0v 554.745n 0.0v 554.755n 0.0v 559.745n 0.0v 559.755n 0.0v 564.745n 0.0v 564.755n 0.0v 569.745n 0.0v 569.755n 0.0v 574.745n 0.0v 574.755n 0.0v 579.745n 0.0v 579.755n 0.0v 584.745n 0.0v 584.755n 0.0v 589.745n 0.0v 589.755n 0.0v 594.745n 0.0v 594.755n 0.0v 599.745n 0.0v 599.755n 1.0v 604.745n 1.0v 604.755n 1.0v 609.745n 1.0v 609.755n 0.0v 614.745n 0.0v 614.755n 0.0v 619.745n 0.0v 619.755n 0.0v 624.745n 0.0v 624.755n 0.0v 629.745n 0.0v 629.755n 0.0v 634.745n 0.0v 634.755n 0.0v 639.745n 0.0v 639.755n 0.0v 644.745n 0.0v 644.755n 1.0v 649.745n 1.0v 649.755n 0.0v 654.745n 0.0v 654.755n 1.0v 659.745n 1.0v 659.755n 1.0v 664.745n 1.0v 664.755n 1.0v 669.745n 1.0v 669.755n 0.0v 674.745n 0.0v 674.755n 0.0v 679.745n 0.0v 679.755n 0.0v 684.745n 0.0v 684.755n 0.0v 689.745n 0.0v 689.755n 0.0v 694.745n 0.0v 694.755n 0.0v 699.745n 0.0v 699.755n 0.0v 704.745n 0.0v 704.755n 0.0v 709.745n 0.0v 709.755n 0.0v 714.745n 0.0v 714.755n 0.0v 719.745n 0.0v 719.755n 0.0v 724.745n 0.0v 724.755n 0.0v 729.745n 0.0v 729.755n 0.0v 734.745n 0.0v 734.755n 0.0v 739.745n 0.0v 739.755n 1.0v 744.745n 1.0v 744.755n 1.0v 749.745n 1.0v 749.755n 1.0v 754.745n 1.0v 754.755n 1.0v 759.745n 1.0v 759.755n 1.0v 764.745n 1.0v 764.755n 1.0v 769.745n 1.0v 769.755n 1.0v 774.745n 1.0v 774.755n 1.0v 779.745n 1.0v 779.755n 1.0v 784.745n 1.0v 784.755n 1.0v 789.745n 1.0v 789.755n 1.0v 794.745n 1.0v 794.755n 1.0v 799.745n 1.0v 799.755n 1.0v 804.745n 1.0v 804.755n 0.0v 809.745n 0.0v 809.755n 1.0v 814.745n 1.0v 814.755n 1.0v 819.745n 1.0v 819.755n 1.0v 824.745n 1.0v 824.755n 1.0v 829.745n 1.0v 829.755n 1.0v 834.745n 1.0v 834.755n 1.0v 839.745n 1.0v 839.755n 1.0v 844.745n 1.0v 844.755n 1.0v 849.745n 1.0v 849.755n 1.0v 854.745n 1.0v 854.755n 0.0v 859.745n 0.0v 859.755n 0.0v 864.745n 0.0v 864.755n 1.0v 869.745n 1.0v 869.755n 1.0v 874.745n 1.0v 874.755n 1.0v 879.745n 1.0v 879.755n 1.0v 884.745n 1.0v 884.755n 1.0v 889.745n 1.0v 889.755n 1.0v 894.745n 1.0v 894.755n 1.0v 899.745n 1.0v 899.755n 1.0v 904.745n 1.0v 904.755n 1.0v 909.745n 1.0v 909.755n 0.0v 914.745n 0.0v 914.755n 0.0v 919.745n 0.0v 919.755n 0.0v 924.745n 0.0v 924.755n 0.0v 929.745n 0.0v 929.755n 0.0v 934.745n 0.0v 934.755n 0.0v 939.745n 0.0v 939.755n 0.0v 944.745n 0.0v 944.755n 0.0v 949.745n 0.0v 949.755n 0.0v 954.745n 0.0v 954.755n 0.0v 959.745n 0.0v 959.755n 0.0v 964.745n 0.0v 964.755n 0.0v 969.745n 0.0v 969.755n 0.0v 974.745n 0.0v 974.755n 0.0v 979.745n 0.0v 979.755n 0.0v 984.745n 0.0v 984.755n 0.0v 989.745n 0.0v 989.755n 0.0v 994.745n 0.0v 994.755n 0.0v 999.745n 0.0v 999.755n 0.0v 1004.745n 0.0v 1004.755n 0.0v 1009.745n 0.0v 1009.755n 0.0v 1014.745n 0.0v 1014.755n 0.0v 1019.745n 0.0v 1019.755n 0.0v 1024.745n 0.0v 1024.755n 0.0v )
* (time, data): [(0, 0), (5, 1), (10, 0), (15, 1), (20, 1), (25, 1), (30, 1), (35, 1), (40, 0), (45, 0), (50, 0), (55, 0), (60, 0), (65, 0), (70, 0), (75, 0), (80, 0), (85, 1), (90, 1), (95, 1), (100, 1), (105, 1), (110, 1), (115, 1), (120, 1), (125, 1), (130, 1), (135, 1), (140, 1), (145, 1), (150, 1), (155, 1), (160, 1), (165, 1), (170, 1), (175, 1), (180, 1), (185, 1), (190, 0), (195, 0), (200, 0), (205, 0), (210, 0), (215, 0), (220, 0), (225, 0), (230, 0), (235, 0), (240, 0), (245, 1), (250, 1), (255, 1), (260, 1), (265, 1), (270, 1), (275, 1), (280, 1), (285, 1), (290, 0), (295, 0), (300, 0), (305, 0), (310, 0), (315, 0), (320, 0), (325, 0), (330, 0), (335, 1), (340, 1), (345, 1), (350, 0), (355, 0), (360, 0), (365, 0), (370, 0), (375, 0), (380, 0), (385, 0), (390, 0), (395, 0), (400, 0), (405, 0), (410, 1), (415, 1), (420, 1), (425, 1), (430, 1), (435, 1), (440, 1), (445, 1), (450, 1), (455, 1), (460, 1), (465, 1), (470, 1), (475, 1), (480, 1), (485, 0), (490, 1), (495, 1), (500, 1), (505, 1), (510, 1), (515, 0), (520, 0), (525, 0), (530, 0), (535, 1), (540, 1), (545, 0), (550, 0), (555, 0), (560, 1), (565, 1), (570, 1), (575, 1), (580, 1), (585, 1), (590, 1), (595, 1), (600, 1), (605, 1), (610, 1), (615, 1), (620, 0), (625, 0), (630, 0), (635, 1), (640, 1), (645, 1), (650, 0), (655, 1), (660, 1), (665, 1), (670, 0), (675, 0), (680, 0), (685, 0), (690, 0), (695, 0), (700, 0), (705, 0), (710, 0), (715, 0), (720, 1), (725, 1), (730, 1), (735, 1), (740, 1), (745, 1), (750, 1), (755, 1), (760, 1), (765, 1), (770, 0), (775, 0), (780, 1), (785, 1), (790, 1), (795, 1), (800, 1), (805, 1), (810, 1), (815, 1), (820, 1), (825, 1), (830, 1), (835, 1), (840, 1), (845, 1), (850, 1), (855, 0), (860, 0), (865, 1), (870, 1), (875, 1), (880, 1), (885, 1), (890, 1), (895, 1), (900, 1), (905, 1), (910, 1), (915, 1), (920, 1), (925, 1), (930, 1), (935, 1), (940, 1), (945, 1), (950, 1), (955, 1), (960, 1), (965, 0), (970, 0), (975, 0), (980, 0), (985, 0), (990, 0), (995, 0), (1000, 0), (1005, 0), (1010, 0), (1015, 0), (1020, 0), (1025, 0)]
Vdin0_37  din0_37  0 PWL (0n 0.0v 4.745n 0.0v 4.755n 1.0v 9.745n 1.0v 9.755n 0.0v 14.745n 0.0v 14.755n 1.0v 19.745n 1.0v 19.755n 1.0v 24.745n 1.0v 24.755n 1.0v 29.745n 1.0v 29.755n 1.0v 34.745n 1.0v 34.755n 1.0v 39.745n 1.0v 39.755n 0.0v 44.745n 0.0v 44.755n 0.0v 49.745n 0.0v 49.755n 0.0v 54.745n 0.0v 54.755n 0.0v 59.745n 0.0v 59.755n 0.0v 64.745n 0.0v 64.755n 0.0v 69.745n 0.0v 69.755n 0.0v 74.745n 0.0v 74.755n 0.0v 79.745n 0.0v 79.755n 0.0v 84.745n 0.0v 84.755n 1.0v 89.745n 1.0v 89.755n 1.0v 94.745n 1.0v 94.755n 1.0v 99.745n 1.0v 99.755n 1.0v 104.745n 1.0v 104.755n 1.0v 109.745n 1.0v 109.755n 1.0v 114.745n 1.0v 114.755n 1.0v 119.745n 1.0v 119.755n 1.0v 124.745n 1.0v 124.755n 1.0v 129.745n 1.0v 129.755n 1.0v 134.745n 1.0v 134.755n 1.0v 139.745n 1.0v 139.755n 1.0v 144.745n 1.0v 144.755n 1.0v 149.745n 1.0v 149.755n 1.0v 154.745n 1.0v 154.755n 1.0v 159.745n 1.0v 159.755n 1.0v 164.745n 1.0v 164.755n 1.0v 169.745n 1.0v 169.755n 1.0v 174.745n 1.0v 174.755n 1.0v 179.745n 1.0v 179.755n 1.0v 184.745n 1.0v 184.755n 1.0v 189.745n 1.0v 189.755n 0.0v 194.745n 0.0v 194.755n 0.0v 199.745n 0.0v 199.755n 0.0v 204.745n 0.0v 204.755n 0.0v 209.745n 0.0v 209.755n 0.0v 214.745n 0.0v 214.755n 0.0v 219.745n 0.0v 219.755n 0.0v 224.745n 0.0v 224.755n 0.0v 229.745n 0.0v 229.755n 0.0v 234.745n 0.0v 234.755n 0.0v 239.745n 0.0v 239.755n 0.0v 244.745n 0.0v 244.755n 1.0v 249.745n 1.0v 249.755n 1.0v 254.745n 1.0v 254.755n 1.0v 259.745n 1.0v 259.755n 1.0v 264.745n 1.0v 264.755n 1.0v 269.745n 1.0v 269.755n 1.0v 274.745n 1.0v 274.755n 1.0v 279.745n 1.0v 279.755n 1.0v 284.745n 1.0v 284.755n 1.0v 289.745n 1.0v 289.755n 0.0v 294.745n 0.0v 294.755n 0.0v 299.745n 0.0v 299.755n 0.0v 304.745n 0.0v 304.755n 0.0v 309.745n 0.0v 309.755n 0.0v 314.745n 0.0v 314.755n 0.0v 319.745n 0.0v 319.755n 0.0v 324.745n 0.0v 324.755n 0.0v 329.745n 0.0v 329.755n 0.0v 334.745n 0.0v 334.755n 1.0v 339.745n 1.0v 339.755n 1.0v 344.745n 1.0v 344.755n 1.0v 349.745n 1.0v 349.755n 0.0v 354.745n 0.0v 354.755n 0.0v 359.745n 0.0v 359.755n 0.0v 364.745n 0.0v 364.755n 0.0v 369.745n 0.0v 369.755n 0.0v 374.745n 0.0v 374.755n 0.0v 379.745n 0.0v 379.755n 0.0v 384.745n 0.0v 384.755n 0.0v 389.745n 0.0v 389.755n 0.0v 394.745n 0.0v 394.755n 0.0v 399.745n 0.0v 399.755n 0.0v 404.745n 0.0v 404.755n 0.0v 409.745n 0.0v 409.755n 1.0v 414.745n 1.0v 414.755n 1.0v 419.745n 1.0v 419.755n 1.0v 424.745n 1.0v 424.755n 1.0v 429.745n 1.0v 429.755n 1.0v 434.745n 1.0v 434.755n 1.0v 439.745n 1.0v 439.755n 1.0v 444.745n 1.0v 444.755n 1.0v 449.745n 1.0v 449.755n 1.0v 454.745n 1.0v 454.755n 1.0v 459.745n 1.0v 459.755n 1.0v 464.745n 1.0v 464.755n 1.0v 469.745n 1.0v 469.755n 1.0v 474.745n 1.0v 474.755n 1.0v 479.745n 1.0v 479.755n 1.0v 484.745n 1.0v 484.755n 0.0v 489.745n 0.0v 489.755n 1.0v 494.745n 1.0v 494.755n 1.0v 499.745n 1.0v 499.755n 1.0v 504.745n 1.0v 504.755n 1.0v 509.745n 1.0v 509.755n 1.0v 514.745n 1.0v 514.755n 0.0v 519.745n 0.0v 519.755n 0.0v 524.745n 0.0v 524.755n 0.0v 529.745n 0.0v 529.755n 0.0v 534.745n 0.0v 534.755n 1.0v 539.745n 1.0v 539.755n 1.0v 544.745n 1.0v 544.755n 0.0v 549.745n 0.0v 549.755n 0.0v 554.745n 0.0v 554.755n 0.0v 559.745n 0.0v 559.755n 1.0v 564.745n 1.0v 564.755n 1.0v 569.745n 1.0v 569.755n 1.0v 574.745n 1.0v 574.755n 1.0v 579.745n 1.0v 579.755n 1.0v 584.745n 1.0v 584.755n 1.0v 589.745n 1.0v 589.755n 1.0v 594.745n 1.0v 594.755n 1.0v 599.745n 1.0v 599.755n 1.0v 604.745n 1.0v 604.755n 1.0v 609.745n 1.0v 609.755n 1.0v 614.745n 1.0v 614.755n 1.0v 619.745n 1.0v 619.755n 0.0v 624.745n 0.0v 624.755n 0.0v 629.745n 0.0v 629.755n 0.0v 634.745n 0.0v 634.755n 1.0v 639.745n 1.0v 639.755n 1.0v 644.745n 1.0v 644.755n 1.0v 649.745n 1.0v 649.755n 0.0v 654.745n 0.0v 654.755n 1.0v 659.745n 1.0v 659.755n 1.0v 664.745n 1.0v 664.755n 1.0v 669.745n 1.0v 669.755n 0.0v 674.745n 0.0v 674.755n 0.0v 679.745n 0.0v 679.755n 0.0v 684.745n 0.0v 684.755n 0.0v 689.745n 0.0v 689.755n 0.0v 694.745n 0.0v 694.755n 0.0v 699.745n 0.0v 699.755n 0.0v 704.745n 0.0v 704.755n 0.0v 709.745n 0.0v 709.755n 0.0v 714.745n 0.0v 714.755n 0.0v 719.745n 0.0v 719.755n 1.0v 724.745n 1.0v 724.755n 1.0v 729.745n 1.0v 729.755n 1.0v 734.745n 1.0v 734.755n 1.0v 739.745n 1.0v 739.755n 1.0v 744.745n 1.0v 744.755n 1.0v 749.745n 1.0v 749.755n 1.0v 754.745n 1.0v 754.755n 1.0v 759.745n 1.0v 759.755n 1.0v 764.745n 1.0v 764.755n 1.0v 769.745n 1.0v 769.755n 0.0v 774.745n 0.0v 774.755n 0.0v 779.745n 0.0v 779.755n 1.0v 784.745n 1.0v 784.755n 1.0v 789.745n 1.0v 789.755n 1.0v 794.745n 1.0v 794.755n 1.0v 799.745n 1.0v 799.755n 1.0v 804.745n 1.0v 804.755n 1.0v 809.745n 1.0v 809.755n 1.0v 814.745n 1.0v 814.755n 1.0v 819.745n 1.0v 819.755n 1.0v 824.745n 1.0v 824.755n 1.0v 829.745n 1.0v 829.755n 1.0v 834.745n 1.0v 834.755n 1.0v 839.745n 1.0v 839.755n 1.0v 844.745n 1.0v 844.755n 1.0v 849.745n 1.0v 849.755n 1.0v 854.745n 1.0v 854.755n 0.0v 859.745n 0.0v 859.755n 0.0v 864.745n 0.0v 864.755n 1.0v 869.745n 1.0v 869.755n 1.0v 874.745n 1.0v 874.755n 1.0v 879.745n 1.0v 879.755n 1.0v 884.745n 1.0v 884.755n 1.0v 889.745n 1.0v 889.755n 1.0v 894.745n 1.0v 894.755n 1.0v 899.745n 1.0v 899.755n 1.0v 904.745n 1.0v 904.755n 1.0v 909.745n 1.0v 909.755n 1.0v 914.745n 1.0v 914.755n 1.0v 919.745n 1.0v 919.755n 1.0v 924.745n 1.0v 924.755n 1.0v 929.745n 1.0v 929.755n 1.0v 934.745n 1.0v 934.755n 1.0v 939.745n 1.0v 939.755n 1.0v 944.745n 1.0v 944.755n 1.0v 949.745n 1.0v 949.755n 1.0v 954.745n 1.0v 954.755n 1.0v 959.745n 1.0v 959.755n 1.0v 964.745n 1.0v 964.755n 0.0v 969.745n 0.0v 969.755n 0.0v 974.745n 0.0v 974.755n 0.0v 979.745n 0.0v 979.755n 0.0v 984.745n 0.0v 984.755n 0.0v 989.745n 0.0v 989.755n 0.0v 994.745n 0.0v 994.755n 0.0v 999.745n 0.0v 999.755n 0.0v 1004.745n 0.0v 1004.755n 0.0v 1009.745n 0.0v 1009.755n 0.0v 1014.745n 0.0v 1014.755n 0.0v 1019.745n 0.0v 1019.755n 0.0v 1024.745n 0.0v 1024.755n 0.0v )
* (time, data): [(0, 0), (5, 0), (10, 0), (15, 0), (20, 0), (25, 0), (30, 0), (35, 0), (40, 0), (45, 0), (50, 1), (55, 1), (60, 1), (65, 1), (70, 1), (75, 1), (80, 1), (85, 1), (90, 1), (95, 1), (100, 0), (105, 1), (110, 1), (115, 1), (120, 1), (125, 1), (130, 1), (135, 1), (140, 1), (145, 1), (150, 1), (155, 0), (160, 0), (165, 0), (170, 0), (175, 0), (180, 0), (185, 0), (190, 0), (195, 0), (200, 0), (205, 0), (210, 0), (215, 0), (220, 0), (225, 0), (230, 0), (235, 0), (240, 0), (245, 0), (250, 0), (255, 0), (260, 0), (265, 0), (270, 0), (275, 0), (280, 0), (285, 0), (290, 1), (295, 1), (300, 1), (305, 1), (310, 1), (315, 1), (320, 1), (325, 1), (330, 1), (335, 0), (340, 0), (345, 0), (350, 0), (355, 0), (360, 0), (365, 0), (370, 0), (375, 0), (380, 0), (385, 0), (390, 0), (395, 0), (400, 0), (405, 0), (410, 0), (415, 0), (420, 0), (425, 0), (430, 0), (435, 0), (440, 0), (445, 1), (450, 1), (455, 1), (460, 1), (465, 1), (470, 1), (475, 1), (480, 1), (485, 0), (490, 1), (495, 1), (500, 0), (505, 0), (510, 0), (515, 1), (520, 1), (525, 1), (530, 1), (535, 0), (540, 1), (545, 0), (550, 0), (555, 0), (560, 1), (565, 1), (570, 1), (575, 1), (580, 1), (585, 1), (590, 1), (595, 1), (600, 0), (605, 0), (610, 0), (615, 0), (620, 0), (625, 0), (630, 0), (635, 1), (640, 1), (645, 0), (650, 0), (655, 0), (660, 0), (665, 0), (670, 0), (675, 0), (680, 0), (685, 0), (690, 0), (695, 0), (700, 0), (705, 0), (710, 0), (715, 0), (720, 1), (725, 1), (730, 1), (735, 1), (740, 0), (745, 0), (750, 0), (755, 0), (760, 0), (765, 0), (770, 0), (775, 0), (780, 0), (785, 0), (790, 0), (795, 0), (800, 0), (805, 0), (810, 0), (815, 0), (820, 0), (825, 0), (830, 0), (835, 0), (840, 1), (845, 1), (850, 0), (855, 0), (860, 0), (865, 1), (870, 1), (875, 1), (880, 1), (885, 1), (890, 1), (895, 1), (900, 1), (905, 1), (910, 1), (915, 1), (920, 1), (925, 1), (930, 0), (935, 0), (940, 0), (945, 0), (950, 0), (955, 0), (960, 0), (965, 0), (970, 0), (975, 0), (980, 0), (985, 0), (990, 0), (995, 0), (1000, 0), (1005, 0), (1010, 0), (1015, 0), (1020, 1), (1025, 1)]
Vdin0_38  din0_38  0 PWL (0n 0.0v 4.745n 0.0v 4.755n 0.0v 9.745n 0.0v 9.755n 0.0v 14.745n 0.0v 14.755n 0.0v 19.745n 0.0v 19.755n 0.0v 24.745n 0.0v 24.755n 0.0v 29.745n 0.0v 29.755n 0.0v 34.745n 0.0v 34.755n 0.0v 39.745n 0.0v 39.755n 0.0v 44.745n 0.0v 44.755n 0.0v 49.745n 0.0v 49.755n 1.0v 54.745n 1.0v 54.755n 1.0v 59.745n 1.0v 59.755n 1.0v 64.745n 1.0v 64.755n 1.0v 69.745n 1.0v 69.755n 1.0v 74.745n 1.0v 74.755n 1.0v 79.745n 1.0v 79.755n 1.0v 84.745n 1.0v 84.755n 1.0v 89.745n 1.0v 89.755n 1.0v 94.745n 1.0v 94.755n 1.0v 99.745n 1.0v 99.755n 0.0v 104.745n 0.0v 104.755n 1.0v 109.745n 1.0v 109.755n 1.0v 114.745n 1.0v 114.755n 1.0v 119.745n 1.0v 119.755n 1.0v 124.745n 1.0v 124.755n 1.0v 129.745n 1.0v 129.755n 1.0v 134.745n 1.0v 134.755n 1.0v 139.745n 1.0v 139.755n 1.0v 144.745n 1.0v 144.755n 1.0v 149.745n 1.0v 149.755n 1.0v 154.745n 1.0v 154.755n 0.0v 159.745n 0.0v 159.755n 0.0v 164.745n 0.0v 164.755n 0.0v 169.745n 0.0v 169.755n 0.0v 174.745n 0.0v 174.755n 0.0v 179.745n 0.0v 179.755n 0.0v 184.745n 0.0v 184.755n 0.0v 189.745n 0.0v 189.755n 0.0v 194.745n 0.0v 194.755n 0.0v 199.745n 0.0v 199.755n 0.0v 204.745n 0.0v 204.755n 0.0v 209.745n 0.0v 209.755n 0.0v 214.745n 0.0v 214.755n 0.0v 219.745n 0.0v 219.755n 0.0v 224.745n 0.0v 224.755n 0.0v 229.745n 0.0v 229.755n 0.0v 234.745n 0.0v 234.755n 0.0v 239.745n 0.0v 239.755n 0.0v 244.745n 0.0v 244.755n 0.0v 249.745n 0.0v 249.755n 0.0v 254.745n 0.0v 254.755n 0.0v 259.745n 0.0v 259.755n 0.0v 264.745n 0.0v 264.755n 0.0v 269.745n 0.0v 269.755n 0.0v 274.745n 0.0v 274.755n 0.0v 279.745n 0.0v 279.755n 0.0v 284.745n 0.0v 284.755n 0.0v 289.745n 0.0v 289.755n 1.0v 294.745n 1.0v 294.755n 1.0v 299.745n 1.0v 299.755n 1.0v 304.745n 1.0v 304.755n 1.0v 309.745n 1.0v 309.755n 1.0v 314.745n 1.0v 314.755n 1.0v 319.745n 1.0v 319.755n 1.0v 324.745n 1.0v 324.755n 1.0v 329.745n 1.0v 329.755n 1.0v 334.745n 1.0v 334.755n 0.0v 339.745n 0.0v 339.755n 0.0v 344.745n 0.0v 344.755n 0.0v 349.745n 0.0v 349.755n 0.0v 354.745n 0.0v 354.755n 0.0v 359.745n 0.0v 359.755n 0.0v 364.745n 0.0v 364.755n 0.0v 369.745n 0.0v 369.755n 0.0v 374.745n 0.0v 374.755n 0.0v 379.745n 0.0v 379.755n 0.0v 384.745n 0.0v 384.755n 0.0v 389.745n 0.0v 389.755n 0.0v 394.745n 0.0v 394.755n 0.0v 399.745n 0.0v 399.755n 0.0v 404.745n 0.0v 404.755n 0.0v 409.745n 0.0v 409.755n 0.0v 414.745n 0.0v 414.755n 0.0v 419.745n 0.0v 419.755n 0.0v 424.745n 0.0v 424.755n 0.0v 429.745n 0.0v 429.755n 0.0v 434.745n 0.0v 434.755n 0.0v 439.745n 0.0v 439.755n 0.0v 444.745n 0.0v 444.755n 1.0v 449.745n 1.0v 449.755n 1.0v 454.745n 1.0v 454.755n 1.0v 459.745n 1.0v 459.755n 1.0v 464.745n 1.0v 464.755n 1.0v 469.745n 1.0v 469.755n 1.0v 474.745n 1.0v 474.755n 1.0v 479.745n 1.0v 479.755n 1.0v 484.745n 1.0v 484.755n 0.0v 489.745n 0.0v 489.755n 1.0v 494.745n 1.0v 494.755n 1.0v 499.745n 1.0v 499.755n 0.0v 504.745n 0.0v 504.755n 0.0v 509.745n 0.0v 509.755n 0.0v 514.745n 0.0v 514.755n 1.0v 519.745n 1.0v 519.755n 1.0v 524.745n 1.0v 524.755n 1.0v 529.745n 1.0v 529.755n 1.0v 534.745n 1.0v 534.755n 0.0v 539.745n 0.0v 539.755n 1.0v 544.745n 1.0v 544.755n 0.0v 549.745n 0.0v 549.755n 0.0v 554.745n 0.0v 554.755n 0.0v 559.745n 0.0v 559.755n 1.0v 564.745n 1.0v 564.755n 1.0v 569.745n 1.0v 569.755n 1.0v 574.745n 1.0v 574.755n 1.0v 579.745n 1.0v 579.755n 1.0v 584.745n 1.0v 584.755n 1.0v 589.745n 1.0v 589.755n 1.0v 594.745n 1.0v 594.755n 1.0v 599.745n 1.0v 599.755n 0.0v 604.745n 0.0v 604.755n 0.0v 609.745n 0.0v 609.755n 0.0v 614.745n 0.0v 614.755n 0.0v 619.745n 0.0v 619.755n 0.0v 624.745n 0.0v 624.755n 0.0v 629.745n 0.0v 629.755n 0.0v 634.745n 0.0v 634.755n 1.0v 639.745n 1.0v 639.755n 1.0v 644.745n 1.0v 644.755n 0.0v 649.745n 0.0v 649.755n 0.0v 654.745n 0.0v 654.755n 0.0v 659.745n 0.0v 659.755n 0.0v 664.745n 0.0v 664.755n 0.0v 669.745n 0.0v 669.755n 0.0v 674.745n 0.0v 674.755n 0.0v 679.745n 0.0v 679.755n 0.0v 684.745n 0.0v 684.755n 0.0v 689.745n 0.0v 689.755n 0.0v 694.745n 0.0v 694.755n 0.0v 699.745n 0.0v 699.755n 0.0v 704.745n 0.0v 704.755n 0.0v 709.745n 0.0v 709.755n 0.0v 714.745n 0.0v 714.755n 0.0v 719.745n 0.0v 719.755n 1.0v 724.745n 1.0v 724.755n 1.0v 729.745n 1.0v 729.755n 1.0v 734.745n 1.0v 734.755n 1.0v 739.745n 1.0v 739.755n 0.0v 744.745n 0.0v 744.755n 0.0v 749.745n 0.0v 749.755n 0.0v 754.745n 0.0v 754.755n 0.0v 759.745n 0.0v 759.755n 0.0v 764.745n 0.0v 764.755n 0.0v 769.745n 0.0v 769.755n 0.0v 774.745n 0.0v 774.755n 0.0v 779.745n 0.0v 779.755n 0.0v 784.745n 0.0v 784.755n 0.0v 789.745n 0.0v 789.755n 0.0v 794.745n 0.0v 794.755n 0.0v 799.745n 0.0v 799.755n 0.0v 804.745n 0.0v 804.755n 0.0v 809.745n 0.0v 809.755n 0.0v 814.745n 0.0v 814.755n 0.0v 819.745n 0.0v 819.755n 0.0v 824.745n 0.0v 824.755n 0.0v 829.745n 0.0v 829.755n 0.0v 834.745n 0.0v 834.755n 0.0v 839.745n 0.0v 839.755n 1.0v 844.745n 1.0v 844.755n 1.0v 849.745n 1.0v 849.755n 0.0v 854.745n 0.0v 854.755n 0.0v 859.745n 0.0v 859.755n 0.0v 864.745n 0.0v 864.755n 1.0v 869.745n 1.0v 869.755n 1.0v 874.745n 1.0v 874.755n 1.0v 879.745n 1.0v 879.755n 1.0v 884.745n 1.0v 884.755n 1.0v 889.745n 1.0v 889.755n 1.0v 894.745n 1.0v 894.755n 1.0v 899.745n 1.0v 899.755n 1.0v 904.745n 1.0v 904.755n 1.0v 909.745n 1.0v 909.755n 1.0v 914.745n 1.0v 914.755n 1.0v 919.745n 1.0v 919.755n 1.0v 924.745n 1.0v 924.755n 1.0v 929.745n 1.0v 929.755n 0.0v 934.745n 0.0v 934.755n 0.0v 939.745n 0.0v 939.755n 0.0v 944.745n 0.0v 944.755n 0.0v 949.745n 0.0v 949.755n 0.0v 954.745n 0.0v 954.755n 0.0v 959.745n 0.0v 959.755n 0.0v 964.745n 0.0v 964.755n 0.0v 969.745n 0.0v 969.755n 0.0v 974.745n 0.0v 974.755n 0.0v 979.745n 0.0v 979.755n 0.0v 984.745n 0.0v 984.755n 0.0v 989.745n 0.0v 989.755n 0.0v 994.745n 0.0v 994.755n 0.0v 999.745n 0.0v 999.755n 0.0v 1004.745n 0.0v 1004.755n 0.0v 1009.745n 0.0v 1009.755n 0.0v 1014.745n 0.0v 1014.755n 0.0v 1019.745n 0.0v 1019.755n 1.0v 1024.745n 1.0v 1024.755n 1.0v )
* (time, data): [(0, 0), (5, 0), (10, 1), (15, 1), (20, 1), (25, 1), (30, 1), (35, 1), (40, 1), (45, 1), (50, 0), (55, 0), (60, 0), (65, 1), (70, 1), (75, 1), (80, 1), (85, 0), (90, 0), (95, 0), (100, 0), (105, 1), (110, 1), (115, 0), (120, 0), (125, 0), (130, 0), (135, 0), (140, 0), (145, 0), (150, 0), (155, 1), (160, 1), (165, 1), (170, 1), (175, 1), (180, 1), (185, 1), (190, 1), (195, 0), (200, 0), (205, 0), (210, 0), (215, 0), (220, 0), (225, 0), (230, 0), (235, 0), (240, 0), (245, 0), (250, 0), (255, 0), (260, 0), (265, 0), (270, 0), (275, 0), (280, 0), (285, 0), (290, 1), (295, 1), (300, 1), (305, 1), (310, 1), (315, 1), (320, 1), (325, 1), (330, 1), (335, 0), (340, 0), (345, 0), (350, 1), (355, 1), (360, 1), (365, 1), (370, 1), (375, 1), (380, 1), (385, 1), (390, 1), (395, 1), (400, 1), (405, 1), (410, 0), (415, 0), (420, 0), (425, 0), (430, 0), (435, 1), (440, 1), (445, 0), (450, 0), (455, 0), (460, 0), (465, 0), (470, 0), (475, 0), (480, 0), (485, 0), (490, 0), (495, 0), (500, 0), (505, 0), (510, 0), (515, 0), (520, 0), (525, 0), (530, 0), (535, 0), (540, 0), (545, 1), (550, 0), (555, 0), (560, 0), (565, 0), (570, 0), (575, 0), (580, 0), (585, 0), (590, 0), (595, 0), (600, 0), (605, 0), (610, 1), (615, 1), (620, 0), (625, 0), (630, 0), (635, 0), (640, 0), (645, 1), (650, 1), (655, 0), (660, 0), (665, 0), (670, 0), (675, 0), (680, 0), (685, 0), (690, 0), (695, 0), (700, 0), (705, 0), (710, 0), (715, 0), (720, 0), (725, 0), (730, 0), (735, 0), (740, 0), (745, 0), (750, 0), (755, 0), (760, 0), (765, 0), (770, 0), (775, 0), (780, 0), (785, 0), (790, 0), (795, 0), (800, 0), (805, 0), (810, 1), (815, 1), (820, 1), (825, 1), (830, 1), (835, 1), (840, 0), (845, 0), (850, 0), (855, 1), (860, 1), (865, 0), (870, 1), (875, 1), (880, 1), (885, 1), (890, 1), (895, 1), (900, 1), (905, 1), (910, 1), (915, 0), (920, 0), (925, 0), (930, 0), (935, 0), (940, 0), (945, 0), (950, 0), (955, 0), (960, 0), (965, 1), (970, 1), (975, 1), (980, 1), (985, 1), (990, 1), (995, 1), (1000, 1), (1005, 1), (1010, 1), (1015, 1), (1020, 0), (1025, 0)]
Vdin0_39  din0_39  0 PWL (0n 0.0v 4.745n 0.0v 4.755n 0.0v 9.745n 0.0v 9.755n 1.0v 14.745n 1.0v 14.755n 1.0v 19.745n 1.0v 19.755n 1.0v 24.745n 1.0v 24.755n 1.0v 29.745n 1.0v 29.755n 1.0v 34.745n 1.0v 34.755n 1.0v 39.745n 1.0v 39.755n 1.0v 44.745n 1.0v 44.755n 1.0v 49.745n 1.0v 49.755n 0.0v 54.745n 0.0v 54.755n 0.0v 59.745n 0.0v 59.755n 0.0v 64.745n 0.0v 64.755n 1.0v 69.745n 1.0v 69.755n 1.0v 74.745n 1.0v 74.755n 1.0v 79.745n 1.0v 79.755n 1.0v 84.745n 1.0v 84.755n 0.0v 89.745n 0.0v 89.755n 0.0v 94.745n 0.0v 94.755n 0.0v 99.745n 0.0v 99.755n 0.0v 104.745n 0.0v 104.755n 1.0v 109.745n 1.0v 109.755n 1.0v 114.745n 1.0v 114.755n 0.0v 119.745n 0.0v 119.755n 0.0v 124.745n 0.0v 124.755n 0.0v 129.745n 0.0v 129.755n 0.0v 134.745n 0.0v 134.755n 0.0v 139.745n 0.0v 139.755n 0.0v 144.745n 0.0v 144.755n 0.0v 149.745n 0.0v 149.755n 0.0v 154.745n 0.0v 154.755n 1.0v 159.745n 1.0v 159.755n 1.0v 164.745n 1.0v 164.755n 1.0v 169.745n 1.0v 169.755n 1.0v 174.745n 1.0v 174.755n 1.0v 179.745n 1.0v 179.755n 1.0v 184.745n 1.0v 184.755n 1.0v 189.745n 1.0v 189.755n 1.0v 194.745n 1.0v 194.755n 0.0v 199.745n 0.0v 199.755n 0.0v 204.745n 0.0v 204.755n 0.0v 209.745n 0.0v 209.755n 0.0v 214.745n 0.0v 214.755n 0.0v 219.745n 0.0v 219.755n 0.0v 224.745n 0.0v 224.755n 0.0v 229.745n 0.0v 229.755n 0.0v 234.745n 0.0v 234.755n 0.0v 239.745n 0.0v 239.755n 0.0v 244.745n 0.0v 244.755n 0.0v 249.745n 0.0v 249.755n 0.0v 254.745n 0.0v 254.755n 0.0v 259.745n 0.0v 259.755n 0.0v 264.745n 0.0v 264.755n 0.0v 269.745n 0.0v 269.755n 0.0v 274.745n 0.0v 274.755n 0.0v 279.745n 0.0v 279.755n 0.0v 284.745n 0.0v 284.755n 0.0v 289.745n 0.0v 289.755n 1.0v 294.745n 1.0v 294.755n 1.0v 299.745n 1.0v 299.755n 1.0v 304.745n 1.0v 304.755n 1.0v 309.745n 1.0v 309.755n 1.0v 314.745n 1.0v 314.755n 1.0v 319.745n 1.0v 319.755n 1.0v 324.745n 1.0v 324.755n 1.0v 329.745n 1.0v 329.755n 1.0v 334.745n 1.0v 334.755n 0.0v 339.745n 0.0v 339.755n 0.0v 344.745n 0.0v 344.755n 0.0v 349.745n 0.0v 349.755n 1.0v 354.745n 1.0v 354.755n 1.0v 359.745n 1.0v 359.755n 1.0v 364.745n 1.0v 364.755n 1.0v 369.745n 1.0v 369.755n 1.0v 374.745n 1.0v 374.755n 1.0v 379.745n 1.0v 379.755n 1.0v 384.745n 1.0v 384.755n 1.0v 389.745n 1.0v 389.755n 1.0v 394.745n 1.0v 394.755n 1.0v 399.745n 1.0v 399.755n 1.0v 404.745n 1.0v 404.755n 1.0v 409.745n 1.0v 409.755n 0.0v 414.745n 0.0v 414.755n 0.0v 419.745n 0.0v 419.755n 0.0v 424.745n 0.0v 424.755n 0.0v 429.745n 0.0v 429.755n 0.0v 434.745n 0.0v 434.755n 1.0v 439.745n 1.0v 439.755n 1.0v 444.745n 1.0v 444.755n 0.0v 449.745n 0.0v 449.755n 0.0v 454.745n 0.0v 454.755n 0.0v 459.745n 0.0v 459.755n 0.0v 464.745n 0.0v 464.755n 0.0v 469.745n 0.0v 469.755n 0.0v 474.745n 0.0v 474.755n 0.0v 479.745n 0.0v 479.755n 0.0v 484.745n 0.0v 484.755n 0.0v 489.745n 0.0v 489.755n 0.0v 494.745n 0.0v 494.755n 0.0v 499.745n 0.0v 499.755n 0.0v 504.745n 0.0v 504.755n 0.0v 509.745n 0.0v 509.755n 0.0v 514.745n 0.0v 514.755n 0.0v 519.745n 0.0v 519.755n 0.0v 524.745n 0.0v 524.755n 0.0v 529.745n 0.0v 529.755n 0.0v 534.745n 0.0v 534.755n 0.0v 539.745n 0.0v 539.755n 0.0v 544.745n 0.0v 544.755n 1.0v 549.745n 1.0v 549.755n 0.0v 554.745n 0.0v 554.755n 0.0v 559.745n 0.0v 559.755n 0.0v 564.745n 0.0v 564.755n 0.0v 569.745n 0.0v 569.755n 0.0v 574.745n 0.0v 574.755n 0.0v 579.745n 0.0v 579.755n 0.0v 584.745n 0.0v 584.755n 0.0v 589.745n 0.0v 589.755n 0.0v 594.745n 0.0v 594.755n 0.0v 599.745n 0.0v 599.755n 0.0v 604.745n 0.0v 604.755n 0.0v 609.745n 0.0v 609.755n 1.0v 614.745n 1.0v 614.755n 1.0v 619.745n 1.0v 619.755n 0.0v 624.745n 0.0v 624.755n 0.0v 629.745n 0.0v 629.755n 0.0v 634.745n 0.0v 634.755n 0.0v 639.745n 0.0v 639.755n 0.0v 644.745n 0.0v 644.755n 1.0v 649.745n 1.0v 649.755n 1.0v 654.745n 1.0v 654.755n 0.0v 659.745n 0.0v 659.755n 0.0v 664.745n 0.0v 664.755n 0.0v 669.745n 0.0v 669.755n 0.0v 674.745n 0.0v 674.755n 0.0v 679.745n 0.0v 679.755n 0.0v 684.745n 0.0v 684.755n 0.0v 689.745n 0.0v 689.755n 0.0v 694.745n 0.0v 694.755n 0.0v 699.745n 0.0v 699.755n 0.0v 704.745n 0.0v 704.755n 0.0v 709.745n 0.0v 709.755n 0.0v 714.745n 0.0v 714.755n 0.0v 719.745n 0.0v 719.755n 0.0v 724.745n 0.0v 724.755n 0.0v 729.745n 0.0v 729.755n 0.0v 734.745n 0.0v 734.755n 0.0v 739.745n 0.0v 739.755n 0.0v 744.745n 0.0v 744.755n 0.0v 749.745n 0.0v 749.755n 0.0v 754.745n 0.0v 754.755n 0.0v 759.745n 0.0v 759.755n 0.0v 764.745n 0.0v 764.755n 0.0v 769.745n 0.0v 769.755n 0.0v 774.745n 0.0v 774.755n 0.0v 779.745n 0.0v 779.755n 0.0v 784.745n 0.0v 784.755n 0.0v 789.745n 0.0v 789.755n 0.0v 794.745n 0.0v 794.755n 0.0v 799.745n 0.0v 799.755n 0.0v 804.745n 0.0v 804.755n 0.0v 809.745n 0.0v 809.755n 1.0v 814.745n 1.0v 814.755n 1.0v 819.745n 1.0v 819.755n 1.0v 824.745n 1.0v 824.755n 1.0v 829.745n 1.0v 829.755n 1.0v 834.745n 1.0v 834.755n 1.0v 839.745n 1.0v 839.755n 0.0v 844.745n 0.0v 844.755n 0.0v 849.745n 0.0v 849.755n 0.0v 854.745n 0.0v 854.755n 1.0v 859.745n 1.0v 859.755n 1.0v 864.745n 1.0v 864.755n 0.0v 869.745n 0.0v 869.755n 1.0v 874.745n 1.0v 874.755n 1.0v 879.745n 1.0v 879.755n 1.0v 884.745n 1.0v 884.755n 1.0v 889.745n 1.0v 889.755n 1.0v 894.745n 1.0v 894.755n 1.0v 899.745n 1.0v 899.755n 1.0v 904.745n 1.0v 904.755n 1.0v 909.745n 1.0v 909.755n 1.0v 914.745n 1.0v 914.755n 0.0v 919.745n 0.0v 919.755n 0.0v 924.745n 0.0v 924.755n 0.0v 929.745n 0.0v 929.755n 0.0v 934.745n 0.0v 934.755n 0.0v 939.745n 0.0v 939.755n 0.0v 944.745n 0.0v 944.755n 0.0v 949.745n 0.0v 949.755n 0.0v 954.745n 0.0v 954.755n 0.0v 959.745n 0.0v 959.755n 0.0v 964.745n 0.0v 964.755n 1.0v 969.745n 1.0v 969.755n 1.0v 974.745n 1.0v 974.755n 1.0v 979.745n 1.0v 979.755n 1.0v 984.745n 1.0v 984.755n 1.0v 989.745n 1.0v 989.755n 1.0v 994.745n 1.0v 994.755n 1.0v 999.745n 1.0v 999.755n 1.0v 1004.745n 1.0v 1004.755n 1.0v 1009.745n 1.0v 1009.755n 1.0v 1014.745n 1.0v 1014.755n 1.0v 1019.745n 1.0v 1019.755n 0.0v 1024.745n 0.0v 1024.755n 0.0v )
* (time, data): [(0, 0), (5, 0), (10, 1), (15, 0), (20, 0), (25, 0), (30, 0), (35, 0), (40, 0), (45, 0), (50, 0), (55, 0), (60, 0), (65, 1), (70, 1), (75, 1), (80, 1), (85, 0), (90, 0), (95, 0), (100, 1), (105, 1), (110, 1), (115, 0), (120, 0), (125, 0), (130, 0), (135, 0), (140, 0), (145, 0), (150, 0), (155, 1), (160, 1), (165, 1), (170, 1), (175, 1), (180, 1), (185, 1), (190, 1), (195, 1), (200, 1), (205, 1), (210, 1), (215, 1), (220, 1), (225, 1), (230, 1), (235, 1), (240, 1), (245, 0), (250, 0), (255, 0), (260, 0), (265, 0), (270, 0), (275, 0), (280, 0), (285, 0), (290, 1), (295, 1), (300, 1), (305, 1), (310, 1), (315, 1), (320, 1), (325, 1), (330, 1), (335, 0), (340, 0), (345, 0), (350, 0), (355, 0), (360, 0), (365, 0), (370, 0), (375, 0), (380, 0), (385, 0), (390, 0), (395, 0), (400, 0), (405, 0), (410, 1), (415, 1), (420, 1), (425, 1), (430, 1), (435, 1), (440, 1), (445, 0), (450, 0), (455, 0), (460, 0), (465, 0), (470, 0), (475, 0), (480, 0), (485, 0), (490, 1), (495, 1), (500, 0), (505, 0), (510, 0), (515, 0), (520, 0), (525, 0), (530, 0), (535, 1), (540, 1), (545, 0), (550, 1), (555, 1), (560, 0), (565, 0), (570, 0), (575, 0), (580, 0), (585, 0), (590, 0), (595, 0), (600, 1), (605, 1), (610, 1), (615, 1), (620, 1), (625, 1), (630, 1), (635, 1), (640, 1), (645, 1), (650, 1), (655, 0), (660, 0), (665, 0), (670, 0), (675, 0), (680, 0), (685, 0), (690, 0), (695, 0), (700, 0), (705, 0), (710, 0), (715, 0), (720, 1), (725, 1), (730, 1), (735, 1), (740, 0), (745, 0), (750, 0), (755, 0), (760, 0), (765, 0), (770, 1), (775, 1), (780, 1), (785, 1), (790, 1), (795, 1), (800, 1), (805, 0), (810, 1), (815, 1), (820, 1), (825, 1), (830, 1), (835, 1), (840, 1), (845, 1), (850, 1), (855, 0), (860, 0), (865, 1), (870, 1), (875, 1), (880, 1), (885, 1), (890, 1), (895, 1), (900, 1), (905, 1), (910, 0), (915, 0), (920, 0), (925, 0), (930, 0), (935, 0), (940, 0), (945, 0), (950, 0), (955, 0), (960, 0), (965, 0), (970, 0), (975, 0), (980, 0), (985, 0), (990, 0), (995, 0), (1000, 0), (1005, 0), (1010, 0), (1015, 0), (1020, 1), (1025, 1)]
Vdin0_40  din0_40  0 PWL (0n 0.0v 4.745n 0.0v 4.755n 0.0v 9.745n 0.0v 9.755n 1.0v 14.745n 1.0v 14.755n 0.0v 19.745n 0.0v 19.755n 0.0v 24.745n 0.0v 24.755n 0.0v 29.745n 0.0v 29.755n 0.0v 34.745n 0.0v 34.755n 0.0v 39.745n 0.0v 39.755n 0.0v 44.745n 0.0v 44.755n 0.0v 49.745n 0.0v 49.755n 0.0v 54.745n 0.0v 54.755n 0.0v 59.745n 0.0v 59.755n 0.0v 64.745n 0.0v 64.755n 1.0v 69.745n 1.0v 69.755n 1.0v 74.745n 1.0v 74.755n 1.0v 79.745n 1.0v 79.755n 1.0v 84.745n 1.0v 84.755n 0.0v 89.745n 0.0v 89.755n 0.0v 94.745n 0.0v 94.755n 0.0v 99.745n 0.0v 99.755n 1.0v 104.745n 1.0v 104.755n 1.0v 109.745n 1.0v 109.755n 1.0v 114.745n 1.0v 114.755n 0.0v 119.745n 0.0v 119.755n 0.0v 124.745n 0.0v 124.755n 0.0v 129.745n 0.0v 129.755n 0.0v 134.745n 0.0v 134.755n 0.0v 139.745n 0.0v 139.755n 0.0v 144.745n 0.0v 144.755n 0.0v 149.745n 0.0v 149.755n 0.0v 154.745n 0.0v 154.755n 1.0v 159.745n 1.0v 159.755n 1.0v 164.745n 1.0v 164.755n 1.0v 169.745n 1.0v 169.755n 1.0v 174.745n 1.0v 174.755n 1.0v 179.745n 1.0v 179.755n 1.0v 184.745n 1.0v 184.755n 1.0v 189.745n 1.0v 189.755n 1.0v 194.745n 1.0v 194.755n 1.0v 199.745n 1.0v 199.755n 1.0v 204.745n 1.0v 204.755n 1.0v 209.745n 1.0v 209.755n 1.0v 214.745n 1.0v 214.755n 1.0v 219.745n 1.0v 219.755n 1.0v 224.745n 1.0v 224.755n 1.0v 229.745n 1.0v 229.755n 1.0v 234.745n 1.0v 234.755n 1.0v 239.745n 1.0v 239.755n 1.0v 244.745n 1.0v 244.755n 0.0v 249.745n 0.0v 249.755n 0.0v 254.745n 0.0v 254.755n 0.0v 259.745n 0.0v 259.755n 0.0v 264.745n 0.0v 264.755n 0.0v 269.745n 0.0v 269.755n 0.0v 274.745n 0.0v 274.755n 0.0v 279.745n 0.0v 279.755n 0.0v 284.745n 0.0v 284.755n 0.0v 289.745n 0.0v 289.755n 1.0v 294.745n 1.0v 294.755n 1.0v 299.745n 1.0v 299.755n 1.0v 304.745n 1.0v 304.755n 1.0v 309.745n 1.0v 309.755n 1.0v 314.745n 1.0v 314.755n 1.0v 319.745n 1.0v 319.755n 1.0v 324.745n 1.0v 324.755n 1.0v 329.745n 1.0v 329.755n 1.0v 334.745n 1.0v 334.755n 0.0v 339.745n 0.0v 339.755n 0.0v 344.745n 0.0v 344.755n 0.0v 349.745n 0.0v 349.755n 0.0v 354.745n 0.0v 354.755n 0.0v 359.745n 0.0v 359.755n 0.0v 364.745n 0.0v 364.755n 0.0v 369.745n 0.0v 369.755n 0.0v 374.745n 0.0v 374.755n 0.0v 379.745n 0.0v 379.755n 0.0v 384.745n 0.0v 384.755n 0.0v 389.745n 0.0v 389.755n 0.0v 394.745n 0.0v 394.755n 0.0v 399.745n 0.0v 399.755n 0.0v 404.745n 0.0v 404.755n 0.0v 409.745n 0.0v 409.755n 1.0v 414.745n 1.0v 414.755n 1.0v 419.745n 1.0v 419.755n 1.0v 424.745n 1.0v 424.755n 1.0v 429.745n 1.0v 429.755n 1.0v 434.745n 1.0v 434.755n 1.0v 439.745n 1.0v 439.755n 1.0v 444.745n 1.0v 444.755n 0.0v 449.745n 0.0v 449.755n 0.0v 454.745n 0.0v 454.755n 0.0v 459.745n 0.0v 459.755n 0.0v 464.745n 0.0v 464.755n 0.0v 469.745n 0.0v 469.755n 0.0v 474.745n 0.0v 474.755n 0.0v 479.745n 0.0v 479.755n 0.0v 484.745n 0.0v 484.755n 0.0v 489.745n 0.0v 489.755n 1.0v 494.745n 1.0v 494.755n 1.0v 499.745n 1.0v 499.755n 0.0v 504.745n 0.0v 504.755n 0.0v 509.745n 0.0v 509.755n 0.0v 514.745n 0.0v 514.755n 0.0v 519.745n 0.0v 519.755n 0.0v 524.745n 0.0v 524.755n 0.0v 529.745n 0.0v 529.755n 0.0v 534.745n 0.0v 534.755n 1.0v 539.745n 1.0v 539.755n 1.0v 544.745n 1.0v 544.755n 0.0v 549.745n 0.0v 549.755n 1.0v 554.745n 1.0v 554.755n 1.0v 559.745n 1.0v 559.755n 0.0v 564.745n 0.0v 564.755n 0.0v 569.745n 0.0v 569.755n 0.0v 574.745n 0.0v 574.755n 0.0v 579.745n 0.0v 579.755n 0.0v 584.745n 0.0v 584.755n 0.0v 589.745n 0.0v 589.755n 0.0v 594.745n 0.0v 594.755n 0.0v 599.745n 0.0v 599.755n 1.0v 604.745n 1.0v 604.755n 1.0v 609.745n 1.0v 609.755n 1.0v 614.745n 1.0v 614.755n 1.0v 619.745n 1.0v 619.755n 1.0v 624.745n 1.0v 624.755n 1.0v 629.745n 1.0v 629.755n 1.0v 634.745n 1.0v 634.755n 1.0v 639.745n 1.0v 639.755n 1.0v 644.745n 1.0v 644.755n 1.0v 649.745n 1.0v 649.755n 1.0v 654.745n 1.0v 654.755n 0.0v 659.745n 0.0v 659.755n 0.0v 664.745n 0.0v 664.755n 0.0v 669.745n 0.0v 669.755n 0.0v 674.745n 0.0v 674.755n 0.0v 679.745n 0.0v 679.755n 0.0v 684.745n 0.0v 684.755n 0.0v 689.745n 0.0v 689.755n 0.0v 694.745n 0.0v 694.755n 0.0v 699.745n 0.0v 699.755n 0.0v 704.745n 0.0v 704.755n 0.0v 709.745n 0.0v 709.755n 0.0v 714.745n 0.0v 714.755n 0.0v 719.745n 0.0v 719.755n 1.0v 724.745n 1.0v 724.755n 1.0v 729.745n 1.0v 729.755n 1.0v 734.745n 1.0v 734.755n 1.0v 739.745n 1.0v 739.755n 0.0v 744.745n 0.0v 744.755n 0.0v 749.745n 0.0v 749.755n 0.0v 754.745n 0.0v 754.755n 0.0v 759.745n 0.0v 759.755n 0.0v 764.745n 0.0v 764.755n 0.0v 769.745n 0.0v 769.755n 1.0v 774.745n 1.0v 774.755n 1.0v 779.745n 1.0v 779.755n 1.0v 784.745n 1.0v 784.755n 1.0v 789.745n 1.0v 789.755n 1.0v 794.745n 1.0v 794.755n 1.0v 799.745n 1.0v 799.755n 1.0v 804.745n 1.0v 804.755n 0.0v 809.745n 0.0v 809.755n 1.0v 814.745n 1.0v 814.755n 1.0v 819.745n 1.0v 819.755n 1.0v 824.745n 1.0v 824.755n 1.0v 829.745n 1.0v 829.755n 1.0v 834.745n 1.0v 834.755n 1.0v 839.745n 1.0v 839.755n 1.0v 844.745n 1.0v 844.755n 1.0v 849.745n 1.0v 849.755n 1.0v 854.745n 1.0v 854.755n 0.0v 859.745n 0.0v 859.755n 0.0v 864.745n 0.0v 864.755n 1.0v 869.745n 1.0v 869.755n 1.0v 874.745n 1.0v 874.755n 1.0v 879.745n 1.0v 879.755n 1.0v 884.745n 1.0v 884.755n 1.0v 889.745n 1.0v 889.755n 1.0v 894.745n 1.0v 894.755n 1.0v 899.745n 1.0v 899.755n 1.0v 904.745n 1.0v 904.755n 1.0v 909.745n 1.0v 909.755n 0.0v 914.745n 0.0v 914.755n 0.0v 919.745n 0.0v 919.755n 0.0v 924.745n 0.0v 924.755n 0.0v 929.745n 0.0v 929.755n 0.0v 934.745n 0.0v 934.755n 0.0v 939.745n 0.0v 939.755n 0.0v 944.745n 0.0v 944.755n 0.0v 949.745n 0.0v 949.755n 0.0v 954.745n 0.0v 954.755n 0.0v 959.745n 0.0v 959.755n 0.0v 964.745n 0.0v 964.755n 0.0v 969.745n 0.0v 969.755n 0.0v 974.745n 0.0v 974.755n 0.0v 979.745n 0.0v 979.755n 0.0v 984.745n 0.0v 984.755n 0.0v 989.745n 0.0v 989.755n 0.0v 994.745n 0.0v 994.755n 0.0v 999.745n 0.0v 999.755n 0.0v 1004.745n 0.0v 1004.755n 0.0v 1009.745n 0.0v 1009.755n 0.0v 1014.745n 0.0v 1014.755n 0.0v 1019.745n 0.0v 1019.755n 1.0v 1024.745n 1.0v 1024.755n 1.0v )
* (time, data): [(0, 0), (5, 0), (10, 0), (15, 1), (20, 1), (25, 1), (30, 1), (35, 1), (40, 0), (45, 0), (50, 0), (55, 0), (60, 0), (65, 0), (70, 0), (75, 0), (80, 0), (85, 1), (90, 1), (95, 1), (100, 0), (105, 0), (110, 0), (115, 0), (120, 0), (125, 0), (130, 0), (135, 0), (140, 0), (145, 0), (150, 0), (155, 1), (160, 1), (165, 1), (170, 1), (175, 1), (180, 1), (185, 1), (190, 0), (195, 0), (200, 0), (205, 0), (210, 0), (215, 0), (220, 0), (225, 0), (230, 0), (235, 0), (240, 0), (245, 0), (250, 0), (255, 0), (260, 0), (265, 0), (270, 0), (275, 0), (280, 0), (285, 0), (290, 1), (295, 1), (300, 1), (305, 1), (310, 1), (315, 1), (320, 1), (325, 1), (330, 1), (335, 1), (340, 1), (345, 1), (350, 1), (355, 1), (360, 1), (365, 1), (370, 1), (375, 1), (380, 1), (385, 1), (390, 1), (395, 1), (400, 1), (405, 1), (410, 0), (415, 0), (420, 0), (425, 0), (430, 0), (435, 1), (440, 1), (445, 1), (450, 1), (455, 1), (460, 1), (465, 1), (470, 1), (475, 1), (480, 1), (485, 1), (490, 1), (495, 1), (500, 1), (505, 1), (510, 1), (515, 1), (520, 1), (525, 1), (530, 1), (535, 0), (540, 0), (545, 1), (550, 0), (555, 0), (560, 0), (565, 0), (570, 0), (575, 0), (580, 0), (585, 0), (590, 0), (595, 0), (600, 1), (605, 1), (610, 0), (615, 0), (620, 1), (625, 1), (630, 1), (635, 1), (640, 1), (645, 1), (650, 1), (655, 0), (660, 0), (665, 0), (670, 0), (675, 0), (680, 0), (685, 0), (690, 0), (695, 0), (700, 0), (705, 0), (710, 0), (715, 0), (720, 1), (725, 1), (730, 1), (735, 1), (740, 0), (745, 0), (750, 0), (755, 0), (760, 0), (765, 0), (770, 1), (775, 1), (780, 1), (785, 1), (790, 1), (795, 1), (800, 1), (805, 0), (810, 0), (815, 0), (820, 0), (825, 0), (830, 0), (835, 0), (840, 0), (845, 0), (850, 0), (855, 0), (860, 0), (865, 0), (870, 1), (875, 1), (880, 1), (885, 1), (890, 1), (895, 1), (900, 1), (905, 1), (910, 1), (915, 1), (920, 1), (925, 1), (930, 1), (935, 1), (940, 1), (945, 1), (950, 1), (955, 1), (960, 1), (965, 1), (970, 1), (975, 1), (980, 1), (985, 1), (990, 1), (995, 1), (1000, 1), (1005, 1), (1010, 1), (1015, 1), (1020, 0), (1025, 0)]
Vdin0_41  din0_41  0 PWL (0n 0.0v 4.745n 0.0v 4.755n 0.0v 9.745n 0.0v 9.755n 0.0v 14.745n 0.0v 14.755n 1.0v 19.745n 1.0v 19.755n 1.0v 24.745n 1.0v 24.755n 1.0v 29.745n 1.0v 29.755n 1.0v 34.745n 1.0v 34.755n 1.0v 39.745n 1.0v 39.755n 0.0v 44.745n 0.0v 44.755n 0.0v 49.745n 0.0v 49.755n 0.0v 54.745n 0.0v 54.755n 0.0v 59.745n 0.0v 59.755n 0.0v 64.745n 0.0v 64.755n 0.0v 69.745n 0.0v 69.755n 0.0v 74.745n 0.0v 74.755n 0.0v 79.745n 0.0v 79.755n 0.0v 84.745n 0.0v 84.755n 1.0v 89.745n 1.0v 89.755n 1.0v 94.745n 1.0v 94.755n 1.0v 99.745n 1.0v 99.755n 0.0v 104.745n 0.0v 104.755n 0.0v 109.745n 0.0v 109.755n 0.0v 114.745n 0.0v 114.755n 0.0v 119.745n 0.0v 119.755n 0.0v 124.745n 0.0v 124.755n 0.0v 129.745n 0.0v 129.755n 0.0v 134.745n 0.0v 134.755n 0.0v 139.745n 0.0v 139.755n 0.0v 144.745n 0.0v 144.755n 0.0v 149.745n 0.0v 149.755n 0.0v 154.745n 0.0v 154.755n 1.0v 159.745n 1.0v 159.755n 1.0v 164.745n 1.0v 164.755n 1.0v 169.745n 1.0v 169.755n 1.0v 174.745n 1.0v 174.755n 1.0v 179.745n 1.0v 179.755n 1.0v 184.745n 1.0v 184.755n 1.0v 189.745n 1.0v 189.755n 0.0v 194.745n 0.0v 194.755n 0.0v 199.745n 0.0v 199.755n 0.0v 204.745n 0.0v 204.755n 0.0v 209.745n 0.0v 209.755n 0.0v 214.745n 0.0v 214.755n 0.0v 219.745n 0.0v 219.755n 0.0v 224.745n 0.0v 224.755n 0.0v 229.745n 0.0v 229.755n 0.0v 234.745n 0.0v 234.755n 0.0v 239.745n 0.0v 239.755n 0.0v 244.745n 0.0v 244.755n 0.0v 249.745n 0.0v 249.755n 0.0v 254.745n 0.0v 254.755n 0.0v 259.745n 0.0v 259.755n 0.0v 264.745n 0.0v 264.755n 0.0v 269.745n 0.0v 269.755n 0.0v 274.745n 0.0v 274.755n 0.0v 279.745n 0.0v 279.755n 0.0v 284.745n 0.0v 284.755n 0.0v 289.745n 0.0v 289.755n 1.0v 294.745n 1.0v 294.755n 1.0v 299.745n 1.0v 299.755n 1.0v 304.745n 1.0v 304.755n 1.0v 309.745n 1.0v 309.755n 1.0v 314.745n 1.0v 314.755n 1.0v 319.745n 1.0v 319.755n 1.0v 324.745n 1.0v 324.755n 1.0v 329.745n 1.0v 329.755n 1.0v 334.745n 1.0v 334.755n 1.0v 339.745n 1.0v 339.755n 1.0v 344.745n 1.0v 344.755n 1.0v 349.745n 1.0v 349.755n 1.0v 354.745n 1.0v 354.755n 1.0v 359.745n 1.0v 359.755n 1.0v 364.745n 1.0v 364.755n 1.0v 369.745n 1.0v 369.755n 1.0v 374.745n 1.0v 374.755n 1.0v 379.745n 1.0v 379.755n 1.0v 384.745n 1.0v 384.755n 1.0v 389.745n 1.0v 389.755n 1.0v 394.745n 1.0v 394.755n 1.0v 399.745n 1.0v 399.755n 1.0v 404.745n 1.0v 404.755n 1.0v 409.745n 1.0v 409.755n 0.0v 414.745n 0.0v 414.755n 0.0v 419.745n 0.0v 419.755n 0.0v 424.745n 0.0v 424.755n 0.0v 429.745n 0.0v 429.755n 0.0v 434.745n 0.0v 434.755n 1.0v 439.745n 1.0v 439.755n 1.0v 444.745n 1.0v 444.755n 1.0v 449.745n 1.0v 449.755n 1.0v 454.745n 1.0v 454.755n 1.0v 459.745n 1.0v 459.755n 1.0v 464.745n 1.0v 464.755n 1.0v 469.745n 1.0v 469.755n 1.0v 474.745n 1.0v 474.755n 1.0v 479.745n 1.0v 479.755n 1.0v 484.745n 1.0v 484.755n 1.0v 489.745n 1.0v 489.755n 1.0v 494.745n 1.0v 494.755n 1.0v 499.745n 1.0v 499.755n 1.0v 504.745n 1.0v 504.755n 1.0v 509.745n 1.0v 509.755n 1.0v 514.745n 1.0v 514.755n 1.0v 519.745n 1.0v 519.755n 1.0v 524.745n 1.0v 524.755n 1.0v 529.745n 1.0v 529.755n 1.0v 534.745n 1.0v 534.755n 0.0v 539.745n 0.0v 539.755n 0.0v 544.745n 0.0v 544.755n 1.0v 549.745n 1.0v 549.755n 0.0v 554.745n 0.0v 554.755n 0.0v 559.745n 0.0v 559.755n 0.0v 564.745n 0.0v 564.755n 0.0v 569.745n 0.0v 569.755n 0.0v 574.745n 0.0v 574.755n 0.0v 579.745n 0.0v 579.755n 0.0v 584.745n 0.0v 584.755n 0.0v 589.745n 0.0v 589.755n 0.0v 594.745n 0.0v 594.755n 0.0v 599.745n 0.0v 599.755n 1.0v 604.745n 1.0v 604.755n 1.0v 609.745n 1.0v 609.755n 0.0v 614.745n 0.0v 614.755n 0.0v 619.745n 0.0v 619.755n 1.0v 624.745n 1.0v 624.755n 1.0v 629.745n 1.0v 629.755n 1.0v 634.745n 1.0v 634.755n 1.0v 639.745n 1.0v 639.755n 1.0v 644.745n 1.0v 644.755n 1.0v 649.745n 1.0v 649.755n 1.0v 654.745n 1.0v 654.755n 0.0v 659.745n 0.0v 659.755n 0.0v 664.745n 0.0v 664.755n 0.0v 669.745n 0.0v 669.755n 0.0v 674.745n 0.0v 674.755n 0.0v 679.745n 0.0v 679.755n 0.0v 684.745n 0.0v 684.755n 0.0v 689.745n 0.0v 689.755n 0.0v 694.745n 0.0v 694.755n 0.0v 699.745n 0.0v 699.755n 0.0v 704.745n 0.0v 704.755n 0.0v 709.745n 0.0v 709.755n 0.0v 714.745n 0.0v 714.755n 0.0v 719.745n 0.0v 719.755n 1.0v 724.745n 1.0v 724.755n 1.0v 729.745n 1.0v 729.755n 1.0v 734.745n 1.0v 734.755n 1.0v 739.745n 1.0v 739.755n 0.0v 744.745n 0.0v 744.755n 0.0v 749.745n 0.0v 749.755n 0.0v 754.745n 0.0v 754.755n 0.0v 759.745n 0.0v 759.755n 0.0v 764.745n 0.0v 764.755n 0.0v 769.745n 0.0v 769.755n 1.0v 774.745n 1.0v 774.755n 1.0v 779.745n 1.0v 779.755n 1.0v 784.745n 1.0v 784.755n 1.0v 789.745n 1.0v 789.755n 1.0v 794.745n 1.0v 794.755n 1.0v 799.745n 1.0v 799.755n 1.0v 804.745n 1.0v 804.755n 0.0v 809.745n 0.0v 809.755n 0.0v 814.745n 0.0v 814.755n 0.0v 819.745n 0.0v 819.755n 0.0v 824.745n 0.0v 824.755n 0.0v 829.745n 0.0v 829.755n 0.0v 834.745n 0.0v 834.755n 0.0v 839.745n 0.0v 839.755n 0.0v 844.745n 0.0v 844.755n 0.0v 849.745n 0.0v 849.755n 0.0v 854.745n 0.0v 854.755n 0.0v 859.745n 0.0v 859.755n 0.0v 864.745n 0.0v 864.755n 0.0v 869.745n 0.0v 869.755n 1.0v 874.745n 1.0v 874.755n 1.0v 879.745n 1.0v 879.755n 1.0v 884.745n 1.0v 884.755n 1.0v 889.745n 1.0v 889.755n 1.0v 894.745n 1.0v 894.755n 1.0v 899.745n 1.0v 899.755n 1.0v 904.745n 1.0v 904.755n 1.0v 909.745n 1.0v 909.755n 1.0v 914.745n 1.0v 914.755n 1.0v 919.745n 1.0v 919.755n 1.0v 924.745n 1.0v 924.755n 1.0v 929.745n 1.0v 929.755n 1.0v 934.745n 1.0v 934.755n 1.0v 939.745n 1.0v 939.755n 1.0v 944.745n 1.0v 944.755n 1.0v 949.745n 1.0v 949.755n 1.0v 954.745n 1.0v 954.755n 1.0v 959.745n 1.0v 959.755n 1.0v 964.745n 1.0v 964.755n 1.0v 969.745n 1.0v 969.755n 1.0v 974.745n 1.0v 974.755n 1.0v 979.745n 1.0v 979.755n 1.0v 984.745n 1.0v 984.755n 1.0v 989.745n 1.0v 989.755n 1.0v 994.745n 1.0v 994.755n 1.0v 999.745n 1.0v 999.755n 1.0v 1004.745n 1.0v 1004.755n 1.0v 1009.745n 1.0v 1009.755n 1.0v 1014.745n 1.0v 1014.755n 1.0v 1019.745n 1.0v 1019.755n 0.0v 1024.745n 0.0v 1024.755n 0.0v )
* (time, data): [(0, 0), (5, 1), (10, 1), (15, 1), (20, 1), (25, 1), (30, 1), (35, 1), (40, 1), (45, 1), (50, 0), (55, 0), (60, 0), (65, 1), (70, 1), (75, 1), (80, 1), (85, 1), (90, 1), (95, 1), (100, 0), (105, 0), (110, 0), (115, 0), (120, 0), (125, 0), (130, 0), (135, 0), (140, 0), (145, 0), (150, 0), (155, 0), (160, 0), (165, 0), (170, 0), (175, 1), (180, 1), (185, 1), (190, 0), (195, 1), (200, 1), (205, 1), (210, 1), (215, 1), (220, 1), (225, 1), (230, 1), (235, 1), (240, 1), (245, 0), (250, 0), (255, 0), (260, 0), (265, 0), (270, 0), (275, 0), (280, 0), (285, 0), (290, 0), (295, 0), (300, 0), (305, 0), (310, 0), (315, 0), (320, 0), (325, 0), (330, 0), (335, 1), (340, 1), (345, 1), (350, 0), (355, 0), (360, 0), (365, 0), (370, 0), (375, 0), (380, 0), (385, 0), (390, 0), (395, 0), (400, 0), (405, 0), (410, 1), (415, 1), (420, 1), (425, 1), (430, 1), (435, 1), (440, 1), (445, 1), (450, 1), (455, 1), (460, 1), (465, 1), (470, 1), (475, 1), (480, 1), (485, 0), (490, 1), (495, 1), (500, 0), (505, 0), (510, 0), (515, 0), (520, 0), (525, 0), (530, 0), (535, 0), (540, 0), (545, 1), (550, 1), (555, 1), (560, 1), (565, 1), (570, 1), (575, 1), (580, 1), (585, 1), (590, 1), (595, 1), (600, 1), (605, 1), (610, 0), (615, 0), (620, 1), (625, 1), (630, 1), (635, 1), (640, 1), (645, 0), (650, 0), (655, 1), (660, 1), (665, 1), (670, 1), (675, 1), (680, 1), (685, 1), (690, 1), (695, 1), (700, 1), (705, 1), (710, 1), (715, 1), (720, 1), (725, 1), (730, 1), (735, 1), (740, 1), (745, 1), (750, 1), (755, 1), (760, 1), (765, 1), (770, 0), (775, 0), (780, 0), (785, 0), (790, 0), (795, 0), (800, 0), (805, 0), (810, 0), (815, 0), (820, 0), (825, 0), (830, 0), (835, 0), (840, 1), (845, 1), (850, 0), (855, 0), (860, 0), (865, 1), (870, 1), (875, 1), (880, 1), (885, 1), (890, 1), (895, 1), (900, 1), (905, 1), (910, 1), (915, 0), (920, 0), (925, 0), (930, 1), (935, 1), (940, 1), (945, 1), (950, 1), (955, 1), (960, 1), (965, 1), (970, 1), (975, 1), (980, 1), (985, 1), (990, 1), (995, 1), (1000, 1), (1005, 1), (1010, 1), (1015, 1), (1020, 0), (1025, 0)]
Vdin0_42  din0_42  0 PWL (0n 0.0v 4.745n 0.0v 4.755n 1.0v 9.745n 1.0v 9.755n 1.0v 14.745n 1.0v 14.755n 1.0v 19.745n 1.0v 19.755n 1.0v 24.745n 1.0v 24.755n 1.0v 29.745n 1.0v 29.755n 1.0v 34.745n 1.0v 34.755n 1.0v 39.745n 1.0v 39.755n 1.0v 44.745n 1.0v 44.755n 1.0v 49.745n 1.0v 49.755n 0.0v 54.745n 0.0v 54.755n 0.0v 59.745n 0.0v 59.755n 0.0v 64.745n 0.0v 64.755n 1.0v 69.745n 1.0v 69.755n 1.0v 74.745n 1.0v 74.755n 1.0v 79.745n 1.0v 79.755n 1.0v 84.745n 1.0v 84.755n 1.0v 89.745n 1.0v 89.755n 1.0v 94.745n 1.0v 94.755n 1.0v 99.745n 1.0v 99.755n 0.0v 104.745n 0.0v 104.755n 0.0v 109.745n 0.0v 109.755n 0.0v 114.745n 0.0v 114.755n 0.0v 119.745n 0.0v 119.755n 0.0v 124.745n 0.0v 124.755n 0.0v 129.745n 0.0v 129.755n 0.0v 134.745n 0.0v 134.755n 0.0v 139.745n 0.0v 139.755n 0.0v 144.745n 0.0v 144.755n 0.0v 149.745n 0.0v 149.755n 0.0v 154.745n 0.0v 154.755n 0.0v 159.745n 0.0v 159.755n 0.0v 164.745n 0.0v 164.755n 0.0v 169.745n 0.0v 169.755n 0.0v 174.745n 0.0v 174.755n 1.0v 179.745n 1.0v 179.755n 1.0v 184.745n 1.0v 184.755n 1.0v 189.745n 1.0v 189.755n 0.0v 194.745n 0.0v 194.755n 1.0v 199.745n 1.0v 199.755n 1.0v 204.745n 1.0v 204.755n 1.0v 209.745n 1.0v 209.755n 1.0v 214.745n 1.0v 214.755n 1.0v 219.745n 1.0v 219.755n 1.0v 224.745n 1.0v 224.755n 1.0v 229.745n 1.0v 229.755n 1.0v 234.745n 1.0v 234.755n 1.0v 239.745n 1.0v 239.755n 1.0v 244.745n 1.0v 244.755n 0.0v 249.745n 0.0v 249.755n 0.0v 254.745n 0.0v 254.755n 0.0v 259.745n 0.0v 259.755n 0.0v 264.745n 0.0v 264.755n 0.0v 269.745n 0.0v 269.755n 0.0v 274.745n 0.0v 274.755n 0.0v 279.745n 0.0v 279.755n 0.0v 284.745n 0.0v 284.755n 0.0v 289.745n 0.0v 289.755n 0.0v 294.745n 0.0v 294.755n 0.0v 299.745n 0.0v 299.755n 0.0v 304.745n 0.0v 304.755n 0.0v 309.745n 0.0v 309.755n 0.0v 314.745n 0.0v 314.755n 0.0v 319.745n 0.0v 319.755n 0.0v 324.745n 0.0v 324.755n 0.0v 329.745n 0.0v 329.755n 0.0v 334.745n 0.0v 334.755n 1.0v 339.745n 1.0v 339.755n 1.0v 344.745n 1.0v 344.755n 1.0v 349.745n 1.0v 349.755n 0.0v 354.745n 0.0v 354.755n 0.0v 359.745n 0.0v 359.755n 0.0v 364.745n 0.0v 364.755n 0.0v 369.745n 0.0v 369.755n 0.0v 374.745n 0.0v 374.755n 0.0v 379.745n 0.0v 379.755n 0.0v 384.745n 0.0v 384.755n 0.0v 389.745n 0.0v 389.755n 0.0v 394.745n 0.0v 394.755n 0.0v 399.745n 0.0v 399.755n 0.0v 404.745n 0.0v 404.755n 0.0v 409.745n 0.0v 409.755n 1.0v 414.745n 1.0v 414.755n 1.0v 419.745n 1.0v 419.755n 1.0v 424.745n 1.0v 424.755n 1.0v 429.745n 1.0v 429.755n 1.0v 434.745n 1.0v 434.755n 1.0v 439.745n 1.0v 439.755n 1.0v 444.745n 1.0v 444.755n 1.0v 449.745n 1.0v 449.755n 1.0v 454.745n 1.0v 454.755n 1.0v 459.745n 1.0v 459.755n 1.0v 464.745n 1.0v 464.755n 1.0v 469.745n 1.0v 469.755n 1.0v 474.745n 1.0v 474.755n 1.0v 479.745n 1.0v 479.755n 1.0v 484.745n 1.0v 484.755n 0.0v 489.745n 0.0v 489.755n 1.0v 494.745n 1.0v 494.755n 1.0v 499.745n 1.0v 499.755n 0.0v 504.745n 0.0v 504.755n 0.0v 509.745n 0.0v 509.755n 0.0v 514.745n 0.0v 514.755n 0.0v 519.745n 0.0v 519.755n 0.0v 524.745n 0.0v 524.755n 0.0v 529.745n 0.0v 529.755n 0.0v 534.745n 0.0v 534.755n 0.0v 539.745n 0.0v 539.755n 0.0v 544.745n 0.0v 544.755n 1.0v 549.745n 1.0v 549.755n 1.0v 554.745n 1.0v 554.755n 1.0v 559.745n 1.0v 559.755n 1.0v 564.745n 1.0v 564.755n 1.0v 569.745n 1.0v 569.755n 1.0v 574.745n 1.0v 574.755n 1.0v 579.745n 1.0v 579.755n 1.0v 584.745n 1.0v 584.755n 1.0v 589.745n 1.0v 589.755n 1.0v 594.745n 1.0v 594.755n 1.0v 599.745n 1.0v 599.755n 1.0v 604.745n 1.0v 604.755n 1.0v 609.745n 1.0v 609.755n 0.0v 614.745n 0.0v 614.755n 0.0v 619.745n 0.0v 619.755n 1.0v 624.745n 1.0v 624.755n 1.0v 629.745n 1.0v 629.755n 1.0v 634.745n 1.0v 634.755n 1.0v 639.745n 1.0v 639.755n 1.0v 644.745n 1.0v 644.755n 0.0v 649.745n 0.0v 649.755n 0.0v 654.745n 0.0v 654.755n 1.0v 659.745n 1.0v 659.755n 1.0v 664.745n 1.0v 664.755n 1.0v 669.745n 1.0v 669.755n 1.0v 674.745n 1.0v 674.755n 1.0v 679.745n 1.0v 679.755n 1.0v 684.745n 1.0v 684.755n 1.0v 689.745n 1.0v 689.755n 1.0v 694.745n 1.0v 694.755n 1.0v 699.745n 1.0v 699.755n 1.0v 704.745n 1.0v 704.755n 1.0v 709.745n 1.0v 709.755n 1.0v 714.745n 1.0v 714.755n 1.0v 719.745n 1.0v 719.755n 1.0v 724.745n 1.0v 724.755n 1.0v 729.745n 1.0v 729.755n 1.0v 734.745n 1.0v 734.755n 1.0v 739.745n 1.0v 739.755n 1.0v 744.745n 1.0v 744.755n 1.0v 749.745n 1.0v 749.755n 1.0v 754.745n 1.0v 754.755n 1.0v 759.745n 1.0v 759.755n 1.0v 764.745n 1.0v 764.755n 1.0v 769.745n 1.0v 769.755n 0.0v 774.745n 0.0v 774.755n 0.0v 779.745n 0.0v 779.755n 0.0v 784.745n 0.0v 784.755n 0.0v 789.745n 0.0v 789.755n 0.0v 794.745n 0.0v 794.755n 0.0v 799.745n 0.0v 799.755n 0.0v 804.745n 0.0v 804.755n 0.0v 809.745n 0.0v 809.755n 0.0v 814.745n 0.0v 814.755n 0.0v 819.745n 0.0v 819.755n 0.0v 824.745n 0.0v 824.755n 0.0v 829.745n 0.0v 829.755n 0.0v 834.745n 0.0v 834.755n 0.0v 839.745n 0.0v 839.755n 1.0v 844.745n 1.0v 844.755n 1.0v 849.745n 1.0v 849.755n 0.0v 854.745n 0.0v 854.755n 0.0v 859.745n 0.0v 859.755n 0.0v 864.745n 0.0v 864.755n 1.0v 869.745n 1.0v 869.755n 1.0v 874.745n 1.0v 874.755n 1.0v 879.745n 1.0v 879.755n 1.0v 884.745n 1.0v 884.755n 1.0v 889.745n 1.0v 889.755n 1.0v 894.745n 1.0v 894.755n 1.0v 899.745n 1.0v 899.755n 1.0v 904.745n 1.0v 904.755n 1.0v 909.745n 1.0v 909.755n 1.0v 914.745n 1.0v 914.755n 0.0v 919.745n 0.0v 919.755n 0.0v 924.745n 0.0v 924.755n 0.0v 929.745n 0.0v 929.755n 1.0v 934.745n 1.0v 934.755n 1.0v 939.745n 1.0v 939.755n 1.0v 944.745n 1.0v 944.755n 1.0v 949.745n 1.0v 949.755n 1.0v 954.745n 1.0v 954.755n 1.0v 959.745n 1.0v 959.755n 1.0v 964.745n 1.0v 964.755n 1.0v 969.745n 1.0v 969.755n 1.0v 974.745n 1.0v 974.755n 1.0v 979.745n 1.0v 979.755n 1.0v 984.745n 1.0v 984.755n 1.0v 989.745n 1.0v 989.755n 1.0v 994.745n 1.0v 994.755n 1.0v 999.745n 1.0v 999.755n 1.0v 1004.745n 1.0v 1004.755n 1.0v 1009.745n 1.0v 1009.755n 1.0v 1014.745n 1.0v 1014.755n 1.0v 1019.745n 1.0v 1019.755n 0.0v 1024.745n 0.0v 1024.755n 0.0v )
* (time, data): [(0, 0), (5, 1), (10, 0), (15, 1), (20, 1), (25, 1), (30, 1), (35, 1), (40, 1), (45, 1), (50, 1), (55, 1), (60, 1), (65, 1), (70, 1), (75, 1), (80, 1), (85, 1), (90, 1), (95, 1), (100, 0), (105, 1), (110, 1), (115, 1), (120, 1), (125, 1), (130, 1), (135, 1), (140, 1), (145, 1), (150, 1), (155, 1), (160, 1), (165, 1), (170, 1), (175, 0), (180, 0), (185, 0), (190, 0), (195, 1), (200, 1), (205, 1), (210, 1), (215, 1), (220, 1), (225, 1), (230, 1), (235, 1), (240, 1), (245, 1), (250, 1), (255, 1), (260, 1), (265, 1), (270, 1), (275, 1), (280, 1), (285, 1), (290, 0), (295, 0), (300, 0), (305, 0), (310, 0), (315, 0), (320, 0), (325, 0), (330, 0), (335, 0), (340, 0), (345, 0), (350, 0), (355, 0), (360, 0), (365, 0), (370, 0), (375, 0), (380, 0), (385, 0), (390, 0), (395, 0), (400, 0), (405, 0), (410, 0), (415, 0), (420, 0), (425, 0), (430, 0), (435, 1), (440, 1), (445, 1), (450, 1), (455, 1), (460, 1), (465, 1), (470, 1), (475, 1), (480, 1), (485, 0), (490, 0), (495, 0), (500, 1), (505, 1), (510, 1), (515, 0), (520, 0), (525, 0), (530, 0), (535, 1), (540, 0), (545, 0), (550, 1), (555, 1), (560, 1), (565, 1), (570, 1), (575, 1), (580, 1), (585, 1), (590, 1), (595, 1), (600, 0), (605, 0), (610, 1), (615, 1), (620, 1), (625, 1), (630, 1), (635, 1), (640, 1), (645, 0), (650, 1), (655, 0), (660, 0), (665, 0), (670, 1), (675, 1), (680, 1), (685, 1), (690, 1), (695, 1), (700, 1), (705, 1), (710, 1), (715, 1), (720, 1), (725, 1), (730, 1), (735, 1), (740, 1), (745, 1), (750, 1), (755, 1), (760, 1), (765, 1), (770, 0), (775, 0), (780, 0), (785, 0), (790, 0), (795, 0), (800, 0), (805, 0), (810, 1), (815, 1), (820, 1), (825, 1), (830, 1), (835, 1), (840, 1), (845, 1), (850, 0), (855, 0), (860, 0), (865, 0), (870, 1), (875, 1), (880, 1), (885, 1), (890, 1), (895, 1), (900, 1), (905, 1), (910, 0), (915, 1), (920, 1), (925, 1), (930, 1), (935, 1), (940, 1), (945, 1), (950, 1), (955, 1), (960, 1), (965, 0), (970, 0), (975, 0), (980, 0), (985, 0), (990, 0), (995, 0), (1000, 0), (1005, 0), (1010, 0), (1015, 0), (1020, 1), (1025, 1)]
Vdin0_43  din0_43  0 PWL (0n 0.0v 4.745n 0.0v 4.755n 1.0v 9.745n 1.0v 9.755n 0.0v 14.745n 0.0v 14.755n 1.0v 19.745n 1.0v 19.755n 1.0v 24.745n 1.0v 24.755n 1.0v 29.745n 1.0v 29.755n 1.0v 34.745n 1.0v 34.755n 1.0v 39.745n 1.0v 39.755n 1.0v 44.745n 1.0v 44.755n 1.0v 49.745n 1.0v 49.755n 1.0v 54.745n 1.0v 54.755n 1.0v 59.745n 1.0v 59.755n 1.0v 64.745n 1.0v 64.755n 1.0v 69.745n 1.0v 69.755n 1.0v 74.745n 1.0v 74.755n 1.0v 79.745n 1.0v 79.755n 1.0v 84.745n 1.0v 84.755n 1.0v 89.745n 1.0v 89.755n 1.0v 94.745n 1.0v 94.755n 1.0v 99.745n 1.0v 99.755n 0.0v 104.745n 0.0v 104.755n 1.0v 109.745n 1.0v 109.755n 1.0v 114.745n 1.0v 114.755n 1.0v 119.745n 1.0v 119.755n 1.0v 124.745n 1.0v 124.755n 1.0v 129.745n 1.0v 129.755n 1.0v 134.745n 1.0v 134.755n 1.0v 139.745n 1.0v 139.755n 1.0v 144.745n 1.0v 144.755n 1.0v 149.745n 1.0v 149.755n 1.0v 154.745n 1.0v 154.755n 1.0v 159.745n 1.0v 159.755n 1.0v 164.745n 1.0v 164.755n 1.0v 169.745n 1.0v 169.755n 1.0v 174.745n 1.0v 174.755n 0.0v 179.745n 0.0v 179.755n 0.0v 184.745n 0.0v 184.755n 0.0v 189.745n 0.0v 189.755n 0.0v 194.745n 0.0v 194.755n 1.0v 199.745n 1.0v 199.755n 1.0v 204.745n 1.0v 204.755n 1.0v 209.745n 1.0v 209.755n 1.0v 214.745n 1.0v 214.755n 1.0v 219.745n 1.0v 219.755n 1.0v 224.745n 1.0v 224.755n 1.0v 229.745n 1.0v 229.755n 1.0v 234.745n 1.0v 234.755n 1.0v 239.745n 1.0v 239.755n 1.0v 244.745n 1.0v 244.755n 1.0v 249.745n 1.0v 249.755n 1.0v 254.745n 1.0v 254.755n 1.0v 259.745n 1.0v 259.755n 1.0v 264.745n 1.0v 264.755n 1.0v 269.745n 1.0v 269.755n 1.0v 274.745n 1.0v 274.755n 1.0v 279.745n 1.0v 279.755n 1.0v 284.745n 1.0v 284.755n 1.0v 289.745n 1.0v 289.755n 0.0v 294.745n 0.0v 294.755n 0.0v 299.745n 0.0v 299.755n 0.0v 304.745n 0.0v 304.755n 0.0v 309.745n 0.0v 309.755n 0.0v 314.745n 0.0v 314.755n 0.0v 319.745n 0.0v 319.755n 0.0v 324.745n 0.0v 324.755n 0.0v 329.745n 0.0v 329.755n 0.0v 334.745n 0.0v 334.755n 0.0v 339.745n 0.0v 339.755n 0.0v 344.745n 0.0v 344.755n 0.0v 349.745n 0.0v 349.755n 0.0v 354.745n 0.0v 354.755n 0.0v 359.745n 0.0v 359.755n 0.0v 364.745n 0.0v 364.755n 0.0v 369.745n 0.0v 369.755n 0.0v 374.745n 0.0v 374.755n 0.0v 379.745n 0.0v 379.755n 0.0v 384.745n 0.0v 384.755n 0.0v 389.745n 0.0v 389.755n 0.0v 394.745n 0.0v 394.755n 0.0v 399.745n 0.0v 399.755n 0.0v 404.745n 0.0v 404.755n 0.0v 409.745n 0.0v 409.755n 0.0v 414.745n 0.0v 414.755n 0.0v 419.745n 0.0v 419.755n 0.0v 424.745n 0.0v 424.755n 0.0v 429.745n 0.0v 429.755n 0.0v 434.745n 0.0v 434.755n 1.0v 439.745n 1.0v 439.755n 1.0v 444.745n 1.0v 444.755n 1.0v 449.745n 1.0v 449.755n 1.0v 454.745n 1.0v 454.755n 1.0v 459.745n 1.0v 459.755n 1.0v 464.745n 1.0v 464.755n 1.0v 469.745n 1.0v 469.755n 1.0v 474.745n 1.0v 474.755n 1.0v 479.745n 1.0v 479.755n 1.0v 484.745n 1.0v 484.755n 0.0v 489.745n 0.0v 489.755n 0.0v 494.745n 0.0v 494.755n 0.0v 499.745n 0.0v 499.755n 1.0v 504.745n 1.0v 504.755n 1.0v 509.745n 1.0v 509.755n 1.0v 514.745n 1.0v 514.755n 0.0v 519.745n 0.0v 519.755n 0.0v 524.745n 0.0v 524.755n 0.0v 529.745n 0.0v 529.755n 0.0v 534.745n 0.0v 534.755n 1.0v 539.745n 1.0v 539.755n 0.0v 544.745n 0.0v 544.755n 0.0v 549.745n 0.0v 549.755n 1.0v 554.745n 1.0v 554.755n 1.0v 559.745n 1.0v 559.755n 1.0v 564.745n 1.0v 564.755n 1.0v 569.745n 1.0v 569.755n 1.0v 574.745n 1.0v 574.755n 1.0v 579.745n 1.0v 579.755n 1.0v 584.745n 1.0v 584.755n 1.0v 589.745n 1.0v 589.755n 1.0v 594.745n 1.0v 594.755n 1.0v 599.745n 1.0v 599.755n 0.0v 604.745n 0.0v 604.755n 0.0v 609.745n 0.0v 609.755n 1.0v 614.745n 1.0v 614.755n 1.0v 619.745n 1.0v 619.755n 1.0v 624.745n 1.0v 624.755n 1.0v 629.745n 1.0v 629.755n 1.0v 634.745n 1.0v 634.755n 1.0v 639.745n 1.0v 639.755n 1.0v 644.745n 1.0v 644.755n 0.0v 649.745n 0.0v 649.755n 1.0v 654.745n 1.0v 654.755n 0.0v 659.745n 0.0v 659.755n 0.0v 664.745n 0.0v 664.755n 0.0v 669.745n 0.0v 669.755n 1.0v 674.745n 1.0v 674.755n 1.0v 679.745n 1.0v 679.755n 1.0v 684.745n 1.0v 684.755n 1.0v 689.745n 1.0v 689.755n 1.0v 694.745n 1.0v 694.755n 1.0v 699.745n 1.0v 699.755n 1.0v 704.745n 1.0v 704.755n 1.0v 709.745n 1.0v 709.755n 1.0v 714.745n 1.0v 714.755n 1.0v 719.745n 1.0v 719.755n 1.0v 724.745n 1.0v 724.755n 1.0v 729.745n 1.0v 729.755n 1.0v 734.745n 1.0v 734.755n 1.0v 739.745n 1.0v 739.755n 1.0v 744.745n 1.0v 744.755n 1.0v 749.745n 1.0v 749.755n 1.0v 754.745n 1.0v 754.755n 1.0v 759.745n 1.0v 759.755n 1.0v 764.745n 1.0v 764.755n 1.0v 769.745n 1.0v 769.755n 0.0v 774.745n 0.0v 774.755n 0.0v 779.745n 0.0v 779.755n 0.0v 784.745n 0.0v 784.755n 0.0v 789.745n 0.0v 789.755n 0.0v 794.745n 0.0v 794.755n 0.0v 799.745n 0.0v 799.755n 0.0v 804.745n 0.0v 804.755n 0.0v 809.745n 0.0v 809.755n 1.0v 814.745n 1.0v 814.755n 1.0v 819.745n 1.0v 819.755n 1.0v 824.745n 1.0v 824.755n 1.0v 829.745n 1.0v 829.755n 1.0v 834.745n 1.0v 834.755n 1.0v 839.745n 1.0v 839.755n 1.0v 844.745n 1.0v 844.755n 1.0v 849.745n 1.0v 849.755n 0.0v 854.745n 0.0v 854.755n 0.0v 859.745n 0.0v 859.755n 0.0v 864.745n 0.0v 864.755n 0.0v 869.745n 0.0v 869.755n 1.0v 874.745n 1.0v 874.755n 1.0v 879.745n 1.0v 879.755n 1.0v 884.745n 1.0v 884.755n 1.0v 889.745n 1.0v 889.755n 1.0v 894.745n 1.0v 894.755n 1.0v 899.745n 1.0v 899.755n 1.0v 904.745n 1.0v 904.755n 1.0v 909.745n 1.0v 909.755n 0.0v 914.745n 0.0v 914.755n 1.0v 919.745n 1.0v 919.755n 1.0v 924.745n 1.0v 924.755n 1.0v 929.745n 1.0v 929.755n 1.0v 934.745n 1.0v 934.755n 1.0v 939.745n 1.0v 939.755n 1.0v 944.745n 1.0v 944.755n 1.0v 949.745n 1.0v 949.755n 1.0v 954.745n 1.0v 954.755n 1.0v 959.745n 1.0v 959.755n 1.0v 964.745n 1.0v 964.755n 0.0v 969.745n 0.0v 969.755n 0.0v 974.745n 0.0v 974.755n 0.0v 979.745n 0.0v 979.755n 0.0v 984.745n 0.0v 984.755n 0.0v 989.745n 0.0v 989.755n 0.0v 994.745n 0.0v 994.755n 0.0v 999.745n 0.0v 999.755n 0.0v 1004.745n 0.0v 1004.755n 0.0v 1009.745n 0.0v 1009.755n 0.0v 1014.745n 0.0v 1014.755n 0.0v 1019.745n 0.0v 1019.755n 1.0v 1024.745n 1.0v 1024.755n 1.0v )
* (time, data): [(0, 0), (5, 0), (10, 0), (15, 1), (20, 1), (25, 1), (30, 1), (35, 1), (40, 1), (45, 1), (50, 0), (55, 0), (60, 0), (65, 1), (70, 1), (75, 1), (80, 1), (85, 1), (90, 1), (95, 1), (100, 0), (105, 1), (110, 1), (115, 0), (120, 0), (125, 0), (130, 0), (135, 0), (140, 0), (145, 0), (150, 0), (155, 1), (160, 1), (165, 1), (170, 1), (175, 1), (180, 1), (185, 1), (190, 1), (195, 1), (200, 1), (205, 1), (210, 1), (215, 1), (220, 1), (225, 1), (230, 1), (235, 1), (240, 1), (245, 0), (250, 0), (255, 0), (260, 0), (265, 0), (270, 0), (275, 0), (280, 0), (285, 0), (290, 0), (295, 0), (300, 0), (305, 0), (310, 0), (315, 0), (320, 0), (325, 0), (330, 0), (335, 0), (340, 0), (345, 0), (350, 0), (355, 0), (360, 0), (365, 0), (370, 0), (375, 0), (380, 0), (385, 0), (390, 0), (395, 0), (400, 0), (405, 0), (410, 1), (415, 1), (420, 1), (425, 1), (430, 1), (435, 0), (440, 0), (445, 1), (450, 1), (455, 1), (460, 1), (465, 1), (470, 1), (475, 1), (480, 1), (485, 1), (490, 0), (495, 0), (500, 0), (505, 0), (510, 0), (515, 0), (520, 0), (525, 0), (530, 0), (535, 1), (540, 0), (545, 1), (550, 1), (555, 1), (560, 1), (565, 1), (570, 1), (575, 1), (580, 1), (585, 1), (590, 1), (595, 1), (600, 0), (605, 0), (610, 1), (615, 1), (620, 0), (625, 0), (630, 0), (635, 0), (640, 0), (645, 0), (650, 1), (655, 0), (660, 0), (665, 0), (670, 1), (675, 1), (680, 1), (685, 1), (690, 1), (695, 1), (700, 1), (705, 1), (710, 1), (715, 1), (720, 1), (725, 1), (730, 1), (735, 1), (740, 1), (745, 1), (750, 1), (755, 1), (760, 1), (765, 1), (770, 0), (775, 0), (780, 0), (785, 0), (790, 0), (795, 0), (800, 0), (805, 0), (810, 1), (815, 1), (820, 1), (825, 1), (830, 1), (835, 1), (840, 1), (845, 1), (850, 0), (855, 1), (860, 1), (865, 0), (870, 0), (875, 0), (880, 0), (885, 0), (890, 0), (895, 0), (900, 0), (905, 0), (910, 0), (915, 0), (920, 0), (925, 0), (930, 0), (935, 0), (940, 0), (945, 0), (950, 0), (955, 0), (960, 0), (965, 1), (970, 1), (975, 1), (980, 1), (985, 1), (990, 1), (995, 1), (1000, 1), (1005, 1), (1010, 1), (1015, 1), (1020, 0), (1025, 0)]
Vdin0_44  din0_44  0 PWL (0n 0.0v 4.745n 0.0v 4.755n 0.0v 9.745n 0.0v 9.755n 0.0v 14.745n 0.0v 14.755n 1.0v 19.745n 1.0v 19.755n 1.0v 24.745n 1.0v 24.755n 1.0v 29.745n 1.0v 29.755n 1.0v 34.745n 1.0v 34.755n 1.0v 39.745n 1.0v 39.755n 1.0v 44.745n 1.0v 44.755n 1.0v 49.745n 1.0v 49.755n 0.0v 54.745n 0.0v 54.755n 0.0v 59.745n 0.0v 59.755n 0.0v 64.745n 0.0v 64.755n 1.0v 69.745n 1.0v 69.755n 1.0v 74.745n 1.0v 74.755n 1.0v 79.745n 1.0v 79.755n 1.0v 84.745n 1.0v 84.755n 1.0v 89.745n 1.0v 89.755n 1.0v 94.745n 1.0v 94.755n 1.0v 99.745n 1.0v 99.755n 0.0v 104.745n 0.0v 104.755n 1.0v 109.745n 1.0v 109.755n 1.0v 114.745n 1.0v 114.755n 0.0v 119.745n 0.0v 119.755n 0.0v 124.745n 0.0v 124.755n 0.0v 129.745n 0.0v 129.755n 0.0v 134.745n 0.0v 134.755n 0.0v 139.745n 0.0v 139.755n 0.0v 144.745n 0.0v 144.755n 0.0v 149.745n 0.0v 149.755n 0.0v 154.745n 0.0v 154.755n 1.0v 159.745n 1.0v 159.755n 1.0v 164.745n 1.0v 164.755n 1.0v 169.745n 1.0v 169.755n 1.0v 174.745n 1.0v 174.755n 1.0v 179.745n 1.0v 179.755n 1.0v 184.745n 1.0v 184.755n 1.0v 189.745n 1.0v 189.755n 1.0v 194.745n 1.0v 194.755n 1.0v 199.745n 1.0v 199.755n 1.0v 204.745n 1.0v 204.755n 1.0v 209.745n 1.0v 209.755n 1.0v 214.745n 1.0v 214.755n 1.0v 219.745n 1.0v 219.755n 1.0v 224.745n 1.0v 224.755n 1.0v 229.745n 1.0v 229.755n 1.0v 234.745n 1.0v 234.755n 1.0v 239.745n 1.0v 239.755n 1.0v 244.745n 1.0v 244.755n 0.0v 249.745n 0.0v 249.755n 0.0v 254.745n 0.0v 254.755n 0.0v 259.745n 0.0v 259.755n 0.0v 264.745n 0.0v 264.755n 0.0v 269.745n 0.0v 269.755n 0.0v 274.745n 0.0v 274.755n 0.0v 279.745n 0.0v 279.755n 0.0v 284.745n 0.0v 284.755n 0.0v 289.745n 0.0v 289.755n 0.0v 294.745n 0.0v 294.755n 0.0v 299.745n 0.0v 299.755n 0.0v 304.745n 0.0v 304.755n 0.0v 309.745n 0.0v 309.755n 0.0v 314.745n 0.0v 314.755n 0.0v 319.745n 0.0v 319.755n 0.0v 324.745n 0.0v 324.755n 0.0v 329.745n 0.0v 329.755n 0.0v 334.745n 0.0v 334.755n 0.0v 339.745n 0.0v 339.755n 0.0v 344.745n 0.0v 344.755n 0.0v 349.745n 0.0v 349.755n 0.0v 354.745n 0.0v 354.755n 0.0v 359.745n 0.0v 359.755n 0.0v 364.745n 0.0v 364.755n 0.0v 369.745n 0.0v 369.755n 0.0v 374.745n 0.0v 374.755n 0.0v 379.745n 0.0v 379.755n 0.0v 384.745n 0.0v 384.755n 0.0v 389.745n 0.0v 389.755n 0.0v 394.745n 0.0v 394.755n 0.0v 399.745n 0.0v 399.755n 0.0v 404.745n 0.0v 404.755n 0.0v 409.745n 0.0v 409.755n 1.0v 414.745n 1.0v 414.755n 1.0v 419.745n 1.0v 419.755n 1.0v 424.745n 1.0v 424.755n 1.0v 429.745n 1.0v 429.755n 1.0v 434.745n 1.0v 434.755n 0.0v 439.745n 0.0v 439.755n 0.0v 444.745n 0.0v 444.755n 1.0v 449.745n 1.0v 449.755n 1.0v 454.745n 1.0v 454.755n 1.0v 459.745n 1.0v 459.755n 1.0v 464.745n 1.0v 464.755n 1.0v 469.745n 1.0v 469.755n 1.0v 474.745n 1.0v 474.755n 1.0v 479.745n 1.0v 479.755n 1.0v 484.745n 1.0v 484.755n 1.0v 489.745n 1.0v 489.755n 0.0v 494.745n 0.0v 494.755n 0.0v 499.745n 0.0v 499.755n 0.0v 504.745n 0.0v 504.755n 0.0v 509.745n 0.0v 509.755n 0.0v 514.745n 0.0v 514.755n 0.0v 519.745n 0.0v 519.755n 0.0v 524.745n 0.0v 524.755n 0.0v 529.745n 0.0v 529.755n 0.0v 534.745n 0.0v 534.755n 1.0v 539.745n 1.0v 539.755n 0.0v 544.745n 0.0v 544.755n 1.0v 549.745n 1.0v 549.755n 1.0v 554.745n 1.0v 554.755n 1.0v 559.745n 1.0v 559.755n 1.0v 564.745n 1.0v 564.755n 1.0v 569.745n 1.0v 569.755n 1.0v 574.745n 1.0v 574.755n 1.0v 579.745n 1.0v 579.755n 1.0v 584.745n 1.0v 584.755n 1.0v 589.745n 1.0v 589.755n 1.0v 594.745n 1.0v 594.755n 1.0v 599.745n 1.0v 599.755n 0.0v 604.745n 0.0v 604.755n 0.0v 609.745n 0.0v 609.755n 1.0v 614.745n 1.0v 614.755n 1.0v 619.745n 1.0v 619.755n 0.0v 624.745n 0.0v 624.755n 0.0v 629.745n 0.0v 629.755n 0.0v 634.745n 0.0v 634.755n 0.0v 639.745n 0.0v 639.755n 0.0v 644.745n 0.0v 644.755n 0.0v 649.745n 0.0v 649.755n 1.0v 654.745n 1.0v 654.755n 0.0v 659.745n 0.0v 659.755n 0.0v 664.745n 0.0v 664.755n 0.0v 669.745n 0.0v 669.755n 1.0v 674.745n 1.0v 674.755n 1.0v 679.745n 1.0v 679.755n 1.0v 684.745n 1.0v 684.755n 1.0v 689.745n 1.0v 689.755n 1.0v 694.745n 1.0v 694.755n 1.0v 699.745n 1.0v 699.755n 1.0v 704.745n 1.0v 704.755n 1.0v 709.745n 1.0v 709.755n 1.0v 714.745n 1.0v 714.755n 1.0v 719.745n 1.0v 719.755n 1.0v 724.745n 1.0v 724.755n 1.0v 729.745n 1.0v 729.755n 1.0v 734.745n 1.0v 734.755n 1.0v 739.745n 1.0v 739.755n 1.0v 744.745n 1.0v 744.755n 1.0v 749.745n 1.0v 749.755n 1.0v 754.745n 1.0v 754.755n 1.0v 759.745n 1.0v 759.755n 1.0v 764.745n 1.0v 764.755n 1.0v 769.745n 1.0v 769.755n 0.0v 774.745n 0.0v 774.755n 0.0v 779.745n 0.0v 779.755n 0.0v 784.745n 0.0v 784.755n 0.0v 789.745n 0.0v 789.755n 0.0v 794.745n 0.0v 794.755n 0.0v 799.745n 0.0v 799.755n 0.0v 804.745n 0.0v 804.755n 0.0v 809.745n 0.0v 809.755n 1.0v 814.745n 1.0v 814.755n 1.0v 819.745n 1.0v 819.755n 1.0v 824.745n 1.0v 824.755n 1.0v 829.745n 1.0v 829.755n 1.0v 834.745n 1.0v 834.755n 1.0v 839.745n 1.0v 839.755n 1.0v 844.745n 1.0v 844.755n 1.0v 849.745n 1.0v 849.755n 0.0v 854.745n 0.0v 854.755n 1.0v 859.745n 1.0v 859.755n 1.0v 864.745n 1.0v 864.755n 0.0v 869.745n 0.0v 869.755n 0.0v 874.745n 0.0v 874.755n 0.0v 879.745n 0.0v 879.755n 0.0v 884.745n 0.0v 884.755n 0.0v 889.745n 0.0v 889.755n 0.0v 894.745n 0.0v 894.755n 0.0v 899.745n 0.0v 899.755n 0.0v 904.745n 0.0v 904.755n 0.0v 909.745n 0.0v 909.755n 0.0v 914.745n 0.0v 914.755n 0.0v 919.745n 0.0v 919.755n 0.0v 924.745n 0.0v 924.755n 0.0v 929.745n 0.0v 929.755n 0.0v 934.745n 0.0v 934.755n 0.0v 939.745n 0.0v 939.755n 0.0v 944.745n 0.0v 944.755n 0.0v 949.745n 0.0v 949.755n 0.0v 954.745n 0.0v 954.755n 0.0v 959.745n 0.0v 959.755n 0.0v 964.745n 0.0v 964.755n 1.0v 969.745n 1.0v 969.755n 1.0v 974.745n 1.0v 974.755n 1.0v 979.745n 1.0v 979.755n 1.0v 984.745n 1.0v 984.755n 1.0v 989.745n 1.0v 989.755n 1.0v 994.745n 1.0v 994.755n 1.0v 999.745n 1.0v 999.755n 1.0v 1004.745n 1.0v 1004.755n 1.0v 1009.745n 1.0v 1009.755n 1.0v 1014.745n 1.0v 1014.755n 1.0v 1019.745n 1.0v 1019.755n 0.0v 1024.745n 0.0v 1024.755n 0.0v )
* (time, data): [(0, 0), (5, 1), (10, 1), (15, 1), (20, 1), (25, 1), (30, 0), (35, 0), (40, 1), (45, 1), (50, 0), (55, 0), (60, 0), (65, 0), (70, 0), (75, 0), (80, 0), (85, 0), (90, 0), (95, 0), (100, 1), (105, 1), (110, 1), (115, 1), (120, 1), (125, 1), (130, 1), (135, 1), (140, 1), (145, 1), (150, 1), (155, 0), (160, 0), (165, 0), (170, 0), (175, 1), (180, 1), (185, 1), (190, 0), (195, 0), (200, 0), (205, 0), (210, 0), (215, 0), (220, 0), (225, 0), (230, 0), (235, 0), (240, 0), (245, 0), (250, 0), (255, 0), (260, 0), (265, 0), (270, 0), (275, 0), (280, 0), (285, 0), (290, 0), (295, 0), (300, 0), (305, 0), (310, 0), (315, 0), (320, 0), (325, 0), (330, 0), (335, 0), (340, 0), (345, 0), (350, 0), (355, 0), (360, 0), (365, 0), (370, 0), (375, 0), (380, 0), (385, 0), (390, 0), (395, 0), (400, 0), (405, 0), (410, 0), (415, 0), (420, 0), (425, 0), (430, 0), (435, 1), (440, 1), (445, 1), (450, 1), (455, 1), (460, 1), (465, 1), (470, 1), (475, 1), (480, 1), (485, 1), (490, 0), (495, 0), (500, 1), (505, 1), (510, 1), (515, 1), (520, 1), (525, 1), (530, 1), (535, 0), (540, 1), (545, 1), (550, 0), (555, 0), (560, 0), (565, 0), (570, 0), (575, 0), (580, 0), (585, 0), (590, 0), (595, 0), (600, 1), (605, 1), (610, 1), (615, 1), (620, 0), (625, 0), (630, 0), (635, 1), (640, 1), (645, 1), (650, 1), (655, 1), (660, 1), (665, 1), (670, 1), (675, 1), (680, 1), (685, 1), (690, 1), (695, 1), (700, 1), (705, 1), (710, 1), (715, 1), (720, 0), (725, 0), (730, 0), (735, 0), (740, 1), (745, 1), (750, 1), (755, 1), (760, 1), (765, 1), (770, 1), (775, 1), (780, 1), (785, 1), (790, 1), (795, 1), (800, 1), (805, 1), (810, 1), (815, 1), (820, 1), (825, 1), (830, 1), (835, 1), (840, 0), (845, 0), (850, 0), (855, 1), (860, 1), (865, 0), (870, 1), (875, 1), (880, 1), (885, 1), (890, 1), (895, 1), (900, 1), (905, 1), (910, 1), (915, 0), (920, 0), (925, 0), (930, 1), (935, 1), (940, 1), (945, 1), (950, 1), (955, 1), (960, 1), (965, 0), (970, 0), (975, 0), (980, 0), (985, 0), (990, 0), (995, 0), (1000, 0), (1005, 0), (1010, 0), (1015, 0), (1020, 0), (1025, 0)]
Vdin0_45  din0_45  0 PWL (0n 0.0v 4.745n 0.0v 4.755n 1.0v 9.745n 1.0v 9.755n 1.0v 14.745n 1.0v 14.755n 1.0v 19.745n 1.0v 19.755n 1.0v 24.745n 1.0v 24.755n 1.0v 29.745n 1.0v 29.755n 0.0v 34.745n 0.0v 34.755n 0.0v 39.745n 0.0v 39.755n 1.0v 44.745n 1.0v 44.755n 1.0v 49.745n 1.0v 49.755n 0.0v 54.745n 0.0v 54.755n 0.0v 59.745n 0.0v 59.755n 0.0v 64.745n 0.0v 64.755n 0.0v 69.745n 0.0v 69.755n 0.0v 74.745n 0.0v 74.755n 0.0v 79.745n 0.0v 79.755n 0.0v 84.745n 0.0v 84.755n 0.0v 89.745n 0.0v 89.755n 0.0v 94.745n 0.0v 94.755n 0.0v 99.745n 0.0v 99.755n 1.0v 104.745n 1.0v 104.755n 1.0v 109.745n 1.0v 109.755n 1.0v 114.745n 1.0v 114.755n 1.0v 119.745n 1.0v 119.755n 1.0v 124.745n 1.0v 124.755n 1.0v 129.745n 1.0v 129.755n 1.0v 134.745n 1.0v 134.755n 1.0v 139.745n 1.0v 139.755n 1.0v 144.745n 1.0v 144.755n 1.0v 149.745n 1.0v 149.755n 1.0v 154.745n 1.0v 154.755n 0.0v 159.745n 0.0v 159.755n 0.0v 164.745n 0.0v 164.755n 0.0v 169.745n 0.0v 169.755n 0.0v 174.745n 0.0v 174.755n 1.0v 179.745n 1.0v 179.755n 1.0v 184.745n 1.0v 184.755n 1.0v 189.745n 1.0v 189.755n 0.0v 194.745n 0.0v 194.755n 0.0v 199.745n 0.0v 199.755n 0.0v 204.745n 0.0v 204.755n 0.0v 209.745n 0.0v 209.755n 0.0v 214.745n 0.0v 214.755n 0.0v 219.745n 0.0v 219.755n 0.0v 224.745n 0.0v 224.755n 0.0v 229.745n 0.0v 229.755n 0.0v 234.745n 0.0v 234.755n 0.0v 239.745n 0.0v 239.755n 0.0v 244.745n 0.0v 244.755n 0.0v 249.745n 0.0v 249.755n 0.0v 254.745n 0.0v 254.755n 0.0v 259.745n 0.0v 259.755n 0.0v 264.745n 0.0v 264.755n 0.0v 269.745n 0.0v 269.755n 0.0v 274.745n 0.0v 274.755n 0.0v 279.745n 0.0v 279.755n 0.0v 284.745n 0.0v 284.755n 0.0v 289.745n 0.0v 289.755n 0.0v 294.745n 0.0v 294.755n 0.0v 299.745n 0.0v 299.755n 0.0v 304.745n 0.0v 304.755n 0.0v 309.745n 0.0v 309.755n 0.0v 314.745n 0.0v 314.755n 0.0v 319.745n 0.0v 319.755n 0.0v 324.745n 0.0v 324.755n 0.0v 329.745n 0.0v 329.755n 0.0v 334.745n 0.0v 334.755n 0.0v 339.745n 0.0v 339.755n 0.0v 344.745n 0.0v 344.755n 0.0v 349.745n 0.0v 349.755n 0.0v 354.745n 0.0v 354.755n 0.0v 359.745n 0.0v 359.755n 0.0v 364.745n 0.0v 364.755n 0.0v 369.745n 0.0v 369.755n 0.0v 374.745n 0.0v 374.755n 0.0v 379.745n 0.0v 379.755n 0.0v 384.745n 0.0v 384.755n 0.0v 389.745n 0.0v 389.755n 0.0v 394.745n 0.0v 394.755n 0.0v 399.745n 0.0v 399.755n 0.0v 404.745n 0.0v 404.755n 0.0v 409.745n 0.0v 409.755n 0.0v 414.745n 0.0v 414.755n 0.0v 419.745n 0.0v 419.755n 0.0v 424.745n 0.0v 424.755n 0.0v 429.745n 0.0v 429.755n 0.0v 434.745n 0.0v 434.755n 1.0v 439.745n 1.0v 439.755n 1.0v 444.745n 1.0v 444.755n 1.0v 449.745n 1.0v 449.755n 1.0v 454.745n 1.0v 454.755n 1.0v 459.745n 1.0v 459.755n 1.0v 464.745n 1.0v 464.755n 1.0v 469.745n 1.0v 469.755n 1.0v 474.745n 1.0v 474.755n 1.0v 479.745n 1.0v 479.755n 1.0v 484.745n 1.0v 484.755n 1.0v 489.745n 1.0v 489.755n 0.0v 494.745n 0.0v 494.755n 0.0v 499.745n 0.0v 499.755n 1.0v 504.745n 1.0v 504.755n 1.0v 509.745n 1.0v 509.755n 1.0v 514.745n 1.0v 514.755n 1.0v 519.745n 1.0v 519.755n 1.0v 524.745n 1.0v 524.755n 1.0v 529.745n 1.0v 529.755n 1.0v 534.745n 1.0v 534.755n 0.0v 539.745n 0.0v 539.755n 1.0v 544.745n 1.0v 544.755n 1.0v 549.745n 1.0v 549.755n 0.0v 554.745n 0.0v 554.755n 0.0v 559.745n 0.0v 559.755n 0.0v 564.745n 0.0v 564.755n 0.0v 569.745n 0.0v 569.755n 0.0v 574.745n 0.0v 574.755n 0.0v 579.745n 0.0v 579.755n 0.0v 584.745n 0.0v 584.755n 0.0v 589.745n 0.0v 589.755n 0.0v 594.745n 0.0v 594.755n 0.0v 599.745n 0.0v 599.755n 1.0v 604.745n 1.0v 604.755n 1.0v 609.745n 1.0v 609.755n 1.0v 614.745n 1.0v 614.755n 1.0v 619.745n 1.0v 619.755n 0.0v 624.745n 0.0v 624.755n 0.0v 629.745n 0.0v 629.755n 0.0v 634.745n 0.0v 634.755n 1.0v 639.745n 1.0v 639.755n 1.0v 644.745n 1.0v 644.755n 1.0v 649.745n 1.0v 649.755n 1.0v 654.745n 1.0v 654.755n 1.0v 659.745n 1.0v 659.755n 1.0v 664.745n 1.0v 664.755n 1.0v 669.745n 1.0v 669.755n 1.0v 674.745n 1.0v 674.755n 1.0v 679.745n 1.0v 679.755n 1.0v 684.745n 1.0v 684.755n 1.0v 689.745n 1.0v 689.755n 1.0v 694.745n 1.0v 694.755n 1.0v 699.745n 1.0v 699.755n 1.0v 704.745n 1.0v 704.755n 1.0v 709.745n 1.0v 709.755n 1.0v 714.745n 1.0v 714.755n 1.0v 719.745n 1.0v 719.755n 0.0v 724.745n 0.0v 724.755n 0.0v 729.745n 0.0v 729.755n 0.0v 734.745n 0.0v 734.755n 0.0v 739.745n 0.0v 739.755n 1.0v 744.745n 1.0v 744.755n 1.0v 749.745n 1.0v 749.755n 1.0v 754.745n 1.0v 754.755n 1.0v 759.745n 1.0v 759.755n 1.0v 764.745n 1.0v 764.755n 1.0v 769.745n 1.0v 769.755n 1.0v 774.745n 1.0v 774.755n 1.0v 779.745n 1.0v 779.755n 1.0v 784.745n 1.0v 784.755n 1.0v 789.745n 1.0v 789.755n 1.0v 794.745n 1.0v 794.755n 1.0v 799.745n 1.0v 799.755n 1.0v 804.745n 1.0v 804.755n 1.0v 809.745n 1.0v 809.755n 1.0v 814.745n 1.0v 814.755n 1.0v 819.745n 1.0v 819.755n 1.0v 824.745n 1.0v 824.755n 1.0v 829.745n 1.0v 829.755n 1.0v 834.745n 1.0v 834.755n 1.0v 839.745n 1.0v 839.755n 0.0v 844.745n 0.0v 844.755n 0.0v 849.745n 0.0v 849.755n 0.0v 854.745n 0.0v 854.755n 1.0v 859.745n 1.0v 859.755n 1.0v 864.745n 1.0v 864.755n 0.0v 869.745n 0.0v 869.755n 1.0v 874.745n 1.0v 874.755n 1.0v 879.745n 1.0v 879.755n 1.0v 884.745n 1.0v 884.755n 1.0v 889.745n 1.0v 889.755n 1.0v 894.745n 1.0v 894.755n 1.0v 899.745n 1.0v 899.755n 1.0v 904.745n 1.0v 904.755n 1.0v 909.745n 1.0v 909.755n 1.0v 914.745n 1.0v 914.755n 0.0v 919.745n 0.0v 919.755n 0.0v 924.745n 0.0v 924.755n 0.0v 929.745n 0.0v 929.755n 1.0v 934.745n 1.0v 934.755n 1.0v 939.745n 1.0v 939.755n 1.0v 944.745n 1.0v 944.755n 1.0v 949.745n 1.0v 949.755n 1.0v 954.745n 1.0v 954.755n 1.0v 959.745n 1.0v 959.755n 1.0v 964.745n 1.0v 964.755n 0.0v 969.745n 0.0v 969.755n 0.0v 974.745n 0.0v 974.755n 0.0v 979.745n 0.0v 979.755n 0.0v 984.745n 0.0v 984.755n 0.0v 989.745n 0.0v 989.755n 0.0v 994.745n 0.0v 994.755n 0.0v 999.745n 0.0v 999.755n 0.0v 1004.745n 0.0v 1004.755n 0.0v 1009.745n 0.0v 1009.755n 0.0v 1014.745n 0.0v 1014.755n 0.0v 1019.745n 0.0v 1019.755n 0.0v 1024.745n 0.0v 1024.755n 0.0v )
* (time, data): [(0, 0), (5, 1), (10, 0), (15, 0), (20, 0), (25, 0), (30, 0), (35, 0), (40, 0), (45, 0), (50, 1), (55, 1), (60, 1), (65, 0), (70, 0), (75, 0), (80, 0), (85, 0), (90, 0), (95, 0), (100, 0), (105, 1), (110, 1), (115, 0), (120, 0), (125, 0), (130, 0), (135, 0), (140, 0), (145, 0), (150, 0), (155, 1), (160, 1), (165, 1), (170, 1), (175, 0), (180, 0), (185, 0), (190, 1), (195, 0), (200, 0), (205, 0), (210, 0), (215, 0), (220, 0), (225, 0), (230, 0), (235, 0), (240, 0), (245, 0), (250, 0), (255, 0), (260, 0), (265, 0), (270, 0), (275, 0), (280, 0), (285, 0), (290, 1), (295, 1), (300, 1), (305, 1), (310, 1), (315, 1), (320, 1), (325, 1), (330, 1), (335, 1), (340, 1), (345, 1), (350, 1), (355, 1), (360, 1), (365, 1), (370, 1), (375, 1), (380, 1), (385, 1), (390, 1), (395, 1), (400, 1), (405, 1), (410, 1), (415, 1), (420, 1), (425, 1), (430, 1), (435, 0), (440, 0), (445, 1), (450, 1), (455, 1), (460, 1), (465, 1), (470, 1), (475, 1), (480, 1), (485, 1), (490, 0), (495, 0), (500, 0), (505, 0), (510, 0), (515, 0), (520, 0), (525, 0), (530, 0), (535, 1), (540, 0), (545, 0), (550, 1), (555, 1), (560, 1), (565, 1), (570, 1), (575, 1), (580, 1), (585, 1), (590, 1), (595, 1), (600, 0), (605, 0), (610, 0), (615, 0), (620, 1), (625, 1), (630, 1), (635, 0), (640, 0), (645, 0), (650, 0), (655, 1), (660, 1), (665, 1), (670, 0), (675, 0), (680, 0), (685, 0), (690, 0), (695, 0), (700, 0), (705, 0), (710, 0), (715, 0), (720, 1), (725, 1), (730, 1), (735, 1), (740, 1), (745, 1), (750, 1), (755, 1), (760, 1), (765, 1), (770, 1), (775, 1), (780, 1), (785, 1), (790, 1), (795, 1), (800, 1), (805, 0), (810, 0), (815, 0), (820, 0), (825, 0), (830, 0), (835, 0), (840, 0), (845, 0), (850, 1), (855, 1), (860, 1), (865, 0), (870, 0), (875, 0), (880, 0), (885, 0), (890, 0), (895, 0), (900, 0), (905, 0), (910, 0), (915, 1), (920, 1), (925, 1), (930, 1), (935, 1), (940, 1), (945, 1), (950, 1), (955, 1), (960, 1), (965, 1), (970, 1), (975, 1), (980, 1), (985, 1), (990, 1), (995, 1), (1000, 1), (1005, 1), (1010, 1), (1015, 1), (1020, 1), (1025, 1)]
Vdin0_46  din0_46  0 PWL (0n 0.0v 4.745n 0.0v 4.755n 1.0v 9.745n 1.0v 9.755n 0.0v 14.745n 0.0v 14.755n 0.0v 19.745n 0.0v 19.755n 0.0v 24.745n 0.0v 24.755n 0.0v 29.745n 0.0v 29.755n 0.0v 34.745n 0.0v 34.755n 0.0v 39.745n 0.0v 39.755n 0.0v 44.745n 0.0v 44.755n 0.0v 49.745n 0.0v 49.755n 1.0v 54.745n 1.0v 54.755n 1.0v 59.745n 1.0v 59.755n 1.0v 64.745n 1.0v 64.755n 0.0v 69.745n 0.0v 69.755n 0.0v 74.745n 0.0v 74.755n 0.0v 79.745n 0.0v 79.755n 0.0v 84.745n 0.0v 84.755n 0.0v 89.745n 0.0v 89.755n 0.0v 94.745n 0.0v 94.755n 0.0v 99.745n 0.0v 99.755n 0.0v 104.745n 0.0v 104.755n 1.0v 109.745n 1.0v 109.755n 1.0v 114.745n 1.0v 114.755n 0.0v 119.745n 0.0v 119.755n 0.0v 124.745n 0.0v 124.755n 0.0v 129.745n 0.0v 129.755n 0.0v 134.745n 0.0v 134.755n 0.0v 139.745n 0.0v 139.755n 0.0v 144.745n 0.0v 144.755n 0.0v 149.745n 0.0v 149.755n 0.0v 154.745n 0.0v 154.755n 1.0v 159.745n 1.0v 159.755n 1.0v 164.745n 1.0v 164.755n 1.0v 169.745n 1.0v 169.755n 1.0v 174.745n 1.0v 174.755n 0.0v 179.745n 0.0v 179.755n 0.0v 184.745n 0.0v 184.755n 0.0v 189.745n 0.0v 189.755n 1.0v 194.745n 1.0v 194.755n 0.0v 199.745n 0.0v 199.755n 0.0v 204.745n 0.0v 204.755n 0.0v 209.745n 0.0v 209.755n 0.0v 214.745n 0.0v 214.755n 0.0v 219.745n 0.0v 219.755n 0.0v 224.745n 0.0v 224.755n 0.0v 229.745n 0.0v 229.755n 0.0v 234.745n 0.0v 234.755n 0.0v 239.745n 0.0v 239.755n 0.0v 244.745n 0.0v 244.755n 0.0v 249.745n 0.0v 249.755n 0.0v 254.745n 0.0v 254.755n 0.0v 259.745n 0.0v 259.755n 0.0v 264.745n 0.0v 264.755n 0.0v 269.745n 0.0v 269.755n 0.0v 274.745n 0.0v 274.755n 0.0v 279.745n 0.0v 279.755n 0.0v 284.745n 0.0v 284.755n 0.0v 289.745n 0.0v 289.755n 1.0v 294.745n 1.0v 294.755n 1.0v 299.745n 1.0v 299.755n 1.0v 304.745n 1.0v 304.755n 1.0v 309.745n 1.0v 309.755n 1.0v 314.745n 1.0v 314.755n 1.0v 319.745n 1.0v 319.755n 1.0v 324.745n 1.0v 324.755n 1.0v 329.745n 1.0v 329.755n 1.0v 334.745n 1.0v 334.755n 1.0v 339.745n 1.0v 339.755n 1.0v 344.745n 1.0v 344.755n 1.0v 349.745n 1.0v 349.755n 1.0v 354.745n 1.0v 354.755n 1.0v 359.745n 1.0v 359.755n 1.0v 364.745n 1.0v 364.755n 1.0v 369.745n 1.0v 369.755n 1.0v 374.745n 1.0v 374.755n 1.0v 379.745n 1.0v 379.755n 1.0v 384.745n 1.0v 384.755n 1.0v 389.745n 1.0v 389.755n 1.0v 394.745n 1.0v 394.755n 1.0v 399.745n 1.0v 399.755n 1.0v 404.745n 1.0v 404.755n 1.0v 409.745n 1.0v 409.755n 1.0v 414.745n 1.0v 414.755n 1.0v 419.745n 1.0v 419.755n 1.0v 424.745n 1.0v 424.755n 1.0v 429.745n 1.0v 429.755n 1.0v 434.745n 1.0v 434.755n 0.0v 439.745n 0.0v 439.755n 0.0v 444.745n 0.0v 444.755n 1.0v 449.745n 1.0v 449.755n 1.0v 454.745n 1.0v 454.755n 1.0v 459.745n 1.0v 459.755n 1.0v 464.745n 1.0v 464.755n 1.0v 469.745n 1.0v 469.755n 1.0v 474.745n 1.0v 474.755n 1.0v 479.745n 1.0v 479.755n 1.0v 484.745n 1.0v 484.755n 1.0v 489.745n 1.0v 489.755n 0.0v 494.745n 0.0v 494.755n 0.0v 499.745n 0.0v 499.755n 0.0v 504.745n 0.0v 504.755n 0.0v 509.745n 0.0v 509.755n 0.0v 514.745n 0.0v 514.755n 0.0v 519.745n 0.0v 519.755n 0.0v 524.745n 0.0v 524.755n 0.0v 529.745n 0.0v 529.755n 0.0v 534.745n 0.0v 534.755n 1.0v 539.745n 1.0v 539.755n 0.0v 544.745n 0.0v 544.755n 0.0v 549.745n 0.0v 549.755n 1.0v 554.745n 1.0v 554.755n 1.0v 559.745n 1.0v 559.755n 1.0v 564.745n 1.0v 564.755n 1.0v 569.745n 1.0v 569.755n 1.0v 574.745n 1.0v 574.755n 1.0v 579.745n 1.0v 579.755n 1.0v 584.745n 1.0v 584.755n 1.0v 589.745n 1.0v 589.755n 1.0v 594.745n 1.0v 594.755n 1.0v 599.745n 1.0v 599.755n 0.0v 604.745n 0.0v 604.755n 0.0v 609.745n 0.0v 609.755n 0.0v 614.745n 0.0v 614.755n 0.0v 619.745n 0.0v 619.755n 1.0v 624.745n 1.0v 624.755n 1.0v 629.745n 1.0v 629.755n 1.0v 634.745n 1.0v 634.755n 0.0v 639.745n 0.0v 639.755n 0.0v 644.745n 0.0v 644.755n 0.0v 649.745n 0.0v 649.755n 0.0v 654.745n 0.0v 654.755n 1.0v 659.745n 1.0v 659.755n 1.0v 664.745n 1.0v 664.755n 1.0v 669.745n 1.0v 669.755n 0.0v 674.745n 0.0v 674.755n 0.0v 679.745n 0.0v 679.755n 0.0v 684.745n 0.0v 684.755n 0.0v 689.745n 0.0v 689.755n 0.0v 694.745n 0.0v 694.755n 0.0v 699.745n 0.0v 699.755n 0.0v 704.745n 0.0v 704.755n 0.0v 709.745n 0.0v 709.755n 0.0v 714.745n 0.0v 714.755n 0.0v 719.745n 0.0v 719.755n 1.0v 724.745n 1.0v 724.755n 1.0v 729.745n 1.0v 729.755n 1.0v 734.745n 1.0v 734.755n 1.0v 739.745n 1.0v 739.755n 1.0v 744.745n 1.0v 744.755n 1.0v 749.745n 1.0v 749.755n 1.0v 754.745n 1.0v 754.755n 1.0v 759.745n 1.0v 759.755n 1.0v 764.745n 1.0v 764.755n 1.0v 769.745n 1.0v 769.755n 1.0v 774.745n 1.0v 774.755n 1.0v 779.745n 1.0v 779.755n 1.0v 784.745n 1.0v 784.755n 1.0v 789.745n 1.0v 789.755n 1.0v 794.745n 1.0v 794.755n 1.0v 799.745n 1.0v 799.755n 1.0v 804.745n 1.0v 804.755n 0.0v 809.745n 0.0v 809.755n 0.0v 814.745n 0.0v 814.755n 0.0v 819.745n 0.0v 819.755n 0.0v 824.745n 0.0v 824.755n 0.0v 829.745n 0.0v 829.755n 0.0v 834.745n 0.0v 834.755n 0.0v 839.745n 0.0v 839.755n 0.0v 844.745n 0.0v 844.755n 0.0v 849.745n 0.0v 849.755n 1.0v 854.745n 1.0v 854.755n 1.0v 859.745n 1.0v 859.755n 1.0v 864.745n 1.0v 864.755n 0.0v 869.745n 0.0v 869.755n 0.0v 874.745n 0.0v 874.755n 0.0v 879.745n 0.0v 879.755n 0.0v 884.745n 0.0v 884.755n 0.0v 889.745n 0.0v 889.755n 0.0v 894.745n 0.0v 894.755n 0.0v 899.745n 0.0v 899.755n 0.0v 904.745n 0.0v 904.755n 0.0v 909.745n 0.0v 909.755n 0.0v 914.745n 0.0v 914.755n 1.0v 919.745n 1.0v 919.755n 1.0v 924.745n 1.0v 924.755n 1.0v 929.745n 1.0v 929.755n 1.0v 934.745n 1.0v 934.755n 1.0v 939.745n 1.0v 939.755n 1.0v 944.745n 1.0v 944.755n 1.0v 949.745n 1.0v 949.755n 1.0v 954.745n 1.0v 954.755n 1.0v 959.745n 1.0v 959.755n 1.0v 964.745n 1.0v 964.755n 1.0v 969.745n 1.0v 969.755n 1.0v 974.745n 1.0v 974.755n 1.0v 979.745n 1.0v 979.755n 1.0v 984.745n 1.0v 984.755n 1.0v 989.745n 1.0v 989.755n 1.0v 994.745n 1.0v 994.755n 1.0v 999.745n 1.0v 999.755n 1.0v 1004.745n 1.0v 1004.755n 1.0v 1009.745n 1.0v 1009.755n 1.0v 1014.745n 1.0v 1014.755n 1.0v 1019.745n 1.0v 1019.755n 1.0v 1024.745n 1.0v 1024.755n 1.0v )
* (time, data): [(0, 0), (5, 1), (10, 0), (15, 1), (20, 1), (25, 1), (30, 0), (35, 0), (40, 1), (45, 1), (50, 0), (55, 0), (60, 0), (65, 0), (70, 0), (75, 0), (80, 0), (85, 1), (90, 1), (95, 1), (100, 0), (105, 1), (110, 1), (115, 0), (120, 0), (125, 0), (130, 0), (135, 0), (140, 0), (145, 0), (150, 0), (155, 1), (160, 1), (165, 1), (170, 1), (175, 0), (180, 0), (185, 0), (190, 0), (195, 1), (200, 1), (205, 1), (210, 1), (215, 1), (220, 1), (225, 1), (230, 1), (235, 1), (240, 1), (245, 0), (250, 0), (255, 0), (260, 0), (265, 0), (270, 0), (275, 0), (280, 0), (285, 0), (290, 1), (295, 1), (300, 1), (305, 1), (310, 1), (315, 1), (320, 1), (325, 1), (330, 1), (335, 1), (340, 1), (345, 1), (350, 1), (355, 1), (360, 1), (365, 1), (370, 1), (375, 1), (380, 1), (385, 1), (390, 1), (395, 1), (400, 1), (405, 1), (410, 0), (415, 0), (420, 0), (425, 0), (430, 0), (435, 1), (440, 1), (445, 1), (450, 1), (455, 1), (460, 1), (465, 1), (470, 1), (475, 1), (480, 1), (485, 0), (490, 0), (495, 0), (500, 0), (505, 0), (510, 0), (515, 0), (520, 0), (525, 0), (530, 0), (535, 1), (540, 1), (545, 0), (550, 0), (555, 0), (560, 1), (565, 1), (570, 1), (575, 1), (580, 1), (585, 1), (590, 1), (595, 1), (600, 0), (605, 0), (610, 0), (615, 0), (620, 0), (625, 0), (630, 0), (635, 0), (640, 0), (645, 1), (650, 1), (655, 0), (660, 0), (665, 0), (670, 1), (675, 1), (680, 1), (685, 1), (690, 1), (695, 1), (700, 1), (705, 1), (710, 1), (715, 1), (720, 0), (725, 0), (730, 0), (735, 0), (740, 1), (745, 1), (750, 1), (755, 1), (760, 1), (765, 1), (770, 1), (775, 1), (780, 0), (785, 0), (790, 0), (795, 0), (800, 0), (805, 1), (810, 0), (815, 0), (820, 0), (825, 0), (830, 0), (835, 0), (840, 0), (845, 0), (850, 1), (855, 0), (860, 0), (865, 0), (870, 0), (875, 0), (880, 0), (885, 0), (890, 0), (895, 0), (900, 0), (905, 0), (910, 1), (915, 1), (920, 1), (925, 1), (930, 0), (935, 0), (940, 0), (945, 0), (950, 0), (955, 0), (960, 0), (965, 1), (970, 1), (975, 1), (980, 1), (985, 1), (990, 1), (995, 1), (1000, 1), (1005, 1), (1010, 1), (1015, 1), (1020, 0), (1025, 0)]
Vdin0_47  din0_47  0 PWL (0n 0.0v 4.745n 0.0v 4.755n 1.0v 9.745n 1.0v 9.755n 0.0v 14.745n 0.0v 14.755n 1.0v 19.745n 1.0v 19.755n 1.0v 24.745n 1.0v 24.755n 1.0v 29.745n 1.0v 29.755n 0.0v 34.745n 0.0v 34.755n 0.0v 39.745n 0.0v 39.755n 1.0v 44.745n 1.0v 44.755n 1.0v 49.745n 1.0v 49.755n 0.0v 54.745n 0.0v 54.755n 0.0v 59.745n 0.0v 59.755n 0.0v 64.745n 0.0v 64.755n 0.0v 69.745n 0.0v 69.755n 0.0v 74.745n 0.0v 74.755n 0.0v 79.745n 0.0v 79.755n 0.0v 84.745n 0.0v 84.755n 1.0v 89.745n 1.0v 89.755n 1.0v 94.745n 1.0v 94.755n 1.0v 99.745n 1.0v 99.755n 0.0v 104.745n 0.0v 104.755n 1.0v 109.745n 1.0v 109.755n 1.0v 114.745n 1.0v 114.755n 0.0v 119.745n 0.0v 119.755n 0.0v 124.745n 0.0v 124.755n 0.0v 129.745n 0.0v 129.755n 0.0v 134.745n 0.0v 134.755n 0.0v 139.745n 0.0v 139.755n 0.0v 144.745n 0.0v 144.755n 0.0v 149.745n 0.0v 149.755n 0.0v 154.745n 0.0v 154.755n 1.0v 159.745n 1.0v 159.755n 1.0v 164.745n 1.0v 164.755n 1.0v 169.745n 1.0v 169.755n 1.0v 174.745n 1.0v 174.755n 0.0v 179.745n 0.0v 179.755n 0.0v 184.745n 0.0v 184.755n 0.0v 189.745n 0.0v 189.755n 0.0v 194.745n 0.0v 194.755n 1.0v 199.745n 1.0v 199.755n 1.0v 204.745n 1.0v 204.755n 1.0v 209.745n 1.0v 209.755n 1.0v 214.745n 1.0v 214.755n 1.0v 219.745n 1.0v 219.755n 1.0v 224.745n 1.0v 224.755n 1.0v 229.745n 1.0v 229.755n 1.0v 234.745n 1.0v 234.755n 1.0v 239.745n 1.0v 239.755n 1.0v 244.745n 1.0v 244.755n 0.0v 249.745n 0.0v 249.755n 0.0v 254.745n 0.0v 254.755n 0.0v 259.745n 0.0v 259.755n 0.0v 264.745n 0.0v 264.755n 0.0v 269.745n 0.0v 269.755n 0.0v 274.745n 0.0v 274.755n 0.0v 279.745n 0.0v 279.755n 0.0v 284.745n 0.0v 284.755n 0.0v 289.745n 0.0v 289.755n 1.0v 294.745n 1.0v 294.755n 1.0v 299.745n 1.0v 299.755n 1.0v 304.745n 1.0v 304.755n 1.0v 309.745n 1.0v 309.755n 1.0v 314.745n 1.0v 314.755n 1.0v 319.745n 1.0v 319.755n 1.0v 324.745n 1.0v 324.755n 1.0v 329.745n 1.0v 329.755n 1.0v 334.745n 1.0v 334.755n 1.0v 339.745n 1.0v 339.755n 1.0v 344.745n 1.0v 344.755n 1.0v 349.745n 1.0v 349.755n 1.0v 354.745n 1.0v 354.755n 1.0v 359.745n 1.0v 359.755n 1.0v 364.745n 1.0v 364.755n 1.0v 369.745n 1.0v 369.755n 1.0v 374.745n 1.0v 374.755n 1.0v 379.745n 1.0v 379.755n 1.0v 384.745n 1.0v 384.755n 1.0v 389.745n 1.0v 389.755n 1.0v 394.745n 1.0v 394.755n 1.0v 399.745n 1.0v 399.755n 1.0v 404.745n 1.0v 404.755n 1.0v 409.745n 1.0v 409.755n 0.0v 414.745n 0.0v 414.755n 0.0v 419.745n 0.0v 419.755n 0.0v 424.745n 0.0v 424.755n 0.0v 429.745n 0.0v 429.755n 0.0v 434.745n 0.0v 434.755n 1.0v 439.745n 1.0v 439.755n 1.0v 444.745n 1.0v 444.755n 1.0v 449.745n 1.0v 449.755n 1.0v 454.745n 1.0v 454.755n 1.0v 459.745n 1.0v 459.755n 1.0v 464.745n 1.0v 464.755n 1.0v 469.745n 1.0v 469.755n 1.0v 474.745n 1.0v 474.755n 1.0v 479.745n 1.0v 479.755n 1.0v 484.745n 1.0v 484.755n 0.0v 489.745n 0.0v 489.755n 0.0v 494.745n 0.0v 494.755n 0.0v 499.745n 0.0v 499.755n 0.0v 504.745n 0.0v 504.755n 0.0v 509.745n 0.0v 509.755n 0.0v 514.745n 0.0v 514.755n 0.0v 519.745n 0.0v 519.755n 0.0v 524.745n 0.0v 524.755n 0.0v 529.745n 0.0v 529.755n 0.0v 534.745n 0.0v 534.755n 1.0v 539.745n 1.0v 539.755n 1.0v 544.745n 1.0v 544.755n 0.0v 549.745n 0.0v 549.755n 0.0v 554.745n 0.0v 554.755n 0.0v 559.745n 0.0v 559.755n 1.0v 564.745n 1.0v 564.755n 1.0v 569.745n 1.0v 569.755n 1.0v 574.745n 1.0v 574.755n 1.0v 579.745n 1.0v 579.755n 1.0v 584.745n 1.0v 584.755n 1.0v 589.745n 1.0v 589.755n 1.0v 594.745n 1.0v 594.755n 1.0v 599.745n 1.0v 599.755n 0.0v 604.745n 0.0v 604.755n 0.0v 609.745n 0.0v 609.755n 0.0v 614.745n 0.0v 614.755n 0.0v 619.745n 0.0v 619.755n 0.0v 624.745n 0.0v 624.755n 0.0v 629.745n 0.0v 629.755n 0.0v 634.745n 0.0v 634.755n 0.0v 639.745n 0.0v 639.755n 0.0v 644.745n 0.0v 644.755n 1.0v 649.745n 1.0v 649.755n 1.0v 654.745n 1.0v 654.755n 0.0v 659.745n 0.0v 659.755n 0.0v 664.745n 0.0v 664.755n 0.0v 669.745n 0.0v 669.755n 1.0v 674.745n 1.0v 674.755n 1.0v 679.745n 1.0v 679.755n 1.0v 684.745n 1.0v 684.755n 1.0v 689.745n 1.0v 689.755n 1.0v 694.745n 1.0v 694.755n 1.0v 699.745n 1.0v 699.755n 1.0v 704.745n 1.0v 704.755n 1.0v 709.745n 1.0v 709.755n 1.0v 714.745n 1.0v 714.755n 1.0v 719.745n 1.0v 719.755n 0.0v 724.745n 0.0v 724.755n 0.0v 729.745n 0.0v 729.755n 0.0v 734.745n 0.0v 734.755n 0.0v 739.745n 0.0v 739.755n 1.0v 744.745n 1.0v 744.755n 1.0v 749.745n 1.0v 749.755n 1.0v 754.745n 1.0v 754.755n 1.0v 759.745n 1.0v 759.755n 1.0v 764.745n 1.0v 764.755n 1.0v 769.745n 1.0v 769.755n 1.0v 774.745n 1.0v 774.755n 1.0v 779.745n 1.0v 779.755n 0.0v 784.745n 0.0v 784.755n 0.0v 789.745n 0.0v 789.755n 0.0v 794.745n 0.0v 794.755n 0.0v 799.745n 0.0v 799.755n 0.0v 804.745n 0.0v 804.755n 1.0v 809.745n 1.0v 809.755n 0.0v 814.745n 0.0v 814.755n 0.0v 819.745n 0.0v 819.755n 0.0v 824.745n 0.0v 824.755n 0.0v 829.745n 0.0v 829.755n 0.0v 834.745n 0.0v 834.755n 0.0v 839.745n 0.0v 839.755n 0.0v 844.745n 0.0v 844.755n 0.0v 849.745n 0.0v 849.755n 1.0v 854.745n 1.0v 854.755n 0.0v 859.745n 0.0v 859.755n 0.0v 864.745n 0.0v 864.755n 0.0v 869.745n 0.0v 869.755n 0.0v 874.745n 0.0v 874.755n 0.0v 879.745n 0.0v 879.755n 0.0v 884.745n 0.0v 884.755n 0.0v 889.745n 0.0v 889.755n 0.0v 894.745n 0.0v 894.755n 0.0v 899.745n 0.0v 899.755n 0.0v 904.745n 0.0v 904.755n 0.0v 909.745n 0.0v 909.755n 1.0v 914.745n 1.0v 914.755n 1.0v 919.745n 1.0v 919.755n 1.0v 924.745n 1.0v 924.755n 1.0v 929.745n 1.0v 929.755n 0.0v 934.745n 0.0v 934.755n 0.0v 939.745n 0.0v 939.755n 0.0v 944.745n 0.0v 944.755n 0.0v 949.745n 0.0v 949.755n 0.0v 954.745n 0.0v 954.755n 0.0v 959.745n 0.0v 959.755n 0.0v 964.745n 0.0v 964.755n 1.0v 969.745n 1.0v 969.755n 1.0v 974.745n 1.0v 974.755n 1.0v 979.745n 1.0v 979.755n 1.0v 984.745n 1.0v 984.755n 1.0v 989.745n 1.0v 989.755n 1.0v 994.745n 1.0v 994.755n 1.0v 999.745n 1.0v 999.755n 1.0v 1004.745n 1.0v 1004.755n 1.0v 1009.745n 1.0v 1009.755n 1.0v 1014.745n 1.0v 1014.755n 1.0v 1019.745n 1.0v 1019.755n 0.0v 1024.745n 0.0v 1024.755n 0.0v )
* (time, data): [(0, 0), (5, 1), (10, 0), (15, 1), (20, 1), (25, 1), (30, 1), (35, 1), (40, 1), (45, 1), (50, 0), (55, 0), (60, 0), (65, 1), (70, 1), (75, 1), (80, 1), (85, 0), (90, 0), (95, 0), (100, 1), (105, 0), (110, 0), (115, 1), (120, 1), (125, 1), (130, 1), (135, 1), (140, 1), (145, 1), (150, 1), (155, 1), (160, 1), (165, 1), (170, 1), (175, 0), (180, 0), (185, 0), (190, 0), (195, 1), (200, 1), (205, 1), (210, 1), (215, 1), (220, 1), (225, 1), (230, 1), (235, 1), (240, 1), (245, 0), (250, 0), (255, 0), (260, 0), (265, 0), (270, 0), (275, 0), (280, 0), (285, 0), (290, 1), (295, 1), (300, 1), (305, 1), (310, 1), (315, 1), (320, 1), (325, 1), (330, 1), (335, 0), (340, 0), (345, 0), (350, 0), (355, 0), (360, 0), (365, 0), (370, 0), (375, 0), (380, 0), (385, 0), (390, 0), (395, 0), (400, 0), (405, 0), (410, 1), (415, 1), (420, 1), (425, 1), (430, 1), (435, 0), (440, 0), (445, 0), (450, 0), (455, 0), (460, 0), (465, 0), (470, 0), (475, 0), (480, 0), (485, 0), (490, 0), (495, 0), (500, 0), (505, 0), (510, 0), (515, 0), (520, 0), (525, 0), (530, 0), (535, 1), (540, 0), (545, 0), (550, 1), (555, 1), (560, 0), (565, 0), (570, 0), (575, 0), (580, 0), (585, 0), (590, 0), (595, 0), (600, 0), (605, 0), (610, 0), (615, 0), (620, 0), (625, 0), (630, 0), (635, 1), (640, 1), (645, 0), (650, 0), (655, 1), (660, 1), (665, 1), (670, 0), (675, 0), (680, 0), (685, 0), (690, 0), (695, 0), (700, 0), (705, 0), (710, 0), (715, 0), (720, 0), (725, 0), (730, 0), (735, 0), (740, 1), (745, 1), (750, 1), (755, 1), (760, 1), (765, 1), (770, 0), (775, 0), (780, 1), (785, 1), (790, 1), (795, 1), (800, 1), (805, 1), (810, 1), (815, 1), (820, 1), (825, 1), (830, 1), (835, 1), (840, 0), (845, 0), (850, 0), (855, 1), (860, 1), (865, 0), (870, 1), (875, 1), (880, 1), (885, 1), (890, 1), (895, 1), (900, 1), (905, 1), (910, 0), (915, 1), (920, 1), (925, 1), (930, 1), (935, 1), (940, 1), (945, 1), (950, 1), (955, 1), (960, 1), (965, 0), (970, 0), (975, 0), (980, 0), (985, 0), (990, 0), (995, 0), (1000, 0), (1005, 0), (1010, 0), (1015, 0), (1020, 0), (1025, 0)]
Vdin0_48  din0_48  0 PWL (0n 0.0v 4.745n 0.0v 4.755n 1.0v 9.745n 1.0v 9.755n 0.0v 14.745n 0.0v 14.755n 1.0v 19.745n 1.0v 19.755n 1.0v 24.745n 1.0v 24.755n 1.0v 29.745n 1.0v 29.755n 1.0v 34.745n 1.0v 34.755n 1.0v 39.745n 1.0v 39.755n 1.0v 44.745n 1.0v 44.755n 1.0v 49.745n 1.0v 49.755n 0.0v 54.745n 0.0v 54.755n 0.0v 59.745n 0.0v 59.755n 0.0v 64.745n 0.0v 64.755n 1.0v 69.745n 1.0v 69.755n 1.0v 74.745n 1.0v 74.755n 1.0v 79.745n 1.0v 79.755n 1.0v 84.745n 1.0v 84.755n 0.0v 89.745n 0.0v 89.755n 0.0v 94.745n 0.0v 94.755n 0.0v 99.745n 0.0v 99.755n 1.0v 104.745n 1.0v 104.755n 0.0v 109.745n 0.0v 109.755n 0.0v 114.745n 0.0v 114.755n 1.0v 119.745n 1.0v 119.755n 1.0v 124.745n 1.0v 124.755n 1.0v 129.745n 1.0v 129.755n 1.0v 134.745n 1.0v 134.755n 1.0v 139.745n 1.0v 139.755n 1.0v 144.745n 1.0v 144.755n 1.0v 149.745n 1.0v 149.755n 1.0v 154.745n 1.0v 154.755n 1.0v 159.745n 1.0v 159.755n 1.0v 164.745n 1.0v 164.755n 1.0v 169.745n 1.0v 169.755n 1.0v 174.745n 1.0v 174.755n 0.0v 179.745n 0.0v 179.755n 0.0v 184.745n 0.0v 184.755n 0.0v 189.745n 0.0v 189.755n 0.0v 194.745n 0.0v 194.755n 1.0v 199.745n 1.0v 199.755n 1.0v 204.745n 1.0v 204.755n 1.0v 209.745n 1.0v 209.755n 1.0v 214.745n 1.0v 214.755n 1.0v 219.745n 1.0v 219.755n 1.0v 224.745n 1.0v 224.755n 1.0v 229.745n 1.0v 229.755n 1.0v 234.745n 1.0v 234.755n 1.0v 239.745n 1.0v 239.755n 1.0v 244.745n 1.0v 244.755n 0.0v 249.745n 0.0v 249.755n 0.0v 254.745n 0.0v 254.755n 0.0v 259.745n 0.0v 259.755n 0.0v 264.745n 0.0v 264.755n 0.0v 269.745n 0.0v 269.755n 0.0v 274.745n 0.0v 274.755n 0.0v 279.745n 0.0v 279.755n 0.0v 284.745n 0.0v 284.755n 0.0v 289.745n 0.0v 289.755n 1.0v 294.745n 1.0v 294.755n 1.0v 299.745n 1.0v 299.755n 1.0v 304.745n 1.0v 304.755n 1.0v 309.745n 1.0v 309.755n 1.0v 314.745n 1.0v 314.755n 1.0v 319.745n 1.0v 319.755n 1.0v 324.745n 1.0v 324.755n 1.0v 329.745n 1.0v 329.755n 1.0v 334.745n 1.0v 334.755n 0.0v 339.745n 0.0v 339.755n 0.0v 344.745n 0.0v 344.755n 0.0v 349.745n 0.0v 349.755n 0.0v 354.745n 0.0v 354.755n 0.0v 359.745n 0.0v 359.755n 0.0v 364.745n 0.0v 364.755n 0.0v 369.745n 0.0v 369.755n 0.0v 374.745n 0.0v 374.755n 0.0v 379.745n 0.0v 379.755n 0.0v 384.745n 0.0v 384.755n 0.0v 389.745n 0.0v 389.755n 0.0v 394.745n 0.0v 394.755n 0.0v 399.745n 0.0v 399.755n 0.0v 404.745n 0.0v 404.755n 0.0v 409.745n 0.0v 409.755n 1.0v 414.745n 1.0v 414.755n 1.0v 419.745n 1.0v 419.755n 1.0v 424.745n 1.0v 424.755n 1.0v 429.745n 1.0v 429.755n 1.0v 434.745n 1.0v 434.755n 0.0v 439.745n 0.0v 439.755n 0.0v 444.745n 0.0v 444.755n 0.0v 449.745n 0.0v 449.755n 0.0v 454.745n 0.0v 454.755n 0.0v 459.745n 0.0v 459.755n 0.0v 464.745n 0.0v 464.755n 0.0v 469.745n 0.0v 469.755n 0.0v 474.745n 0.0v 474.755n 0.0v 479.745n 0.0v 479.755n 0.0v 484.745n 0.0v 484.755n 0.0v 489.745n 0.0v 489.755n 0.0v 494.745n 0.0v 494.755n 0.0v 499.745n 0.0v 499.755n 0.0v 504.745n 0.0v 504.755n 0.0v 509.745n 0.0v 509.755n 0.0v 514.745n 0.0v 514.755n 0.0v 519.745n 0.0v 519.755n 0.0v 524.745n 0.0v 524.755n 0.0v 529.745n 0.0v 529.755n 0.0v 534.745n 0.0v 534.755n 1.0v 539.745n 1.0v 539.755n 0.0v 544.745n 0.0v 544.755n 0.0v 549.745n 0.0v 549.755n 1.0v 554.745n 1.0v 554.755n 1.0v 559.745n 1.0v 559.755n 0.0v 564.745n 0.0v 564.755n 0.0v 569.745n 0.0v 569.755n 0.0v 574.745n 0.0v 574.755n 0.0v 579.745n 0.0v 579.755n 0.0v 584.745n 0.0v 584.755n 0.0v 589.745n 0.0v 589.755n 0.0v 594.745n 0.0v 594.755n 0.0v 599.745n 0.0v 599.755n 0.0v 604.745n 0.0v 604.755n 0.0v 609.745n 0.0v 609.755n 0.0v 614.745n 0.0v 614.755n 0.0v 619.745n 0.0v 619.755n 0.0v 624.745n 0.0v 624.755n 0.0v 629.745n 0.0v 629.755n 0.0v 634.745n 0.0v 634.755n 1.0v 639.745n 1.0v 639.755n 1.0v 644.745n 1.0v 644.755n 0.0v 649.745n 0.0v 649.755n 0.0v 654.745n 0.0v 654.755n 1.0v 659.745n 1.0v 659.755n 1.0v 664.745n 1.0v 664.755n 1.0v 669.745n 1.0v 669.755n 0.0v 674.745n 0.0v 674.755n 0.0v 679.745n 0.0v 679.755n 0.0v 684.745n 0.0v 684.755n 0.0v 689.745n 0.0v 689.755n 0.0v 694.745n 0.0v 694.755n 0.0v 699.745n 0.0v 699.755n 0.0v 704.745n 0.0v 704.755n 0.0v 709.745n 0.0v 709.755n 0.0v 714.745n 0.0v 714.755n 0.0v 719.745n 0.0v 719.755n 0.0v 724.745n 0.0v 724.755n 0.0v 729.745n 0.0v 729.755n 0.0v 734.745n 0.0v 734.755n 0.0v 739.745n 0.0v 739.755n 1.0v 744.745n 1.0v 744.755n 1.0v 749.745n 1.0v 749.755n 1.0v 754.745n 1.0v 754.755n 1.0v 759.745n 1.0v 759.755n 1.0v 764.745n 1.0v 764.755n 1.0v 769.745n 1.0v 769.755n 0.0v 774.745n 0.0v 774.755n 0.0v 779.745n 0.0v 779.755n 1.0v 784.745n 1.0v 784.755n 1.0v 789.745n 1.0v 789.755n 1.0v 794.745n 1.0v 794.755n 1.0v 799.745n 1.0v 799.755n 1.0v 804.745n 1.0v 804.755n 1.0v 809.745n 1.0v 809.755n 1.0v 814.745n 1.0v 814.755n 1.0v 819.745n 1.0v 819.755n 1.0v 824.745n 1.0v 824.755n 1.0v 829.745n 1.0v 829.755n 1.0v 834.745n 1.0v 834.755n 1.0v 839.745n 1.0v 839.755n 0.0v 844.745n 0.0v 844.755n 0.0v 849.745n 0.0v 849.755n 0.0v 854.745n 0.0v 854.755n 1.0v 859.745n 1.0v 859.755n 1.0v 864.745n 1.0v 864.755n 0.0v 869.745n 0.0v 869.755n 1.0v 874.745n 1.0v 874.755n 1.0v 879.745n 1.0v 879.755n 1.0v 884.745n 1.0v 884.755n 1.0v 889.745n 1.0v 889.755n 1.0v 894.745n 1.0v 894.755n 1.0v 899.745n 1.0v 899.755n 1.0v 904.745n 1.0v 904.755n 1.0v 909.745n 1.0v 909.755n 0.0v 914.745n 0.0v 914.755n 1.0v 919.745n 1.0v 919.755n 1.0v 924.745n 1.0v 924.755n 1.0v 929.745n 1.0v 929.755n 1.0v 934.745n 1.0v 934.755n 1.0v 939.745n 1.0v 939.755n 1.0v 944.745n 1.0v 944.755n 1.0v 949.745n 1.0v 949.755n 1.0v 954.745n 1.0v 954.755n 1.0v 959.745n 1.0v 959.755n 1.0v 964.745n 1.0v 964.755n 0.0v 969.745n 0.0v 969.755n 0.0v 974.745n 0.0v 974.755n 0.0v 979.745n 0.0v 979.755n 0.0v 984.745n 0.0v 984.755n 0.0v 989.745n 0.0v 989.755n 0.0v 994.745n 0.0v 994.755n 0.0v 999.745n 0.0v 999.755n 0.0v 1004.745n 0.0v 1004.755n 0.0v 1009.745n 0.0v 1009.755n 0.0v 1014.745n 0.0v 1014.755n 0.0v 1019.745n 0.0v 1019.755n 0.0v 1024.745n 0.0v 1024.755n 0.0v )
* (time, data): [(0, 0), (5, 0), (10, 0), (15, 0), (20, 0), (25, 0), (30, 1), (35, 1), (40, 0), (45, 0), (50, 1), (55, 1), (60, 1), (65, 1), (70, 1), (75, 1), (80, 1), (85, 1), (90, 1), (95, 1), (100, 1), (105, 0), (110, 0), (115, 1), (120, 1), (125, 1), (130, 1), (135, 1), (140, 1), (145, 1), (150, 1), (155, 0), (160, 0), (165, 0), (170, 0), (175, 1), (180, 1), (185, 1), (190, 0), (195, 0), (200, 0), (205, 0), (210, 0), (215, 0), (220, 0), (225, 0), (230, 0), (235, 0), (240, 0), (245, 1), (250, 1), (255, 1), (260, 1), (265, 1), (270, 1), (275, 1), (280, 1), (285, 1), (290, 1), (295, 1), (300, 1), (305, 1), (310, 1), (315, 1), (320, 1), (325, 1), (330, 1), (335, 1), (340, 1), (345, 1), (350, 0), (355, 0), (360, 0), (365, 0), (370, 0), (375, 0), (380, 0), (385, 0), (390, 0), (395, 0), (400, 0), (405, 0), (410, 1), (415, 1), (420, 1), (425, 1), (430, 1), (435, 0), (440, 0), (445, 1), (450, 1), (455, 1), (460, 1), (465, 1), (470, 1), (475, 1), (480, 1), (485, 1), (490, 1), (495, 1), (500, 1), (505, 1), (510, 1), (515, 0), (520, 0), (525, 0), (530, 0), (535, 0), (540, 0), (545, 1), (550, 0), (555, 0), (560, 0), (565, 0), (570, 0), (575, 0), (580, 0), (585, 0), (590, 0), (595, 0), (600, 0), (605, 0), (610, 1), (615, 1), (620, 0), (625, 0), (630, 0), (635, 1), (640, 1), (645, 0), (650, 0), (655, 0), (660, 0), (665, 0), (670, 1), (675, 1), (680, 1), (685, 1), (690, 1), (695, 1), (700, 1), (705, 1), (710, 1), (715, 1), (720, 1), (725, 1), (730, 1), (735, 1), (740, 0), (745, 0), (750, 0), (755, 0), (760, 0), (765, 0), (770, 0), (775, 0), (780, 1), (785, 1), (790, 1), (795, 1), (800, 1), (805, 1), (810, 0), (815, 0), (820, 0), (825, 0), (830, 0), (835, 0), (840, 1), (845, 1), (850, 0), (855, 0), (860, 0), (865, 1), (870, 1), (875, 1), (880, 1), (885, 1), (890, 1), (895, 1), (900, 1), (905, 1), (910, 0), (915, 0), (920, 0), (925, 0), (930, 1), (935, 1), (940, 1), (945, 1), (950, 1), (955, 1), (960, 1), (965, 0), (970, 0), (975, 0), (980, 0), (985, 0), (990, 0), (995, 0), (1000, 0), (1005, 0), (1010, 0), (1015, 0), (1020, 0), (1025, 0)]
Vdin0_49  din0_49  0 PWL (0n 0.0v 4.745n 0.0v 4.755n 0.0v 9.745n 0.0v 9.755n 0.0v 14.745n 0.0v 14.755n 0.0v 19.745n 0.0v 19.755n 0.0v 24.745n 0.0v 24.755n 0.0v 29.745n 0.0v 29.755n 1.0v 34.745n 1.0v 34.755n 1.0v 39.745n 1.0v 39.755n 0.0v 44.745n 0.0v 44.755n 0.0v 49.745n 0.0v 49.755n 1.0v 54.745n 1.0v 54.755n 1.0v 59.745n 1.0v 59.755n 1.0v 64.745n 1.0v 64.755n 1.0v 69.745n 1.0v 69.755n 1.0v 74.745n 1.0v 74.755n 1.0v 79.745n 1.0v 79.755n 1.0v 84.745n 1.0v 84.755n 1.0v 89.745n 1.0v 89.755n 1.0v 94.745n 1.0v 94.755n 1.0v 99.745n 1.0v 99.755n 1.0v 104.745n 1.0v 104.755n 0.0v 109.745n 0.0v 109.755n 0.0v 114.745n 0.0v 114.755n 1.0v 119.745n 1.0v 119.755n 1.0v 124.745n 1.0v 124.755n 1.0v 129.745n 1.0v 129.755n 1.0v 134.745n 1.0v 134.755n 1.0v 139.745n 1.0v 139.755n 1.0v 144.745n 1.0v 144.755n 1.0v 149.745n 1.0v 149.755n 1.0v 154.745n 1.0v 154.755n 0.0v 159.745n 0.0v 159.755n 0.0v 164.745n 0.0v 164.755n 0.0v 169.745n 0.0v 169.755n 0.0v 174.745n 0.0v 174.755n 1.0v 179.745n 1.0v 179.755n 1.0v 184.745n 1.0v 184.755n 1.0v 189.745n 1.0v 189.755n 0.0v 194.745n 0.0v 194.755n 0.0v 199.745n 0.0v 199.755n 0.0v 204.745n 0.0v 204.755n 0.0v 209.745n 0.0v 209.755n 0.0v 214.745n 0.0v 214.755n 0.0v 219.745n 0.0v 219.755n 0.0v 224.745n 0.0v 224.755n 0.0v 229.745n 0.0v 229.755n 0.0v 234.745n 0.0v 234.755n 0.0v 239.745n 0.0v 239.755n 0.0v 244.745n 0.0v 244.755n 1.0v 249.745n 1.0v 249.755n 1.0v 254.745n 1.0v 254.755n 1.0v 259.745n 1.0v 259.755n 1.0v 264.745n 1.0v 264.755n 1.0v 269.745n 1.0v 269.755n 1.0v 274.745n 1.0v 274.755n 1.0v 279.745n 1.0v 279.755n 1.0v 284.745n 1.0v 284.755n 1.0v 289.745n 1.0v 289.755n 1.0v 294.745n 1.0v 294.755n 1.0v 299.745n 1.0v 299.755n 1.0v 304.745n 1.0v 304.755n 1.0v 309.745n 1.0v 309.755n 1.0v 314.745n 1.0v 314.755n 1.0v 319.745n 1.0v 319.755n 1.0v 324.745n 1.0v 324.755n 1.0v 329.745n 1.0v 329.755n 1.0v 334.745n 1.0v 334.755n 1.0v 339.745n 1.0v 339.755n 1.0v 344.745n 1.0v 344.755n 1.0v 349.745n 1.0v 349.755n 0.0v 354.745n 0.0v 354.755n 0.0v 359.745n 0.0v 359.755n 0.0v 364.745n 0.0v 364.755n 0.0v 369.745n 0.0v 369.755n 0.0v 374.745n 0.0v 374.755n 0.0v 379.745n 0.0v 379.755n 0.0v 384.745n 0.0v 384.755n 0.0v 389.745n 0.0v 389.755n 0.0v 394.745n 0.0v 394.755n 0.0v 399.745n 0.0v 399.755n 0.0v 404.745n 0.0v 404.755n 0.0v 409.745n 0.0v 409.755n 1.0v 414.745n 1.0v 414.755n 1.0v 419.745n 1.0v 419.755n 1.0v 424.745n 1.0v 424.755n 1.0v 429.745n 1.0v 429.755n 1.0v 434.745n 1.0v 434.755n 0.0v 439.745n 0.0v 439.755n 0.0v 444.745n 0.0v 444.755n 1.0v 449.745n 1.0v 449.755n 1.0v 454.745n 1.0v 454.755n 1.0v 459.745n 1.0v 459.755n 1.0v 464.745n 1.0v 464.755n 1.0v 469.745n 1.0v 469.755n 1.0v 474.745n 1.0v 474.755n 1.0v 479.745n 1.0v 479.755n 1.0v 484.745n 1.0v 484.755n 1.0v 489.745n 1.0v 489.755n 1.0v 494.745n 1.0v 494.755n 1.0v 499.745n 1.0v 499.755n 1.0v 504.745n 1.0v 504.755n 1.0v 509.745n 1.0v 509.755n 1.0v 514.745n 1.0v 514.755n 0.0v 519.745n 0.0v 519.755n 0.0v 524.745n 0.0v 524.755n 0.0v 529.745n 0.0v 529.755n 0.0v 534.745n 0.0v 534.755n 0.0v 539.745n 0.0v 539.755n 0.0v 544.745n 0.0v 544.755n 1.0v 549.745n 1.0v 549.755n 0.0v 554.745n 0.0v 554.755n 0.0v 559.745n 0.0v 559.755n 0.0v 564.745n 0.0v 564.755n 0.0v 569.745n 0.0v 569.755n 0.0v 574.745n 0.0v 574.755n 0.0v 579.745n 0.0v 579.755n 0.0v 584.745n 0.0v 584.755n 0.0v 589.745n 0.0v 589.755n 0.0v 594.745n 0.0v 594.755n 0.0v 599.745n 0.0v 599.755n 0.0v 604.745n 0.0v 604.755n 0.0v 609.745n 0.0v 609.755n 1.0v 614.745n 1.0v 614.755n 1.0v 619.745n 1.0v 619.755n 0.0v 624.745n 0.0v 624.755n 0.0v 629.745n 0.0v 629.755n 0.0v 634.745n 0.0v 634.755n 1.0v 639.745n 1.0v 639.755n 1.0v 644.745n 1.0v 644.755n 0.0v 649.745n 0.0v 649.755n 0.0v 654.745n 0.0v 654.755n 0.0v 659.745n 0.0v 659.755n 0.0v 664.745n 0.0v 664.755n 0.0v 669.745n 0.0v 669.755n 1.0v 674.745n 1.0v 674.755n 1.0v 679.745n 1.0v 679.755n 1.0v 684.745n 1.0v 684.755n 1.0v 689.745n 1.0v 689.755n 1.0v 694.745n 1.0v 694.755n 1.0v 699.745n 1.0v 699.755n 1.0v 704.745n 1.0v 704.755n 1.0v 709.745n 1.0v 709.755n 1.0v 714.745n 1.0v 714.755n 1.0v 719.745n 1.0v 719.755n 1.0v 724.745n 1.0v 724.755n 1.0v 729.745n 1.0v 729.755n 1.0v 734.745n 1.0v 734.755n 1.0v 739.745n 1.0v 739.755n 0.0v 744.745n 0.0v 744.755n 0.0v 749.745n 0.0v 749.755n 0.0v 754.745n 0.0v 754.755n 0.0v 759.745n 0.0v 759.755n 0.0v 764.745n 0.0v 764.755n 0.0v 769.745n 0.0v 769.755n 0.0v 774.745n 0.0v 774.755n 0.0v 779.745n 0.0v 779.755n 1.0v 784.745n 1.0v 784.755n 1.0v 789.745n 1.0v 789.755n 1.0v 794.745n 1.0v 794.755n 1.0v 799.745n 1.0v 799.755n 1.0v 804.745n 1.0v 804.755n 1.0v 809.745n 1.0v 809.755n 0.0v 814.745n 0.0v 814.755n 0.0v 819.745n 0.0v 819.755n 0.0v 824.745n 0.0v 824.755n 0.0v 829.745n 0.0v 829.755n 0.0v 834.745n 0.0v 834.755n 0.0v 839.745n 0.0v 839.755n 1.0v 844.745n 1.0v 844.755n 1.0v 849.745n 1.0v 849.755n 0.0v 854.745n 0.0v 854.755n 0.0v 859.745n 0.0v 859.755n 0.0v 864.745n 0.0v 864.755n 1.0v 869.745n 1.0v 869.755n 1.0v 874.745n 1.0v 874.755n 1.0v 879.745n 1.0v 879.755n 1.0v 884.745n 1.0v 884.755n 1.0v 889.745n 1.0v 889.755n 1.0v 894.745n 1.0v 894.755n 1.0v 899.745n 1.0v 899.755n 1.0v 904.745n 1.0v 904.755n 1.0v 909.745n 1.0v 909.755n 0.0v 914.745n 0.0v 914.755n 0.0v 919.745n 0.0v 919.755n 0.0v 924.745n 0.0v 924.755n 0.0v 929.745n 0.0v 929.755n 1.0v 934.745n 1.0v 934.755n 1.0v 939.745n 1.0v 939.755n 1.0v 944.745n 1.0v 944.755n 1.0v 949.745n 1.0v 949.755n 1.0v 954.745n 1.0v 954.755n 1.0v 959.745n 1.0v 959.755n 1.0v 964.745n 1.0v 964.755n 0.0v 969.745n 0.0v 969.755n 0.0v 974.745n 0.0v 974.755n 0.0v 979.745n 0.0v 979.755n 0.0v 984.745n 0.0v 984.755n 0.0v 989.745n 0.0v 989.755n 0.0v 994.745n 0.0v 994.755n 0.0v 999.745n 0.0v 999.755n 0.0v 1004.745n 0.0v 1004.755n 0.0v 1009.745n 0.0v 1009.755n 0.0v 1014.745n 0.0v 1014.755n 0.0v 1019.745n 0.0v 1019.755n 0.0v 1024.745n 0.0v 1024.755n 0.0v )
* (time, data): [(0, 0), (5, 1), (10, 1), (15, 1), (20, 1), (25, 1), (30, 0), (35, 0), (40, 1), (45, 1), (50, 1), (55, 1), (60, 1), (65, 0), (70, 0), (75, 0), (80, 0), (85, 1), (90, 1), (95, 1), (100, 0), (105, 0), (110, 0), (115, 0), (120, 0), (125, 0), (130, 0), (135, 0), (140, 0), (145, 0), (150, 0), (155, 1), (160, 1), (165, 1), (170, 1), (175, 1), (180, 1), (185, 1), (190, 0), (195, 1), (200, 1), (205, 1), (210, 1), (215, 1), (220, 1), (225, 1), (230, 1), (235, 1), (240, 1), (245, 0), (250, 0), (255, 0), (260, 0), (265, 0), (270, 0), (275, 0), (280, 0), (285, 0), (290, 0), (295, 0), (300, 0), (305, 0), (310, 0), (315, 0), (320, 0), (325, 0), (330, 0), (335, 0), (340, 0), (345, 0), (350, 1), (355, 1), (360, 1), (365, 1), (370, 1), (375, 1), (380, 1), (385, 1), (390, 1), (395, 1), (400, 1), (405, 1), (410, 1), (415, 1), (420, 1), (425, 1), (430, 1), (435, 0), (440, 0), (445, 1), (450, 1), (455, 1), (460, 1), (465, 1), (470, 1), (475, 1), (480, 1), (485, 1), (490, 1), (495, 1), (500, 0), (505, 0), (510, 0), (515, 1), (520, 1), (525, 1), (530, 1), (535, 1), (540, 1), (545, 0), (550, 1), (555, 1), (560, 0), (565, 0), (570, 0), (575, 0), (580, 0), (585, 0), (590, 0), (595, 0), (600, 1), (605, 1), (610, 0), (615, 0), (620, 1), (625, 1), (630, 1), (635, 1), (640, 1), (645, 0), (650, 1), (655, 0), (660, 0), (665, 0), (670, 1), (675, 1), (680, 1), (685, 1), (690, 1), (695, 1), (700, 1), (705, 1), (710, 1), (715, 1), (720, 1), (725, 1), (730, 1), (735, 1), (740, 0), (745, 0), (750, 0), (755, 0), (760, 0), (765, 0), (770, 0), (775, 0), (780, 1), (785, 1), (790, 1), (795, 1), (800, 1), (805, 1), (810, 1), (815, 1), (820, 1), (825, 1), (830, 1), (835, 1), (840, 1), (845, 1), (850, 1), (855, 1), (860, 1), (865, 1), (870, 1), (875, 1), (880, 1), (885, 1), (890, 1), (895, 1), (900, 1), (905, 1), (910, 1), (915, 0), (920, 0), (925, 0), (930, 0), (935, 0), (940, 0), (945, 0), (950, 0), (955, 0), (960, 0), (965, 1), (970, 1), (975, 1), (980, 1), (985, 1), (990, 1), (995, 1), (1000, 1), (1005, 1), (1010, 1), (1015, 1), (1020, 0), (1025, 0)]
Vdin0_50  din0_50  0 PWL (0n 0.0v 4.745n 0.0v 4.755n 1.0v 9.745n 1.0v 9.755n 1.0v 14.745n 1.0v 14.755n 1.0v 19.745n 1.0v 19.755n 1.0v 24.745n 1.0v 24.755n 1.0v 29.745n 1.0v 29.755n 0.0v 34.745n 0.0v 34.755n 0.0v 39.745n 0.0v 39.755n 1.0v 44.745n 1.0v 44.755n 1.0v 49.745n 1.0v 49.755n 1.0v 54.745n 1.0v 54.755n 1.0v 59.745n 1.0v 59.755n 1.0v 64.745n 1.0v 64.755n 0.0v 69.745n 0.0v 69.755n 0.0v 74.745n 0.0v 74.755n 0.0v 79.745n 0.0v 79.755n 0.0v 84.745n 0.0v 84.755n 1.0v 89.745n 1.0v 89.755n 1.0v 94.745n 1.0v 94.755n 1.0v 99.745n 1.0v 99.755n 0.0v 104.745n 0.0v 104.755n 0.0v 109.745n 0.0v 109.755n 0.0v 114.745n 0.0v 114.755n 0.0v 119.745n 0.0v 119.755n 0.0v 124.745n 0.0v 124.755n 0.0v 129.745n 0.0v 129.755n 0.0v 134.745n 0.0v 134.755n 0.0v 139.745n 0.0v 139.755n 0.0v 144.745n 0.0v 144.755n 0.0v 149.745n 0.0v 149.755n 0.0v 154.745n 0.0v 154.755n 1.0v 159.745n 1.0v 159.755n 1.0v 164.745n 1.0v 164.755n 1.0v 169.745n 1.0v 169.755n 1.0v 174.745n 1.0v 174.755n 1.0v 179.745n 1.0v 179.755n 1.0v 184.745n 1.0v 184.755n 1.0v 189.745n 1.0v 189.755n 0.0v 194.745n 0.0v 194.755n 1.0v 199.745n 1.0v 199.755n 1.0v 204.745n 1.0v 204.755n 1.0v 209.745n 1.0v 209.755n 1.0v 214.745n 1.0v 214.755n 1.0v 219.745n 1.0v 219.755n 1.0v 224.745n 1.0v 224.755n 1.0v 229.745n 1.0v 229.755n 1.0v 234.745n 1.0v 234.755n 1.0v 239.745n 1.0v 239.755n 1.0v 244.745n 1.0v 244.755n 0.0v 249.745n 0.0v 249.755n 0.0v 254.745n 0.0v 254.755n 0.0v 259.745n 0.0v 259.755n 0.0v 264.745n 0.0v 264.755n 0.0v 269.745n 0.0v 269.755n 0.0v 274.745n 0.0v 274.755n 0.0v 279.745n 0.0v 279.755n 0.0v 284.745n 0.0v 284.755n 0.0v 289.745n 0.0v 289.755n 0.0v 294.745n 0.0v 294.755n 0.0v 299.745n 0.0v 299.755n 0.0v 304.745n 0.0v 304.755n 0.0v 309.745n 0.0v 309.755n 0.0v 314.745n 0.0v 314.755n 0.0v 319.745n 0.0v 319.755n 0.0v 324.745n 0.0v 324.755n 0.0v 329.745n 0.0v 329.755n 0.0v 334.745n 0.0v 334.755n 0.0v 339.745n 0.0v 339.755n 0.0v 344.745n 0.0v 344.755n 0.0v 349.745n 0.0v 349.755n 1.0v 354.745n 1.0v 354.755n 1.0v 359.745n 1.0v 359.755n 1.0v 364.745n 1.0v 364.755n 1.0v 369.745n 1.0v 369.755n 1.0v 374.745n 1.0v 374.755n 1.0v 379.745n 1.0v 379.755n 1.0v 384.745n 1.0v 384.755n 1.0v 389.745n 1.0v 389.755n 1.0v 394.745n 1.0v 394.755n 1.0v 399.745n 1.0v 399.755n 1.0v 404.745n 1.0v 404.755n 1.0v 409.745n 1.0v 409.755n 1.0v 414.745n 1.0v 414.755n 1.0v 419.745n 1.0v 419.755n 1.0v 424.745n 1.0v 424.755n 1.0v 429.745n 1.0v 429.755n 1.0v 434.745n 1.0v 434.755n 0.0v 439.745n 0.0v 439.755n 0.0v 444.745n 0.0v 444.755n 1.0v 449.745n 1.0v 449.755n 1.0v 454.745n 1.0v 454.755n 1.0v 459.745n 1.0v 459.755n 1.0v 464.745n 1.0v 464.755n 1.0v 469.745n 1.0v 469.755n 1.0v 474.745n 1.0v 474.755n 1.0v 479.745n 1.0v 479.755n 1.0v 484.745n 1.0v 484.755n 1.0v 489.745n 1.0v 489.755n 1.0v 494.745n 1.0v 494.755n 1.0v 499.745n 1.0v 499.755n 0.0v 504.745n 0.0v 504.755n 0.0v 509.745n 0.0v 509.755n 0.0v 514.745n 0.0v 514.755n 1.0v 519.745n 1.0v 519.755n 1.0v 524.745n 1.0v 524.755n 1.0v 529.745n 1.0v 529.755n 1.0v 534.745n 1.0v 534.755n 1.0v 539.745n 1.0v 539.755n 1.0v 544.745n 1.0v 544.755n 0.0v 549.745n 0.0v 549.755n 1.0v 554.745n 1.0v 554.755n 1.0v 559.745n 1.0v 559.755n 0.0v 564.745n 0.0v 564.755n 0.0v 569.745n 0.0v 569.755n 0.0v 574.745n 0.0v 574.755n 0.0v 579.745n 0.0v 579.755n 0.0v 584.745n 0.0v 584.755n 0.0v 589.745n 0.0v 589.755n 0.0v 594.745n 0.0v 594.755n 0.0v 599.745n 0.0v 599.755n 1.0v 604.745n 1.0v 604.755n 1.0v 609.745n 1.0v 609.755n 0.0v 614.745n 0.0v 614.755n 0.0v 619.745n 0.0v 619.755n 1.0v 624.745n 1.0v 624.755n 1.0v 629.745n 1.0v 629.755n 1.0v 634.745n 1.0v 634.755n 1.0v 639.745n 1.0v 639.755n 1.0v 644.745n 1.0v 644.755n 0.0v 649.745n 0.0v 649.755n 1.0v 654.745n 1.0v 654.755n 0.0v 659.745n 0.0v 659.755n 0.0v 664.745n 0.0v 664.755n 0.0v 669.745n 0.0v 669.755n 1.0v 674.745n 1.0v 674.755n 1.0v 679.745n 1.0v 679.755n 1.0v 684.745n 1.0v 684.755n 1.0v 689.745n 1.0v 689.755n 1.0v 694.745n 1.0v 694.755n 1.0v 699.745n 1.0v 699.755n 1.0v 704.745n 1.0v 704.755n 1.0v 709.745n 1.0v 709.755n 1.0v 714.745n 1.0v 714.755n 1.0v 719.745n 1.0v 719.755n 1.0v 724.745n 1.0v 724.755n 1.0v 729.745n 1.0v 729.755n 1.0v 734.745n 1.0v 734.755n 1.0v 739.745n 1.0v 739.755n 0.0v 744.745n 0.0v 744.755n 0.0v 749.745n 0.0v 749.755n 0.0v 754.745n 0.0v 754.755n 0.0v 759.745n 0.0v 759.755n 0.0v 764.745n 0.0v 764.755n 0.0v 769.745n 0.0v 769.755n 0.0v 774.745n 0.0v 774.755n 0.0v 779.745n 0.0v 779.755n 1.0v 784.745n 1.0v 784.755n 1.0v 789.745n 1.0v 789.755n 1.0v 794.745n 1.0v 794.755n 1.0v 799.745n 1.0v 799.755n 1.0v 804.745n 1.0v 804.755n 1.0v 809.745n 1.0v 809.755n 1.0v 814.745n 1.0v 814.755n 1.0v 819.745n 1.0v 819.755n 1.0v 824.745n 1.0v 824.755n 1.0v 829.745n 1.0v 829.755n 1.0v 834.745n 1.0v 834.755n 1.0v 839.745n 1.0v 839.755n 1.0v 844.745n 1.0v 844.755n 1.0v 849.745n 1.0v 849.755n 1.0v 854.745n 1.0v 854.755n 1.0v 859.745n 1.0v 859.755n 1.0v 864.745n 1.0v 864.755n 1.0v 869.745n 1.0v 869.755n 1.0v 874.745n 1.0v 874.755n 1.0v 879.745n 1.0v 879.755n 1.0v 884.745n 1.0v 884.755n 1.0v 889.745n 1.0v 889.755n 1.0v 894.745n 1.0v 894.755n 1.0v 899.745n 1.0v 899.755n 1.0v 904.745n 1.0v 904.755n 1.0v 909.745n 1.0v 909.755n 1.0v 914.745n 1.0v 914.755n 0.0v 919.745n 0.0v 919.755n 0.0v 924.745n 0.0v 924.755n 0.0v 929.745n 0.0v 929.755n 0.0v 934.745n 0.0v 934.755n 0.0v 939.745n 0.0v 939.755n 0.0v 944.745n 0.0v 944.755n 0.0v 949.745n 0.0v 949.755n 0.0v 954.745n 0.0v 954.755n 0.0v 959.745n 0.0v 959.755n 0.0v 964.745n 0.0v 964.755n 1.0v 969.745n 1.0v 969.755n 1.0v 974.745n 1.0v 974.755n 1.0v 979.745n 1.0v 979.755n 1.0v 984.745n 1.0v 984.755n 1.0v 989.745n 1.0v 989.755n 1.0v 994.745n 1.0v 994.755n 1.0v 999.745n 1.0v 999.755n 1.0v 1004.745n 1.0v 1004.755n 1.0v 1009.745n 1.0v 1009.755n 1.0v 1014.745n 1.0v 1014.755n 1.0v 1019.745n 1.0v 1019.755n 0.0v 1024.745n 0.0v 1024.755n 0.0v )
* (time, data): [(0, 0), (5, 1), (10, 0), (15, 0), (20, 0), (25, 0), (30, 1), (35, 1), (40, 1), (45, 1), (50, 1), (55, 1), (60, 1), (65, 1), (70, 1), (75, 1), (80, 1), (85, 1), (90, 1), (95, 1), (100, 0), (105, 1), (110, 1), (115, 0), (120, 0), (125, 0), (130, 0), (135, 0), (140, 0), (145, 0), (150, 0), (155, 0), (160, 0), (165, 0), (170, 0), (175, 1), (180, 1), (185, 1), (190, 1), (195, 1), (200, 1), (205, 1), (210, 1), (215, 1), (220, 1), (225, 1), (230, 1), (235, 1), (240, 1), (245, 0), (250, 0), (255, 0), (260, 0), (265, 0), (270, 0), (275, 0), (280, 0), (285, 0), (290, 1), (295, 1), (300, 1), (305, 1), (310, 1), (315, 1), (320, 1), (325, 1), (330, 1), (335, 1), (340, 1), (345, 1), (350, 1), (355, 1), (360, 1), (365, 1), (370, 1), (375, 1), (380, 1), (385, 1), (390, 1), (395, 1), (400, 1), (405, 1), (410, 1), (415, 1), (420, 1), (425, 1), (430, 1), (435, 1), (440, 1), (445, 0), (450, 0), (455, 0), (460, 0), (465, 0), (470, 0), (475, 0), (480, 0), (485, 1), (490, 0), (495, 0), (500, 0), (505, 0), (510, 0), (515, 1), (520, 1), (525, 1), (530, 1), (535, 1), (540, 1), (545, 0), (550, 0), (555, 0), (560, 0), (565, 0), (570, 0), (575, 0), (580, 0), (585, 0), (590, 0), (595, 0), (600, 1), (605, 1), (610, 1), (615, 1), (620, 0), (625, 0), (630, 0), (635, 0), (640, 0), (645, 1), (650, 0), (655, 0), (660, 0), (665, 0), (670, 0), (675, 0), (680, 0), (685, 0), (690, 0), (695, 0), (700, 0), (705, 0), (710, 0), (715, 0), (720, 0), (725, 0), (730, 0), (735, 0), (740, 0), (745, 0), (750, 0), (755, 0), (760, 0), (765, 0), (770, 0), (775, 0), (780, 1), (785, 1), (790, 1), (795, 1), (800, 1), (805, 1), (810, 1), (815, 1), (820, 1), (825, 1), (830, 1), (835, 1), (840, 1), (845, 1), (850, 1), (855, 0), (860, 0), (865, 1), (870, 0), (875, 0), (880, 0), (885, 0), (890, 0), (895, 0), (900, 0), (905, 0), (910, 1), (915, 1), (920, 1), (925, 1), (930, 0), (935, 0), (940, 0), (945, 0), (950, 0), (955, 0), (960, 0), (965, 0), (970, 0), (975, 0), (980, 0), (985, 0), (990, 0), (995, 0), (1000, 0), (1005, 0), (1010, 0), (1015, 0), (1020, 0), (1025, 0)]
Vdin0_51  din0_51  0 PWL (0n 0.0v 4.745n 0.0v 4.755n 1.0v 9.745n 1.0v 9.755n 0.0v 14.745n 0.0v 14.755n 0.0v 19.745n 0.0v 19.755n 0.0v 24.745n 0.0v 24.755n 0.0v 29.745n 0.0v 29.755n 1.0v 34.745n 1.0v 34.755n 1.0v 39.745n 1.0v 39.755n 1.0v 44.745n 1.0v 44.755n 1.0v 49.745n 1.0v 49.755n 1.0v 54.745n 1.0v 54.755n 1.0v 59.745n 1.0v 59.755n 1.0v 64.745n 1.0v 64.755n 1.0v 69.745n 1.0v 69.755n 1.0v 74.745n 1.0v 74.755n 1.0v 79.745n 1.0v 79.755n 1.0v 84.745n 1.0v 84.755n 1.0v 89.745n 1.0v 89.755n 1.0v 94.745n 1.0v 94.755n 1.0v 99.745n 1.0v 99.755n 0.0v 104.745n 0.0v 104.755n 1.0v 109.745n 1.0v 109.755n 1.0v 114.745n 1.0v 114.755n 0.0v 119.745n 0.0v 119.755n 0.0v 124.745n 0.0v 124.755n 0.0v 129.745n 0.0v 129.755n 0.0v 134.745n 0.0v 134.755n 0.0v 139.745n 0.0v 139.755n 0.0v 144.745n 0.0v 144.755n 0.0v 149.745n 0.0v 149.755n 0.0v 154.745n 0.0v 154.755n 0.0v 159.745n 0.0v 159.755n 0.0v 164.745n 0.0v 164.755n 0.0v 169.745n 0.0v 169.755n 0.0v 174.745n 0.0v 174.755n 1.0v 179.745n 1.0v 179.755n 1.0v 184.745n 1.0v 184.755n 1.0v 189.745n 1.0v 189.755n 1.0v 194.745n 1.0v 194.755n 1.0v 199.745n 1.0v 199.755n 1.0v 204.745n 1.0v 204.755n 1.0v 209.745n 1.0v 209.755n 1.0v 214.745n 1.0v 214.755n 1.0v 219.745n 1.0v 219.755n 1.0v 224.745n 1.0v 224.755n 1.0v 229.745n 1.0v 229.755n 1.0v 234.745n 1.0v 234.755n 1.0v 239.745n 1.0v 239.755n 1.0v 244.745n 1.0v 244.755n 0.0v 249.745n 0.0v 249.755n 0.0v 254.745n 0.0v 254.755n 0.0v 259.745n 0.0v 259.755n 0.0v 264.745n 0.0v 264.755n 0.0v 269.745n 0.0v 269.755n 0.0v 274.745n 0.0v 274.755n 0.0v 279.745n 0.0v 279.755n 0.0v 284.745n 0.0v 284.755n 0.0v 289.745n 0.0v 289.755n 1.0v 294.745n 1.0v 294.755n 1.0v 299.745n 1.0v 299.755n 1.0v 304.745n 1.0v 304.755n 1.0v 309.745n 1.0v 309.755n 1.0v 314.745n 1.0v 314.755n 1.0v 319.745n 1.0v 319.755n 1.0v 324.745n 1.0v 324.755n 1.0v 329.745n 1.0v 329.755n 1.0v 334.745n 1.0v 334.755n 1.0v 339.745n 1.0v 339.755n 1.0v 344.745n 1.0v 344.755n 1.0v 349.745n 1.0v 349.755n 1.0v 354.745n 1.0v 354.755n 1.0v 359.745n 1.0v 359.755n 1.0v 364.745n 1.0v 364.755n 1.0v 369.745n 1.0v 369.755n 1.0v 374.745n 1.0v 374.755n 1.0v 379.745n 1.0v 379.755n 1.0v 384.745n 1.0v 384.755n 1.0v 389.745n 1.0v 389.755n 1.0v 394.745n 1.0v 394.755n 1.0v 399.745n 1.0v 399.755n 1.0v 404.745n 1.0v 404.755n 1.0v 409.745n 1.0v 409.755n 1.0v 414.745n 1.0v 414.755n 1.0v 419.745n 1.0v 419.755n 1.0v 424.745n 1.0v 424.755n 1.0v 429.745n 1.0v 429.755n 1.0v 434.745n 1.0v 434.755n 1.0v 439.745n 1.0v 439.755n 1.0v 444.745n 1.0v 444.755n 0.0v 449.745n 0.0v 449.755n 0.0v 454.745n 0.0v 454.755n 0.0v 459.745n 0.0v 459.755n 0.0v 464.745n 0.0v 464.755n 0.0v 469.745n 0.0v 469.755n 0.0v 474.745n 0.0v 474.755n 0.0v 479.745n 0.0v 479.755n 0.0v 484.745n 0.0v 484.755n 1.0v 489.745n 1.0v 489.755n 0.0v 494.745n 0.0v 494.755n 0.0v 499.745n 0.0v 499.755n 0.0v 504.745n 0.0v 504.755n 0.0v 509.745n 0.0v 509.755n 0.0v 514.745n 0.0v 514.755n 1.0v 519.745n 1.0v 519.755n 1.0v 524.745n 1.0v 524.755n 1.0v 529.745n 1.0v 529.755n 1.0v 534.745n 1.0v 534.755n 1.0v 539.745n 1.0v 539.755n 1.0v 544.745n 1.0v 544.755n 0.0v 549.745n 0.0v 549.755n 0.0v 554.745n 0.0v 554.755n 0.0v 559.745n 0.0v 559.755n 0.0v 564.745n 0.0v 564.755n 0.0v 569.745n 0.0v 569.755n 0.0v 574.745n 0.0v 574.755n 0.0v 579.745n 0.0v 579.755n 0.0v 584.745n 0.0v 584.755n 0.0v 589.745n 0.0v 589.755n 0.0v 594.745n 0.0v 594.755n 0.0v 599.745n 0.0v 599.755n 1.0v 604.745n 1.0v 604.755n 1.0v 609.745n 1.0v 609.755n 1.0v 614.745n 1.0v 614.755n 1.0v 619.745n 1.0v 619.755n 0.0v 624.745n 0.0v 624.755n 0.0v 629.745n 0.0v 629.755n 0.0v 634.745n 0.0v 634.755n 0.0v 639.745n 0.0v 639.755n 0.0v 644.745n 0.0v 644.755n 1.0v 649.745n 1.0v 649.755n 0.0v 654.745n 0.0v 654.755n 0.0v 659.745n 0.0v 659.755n 0.0v 664.745n 0.0v 664.755n 0.0v 669.745n 0.0v 669.755n 0.0v 674.745n 0.0v 674.755n 0.0v 679.745n 0.0v 679.755n 0.0v 684.745n 0.0v 684.755n 0.0v 689.745n 0.0v 689.755n 0.0v 694.745n 0.0v 694.755n 0.0v 699.745n 0.0v 699.755n 0.0v 704.745n 0.0v 704.755n 0.0v 709.745n 0.0v 709.755n 0.0v 714.745n 0.0v 714.755n 0.0v 719.745n 0.0v 719.755n 0.0v 724.745n 0.0v 724.755n 0.0v 729.745n 0.0v 729.755n 0.0v 734.745n 0.0v 734.755n 0.0v 739.745n 0.0v 739.755n 0.0v 744.745n 0.0v 744.755n 0.0v 749.745n 0.0v 749.755n 0.0v 754.745n 0.0v 754.755n 0.0v 759.745n 0.0v 759.755n 0.0v 764.745n 0.0v 764.755n 0.0v 769.745n 0.0v 769.755n 0.0v 774.745n 0.0v 774.755n 0.0v 779.745n 0.0v 779.755n 1.0v 784.745n 1.0v 784.755n 1.0v 789.745n 1.0v 789.755n 1.0v 794.745n 1.0v 794.755n 1.0v 799.745n 1.0v 799.755n 1.0v 804.745n 1.0v 804.755n 1.0v 809.745n 1.0v 809.755n 1.0v 814.745n 1.0v 814.755n 1.0v 819.745n 1.0v 819.755n 1.0v 824.745n 1.0v 824.755n 1.0v 829.745n 1.0v 829.755n 1.0v 834.745n 1.0v 834.755n 1.0v 839.745n 1.0v 839.755n 1.0v 844.745n 1.0v 844.755n 1.0v 849.745n 1.0v 849.755n 1.0v 854.745n 1.0v 854.755n 0.0v 859.745n 0.0v 859.755n 0.0v 864.745n 0.0v 864.755n 1.0v 869.745n 1.0v 869.755n 0.0v 874.745n 0.0v 874.755n 0.0v 879.745n 0.0v 879.755n 0.0v 884.745n 0.0v 884.755n 0.0v 889.745n 0.0v 889.755n 0.0v 894.745n 0.0v 894.755n 0.0v 899.745n 0.0v 899.755n 0.0v 904.745n 0.0v 904.755n 0.0v 909.745n 0.0v 909.755n 1.0v 914.745n 1.0v 914.755n 1.0v 919.745n 1.0v 919.755n 1.0v 924.745n 1.0v 924.755n 1.0v 929.745n 1.0v 929.755n 0.0v 934.745n 0.0v 934.755n 0.0v 939.745n 0.0v 939.755n 0.0v 944.745n 0.0v 944.755n 0.0v 949.745n 0.0v 949.755n 0.0v 954.745n 0.0v 954.755n 0.0v 959.745n 0.0v 959.755n 0.0v 964.745n 0.0v 964.755n 0.0v 969.745n 0.0v 969.755n 0.0v 974.745n 0.0v 974.755n 0.0v 979.745n 0.0v 979.755n 0.0v 984.745n 0.0v 984.755n 0.0v 989.745n 0.0v 989.755n 0.0v 994.745n 0.0v 994.755n 0.0v 999.745n 0.0v 999.755n 0.0v 1004.745n 0.0v 1004.755n 0.0v 1009.745n 0.0v 1009.755n 0.0v 1014.745n 0.0v 1014.755n 0.0v 1019.745n 0.0v 1019.755n 0.0v 1024.745n 0.0v 1024.755n 0.0v )
* (time, data): [(0, 0), (5, 0), (10, 0), (15, 1), (20, 1), (25, 1), (30, 0), (35, 0), (40, 1), (45, 1), (50, 0), (55, 0), (60, 0), (65, 1), (70, 1), (75, 1), (80, 1), (85, 0), (90, 0), (95, 0), (100, 0), (105, 0), (110, 0), (115, 0), (120, 0), (125, 0), (130, 0), (135, 0), (140, 0), (145, 0), (150, 0), (155, 1), (160, 1), (165, 1), (170, 1), (175, 1), (180, 1), (185, 1), (190, 0), (195, 1), (200, 1), (205, 1), (210, 1), (215, 1), (220, 1), (225, 1), (230, 1), (235, 1), (240, 1), (245, 1), (250, 1), (255, 1), (260, 1), (265, 1), (270, 1), (275, 1), (280, 1), (285, 1), (290, 0), (295, 0), (300, 0), (305, 0), (310, 0), (315, 0), (320, 0), (325, 0), (330, 0), (335, 0), (340, 0), (345, 0), (350, 0), (355, 0), (360, 0), (365, 0), (370, 0), (375, 0), (380, 0), (385, 0), (390, 0), (395, 0), (400, 0), (405, 0), (410, 1), (415, 1), (420, 1), (425, 1), (430, 1), (435, 0), (440, 0), (445, 0), (450, 0), (455, 0), (460, 0), (465, 0), (470, 0), (475, 0), (480, 0), (485, 1), (490, 1), (495, 1), (500, 0), (505, 0), (510, 0), (515, 1), (520, 1), (525, 1), (530, 1), (535, 1), (540, 0), (545, 0), (550, 0), (555, 0), (560, 0), (565, 0), (570, 0), (575, 0), (580, 0), (585, 0), (590, 0), (595, 0), (600, 0), (605, 0), (610, 0), (615, 0), (620, 1), (625, 1), (630, 1), (635, 0), (640, 0), (645, 0), (650, 0), (655, 0), (660, 0), (665, 0), (670, 1), (675, 1), (680, 1), (685, 1), (690, 1), (695, 1), (700, 1), (705, 1), (710, 1), (715, 1), (720, 0), (725, 0), (730, 0), (735, 0), (740, 0), (745, 0), (750, 0), (755, 0), (760, 0), (765, 0), (770, 1), (775, 1), (780, 1), (785, 1), (790, 1), (795, 1), (800, 1), (805, 1), (810, 1), (815, 1), (820, 1), (825, 1), (830, 1), (835, 1), (840, 1), (845, 1), (850, 0), (855, 0), (860, 0), (865, 0), (870, 1), (875, 1), (880, 1), (885, 1), (890, 1), (895, 1), (900, 1), (905, 1), (910, 1), (915, 0), (920, 0), (925, 0), (930, 1), (935, 1), (940, 1), (945, 1), (950, 1), (955, 1), (960, 1), (965, 1), (970, 1), (975, 1), (980, 1), (985, 1), (990, 1), (995, 1), (1000, 1), (1005, 1), (1010, 1), (1015, 1), (1020, 0), (1025, 0)]
Vdin0_52  din0_52  0 PWL (0n 0.0v 4.745n 0.0v 4.755n 0.0v 9.745n 0.0v 9.755n 0.0v 14.745n 0.0v 14.755n 1.0v 19.745n 1.0v 19.755n 1.0v 24.745n 1.0v 24.755n 1.0v 29.745n 1.0v 29.755n 0.0v 34.745n 0.0v 34.755n 0.0v 39.745n 0.0v 39.755n 1.0v 44.745n 1.0v 44.755n 1.0v 49.745n 1.0v 49.755n 0.0v 54.745n 0.0v 54.755n 0.0v 59.745n 0.0v 59.755n 0.0v 64.745n 0.0v 64.755n 1.0v 69.745n 1.0v 69.755n 1.0v 74.745n 1.0v 74.755n 1.0v 79.745n 1.0v 79.755n 1.0v 84.745n 1.0v 84.755n 0.0v 89.745n 0.0v 89.755n 0.0v 94.745n 0.0v 94.755n 0.0v 99.745n 0.0v 99.755n 0.0v 104.745n 0.0v 104.755n 0.0v 109.745n 0.0v 109.755n 0.0v 114.745n 0.0v 114.755n 0.0v 119.745n 0.0v 119.755n 0.0v 124.745n 0.0v 124.755n 0.0v 129.745n 0.0v 129.755n 0.0v 134.745n 0.0v 134.755n 0.0v 139.745n 0.0v 139.755n 0.0v 144.745n 0.0v 144.755n 0.0v 149.745n 0.0v 149.755n 0.0v 154.745n 0.0v 154.755n 1.0v 159.745n 1.0v 159.755n 1.0v 164.745n 1.0v 164.755n 1.0v 169.745n 1.0v 169.755n 1.0v 174.745n 1.0v 174.755n 1.0v 179.745n 1.0v 179.755n 1.0v 184.745n 1.0v 184.755n 1.0v 189.745n 1.0v 189.755n 0.0v 194.745n 0.0v 194.755n 1.0v 199.745n 1.0v 199.755n 1.0v 204.745n 1.0v 204.755n 1.0v 209.745n 1.0v 209.755n 1.0v 214.745n 1.0v 214.755n 1.0v 219.745n 1.0v 219.755n 1.0v 224.745n 1.0v 224.755n 1.0v 229.745n 1.0v 229.755n 1.0v 234.745n 1.0v 234.755n 1.0v 239.745n 1.0v 239.755n 1.0v 244.745n 1.0v 244.755n 1.0v 249.745n 1.0v 249.755n 1.0v 254.745n 1.0v 254.755n 1.0v 259.745n 1.0v 259.755n 1.0v 264.745n 1.0v 264.755n 1.0v 269.745n 1.0v 269.755n 1.0v 274.745n 1.0v 274.755n 1.0v 279.745n 1.0v 279.755n 1.0v 284.745n 1.0v 284.755n 1.0v 289.745n 1.0v 289.755n 0.0v 294.745n 0.0v 294.755n 0.0v 299.745n 0.0v 299.755n 0.0v 304.745n 0.0v 304.755n 0.0v 309.745n 0.0v 309.755n 0.0v 314.745n 0.0v 314.755n 0.0v 319.745n 0.0v 319.755n 0.0v 324.745n 0.0v 324.755n 0.0v 329.745n 0.0v 329.755n 0.0v 334.745n 0.0v 334.755n 0.0v 339.745n 0.0v 339.755n 0.0v 344.745n 0.0v 344.755n 0.0v 349.745n 0.0v 349.755n 0.0v 354.745n 0.0v 354.755n 0.0v 359.745n 0.0v 359.755n 0.0v 364.745n 0.0v 364.755n 0.0v 369.745n 0.0v 369.755n 0.0v 374.745n 0.0v 374.755n 0.0v 379.745n 0.0v 379.755n 0.0v 384.745n 0.0v 384.755n 0.0v 389.745n 0.0v 389.755n 0.0v 394.745n 0.0v 394.755n 0.0v 399.745n 0.0v 399.755n 0.0v 404.745n 0.0v 404.755n 0.0v 409.745n 0.0v 409.755n 1.0v 414.745n 1.0v 414.755n 1.0v 419.745n 1.0v 419.755n 1.0v 424.745n 1.0v 424.755n 1.0v 429.745n 1.0v 429.755n 1.0v 434.745n 1.0v 434.755n 0.0v 439.745n 0.0v 439.755n 0.0v 444.745n 0.0v 444.755n 0.0v 449.745n 0.0v 449.755n 0.0v 454.745n 0.0v 454.755n 0.0v 459.745n 0.0v 459.755n 0.0v 464.745n 0.0v 464.755n 0.0v 469.745n 0.0v 469.755n 0.0v 474.745n 0.0v 474.755n 0.0v 479.745n 0.0v 479.755n 0.0v 484.745n 0.0v 484.755n 1.0v 489.745n 1.0v 489.755n 1.0v 494.745n 1.0v 494.755n 1.0v 499.745n 1.0v 499.755n 0.0v 504.745n 0.0v 504.755n 0.0v 509.745n 0.0v 509.755n 0.0v 514.745n 0.0v 514.755n 1.0v 519.745n 1.0v 519.755n 1.0v 524.745n 1.0v 524.755n 1.0v 529.745n 1.0v 529.755n 1.0v 534.745n 1.0v 534.755n 1.0v 539.745n 1.0v 539.755n 0.0v 544.745n 0.0v 544.755n 0.0v 549.745n 0.0v 549.755n 0.0v 554.745n 0.0v 554.755n 0.0v 559.745n 0.0v 559.755n 0.0v 564.745n 0.0v 564.755n 0.0v 569.745n 0.0v 569.755n 0.0v 574.745n 0.0v 574.755n 0.0v 579.745n 0.0v 579.755n 0.0v 584.745n 0.0v 584.755n 0.0v 589.745n 0.0v 589.755n 0.0v 594.745n 0.0v 594.755n 0.0v 599.745n 0.0v 599.755n 0.0v 604.745n 0.0v 604.755n 0.0v 609.745n 0.0v 609.755n 0.0v 614.745n 0.0v 614.755n 0.0v 619.745n 0.0v 619.755n 1.0v 624.745n 1.0v 624.755n 1.0v 629.745n 1.0v 629.755n 1.0v 634.745n 1.0v 634.755n 0.0v 639.745n 0.0v 639.755n 0.0v 644.745n 0.0v 644.755n 0.0v 649.745n 0.0v 649.755n 0.0v 654.745n 0.0v 654.755n 0.0v 659.745n 0.0v 659.755n 0.0v 664.745n 0.0v 664.755n 0.0v 669.745n 0.0v 669.755n 1.0v 674.745n 1.0v 674.755n 1.0v 679.745n 1.0v 679.755n 1.0v 684.745n 1.0v 684.755n 1.0v 689.745n 1.0v 689.755n 1.0v 694.745n 1.0v 694.755n 1.0v 699.745n 1.0v 699.755n 1.0v 704.745n 1.0v 704.755n 1.0v 709.745n 1.0v 709.755n 1.0v 714.745n 1.0v 714.755n 1.0v 719.745n 1.0v 719.755n 0.0v 724.745n 0.0v 724.755n 0.0v 729.745n 0.0v 729.755n 0.0v 734.745n 0.0v 734.755n 0.0v 739.745n 0.0v 739.755n 0.0v 744.745n 0.0v 744.755n 0.0v 749.745n 0.0v 749.755n 0.0v 754.745n 0.0v 754.755n 0.0v 759.745n 0.0v 759.755n 0.0v 764.745n 0.0v 764.755n 0.0v 769.745n 0.0v 769.755n 1.0v 774.745n 1.0v 774.755n 1.0v 779.745n 1.0v 779.755n 1.0v 784.745n 1.0v 784.755n 1.0v 789.745n 1.0v 789.755n 1.0v 794.745n 1.0v 794.755n 1.0v 799.745n 1.0v 799.755n 1.0v 804.745n 1.0v 804.755n 1.0v 809.745n 1.0v 809.755n 1.0v 814.745n 1.0v 814.755n 1.0v 819.745n 1.0v 819.755n 1.0v 824.745n 1.0v 824.755n 1.0v 829.745n 1.0v 829.755n 1.0v 834.745n 1.0v 834.755n 1.0v 839.745n 1.0v 839.755n 1.0v 844.745n 1.0v 844.755n 1.0v 849.745n 1.0v 849.755n 0.0v 854.745n 0.0v 854.755n 0.0v 859.745n 0.0v 859.755n 0.0v 864.745n 0.0v 864.755n 0.0v 869.745n 0.0v 869.755n 1.0v 874.745n 1.0v 874.755n 1.0v 879.745n 1.0v 879.755n 1.0v 884.745n 1.0v 884.755n 1.0v 889.745n 1.0v 889.755n 1.0v 894.745n 1.0v 894.755n 1.0v 899.745n 1.0v 899.755n 1.0v 904.745n 1.0v 904.755n 1.0v 909.745n 1.0v 909.755n 1.0v 914.745n 1.0v 914.755n 0.0v 919.745n 0.0v 919.755n 0.0v 924.745n 0.0v 924.755n 0.0v 929.745n 0.0v 929.755n 1.0v 934.745n 1.0v 934.755n 1.0v 939.745n 1.0v 939.755n 1.0v 944.745n 1.0v 944.755n 1.0v 949.745n 1.0v 949.755n 1.0v 954.745n 1.0v 954.755n 1.0v 959.745n 1.0v 959.755n 1.0v 964.745n 1.0v 964.755n 1.0v 969.745n 1.0v 969.755n 1.0v 974.745n 1.0v 974.755n 1.0v 979.745n 1.0v 979.755n 1.0v 984.745n 1.0v 984.755n 1.0v 989.745n 1.0v 989.755n 1.0v 994.745n 1.0v 994.755n 1.0v 999.745n 1.0v 999.755n 1.0v 1004.745n 1.0v 1004.755n 1.0v 1009.745n 1.0v 1009.755n 1.0v 1014.745n 1.0v 1014.755n 1.0v 1019.745n 1.0v 1019.755n 0.0v 1024.745n 0.0v 1024.755n 0.0v )
* (time, data): [(0, 0), (5, 1), (10, 0), (15, 0), (20, 0), (25, 0), (30, 0), (35, 0), (40, 0), (45, 0), (50, 1), (55, 1), (60, 1), (65, 0), (70, 0), (75, 0), (80, 0), (85, 0), (90, 0), (95, 0), (100, 1), (105, 0), (110, 0), (115, 1), (120, 1), (125, 1), (130, 1), (135, 1), (140, 1), (145, 1), (150, 1), (155, 0), (160, 0), (165, 0), (170, 0), (175, 1), (180, 1), (185, 1), (190, 0), (195, 1), (200, 1), (205, 1), (210, 1), (215, 1), (220, 1), (225, 1), (230, 1), (235, 1), (240, 1), (245, 0), (250, 0), (255, 0), (260, 0), (265, 0), (270, 0), (275, 0), (280, 0), (285, 0), (290, 0), (295, 0), (300, 0), (305, 0), (310, 0), (315, 0), (320, 0), (325, 0), (330, 0), (335, 0), (340, 0), (345, 0), (350, 1), (355, 1), (360, 1), (365, 1), (370, 1), (375, 1), (380, 1), (385, 1), (390, 1), (395, 1), (400, 1), (405, 1), (410, 0), (415, 0), (420, 0), (425, 0), (430, 0), (435, 0), (440, 0), (445, 1), (450, 1), (455, 1), (460, 1), (465, 1), (470, 1), (475, 1), (480, 1), (485, 1), (490, 1), (495, 1), (500, 0), (505, 0), (510, 0), (515, 0), (520, 0), (525, 0), (530, 0), (535, 0), (540, 0), (545, 1), (550, 1), (555, 1), (560, 1), (565, 1), (570, 1), (575, 1), (580, 1), (585, 1), (590, 1), (595, 1), (600, 1), (605, 1), (610, 1), (615, 1), (620, 1), (625, 1), (630, 1), (635, 0), (640, 0), (645, 0), (650, 1), (655, 1), (660, 1), (665, 1), (670, 0), (675, 0), (680, 0), (685, 0), (690, 0), (695, 0), (700, 0), (705, 0), (710, 0), (715, 0), (720, 0), (725, 0), (730, 0), (735, 0), (740, 1), (745, 1), (750, 1), (755, 1), (760, 1), (765, 1), (770, 0), (775, 0), (780, 1), (785, 1), (790, 1), (795, 1), (800, 1), (805, 0), (810, 1), (815, 1), (820, 1), (825, 1), (830, 1), (835, 1), (840, 0), (845, 0), (850, 1), (855, 1), (860, 1), (865, 0), (870, 1), (875, 1), (880, 1), (885, 1), (890, 1), (895, 1), (900, 1), (905, 1), (910, 1), (915, 0), (920, 0), (925, 0), (930, 0), (935, 0), (940, 0), (945, 0), (950, 0), (955, 0), (960, 0), (965, 0), (970, 0), (975, 0), (980, 0), (985, 0), (990, 0), (995, 0), (1000, 0), (1005, 0), (1010, 0), (1015, 0), (1020, 0), (1025, 0)]
Vdin0_53  din0_53  0 PWL (0n 0.0v 4.745n 0.0v 4.755n 1.0v 9.745n 1.0v 9.755n 0.0v 14.745n 0.0v 14.755n 0.0v 19.745n 0.0v 19.755n 0.0v 24.745n 0.0v 24.755n 0.0v 29.745n 0.0v 29.755n 0.0v 34.745n 0.0v 34.755n 0.0v 39.745n 0.0v 39.755n 0.0v 44.745n 0.0v 44.755n 0.0v 49.745n 0.0v 49.755n 1.0v 54.745n 1.0v 54.755n 1.0v 59.745n 1.0v 59.755n 1.0v 64.745n 1.0v 64.755n 0.0v 69.745n 0.0v 69.755n 0.0v 74.745n 0.0v 74.755n 0.0v 79.745n 0.0v 79.755n 0.0v 84.745n 0.0v 84.755n 0.0v 89.745n 0.0v 89.755n 0.0v 94.745n 0.0v 94.755n 0.0v 99.745n 0.0v 99.755n 1.0v 104.745n 1.0v 104.755n 0.0v 109.745n 0.0v 109.755n 0.0v 114.745n 0.0v 114.755n 1.0v 119.745n 1.0v 119.755n 1.0v 124.745n 1.0v 124.755n 1.0v 129.745n 1.0v 129.755n 1.0v 134.745n 1.0v 134.755n 1.0v 139.745n 1.0v 139.755n 1.0v 144.745n 1.0v 144.755n 1.0v 149.745n 1.0v 149.755n 1.0v 154.745n 1.0v 154.755n 0.0v 159.745n 0.0v 159.755n 0.0v 164.745n 0.0v 164.755n 0.0v 169.745n 0.0v 169.755n 0.0v 174.745n 0.0v 174.755n 1.0v 179.745n 1.0v 179.755n 1.0v 184.745n 1.0v 184.755n 1.0v 189.745n 1.0v 189.755n 0.0v 194.745n 0.0v 194.755n 1.0v 199.745n 1.0v 199.755n 1.0v 204.745n 1.0v 204.755n 1.0v 209.745n 1.0v 209.755n 1.0v 214.745n 1.0v 214.755n 1.0v 219.745n 1.0v 219.755n 1.0v 224.745n 1.0v 224.755n 1.0v 229.745n 1.0v 229.755n 1.0v 234.745n 1.0v 234.755n 1.0v 239.745n 1.0v 239.755n 1.0v 244.745n 1.0v 244.755n 0.0v 249.745n 0.0v 249.755n 0.0v 254.745n 0.0v 254.755n 0.0v 259.745n 0.0v 259.755n 0.0v 264.745n 0.0v 264.755n 0.0v 269.745n 0.0v 269.755n 0.0v 274.745n 0.0v 274.755n 0.0v 279.745n 0.0v 279.755n 0.0v 284.745n 0.0v 284.755n 0.0v 289.745n 0.0v 289.755n 0.0v 294.745n 0.0v 294.755n 0.0v 299.745n 0.0v 299.755n 0.0v 304.745n 0.0v 304.755n 0.0v 309.745n 0.0v 309.755n 0.0v 314.745n 0.0v 314.755n 0.0v 319.745n 0.0v 319.755n 0.0v 324.745n 0.0v 324.755n 0.0v 329.745n 0.0v 329.755n 0.0v 334.745n 0.0v 334.755n 0.0v 339.745n 0.0v 339.755n 0.0v 344.745n 0.0v 344.755n 0.0v 349.745n 0.0v 349.755n 1.0v 354.745n 1.0v 354.755n 1.0v 359.745n 1.0v 359.755n 1.0v 364.745n 1.0v 364.755n 1.0v 369.745n 1.0v 369.755n 1.0v 374.745n 1.0v 374.755n 1.0v 379.745n 1.0v 379.755n 1.0v 384.745n 1.0v 384.755n 1.0v 389.745n 1.0v 389.755n 1.0v 394.745n 1.0v 394.755n 1.0v 399.745n 1.0v 399.755n 1.0v 404.745n 1.0v 404.755n 1.0v 409.745n 1.0v 409.755n 0.0v 414.745n 0.0v 414.755n 0.0v 419.745n 0.0v 419.755n 0.0v 424.745n 0.0v 424.755n 0.0v 429.745n 0.0v 429.755n 0.0v 434.745n 0.0v 434.755n 0.0v 439.745n 0.0v 439.755n 0.0v 444.745n 0.0v 444.755n 1.0v 449.745n 1.0v 449.755n 1.0v 454.745n 1.0v 454.755n 1.0v 459.745n 1.0v 459.755n 1.0v 464.745n 1.0v 464.755n 1.0v 469.745n 1.0v 469.755n 1.0v 474.745n 1.0v 474.755n 1.0v 479.745n 1.0v 479.755n 1.0v 484.745n 1.0v 484.755n 1.0v 489.745n 1.0v 489.755n 1.0v 494.745n 1.0v 494.755n 1.0v 499.745n 1.0v 499.755n 0.0v 504.745n 0.0v 504.755n 0.0v 509.745n 0.0v 509.755n 0.0v 514.745n 0.0v 514.755n 0.0v 519.745n 0.0v 519.755n 0.0v 524.745n 0.0v 524.755n 0.0v 529.745n 0.0v 529.755n 0.0v 534.745n 0.0v 534.755n 0.0v 539.745n 0.0v 539.755n 0.0v 544.745n 0.0v 544.755n 1.0v 549.745n 1.0v 549.755n 1.0v 554.745n 1.0v 554.755n 1.0v 559.745n 1.0v 559.755n 1.0v 564.745n 1.0v 564.755n 1.0v 569.745n 1.0v 569.755n 1.0v 574.745n 1.0v 574.755n 1.0v 579.745n 1.0v 579.755n 1.0v 584.745n 1.0v 584.755n 1.0v 589.745n 1.0v 589.755n 1.0v 594.745n 1.0v 594.755n 1.0v 599.745n 1.0v 599.755n 1.0v 604.745n 1.0v 604.755n 1.0v 609.745n 1.0v 609.755n 1.0v 614.745n 1.0v 614.755n 1.0v 619.745n 1.0v 619.755n 1.0v 624.745n 1.0v 624.755n 1.0v 629.745n 1.0v 629.755n 1.0v 634.745n 1.0v 634.755n 0.0v 639.745n 0.0v 639.755n 0.0v 644.745n 0.0v 644.755n 0.0v 649.745n 0.0v 649.755n 1.0v 654.745n 1.0v 654.755n 1.0v 659.745n 1.0v 659.755n 1.0v 664.745n 1.0v 664.755n 1.0v 669.745n 1.0v 669.755n 0.0v 674.745n 0.0v 674.755n 0.0v 679.745n 0.0v 679.755n 0.0v 684.745n 0.0v 684.755n 0.0v 689.745n 0.0v 689.755n 0.0v 694.745n 0.0v 694.755n 0.0v 699.745n 0.0v 699.755n 0.0v 704.745n 0.0v 704.755n 0.0v 709.745n 0.0v 709.755n 0.0v 714.745n 0.0v 714.755n 0.0v 719.745n 0.0v 719.755n 0.0v 724.745n 0.0v 724.755n 0.0v 729.745n 0.0v 729.755n 0.0v 734.745n 0.0v 734.755n 0.0v 739.745n 0.0v 739.755n 1.0v 744.745n 1.0v 744.755n 1.0v 749.745n 1.0v 749.755n 1.0v 754.745n 1.0v 754.755n 1.0v 759.745n 1.0v 759.755n 1.0v 764.745n 1.0v 764.755n 1.0v 769.745n 1.0v 769.755n 0.0v 774.745n 0.0v 774.755n 0.0v 779.745n 0.0v 779.755n 1.0v 784.745n 1.0v 784.755n 1.0v 789.745n 1.0v 789.755n 1.0v 794.745n 1.0v 794.755n 1.0v 799.745n 1.0v 799.755n 1.0v 804.745n 1.0v 804.755n 0.0v 809.745n 0.0v 809.755n 1.0v 814.745n 1.0v 814.755n 1.0v 819.745n 1.0v 819.755n 1.0v 824.745n 1.0v 824.755n 1.0v 829.745n 1.0v 829.755n 1.0v 834.745n 1.0v 834.755n 1.0v 839.745n 1.0v 839.755n 0.0v 844.745n 0.0v 844.755n 0.0v 849.745n 0.0v 849.755n 1.0v 854.745n 1.0v 854.755n 1.0v 859.745n 1.0v 859.755n 1.0v 864.745n 1.0v 864.755n 0.0v 869.745n 0.0v 869.755n 1.0v 874.745n 1.0v 874.755n 1.0v 879.745n 1.0v 879.755n 1.0v 884.745n 1.0v 884.755n 1.0v 889.745n 1.0v 889.755n 1.0v 894.745n 1.0v 894.755n 1.0v 899.745n 1.0v 899.755n 1.0v 904.745n 1.0v 904.755n 1.0v 909.745n 1.0v 909.755n 1.0v 914.745n 1.0v 914.755n 0.0v 919.745n 0.0v 919.755n 0.0v 924.745n 0.0v 924.755n 0.0v 929.745n 0.0v 929.755n 0.0v 934.745n 0.0v 934.755n 0.0v 939.745n 0.0v 939.755n 0.0v 944.745n 0.0v 944.755n 0.0v 949.745n 0.0v 949.755n 0.0v 954.745n 0.0v 954.755n 0.0v 959.745n 0.0v 959.755n 0.0v 964.745n 0.0v 964.755n 0.0v 969.745n 0.0v 969.755n 0.0v 974.745n 0.0v 974.755n 0.0v 979.745n 0.0v 979.755n 0.0v 984.745n 0.0v 984.755n 0.0v 989.745n 0.0v 989.755n 0.0v 994.745n 0.0v 994.755n 0.0v 999.745n 0.0v 999.755n 0.0v 1004.745n 0.0v 1004.755n 0.0v 1009.745n 0.0v 1009.755n 0.0v 1014.745n 0.0v 1014.755n 0.0v 1019.745n 0.0v 1019.755n 0.0v 1024.745n 0.0v 1024.755n 0.0v )
* (time, data): [(0, 0), (5, 0), (10, 0), (15, 1), (20, 1), (25, 1), (30, 1), (35, 1), (40, 0), (45, 0), (50, 0), (55, 0), (60, 0), (65, 0), (70, 0), (75, 0), (80, 0), (85, 0), (90, 0), (95, 0), (100, 1), (105, 0), (110, 0), (115, 0), (120, 0), (125, 0), (130, 0), (135, 0), (140, 0), (145, 0), (150, 0), (155, 1), (160, 1), (165, 1), (170, 1), (175, 1), (180, 1), (185, 1), (190, 0), (195, 1), (200, 1), (205, 1), (210, 1), (215, 1), (220, 1), (225, 1), (230, 1), (235, 1), (240, 1), (245, 0), (250, 0), (255, 0), (260, 0), (265, 0), (270, 0), (275, 0), (280, 0), (285, 0), (290, 1), (295, 1), (300, 1), (305, 1), (310, 1), (315, 1), (320, 1), (325, 1), (330, 1), (335, 1), (340, 1), (345, 1), (350, 0), (355, 0), (360, 0), (365, 0), (370, 0), (375, 0), (380, 0), (385, 0), (390, 0), (395, 0), (400, 0), (405, 0), (410, 0), (415, 0), (420, 0), (425, 0), (430, 0), (435, 0), (440, 0), (445, 1), (450, 1), (455, 1), (460, 1), (465, 1), (470, 1), (475, 1), (480, 1), (485, 0), (490, 0), (495, 0), (500, 1), (505, 1), (510, 1), (515, 0), (520, 0), (525, 0), (530, 0), (535, 1), (540, 0), (545, 0), (550, 1), (555, 1), (560, 1), (565, 1), (570, 1), (575, 1), (580, 1), (585, 1), (590, 1), (595, 1), (600, 1), (605, 1), (610, 0), (615, 0), (620, 0), (625, 0), (630, 0), (635, 0), (640, 0), (645, 0), (650, 1), (655, 0), (660, 0), (665, 0), (670, 1), (675, 1), (680, 1), (685, 1), (690, 1), (695, 1), (700, 1), (705, 1), (710, 1), (715, 1), (720, 1), (725, 1), (730, 1), (735, 1), (740, 1), (745, 1), (750, 1), (755, 1), (760, 1), (765, 1), (770, 0), (775, 0), (780, 0), (785, 0), (790, 0), (795, 0), (800, 0), (805, 1), (810, 1), (815, 1), (820, 1), (825, 1), (830, 1), (835, 1), (840, 1), (845, 1), (850, 1), (855, 0), (860, 0), (865, 1), (870, 1), (875, 1), (880, 1), (885, 1), (890, 1), (895, 1), (900, 1), (905, 1), (910, 0), (915, 1), (920, 1), (925, 1), (930, 1), (935, 1), (940, 1), (945, 1), (950, 1), (955, 1), (960, 1), (965, 0), (970, 0), (975, 0), (980, 0), (985, 0), (990, 0), (995, 0), (1000, 0), (1005, 0), (1010, 0), (1015, 0), (1020, 0), (1025, 0)]
Vdin0_54  din0_54  0 PWL (0n 0.0v 4.745n 0.0v 4.755n 0.0v 9.745n 0.0v 9.755n 0.0v 14.745n 0.0v 14.755n 1.0v 19.745n 1.0v 19.755n 1.0v 24.745n 1.0v 24.755n 1.0v 29.745n 1.0v 29.755n 1.0v 34.745n 1.0v 34.755n 1.0v 39.745n 1.0v 39.755n 0.0v 44.745n 0.0v 44.755n 0.0v 49.745n 0.0v 49.755n 0.0v 54.745n 0.0v 54.755n 0.0v 59.745n 0.0v 59.755n 0.0v 64.745n 0.0v 64.755n 0.0v 69.745n 0.0v 69.755n 0.0v 74.745n 0.0v 74.755n 0.0v 79.745n 0.0v 79.755n 0.0v 84.745n 0.0v 84.755n 0.0v 89.745n 0.0v 89.755n 0.0v 94.745n 0.0v 94.755n 0.0v 99.745n 0.0v 99.755n 1.0v 104.745n 1.0v 104.755n 0.0v 109.745n 0.0v 109.755n 0.0v 114.745n 0.0v 114.755n 0.0v 119.745n 0.0v 119.755n 0.0v 124.745n 0.0v 124.755n 0.0v 129.745n 0.0v 129.755n 0.0v 134.745n 0.0v 134.755n 0.0v 139.745n 0.0v 139.755n 0.0v 144.745n 0.0v 144.755n 0.0v 149.745n 0.0v 149.755n 0.0v 154.745n 0.0v 154.755n 1.0v 159.745n 1.0v 159.755n 1.0v 164.745n 1.0v 164.755n 1.0v 169.745n 1.0v 169.755n 1.0v 174.745n 1.0v 174.755n 1.0v 179.745n 1.0v 179.755n 1.0v 184.745n 1.0v 184.755n 1.0v 189.745n 1.0v 189.755n 0.0v 194.745n 0.0v 194.755n 1.0v 199.745n 1.0v 199.755n 1.0v 204.745n 1.0v 204.755n 1.0v 209.745n 1.0v 209.755n 1.0v 214.745n 1.0v 214.755n 1.0v 219.745n 1.0v 219.755n 1.0v 224.745n 1.0v 224.755n 1.0v 229.745n 1.0v 229.755n 1.0v 234.745n 1.0v 234.755n 1.0v 239.745n 1.0v 239.755n 1.0v 244.745n 1.0v 244.755n 0.0v 249.745n 0.0v 249.755n 0.0v 254.745n 0.0v 254.755n 0.0v 259.745n 0.0v 259.755n 0.0v 264.745n 0.0v 264.755n 0.0v 269.745n 0.0v 269.755n 0.0v 274.745n 0.0v 274.755n 0.0v 279.745n 0.0v 279.755n 0.0v 284.745n 0.0v 284.755n 0.0v 289.745n 0.0v 289.755n 1.0v 294.745n 1.0v 294.755n 1.0v 299.745n 1.0v 299.755n 1.0v 304.745n 1.0v 304.755n 1.0v 309.745n 1.0v 309.755n 1.0v 314.745n 1.0v 314.755n 1.0v 319.745n 1.0v 319.755n 1.0v 324.745n 1.0v 324.755n 1.0v 329.745n 1.0v 329.755n 1.0v 334.745n 1.0v 334.755n 1.0v 339.745n 1.0v 339.755n 1.0v 344.745n 1.0v 344.755n 1.0v 349.745n 1.0v 349.755n 0.0v 354.745n 0.0v 354.755n 0.0v 359.745n 0.0v 359.755n 0.0v 364.745n 0.0v 364.755n 0.0v 369.745n 0.0v 369.755n 0.0v 374.745n 0.0v 374.755n 0.0v 379.745n 0.0v 379.755n 0.0v 384.745n 0.0v 384.755n 0.0v 389.745n 0.0v 389.755n 0.0v 394.745n 0.0v 394.755n 0.0v 399.745n 0.0v 399.755n 0.0v 404.745n 0.0v 404.755n 0.0v 409.745n 0.0v 409.755n 0.0v 414.745n 0.0v 414.755n 0.0v 419.745n 0.0v 419.755n 0.0v 424.745n 0.0v 424.755n 0.0v 429.745n 0.0v 429.755n 0.0v 434.745n 0.0v 434.755n 0.0v 439.745n 0.0v 439.755n 0.0v 444.745n 0.0v 444.755n 1.0v 449.745n 1.0v 449.755n 1.0v 454.745n 1.0v 454.755n 1.0v 459.745n 1.0v 459.755n 1.0v 464.745n 1.0v 464.755n 1.0v 469.745n 1.0v 469.755n 1.0v 474.745n 1.0v 474.755n 1.0v 479.745n 1.0v 479.755n 1.0v 484.745n 1.0v 484.755n 0.0v 489.745n 0.0v 489.755n 0.0v 494.745n 0.0v 494.755n 0.0v 499.745n 0.0v 499.755n 1.0v 504.745n 1.0v 504.755n 1.0v 509.745n 1.0v 509.755n 1.0v 514.745n 1.0v 514.755n 0.0v 519.745n 0.0v 519.755n 0.0v 524.745n 0.0v 524.755n 0.0v 529.745n 0.0v 529.755n 0.0v 534.745n 0.0v 534.755n 1.0v 539.745n 1.0v 539.755n 0.0v 544.745n 0.0v 544.755n 0.0v 549.745n 0.0v 549.755n 1.0v 554.745n 1.0v 554.755n 1.0v 559.745n 1.0v 559.755n 1.0v 564.745n 1.0v 564.755n 1.0v 569.745n 1.0v 569.755n 1.0v 574.745n 1.0v 574.755n 1.0v 579.745n 1.0v 579.755n 1.0v 584.745n 1.0v 584.755n 1.0v 589.745n 1.0v 589.755n 1.0v 594.745n 1.0v 594.755n 1.0v 599.745n 1.0v 599.755n 1.0v 604.745n 1.0v 604.755n 1.0v 609.745n 1.0v 609.755n 0.0v 614.745n 0.0v 614.755n 0.0v 619.745n 0.0v 619.755n 0.0v 624.745n 0.0v 624.755n 0.0v 629.745n 0.0v 629.755n 0.0v 634.745n 0.0v 634.755n 0.0v 639.745n 0.0v 639.755n 0.0v 644.745n 0.0v 644.755n 0.0v 649.745n 0.0v 649.755n 1.0v 654.745n 1.0v 654.755n 0.0v 659.745n 0.0v 659.755n 0.0v 664.745n 0.0v 664.755n 0.0v 669.745n 0.0v 669.755n 1.0v 674.745n 1.0v 674.755n 1.0v 679.745n 1.0v 679.755n 1.0v 684.745n 1.0v 684.755n 1.0v 689.745n 1.0v 689.755n 1.0v 694.745n 1.0v 694.755n 1.0v 699.745n 1.0v 699.755n 1.0v 704.745n 1.0v 704.755n 1.0v 709.745n 1.0v 709.755n 1.0v 714.745n 1.0v 714.755n 1.0v 719.745n 1.0v 719.755n 1.0v 724.745n 1.0v 724.755n 1.0v 729.745n 1.0v 729.755n 1.0v 734.745n 1.0v 734.755n 1.0v 739.745n 1.0v 739.755n 1.0v 744.745n 1.0v 744.755n 1.0v 749.745n 1.0v 749.755n 1.0v 754.745n 1.0v 754.755n 1.0v 759.745n 1.0v 759.755n 1.0v 764.745n 1.0v 764.755n 1.0v 769.745n 1.0v 769.755n 0.0v 774.745n 0.0v 774.755n 0.0v 779.745n 0.0v 779.755n 0.0v 784.745n 0.0v 784.755n 0.0v 789.745n 0.0v 789.755n 0.0v 794.745n 0.0v 794.755n 0.0v 799.745n 0.0v 799.755n 0.0v 804.745n 0.0v 804.755n 1.0v 809.745n 1.0v 809.755n 1.0v 814.745n 1.0v 814.755n 1.0v 819.745n 1.0v 819.755n 1.0v 824.745n 1.0v 824.755n 1.0v 829.745n 1.0v 829.755n 1.0v 834.745n 1.0v 834.755n 1.0v 839.745n 1.0v 839.755n 1.0v 844.745n 1.0v 844.755n 1.0v 849.745n 1.0v 849.755n 1.0v 854.745n 1.0v 854.755n 0.0v 859.745n 0.0v 859.755n 0.0v 864.745n 0.0v 864.755n 1.0v 869.745n 1.0v 869.755n 1.0v 874.745n 1.0v 874.755n 1.0v 879.745n 1.0v 879.755n 1.0v 884.745n 1.0v 884.755n 1.0v 889.745n 1.0v 889.755n 1.0v 894.745n 1.0v 894.755n 1.0v 899.745n 1.0v 899.755n 1.0v 904.745n 1.0v 904.755n 1.0v 909.745n 1.0v 909.755n 0.0v 914.745n 0.0v 914.755n 1.0v 919.745n 1.0v 919.755n 1.0v 924.745n 1.0v 924.755n 1.0v 929.745n 1.0v 929.755n 1.0v 934.745n 1.0v 934.755n 1.0v 939.745n 1.0v 939.755n 1.0v 944.745n 1.0v 944.755n 1.0v 949.745n 1.0v 949.755n 1.0v 954.745n 1.0v 954.755n 1.0v 959.745n 1.0v 959.755n 1.0v 964.745n 1.0v 964.755n 0.0v 969.745n 0.0v 969.755n 0.0v 974.745n 0.0v 974.755n 0.0v 979.745n 0.0v 979.755n 0.0v 984.745n 0.0v 984.755n 0.0v 989.745n 0.0v 989.755n 0.0v 994.745n 0.0v 994.755n 0.0v 999.745n 0.0v 999.755n 0.0v 1004.745n 0.0v 1004.755n 0.0v 1009.745n 0.0v 1009.755n 0.0v 1014.745n 0.0v 1014.755n 0.0v 1019.745n 0.0v 1019.755n 0.0v 1024.745n 0.0v 1024.755n 0.0v )
* (time, data): [(0, 0), (5, 0), (10, 0), (15, 1), (20, 1), (25, 1), (30, 1), (35, 1), (40, 0), (45, 0), (50, 0), (55, 0), (60, 0), (65, 0), (70, 0), (75, 0), (80, 0), (85, 0), (90, 0), (95, 0), (100, 1), (105, 1), (110, 1), (115, 0), (120, 0), (125, 0), (130, 0), (135, 0), (140, 0), (145, 0), (150, 0), (155, 1), (160, 1), (165, 1), (170, 1), (175, 1), (180, 1), (185, 1), (190, 1), (195, 1), (200, 1), (205, 1), (210, 1), (215, 1), (220, 1), (225, 1), (230, 1), (235, 1), (240, 1), (245, 1), (250, 1), (255, 1), (260, 1), (265, 1), (270, 1), (275, 1), (280, 1), (285, 1), (290, 1), (295, 1), (300, 1), (305, 1), (310, 1), (315, 1), (320, 1), (325, 1), (330, 1), (335, 1), (340, 1), (345, 1), (350, 1), (355, 1), (360, 1), (365, 1), (370, 1), (375, 1), (380, 1), (385, 1), (390, 1), (395, 1), (400, 1), (405, 1), (410, 0), (415, 0), (420, 0), (425, 0), (430, 0), (435, 0), (440, 0), (445, 1), (450, 1), (455, 1), (460, 1), (465, 1), (470, 1), (475, 1), (480, 1), (485, 1), (490, 1), (495, 1), (500, 0), (505, 0), (510, 0), (515, 0), (520, 0), (525, 0), (530, 0), (535, 1), (540, 1), (545, 0), (550, 0), (555, 0), (560, 0), (565, 0), (570, 0), (575, 0), (580, 0), (585, 0), (590, 0), (595, 0), (600, 0), (605, 0), (610, 0), (615, 0), (620, 1), (625, 1), (630, 1), (635, 0), (640, 0), (645, 0), (650, 0), (655, 1), (660, 1), (665, 1), (670, 1), (675, 1), (680, 1), (685, 1), (690, 1), (695, 1), (700, 1), (705, 1), (710, 1), (715, 1), (720, 1), (725, 1), (730, 1), (735, 1), (740, 0), (745, 0), (750, 0), (755, 0), (760, 0), (765, 0), (770, 0), (775, 0), (780, 0), (785, 0), (790, 0), (795, 0), (800, 0), (805, 1), (810, 0), (815, 0), (820, 0), (825, 0), (830, 0), (835, 0), (840, 1), (845, 1), (850, 0), (855, 1), (860, 1), (865, 0), (870, 0), (875, 0), (880, 0), (885, 0), (890, 0), (895, 0), (900, 0), (905, 0), (910, 1), (915, 1), (920, 1), (925, 1), (930, 1), (935, 1), (940, 1), (945, 1), (950, 1), (955, 1), (960, 1), (965, 1), (970, 1), (975, 1), (980, 1), (985, 1), (990, 1), (995, 1), (1000, 1), (1005, 1), (1010, 1), (1015, 1), (1020, 0), (1025, 0)]
Vdin0_55  din0_55  0 PWL (0n 0.0v 4.745n 0.0v 4.755n 0.0v 9.745n 0.0v 9.755n 0.0v 14.745n 0.0v 14.755n 1.0v 19.745n 1.0v 19.755n 1.0v 24.745n 1.0v 24.755n 1.0v 29.745n 1.0v 29.755n 1.0v 34.745n 1.0v 34.755n 1.0v 39.745n 1.0v 39.755n 0.0v 44.745n 0.0v 44.755n 0.0v 49.745n 0.0v 49.755n 0.0v 54.745n 0.0v 54.755n 0.0v 59.745n 0.0v 59.755n 0.0v 64.745n 0.0v 64.755n 0.0v 69.745n 0.0v 69.755n 0.0v 74.745n 0.0v 74.755n 0.0v 79.745n 0.0v 79.755n 0.0v 84.745n 0.0v 84.755n 0.0v 89.745n 0.0v 89.755n 0.0v 94.745n 0.0v 94.755n 0.0v 99.745n 0.0v 99.755n 1.0v 104.745n 1.0v 104.755n 1.0v 109.745n 1.0v 109.755n 1.0v 114.745n 1.0v 114.755n 0.0v 119.745n 0.0v 119.755n 0.0v 124.745n 0.0v 124.755n 0.0v 129.745n 0.0v 129.755n 0.0v 134.745n 0.0v 134.755n 0.0v 139.745n 0.0v 139.755n 0.0v 144.745n 0.0v 144.755n 0.0v 149.745n 0.0v 149.755n 0.0v 154.745n 0.0v 154.755n 1.0v 159.745n 1.0v 159.755n 1.0v 164.745n 1.0v 164.755n 1.0v 169.745n 1.0v 169.755n 1.0v 174.745n 1.0v 174.755n 1.0v 179.745n 1.0v 179.755n 1.0v 184.745n 1.0v 184.755n 1.0v 189.745n 1.0v 189.755n 1.0v 194.745n 1.0v 194.755n 1.0v 199.745n 1.0v 199.755n 1.0v 204.745n 1.0v 204.755n 1.0v 209.745n 1.0v 209.755n 1.0v 214.745n 1.0v 214.755n 1.0v 219.745n 1.0v 219.755n 1.0v 224.745n 1.0v 224.755n 1.0v 229.745n 1.0v 229.755n 1.0v 234.745n 1.0v 234.755n 1.0v 239.745n 1.0v 239.755n 1.0v 244.745n 1.0v 244.755n 1.0v 249.745n 1.0v 249.755n 1.0v 254.745n 1.0v 254.755n 1.0v 259.745n 1.0v 259.755n 1.0v 264.745n 1.0v 264.755n 1.0v 269.745n 1.0v 269.755n 1.0v 274.745n 1.0v 274.755n 1.0v 279.745n 1.0v 279.755n 1.0v 284.745n 1.0v 284.755n 1.0v 289.745n 1.0v 289.755n 1.0v 294.745n 1.0v 294.755n 1.0v 299.745n 1.0v 299.755n 1.0v 304.745n 1.0v 304.755n 1.0v 309.745n 1.0v 309.755n 1.0v 314.745n 1.0v 314.755n 1.0v 319.745n 1.0v 319.755n 1.0v 324.745n 1.0v 324.755n 1.0v 329.745n 1.0v 329.755n 1.0v 334.745n 1.0v 334.755n 1.0v 339.745n 1.0v 339.755n 1.0v 344.745n 1.0v 344.755n 1.0v 349.745n 1.0v 349.755n 1.0v 354.745n 1.0v 354.755n 1.0v 359.745n 1.0v 359.755n 1.0v 364.745n 1.0v 364.755n 1.0v 369.745n 1.0v 369.755n 1.0v 374.745n 1.0v 374.755n 1.0v 379.745n 1.0v 379.755n 1.0v 384.745n 1.0v 384.755n 1.0v 389.745n 1.0v 389.755n 1.0v 394.745n 1.0v 394.755n 1.0v 399.745n 1.0v 399.755n 1.0v 404.745n 1.0v 404.755n 1.0v 409.745n 1.0v 409.755n 0.0v 414.745n 0.0v 414.755n 0.0v 419.745n 0.0v 419.755n 0.0v 424.745n 0.0v 424.755n 0.0v 429.745n 0.0v 429.755n 0.0v 434.745n 0.0v 434.755n 0.0v 439.745n 0.0v 439.755n 0.0v 444.745n 0.0v 444.755n 1.0v 449.745n 1.0v 449.755n 1.0v 454.745n 1.0v 454.755n 1.0v 459.745n 1.0v 459.755n 1.0v 464.745n 1.0v 464.755n 1.0v 469.745n 1.0v 469.755n 1.0v 474.745n 1.0v 474.755n 1.0v 479.745n 1.0v 479.755n 1.0v 484.745n 1.0v 484.755n 1.0v 489.745n 1.0v 489.755n 1.0v 494.745n 1.0v 494.755n 1.0v 499.745n 1.0v 499.755n 0.0v 504.745n 0.0v 504.755n 0.0v 509.745n 0.0v 509.755n 0.0v 514.745n 0.0v 514.755n 0.0v 519.745n 0.0v 519.755n 0.0v 524.745n 0.0v 524.755n 0.0v 529.745n 0.0v 529.755n 0.0v 534.745n 0.0v 534.755n 1.0v 539.745n 1.0v 539.755n 1.0v 544.745n 1.0v 544.755n 0.0v 549.745n 0.0v 549.755n 0.0v 554.745n 0.0v 554.755n 0.0v 559.745n 0.0v 559.755n 0.0v 564.745n 0.0v 564.755n 0.0v 569.745n 0.0v 569.755n 0.0v 574.745n 0.0v 574.755n 0.0v 579.745n 0.0v 579.755n 0.0v 584.745n 0.0v 584.755n 0.0v 589.745n 0.0v 589.755n 0.0v 594.745n 0.0v 594.755n 0.0v 599.745n 0.0v 599.755n 0.0v 604.745n 0.0v 604.755n 0.0v 609.745n 0.0v 609.755n 0.0v 614.745n 0.0v 614.755n 0.0v 619.745n 0.0v 619.755n 1.0v 624.745n 1.0v 624.755n 1.0v 629.745n 1.0v 629.755n 1.0v 634.745n 1.0v 634.755n 0.0v 639.745n 0.0v 639.755n 0.0v 644.745n 0.0v 644.755n 0.0v 649.745n 0.0v 649.755n 0.0v 654.745n 0.0v 654.755n 1.0v 659.745n 1.0v 659.755n 1.0v 664.745n 1.0v 664.755n 1.0v 669.745n 1.0v 669.755n 1.0v 674.745n 1.0v 674.755n 1.0v 679.745n 1.0v 679.755n 1.0v 684.745n 1.0v 684.755n 1.0v 689.745n 1.0v 689.755n 1.0v 694.745n 1.0v 694.755n 1.0v 699.745n 1.0v 699.755n 1.0v 704.745n 1.0v 704.755n 1.0v 709.745n 1.0v 709.755n 1.0v 714.745n 1.0v 714.755n 1.0v 719.745n 1.0v 719.755n 1.0v 724.745n 1.0v 724.755n 1.0v 729.745n 1.0v 729.755n 1.0v 734.745n 1.0v 734.755n 1.0v 739.745n 1.0v 739.755n 0.0v 744.745n 0.0v 744.755n 0.0v 749.745n 0.0v 749.755n 0.0v 754.745n 0.0v 754.755n 0.0v 759.745n 0.0v 759.755n 0.0v 764.745n 0.0v 764.755n 0.0v 769.745n 0.0v 769.755n 0.0v 774.745n 0.0v 774.755n 0.0v 779.745n 0.0v 779.755n 0.0v 784.745n 0.0v 784.755n 0.0v 789.745n 0.0v 789.755n 0.0v 794.745n 0.0v 794.755n 0.0v 799.745n 0.0v 799.755n 0.0v 804.745n 0.0v 804.755n 1.0v 809.745n 1.0v 809.755n 0.0v 814.745n 0.0v 814.755n 0.0v 819.745n 0.0v 819.755n 0.0v 824.745n 0.0v 824.755n 0.0v 829.745n 0.0v 829.755n 0.0v 834.745n 0.0v 834.755n 0.0v 839.745n 0.0v 839.755n 1.0v 844.745n 1.0v 844.755n 1.0v 849.745n 1.0v 849.755n 0.0v 854.745n 0.0v 854.755n 1.0v 859.745n 1.0v 859.755n 1.0v 864.745n 1.0v 864.755n 0.0v 869.745n 0.0v 869.755n 0.0v 874.745n 0.0v 874.755n 0.0v 879.745n 0.0v 879.755n 0.0v 884.745n 0.0v 884.755n 0.0v 889.745n 0.0v 889.755n 0.0v 894.745n 0.0v 894.755n 0.0v 899.745n 0.0v 899.755n 0.0v 904.745n 0.0v 904.755n 0.0v 909.745n 0.0v 909.755n 1.0v 914.745n 1.0v 914.755n 1.0v 919.745n 1.0v 919.755n 1.0v 924.745n 1.0v 924.755n 1.0v 929.745n 1.0v 929.755n 1.0v 934.745n 1.0v 934.755n 1.0v 939.745n 1.0v 939.755n 1.0v 944.745n 1.0v 944.755n 1.0v 949.745n 1.0v 949.755n 1.0v 954.745n 1.0v 954.755n 1.0v 959.745n 1.0v 959.755n 1.0v 964.745n 1.0v 964.755n 1.0v 969.745n 1.0v 969.755n 1.0v 974.745n 1.0v 974.755n 1.0v 979.745n 1.0v 979.755n 1.0v 984.745n 1.0v 984.755n 1.0v 989.745n 1.0v 989.755n 1.0v 994.745n 1.0v 994.755n 1.0v 999.745n 1.0v 999.755n 1.0v 1004.745n 1.0v 1004.755n 1.0v 1009.745n 1.0v 1009.755n 1.0v 1014.745n 1.0v 1014.755n 1.0v 1019.745n 1.0v 1019.755n 0.0v 1024.745n 0.0v 1024.755n 0.0v )
* (time, data): [(0, 0), (5, 1), (10, 1), (15, 1), (20, 1), (25, 1), (30, 1), (35, 1), (40, 1), (45, 1), (50, 1), (55, 1), (60, 1), (65, 0), (70, 0), (75, 0), (80, 0), (85, 1), (90, 1), (95, 1), (100, 0), (105, 1), (110, 1), (115, 1), (120, 1), (125, 1), (130, 1), (135, 1), (140, 1), (145, 1), (150, 1), (155, 1), (160, 1), (165, 1), (170, 1), (175, 1), (180, 1), (185, 1), (190, 1), (195, 0), (200, 0), (205, 0), (210, 0), (215, 0), (220, 0), (225, 0), (230, 0), (235, 0), (240, 0), (245, 1), (250, 1), (255, 1), (260, 1), (265, 1), (270, 1), (275, 1), (280, 1), (285, 1), (290, 0), (295, 0), (300, 0), (305, 0), (310, 0), (315, 0), (320, 0), (325, 0), (330, 0), (335, 0), (340, 0), (345, 0), (350, 0), (355, 0), (360, 0), (365, 0), (370, 0), (375, 0), (380, 0), (385, 0), (390, 0), (395, 0), (400, 0), (405, 0), (410, 1), (415, 1), (420, 1), (425, 1), (430, 1), (435, 1), (440, 1), (445, 1), (450, 1), (455, 1), (460, 1), (465, 1), (470, 1), (475, 1), (480, 1), (485, 1), (490, 1), (495, 1), (500, 0), (505, 0), (510, 0), (515, 1), (520, 1), (525, 1), (530, 1), (535, 1), (540, 0), (545, 1), (550, 1), (555, 1), (560, 1), (565, 1), (570, 1), (575, 1), (580, 1), (585, 1), (590, 1), (595, 1), (600, 1), (605, 1), (610, 0), (615, 0), (620, 0), (625, 0), (630, 0), (635, 1), (640, 1), (645, 1), (650, 0), (655, 0), (660, 0), (665, 0), (670, 0), (675, 0), (680, 0), (685, 0), (690, 0), (695, 0), (700, 0), (705, 0), (710, 0), (715, 0), (720, 0), (725, 0), (730, 0), (735, 0), (740, 0), (745, 0), (750, 0), (755, 0), (760, 0), (765, 0), (770, 1), (775, 1), (780, 1), (785, 1), (790, 1), (795, 1), (800, 1), (805, 0), (810, 1), (815, 1), (820, 1), (825, 1), (830, 1), (835, 1), (840, 1), (845, 1), (850, 0), (855, 0), (860, 0), (865, 0), (870, 0), (875, 0), (880, 0), (885, 0), (890, 0), (895, 0), (900, 0), (905, 0), (910, 1), (915, 1), (920, 1), (925, 1), (930, 1), (935, 1), (940, 1), (945, 1), (950, 1), (955, 1), (960, 1), (965, 1), (970, 1), (975, 1), (980, 1), (985, 1), (990, 1), (995, 1), (1000, 1), (1005, 1), (1010, 1), (1015, 1), (1020, 1), (1025, 1)]
Vdin0_56  din0_56  0 PWL (0n 0.0v 4.745n 0.0v 4.755n 1.0v 9.745n 1.0v 9.755n 1.0v 14.745n 1.0v 14.755n 1.0v 19.745n 1.0v 19.755n 1.0v 24.745n 1.0v 24.755n 1.0v 29.745n 1.0v 29.755n 1.0v 34.745n 1.0v 34.755n 1.0v 39.745n 1.0v 39.755n 1.0v 44.745n 1.0v 44.755n 1.0v 49.745n 1.0v 49.755n 1.0v 54.745n 1.0v 54.755n 1.0v 59.745n 1.0v 59.755n 1.0v 64.745n 1.0v 64.755n 0.0v 69.745n 0.0v 69.755n 0.0v 74.745n 0.0v 74.755n 0.0v 79.745n 0.0v 79.755n 0.0v 84.745n 0.0v 84.755n 1.0v 89.745n 1.0v 89.755n 1.0v 94.745n 1.0v 94.755n 1.0v 99.745n 1.0v 99.755n 0.0v 104.745n 0.0v 104.755n 1.0v 109.745n 1.0v 109.755n 1.0v 114.745n 1.0v 114.755n 1.0v 119.745n 1.0v 119.755n 1.0v 124.745n 1.0v 124.755n 1.0v 129.745n 1.0v 129.755n 1.0v 134.745n 1.0v 134.755n 1.0v 139.745n 1.0v 139.755n 1.0v 144.745n 1.0v 144.755n 1.0v 149.745n 1.0v 149.755n 1.0v 154.745n 1.0v 154.755n 1.0v 159.745n 1.0v 159.755n 1.0v 164.745n 1.0v 164.755n 1.0v 169.745n 1.0v 169.755n 1.0v 174.745n 1.0v 174.755n 1.0v 179.745n 1.0v 179.755n 1.0v 184.745n 1.0v 184.755n 1.0v 189.745n 1.0v 189.755n 1.0v 194.745n 1.0v 194.755n 0.0v 199.745n 0.0v 199.755n 0.0v 204.745n 0.0v 204.755n 0.0v 209.745n 0.0v 209.755n 0.0v 214.745n 0.0v 214.755n 0.0v 219.745n 0.0v 219.755n 0.0v 224.745n 0.0v 224.755n 0.0v 229.745n 0.0v 229.755n 0.0v 234.745n 0.0v 234.755n 0.0v 239.745n 0.0v 239.755n 0.0v 244.745n 0.0v 244.755n 1.0v 249.745n 1.0v 249.755n 1.0v 254.745n 1.0v 254.755n 1.0v 259.745n 1.0v 259.755n 1.0v 264.745n 1.0v 264.755n 1.0v 269.745n 1.0v 269.755n 1.0v 274.745n 1.0v 274.755n 1.0v 279.745n 1.0v 279.755n 1.0v 284.745n 1.0v 284.755n 1.0v 289.745n 1.0v 289.755n 0.0v 294.745n 0.0v 294.755n 0.0v 299.745n 0.0v 299.755n 0.0v 304.745n 0.0v 304.755n 0.0v 309.745n 0.0v 309.755n 0.0v 314.745n 0.0v 314.755n 0.0v 319.745n 0.0v 319.755n 0.0v 324.745n 0.0v 324.755n 0.0v 329.745n 0.0v 329.755n 0.0v 334.745n 0.0v 334.755n 0.0v 339.745n 0.0v 339.755n 0.0v 344.745n 0.0v 344.755n 0.0v 349.745n 0.0v 349.755n 0.0v 354.745n 0.0v 354.755n 0.0v 359.745n 0.0v 359.755n 0.0v 364.745n 0.0v 364.755n 0.0v 369.745n 0.0v 369.755n 0.0v 374.745n 0.0v 374.755n 0.0v 379.745n 0.0v 379.755n 0.0v 384.745n 0.0v 384.755n 0.0v 389.745n 0.0v 389.755n 0.0v 394.745n 0.0v 394.755n 0.0v 399.745n 0.0v 399.755n 0.0v 404.745n 0.0v 404.755n 0.0v 409.745n 0.0v 409.755n 1.0v 414.745n 1.0v 414.755n 1.0v 419.745n 1.0v 419.755n 1.0v 424.745n 1.0v 424.755n 1.0v 429.745n 1.0v 429.755n 1.0v 434.745n 1.0v 434.755n 1.0v 439.745n 1.0v 439.755n 1.0v 444.745n 1.0v 444.755n 1.0v 449.745n 1.0v 449.755n 1.0v 454.745n 1.0v 454.755n 1.0v 459.745n 1.0v 459.755n 1.0v 464.745n 1.0v 464.755n 1.0v 469.745n 1.0v 469.755n 1.0v 474.745n 1.0v 474.755n 1.0v 479.745n 1.0v 479.755n 1.0v 484.745n 1.0v 484.755n 1.0v 489.745n 1.0v 489.755n 1.0v 494.745n 1.0v 494.755n 1.0v 499.745n 1.0v 499.755n 0.0v 504.745n 0.0v 504.755n 0.0v 509.745n 0.0v 509.755n 0.0v 514.745n 0.0v 514.755n 1.0v 519.745n 1.0v 519.755n 1.0v 524.745n 1.0v 524.755n 1.0v 529.745n 1.0v 529.755n 1.0v 534.745n 1.0v 534.755n 1.0v 539.745n 1.0v 539.755n 0.0v 544.745n 0.0v 544.755n 1.0v 549.745n 1.0v 549.755n 1.0v 554.745n 1.0v 554.755n 1.0v 559.745n 1.0v 559.755n 1.0v 564.745n 1.0v 564.755n 1.0v 569.745n 1.0v 569.755n 1.0v 574.745n 1.0v 574.755n 1.0v 579.745n 1.0v 579.755n 1.0v 584.745n 1.0v 584.755n 1.0v 589.745n 1.0v 589.755n 1.0v 594.745n 1.0v 594.755n 1.0v 599.745n 1.0v 599.755n 1.0v 604.745n 1.0v 604.755n 1.0v 609.745n 1.0v 609.755n 0.0v 614.745n 0.0v 614.755n 0.0v 619.745n 0.0v 619.755n 0.0v 624.745n 0.0v 624.755n 0.0v 629.745n 0.0v 629.755n 0.0v 634.745n 0.0v 634.755n 1.0v 639.745n 1.0v 639.755n 1.0v 644.745n 1.0v 644.755n 1.0v 649.745n 1.0v 649.755n 0.0v 654.745n 0.0v 654.755n 0.0v 659.745n 0.0v 659.755n 0.0v 664.745n 0.0v 664.755n 0.0v 669.745n 0.0v 669.755n 0.0v 674.745n 0.0v 674.755n 0.0v 679.745n 0.0v 679.755n 0.0v 684.745n 0.0v 684.755n 0.0v 689.745n 0.0v 689.755n 0.0v 694.745n 0.0v 694.755n 0.0v 699.745n 0.0v 699.755n 0.0v 704.745n 0.0v 704.755n 0.0v 709.745n 0.0v 709.755n 0.0v 714.745n 0.0v 714.755n 0.0v 719.745n 0.0v 719.755n 0.0v 724.745n 0.0v 724.755n 0.0v 729.745n 0.0v 729.755n 0.0v 734.745n 0.0v 734.755n 0.0v 739.745n 0.0v 739.755n 0.0v 744.745n 0.0v 744.755n 0.0v 749.745n 0.0v 749.755n 0.0v 754.745n 0.0v 754.755n 0.0v 759.745n 0.0v 759.755n 0.0v 764.745n 0.0v 764.755n 0.0v 769.745n 0.0v 769.755n 1.0v 774.745n 1.0v 774.755n 1.0v 779.745n 1.0v 779.755n 1.0v 784.745n 1.0v 784.755n 1.0v 789.745n 1.0v 789.755n 1.0v 794.745n 1.0v 794.755n 1.0v 799.745n 1.0v 799.755n 1.0v 804.745n 1.0v 804.755n 0.0v 809.745n 0.0v 809.755n 1.0v 814.745n 1.0v 814.755n 1.0v 819.745n 1.0v 819.755n 1.0v 824.745n 1.0v 824.755n 1.0v 829.745n 1.0v 829.755n 1.0v 834.745n 1.0v 834.755n 1.0v 839.745n 1.0v 839.755n 1.0v 844.745n 1.0v 844.755n 1.0v 849.745n 1.0v 849.755n 0.0v 854.745n 0.0v 854.755n 0.0v 859.745n 0.0v 859.755n 0.0v 864.745n 0.0v 864.755n 0.0v 869.745n 0.0v 869.755n 0.0v 874.745n 0.0v 874.755n 0.0v 879.745n 0.0v 879.755n 0.0v 884.745n 0.0v 884.755n 0.0v 889.745n 0.0v 889.755n 0.0v 894.745n 0.0v 894.755n 0.0v 899.745n 0.0v 899.755n 0.0v 904.745n 0.0v 904.755n 0.0v 909.745n 0.0v 909.755n 1.0v 914.745n 1.0v 914.755n 1.0v 919.745n 1.0v 919.755n 1.0v 924.745n 1.0v 924.755n 1.0v 929.745n 1.0v 929.755n 1.0v 934.745n 1.0v 934.755n 1.0v 939.745n 1.0v 939.755n 1.0v 944.745n 1.0v 944.755n 1.0v 949.745n 1.0v 949.755n 1.0v 954.745n 1.0v 954.755n 1.0v 959.745n 1.0v 959.755n 1.0v 964.745n 1.0v 964.755n 1.0v 969.745n 1.0v 969.755n 1.0v 974.745n 1.0v 974.755n 1.0v 979.745n 1.0v 979.755n 1.0v 984.745n 1.0v 984.755n 1.0v 989.745n 1.0v 989.755n 1.0v 994.745n 1.0v 994.755n 1.0v 999.745n 1.0v 999.755n 1.0v 1004.745n 1.0v 1004.755n 1.0v 1009.745n 1.0v 1009.755n 1.0v 1014.745n 1.0v 1014.755n 1.0v 1019.745n 1.0v 1019.755n 1.0v 1024.745n 1.0v 1024.755n 1.0v )
* (time, data): [(0, 0), (5, 0), (10, 1), (15, 1), (20, 1), (25, 1), (30, 0), (35, 0), (40, 0), (45, 0), (50, 1), (55, 1), (60, 1), (65, 0), (70, 0), (75, 0), (80, 0), (85, 0), (90, 0), (95, 0), (100, 0), (105, 1), (110, 1), (115, 0), (120, 0), (125, 0), (130, 0), (135, 0), (140, 0), (145, 0), (150, 0), (155, 1), (160, 1), (165, 1), (170, 1), (175, 1), (180, 1), (185, 1), (190, 0), (195, 0), (200, 0), (205, 0), (210, 0), (215, 0), (220, 0), (225, 0), (230, 0), (235, 0), (240, 0), (245, 1), (250, 1), (255, 1), (260, 1), (265, 1), (270, 1), (275, 1), (280, 1), (285, 1), (290, 1), (295, 1), (300, 1), (305, 1), (310, 1), (315, 1), (320, 1), (325, 1), (330, 1), (335, 1), (340, 1), (345, 1), (350, 1), (355, 1), (360, 1), (365, 1), (370, 1), (375, 1), (380, 1), (385, 1), (390, 1), (395, 1), (400, 1), (405, 1), (410, 0), (415, 0), (420, 0), (425, 0), (430, 0), (435, 0), (440, 0), (445, 0), (450, 0), (455, 0), (460, 0), (465, 0), (470, 0), (475, 0), (480, 0), (485, 0), (490, 0), (495, 0), (500, 1), (505, 1), (510, 1), (515, 1), (520, 1), (525, 1), (530, 1), (535, 1), (540, 0), (545, 1), (550, 1), (555, 1), (560, 0), (565, 0), (570, 0), (575, 0), (580, 0), (585, 0), (590, 0), (595, 0), (600, 1), (605, 1), (610, 1), (615, 1), (620, 1), (625, 1), (630, 1), (635, 1), (640, 1), (645, 1), (650, 0), (655, 1), (660, 1), (665, 1), (670, 1), (675, 1), (680, 1), (685, 1), (690, 1), (695, 1), (700, 1), (705, 1), (710, 1), (715, 1), (720, 1), (725, 1), (730, 1), (735, 1), (740, 1), (745, 1), (750, 1), (755, 1), (760, 1), (765, 1), (770, 0), (775, 0), (780, 1), (785, 1), (790, 1), (795, 1), (800, 1), (805, 1), (810, 0), (815, 0), (820, 0), (825, 0), (830, 0), (835, 0), (840, 0), (845, 0), (850, 1), (855, 1), (860, 1), (865, 0), (870, 1), (875, 1), (880, 1), (885, 1), (890, 1), (895, 1), (900, 1), (905, 1), (910, 0), (915, 0), (920, 0), (925, 0), (930, 1), (935, 1), (940, 1), (945, 1), (950, 1), (955, 1), (960, 1), (965, 0), (970, 0), (975, 0), (980, 0), (985, 0), (990, 0), (995, 0), (1000, 0), (1005, 0), (1010, 0), (1015, 0), (1020, 1), (1025, 1)]
Vdin0_57  din0_57  0 PWL (0n 0.0v 4.745n 0.0v 4.755n 0.0v 9.745n 0.0v 9.755n 1.0v 14.745n 1.0v 14.755n 1.0v 19.745n 1.0v 19.755n 1.0v 24.745n 1.0v 24.755n 1.0v 29.745n 1.0v 29.755n 0.0v 34.745n 0.0v 34.755n 0.0v 39.745n 0.0v 39.755n 0.0v 44.745n 0.0v 44.755n 0.0v 49.745n 0.0v 49.755n 1.0v 54.745n 1.0v 54.755n 1.0v 59.745n 1.0v 59.755n 1.0v 64.745n 1.0v 64.755n 0.0v 69.745n 0.0v 69.755n 0.0v 74.745n 0.0v 74.755n 0.0v 79.745n 0.0v 79.755n 0.0v 84.745n 0.0v 84.755n 0.0v 89.745n 0.0v 89.755n 0.0v 94.745n 0.0v 94.755n 0.0v 99.745n 0.0v 99.755n 0.0v 104.745n 0.0v 104.755n 1.0v 109.745n 1.0v 109.755n 1.0v 114.745n 1.0v 114.755n 0.0v 119.745n 0.0v 119.755n 0.0v 124.745n 0.0v 124.755n 0.0v 129.745n 0.0v 129.755n 0.0v 134.745n 0.0v 134.755n 0.0v 139.745n 0.0v 139.755n 0.0v 144.745n 0.0v 144.755n 0.0v 149.745n 0.0v 149.755n 0.0v 154.745n 0.0v 154.755n 1.0v 159.745n 1.0v 159.755n 1.0v 164.745n 1.0v 164.755n 1.0v 169.745n 1.0v 169.755n 1.0v 174.745n 1.0v 174.755n 1.0v 179.745n 1.0v 179.755n 1.0v 184.745n 1.0v 184.755n 1.0v 189.745n 1.0v 189.755n 0.0v 194.745n 0.0v 194.755n 0.0v 199.745n 0.0v 199.755n 0.0v 204.745n 0.0v 204.755n 0.0v 209.745n 0.0v 209.755n 0.0v 214.745n 0.0v 214.755n 0.0v 219.745n 0.0v 219.755n 0.0v 224.745n 0.0v 224.755n 0.0v 229.745n 0.0v 229.755n 0.0v 234.745n 0.0v 234.755n 0.0v 239.745n 0.0v 239.755n 0.0v 244.745n 0.0v 244.755n 1.0v 249.745n 1.0v 249.755n 1.0v 254.745n 1.0v 254.755n 1.0v 259.745n 1.0v 259.755n 1.0v 264.745n 1.0v 264.755n 1.0v 269.745n 1.0v 269.755n 1.0v 274.745n 1.0v 274.755n 1.0v 279.745n 1.0v 279.755n 1.0v 284.745n 1.0v 284.755n 1.0v 289.745n 1.0v 289.755n 1.0v 294.745n 1.0v 294.755n 1.0v 299.745n 1.0v 299.755n 1.0v 304.745n 1.0v 304.755n 1.0v 309.745n 1.0v 309.755n 1.0v 314.745n 1.0v 314.755n 1.0v 319.745n 1.0v 319.755n 1.0v 324.745n 1.0v 324.755n 1.0v 329.745n 1.0v 329.755n 1.0v 334.745n 1.0v 334.755n 1.0v 339.745n 1.0v 339.755n 1.0v 344.745n 1.0v 344.755n 1.0v 349.745n 1.0v 349.755n 1.0v 354.745n 1.0v 354.755n 1.0v 359.745n 1.0v 359.755n 1.0v 364.745n 1.0v 364.755n 1.0v 369.745n 1.0v 369.755n 1.0v 374.745n 1.0v 374.755n 1.0v 379.745n 1.0v 379.755n 1.0v 384.745n 1.0v 384.755n 1.0v 389.745n 1.0v 389.755n 1.0v 394.745n 1.0v 394.755n 1.0v 399.745n 1.0v 399.755n 1.0v 404.745n 1.0v 404.755n 1.0v 409.745n 1.0v 409.755n 0.0v 414.745n 0.0v 414.755n 0.0v 419.745n 0.0v 419.755n 0.0v 424.745n 0.0v 424.755n 0.0v 429.745n 0.0v 429.755n 0.0v 434.745n 0.0v 434.755n 0.0v 439.745n 0.0v 439.755n 0.0v 444.745n 0.0v 444.755n 0.0v 449.745n 0.0v 449.755n 0.0v 454.745n 0.0v 454.755n 0.0v 459.745n 0.0v 459.755n 0.0v 464.745n 0.0v 464.755n 0.0v 469.745n 0.0v 469.755n 0.0v 474.745n 0.0v 474.755n 0.0v 479.745n 0.0v 479.755n 0.0v 484.745n 0.0v 484.755n 0.0v 489.745n 0.0v 489.755n 0.0v 494.745n 0.0v 494.755n 0.0v 499.745n 0.0v 499.755n 1.0v 504.745n 1.0v 504.755n 1.0v 509.745n 1.0v 509.755n 1.0v 514.745n 1.0v 514.755n 1.0v 519.745n 1.0v 519.755n 1.0v 524.745n 1.0v 524.755n 1.0v 529.745n 1.0v 529.755n 1.0v 534.745n 1.0v 534.755n 1.0v 539.745n 1.0v 539.755n 0.0v 544.745n 0.0v 544.755n 1.0v 549.745n 1.0v 549.755n 1.0v 554.745n 1.0v 554.755n 1.0v 559.745n 1.0v 559.755n 0.0v 564.745n 0.0v 564.755n 0.0v 569.745n 0.0v 569.755n 0.0v 574.745n 0.0v 574.755n 0.0v 579.745n 0.0v 579.755n 0.0v 584.745n 0.0v 584.755n 0.0v 589.745n 0.0v 589.755n 0.0v 594.745n 0.0v 594.755n 0.0v 599.745n 0.0v 599.755n 1.0v 604.745n 1.0v 604.755n 1.0v 609.745n 1.0v 609.755n 1.0v 614.745n 1.0v 614.755n 1.0v 619.745n 1.0v 619.755n 1.0v 624.745n 1.0v 624.755n 1.0v 629.745n 1.0v 629.755n 1.0v 634.745n 1.0v 634.755n 1.0v 639.745n 1.0v 639.755n 1.0v 644.745n 1.0v 644.755n 1.0v 649.745n 1.0v 649.755n 0.0v 654.745n 0.0v 654.755n 1.0v 659.745n 1.0v 659.755n 1.0v 664.745n 1.0v 664.755n 1.0v 669.745n 1.0v 669.755n 1.0v 674.745n 1.0v 674.755n 1.0v 679.745n 1.0v 679.755n 1.0v 684.745n 1.0v 684.755n 1.0v 689.745n 1.0v 689.755n 1.0v 694.745n 1.0v 694.755n 1.0v 699.745n 1.0v 699.755n 1.0v 704.745n 1.0v 704.755n 1.0v 709.745n 1.0v 709.755n 1.0v 714.745n 1.0v 714.755n 1.0v 719.745n 1.0v 719.755n 1.0v 724.745n 1.0v 724.755n 1.0v 729.745n 1.0v 729.755n 1.0v 734.745n 1.0v 734.755n 1.0v 739.745n 1.0v 739.755n 1.0v 744.745n 1.0v 744.755n 1.0v 749.745n 1.0v 749.755n 1.0v 754.745n 1.0v 754.755n 1.0v 759.745n 1.0v 759.755n 1.0v 764.745n 1.0v 764.755n 1.0v 769.745n 1.0v 769.755n 0.0v 774.745n 0.0v 774.755n 0.0v 779.745n 0.0v 779.755n 1.0v 784.745n 1.0v 784.755n 1.0v 789.745n 1.0v 789.755n 1.0v 794.745n 1.0v 794.755n 1.0v 799.745n 1.0v 799.755n 1.0v 804.745n 1.0v 804.755n 1.0v 809.745n 1.0v 809.755n 0.0v 814.745n 0.0v 814.755n 0.0v 819.745n 0.0v 819.755n 0.0v 824.745n 0.0v 824.755n 0.0v 829.745n 0.0v 829.755n 0.0v 834.745n 0.0v 834.755n 0.0v 839.745n 0.0v 839.755n 0.0v 844.745n 0.0v 844.755n 0.0v 849.745n 0.0v 849.755n 1.0v 854.745n 1.0v 854.755n 1.0v 859.745n 1.0v 859.755n 1.0v 864.745n 1.0v 864.755n 0.0v 869.745n 0.0v 869.755n 1.0v 874.745n 1.0v 874.755n 1.0v 879.745n 1.0v 879.755n 1.0v 884.745n 1.0v 884.755n 1.0v 889.745n 1.0v 889.755n 1.0v 894.745n 1.0v 894.755n 1.0v 899.745n 1.0v 899.755n 1.0v 904.745n 1.0v 904.755n 1.0v 909.745n 1.0v 909.755n 0.0v 914.745n 0.0v 914.755n 0.0v 919.745n 0.0v 919.755n 0.0v 924.745n 0.0v 924.755n 0.0v 929.745n 0.0v 929.755n 1.0v 934.745n 1.0v 934.755n 1.0v 939.745n 1.0v 939.755n 1.0v 944.745n 1.0v 944.755n 1.0v 949.745n 1.0v 949.755n 1.0v 954.745n 1.0v 954.755n 1.0v 959.745n 1.0v 959.755n 1.0v 964.745n 1.0v 964.755n 0.0v 969.745n 0.0v 969.755n 0.0v 974.745n 0.0v 974.755n 0.0v 979.745n 0.0v 979.755n 0.0v 984.745n 0.0v 984.755n 0.0v 989.745n 0.0v 989.755n 0.0v 994.745n 0.0v 994.755n 0.0v 999.745n 0.0v 999.755n 0.0v 1004.745n 0.0v 1004.755n 0.0v 1009.745n 0.0v 1009.755n 0.0v 1014.745n 0.0v 1014.755n 0.0v 1019.745n 0.0v 1019.755n 1.0v 1024.745n 1.0v 1024.755n 1.0v )
* (time, data): [(0, 0), (5, 0), (10, 0), (15, 1), (20, 1), (25, 1), (30, 0), (35, 0), (40, 1), (45, 1), (50, 0), (55, 0), (60, 0), (65, 1), (70, 1), (75, 1), (80, 1), (85, 1), (90, 1), (95, 1), (100, 1), (105, 0), (110, 0), (115, 1), (120, 1), (125, 1), (130, 1), (135, 1), (140, 1), (145, 1), (150, 1), (155, 0), (160, 0), (165, 0), (170, 0), (175, 0), (180, 0), (185, 0), (190, 1), (195, 0), (200, 0), (205, 0), (210, 0), (215, 0), (220, 0), (225, 0), (230, 0), (235, 0), (240, 0), (245, 0), (250, 0), (255, 0), (260, 0), (265, 0), (270, 0), (275, 0), (280, 0), (285, 0), (290, 0), (295, 0), (300, 0), (305, 0), (310, 0), (315, 0), (320, 0), (325, 0), (330, 0), (335, 1), (340, 1), (345, 1), (350, 0), (355, 0), (360, 0), (365, 0), (370, 0), (375, 0), (380, 0), (385, 0), (390, 0), (395, 0), (400, 0), (405, 0), (410, 1), (415, 1), (420, 1), (425, 1), (430, 1), (435, 0), (440, 0), (445, 0), (450, 0), (455, 0), (460, 0), (465, 0), (470, 0), (475, 0), (480, 0), (485, 0), (490, 0), (495, 0), (500, 1), (505, 1), (510, 1), (515, 1), (520, 1), (525, 1), (530, 1), (535, 0), (540, 1), (545, 0), (550, 0), (555, 0), (560, 0), (565, 0), (570, 0), (575, 0), (580, 0), (585, 0), (590, 0), (595, 0), (600, 1), (605, 1), (610, 1), (615, 1), (620, 1), (625, 1), (630, 1), (635, 0), (640, 0), (645, 0), (650, 1), (655, 1), (660, 1), (665, 1), (670, 0), (675, 0), (680, 0), (685, 0), (690, 0), (695, 0), (700, 0), (705, 0), (710, 0), (715, 0), (720, 0), (725, 0), (730, 0), (735, 0), (740, 0), (745, 0), (750, 0), (755, 0), (760, 0), (765, 0), (770, 0), (775, 0), (780, 0), (785, 0), (790, 0), (795, 0), (800, 0), (805, 0), (810, 0), (815, 0), (820, 0), (825, 0), (830, 0), (835, 0), (840, 0), (845, 0), (850, 0), (855, 1), (860, 1), (865, 0), (870, 1), (875, 1), (880, 1), (885, 1), (890, 1), (895, 1), (900, 1), (905, 1), (910, 1), (915, 0), (920, 0), (925, 0), (930, 0), (935, 0), (940, 0), (945, 0), (950, 0), (955, 0), (960, 0), (965, 1), (970, 1), (975, 1), (980, 1), (985, 1), (990, 1), (995, 1), (1000, 1), (1005, 1), (1010, 1), (1015, 1), (1020, 1), (1025, 1)]
Vdin0_58  din0_58  0 PWL (0n 0.0v 4.745n 0.0v 4.755n 0.0v 9.745n 0.0v 9.755n 0.0v 14.745n 0.0v 14.755n 1.0v 19.745n 1.0v 19.755n 1.0v 24.745n 1.0v 24.755n 1.0v 29.745n 1.0v 29.755n 0.0v 34.745n 0.0v 34.755n 0.0v 39.745n 0.0v 39.755n 1.0v 44.745n 1.0v 44.755n 1.0v 49.745n 1.0v 49.755n 0.0v 54.745n 0.0v 54.755n 0.0v 59.745n 0.0v 59.755n 0.0v 64.745n 0.0v 64.755n 1.0v 69.745n 1.0v 69.755n 1.0v 74.745n 1.0v 74.755n 1.0v 79.745n 1.0v 79.755n 1.0v 84.745n 1.0v 84.755n 1.0v 89.745n 1.0v 89.755n 1.0v 94.745n 1.0v 94.755n 1.0v 99.745n 1.0v 99.755n 1.0v 104.745n 1.0v 104.755n 0.0v 109.745n 0.0v 109.755n 0.0v 114.745n 0.0v 114.755n 1.0v 119.745n 1.0v 119.755n 1.0v 124.745n 1.0v 124.755n 1.0v 129.745n 1.0v 129.755n 1.0v 134.745n 1.0v 134.755n 1.0v 139.745n 1.0v 139.755n 1.0v 144.745n 1.0v 144.755n 1.0v 149.745n 1.0v 149.755n 1.0v 154.745n 1.0v 154.755n 0.0v 159.745n 0.0v 159.755n 0.0v 164.745n 0.0v 164.755n 0.0v 169.745n 0.0v 169.755n 0.0v 174.745n 0.0v 174.755n 0.0v 179.745n 0.0v 179.755n 0.0v 184.745n 0.0v 184.755n 0.0v 189.745n 0.0v 189.755n 1.0v 194.745n 1.0v 194.755n 0.0v 199.745n 0.0v 199.755n 0.0v 204.745n 0.0v 204.755n 0.0v 209.745n 0.0v 209.755n 0.0v 214.745n 0.0v 214.755n 0.0v 219.745n 0.0v 219.755n 0.0v 224.745n 0.0v 224.755n 0.0v 229.745n 0.0v 229.755n 0.0v 234.745n 0.0v 234.755n 0.0v 239.745n 0.0v 239.755n 0.0v 244.745n 0.0v 244.755n 0.0v 249.745n 0.0v 249.755n 0.0v 254.745n 0.0v 254.755n 0.0v 259.745n 0.0v 259.755n 0.0v 264.745n 0.0v 264.755n 0.0v 269.745n 0.0v 269.755n 0.0v 274.745n 0.0v 274.755n 0.0v 279.745n 0.0v 279.755n 0.0v 284.745n 0.0v 284.755n 0.0v 289.745n 0.0v 289.755n 0.0v 294.745n 0.0v 294.755n 0.0v 299.745n 0.0v 299.755n 0.0v 304.745n 0.0v 304.755n 0.0v 309.745n 0.0v 309.755n 0.0v 314.745n 0.0v 314.755n 0.0v 319.745n 0.0v 319.755n 0.0v 324.745n 0.0v 324.755n 0.0v 329.745n 0.0v 329.755n 0.0v 334.745n 0.0v 334.755n 1.0v 339.745n 1.0v 339.755n 1.0v 344.745n 1.0v 344.755n 1.0v 349.745n 1.0v 349.755n 0.0v 354.745n 0.0v 354.755n 0.0v 359.745n 0.0v 359.755n 0.0v 364.745n 0.0v 364.755n 0.0v 369.745n 0.0v 369.755n 0.0v 374.745n 0.0v 374.755n 0.0v 379.745n 0.0v 379.755n 0.0v 384.745n 0.0v 384.755n 0.0v 389.745n 0.0v 389.755n 0.0v 394.745n 0.0v 394.755n 0.0v 399.745n 0.0v 399.755n 0.0v 404.745n 0.0v 404.755n 0.0v 409.745n 0.0v 409.755n 1.0v 414.745n 1.0v 414.755n 1.0v 419.745n 1.0v 419.755n 1.0v 424.745n 1.0v 424.755n 1.0v 429.745n 1.0v 429.755n 1.0v 434.745n 1.0v 434.755n 0.0v 439.745n 0.0v 439.755n 0.0v 444.745n 0.0v 444.755n 0.0v 449.745n 0.0v 449.755n 0.0v 454.745n 0.0v 454.755n 0.0v 459.745n 0.0v 459.755n 0.0v 464.745n 0.0v 464.755n 0.0v 469.745n 0.0v 469.755n 0.0v 474.745n 0.0v 474.755n 0.0v 479.745n 0.0v 479.755n 0.0v 484.745n 0.0v 484.755n 0.0v 489.745n 0.0v 489.755n 0.0v 494.745n 0.0v 494.755n 0.0v 499.745n 0.0v 499.755n 1.0v 504.745n 1.0v 504.755n 1.0v 509.745n 1.0v 509.755n 1.0v 514.745n 1.0v 514.755n 1.0v 519.745n 1.0v 519.755n 1.0v 524.745n 1.0v 524.755n 1.0v 529.745n 1.0v 529.755n 1.0v 534.745n 1.0v 534.755n 0.0v 539.745n 0.0v 539.755n 1.0v 544.745n 1.0v 544.755n 0.0v 549.745n 0.0v 549.755n 0.0v 554.745n 0.0v 554.755n 0.0v 559.745n 0.0v 559.755n 0.0v 564.745n 0.0v 564.755n 0.0v 569.745n 0.0v 569.755n 0.0v 574.745n 0.0v 574.755n 0.0v 579.745n 0.0v 579.755n 0.0v 584.745n 0.0v 584.755n 0.0v 589.745n 0.0v 589.755n 0.0v 594.745n 0.0v 594.755n 0.0v 599.745n 0.0v 599.755n 1.0v 604.745n 1.0v 604.755n 1.0v 609.745n 1.0v 609.755n 1.0v 614.745n 1.0v 614.755n 1.0v 619.745n 1.0v 619.755n 1.0v 624.745n 1.0v 624.755n 1.0v 629.745n 1.0v 629.755n 1.0v 634.745n 1.0v 634.755n 0.0v 639.745n 0.0v 639.755n 0.0v 644.745n 0.0v 644.755n 0.0v 649.745n 0.0v 649.755n 1.0v 654.745n 1.0v 654.755n 1.0v 659.745n 1.0v 659.755n 1.0v 664.745n 1.0v 664.755n 1.0v 669.745n 1.0v 669.755n 0.0v 674.745n 0.0v 674.755n 0.0v 679.745n 0.0v 679.755n 0.0v 684.745n 0.0v 684.755n 0.0v 689.745n 0.0v 689.755n 0.0v 694.745n 0.0v 694.755n 0.0v 699.745n 0.0v 699.755n 0.0v 704.745n 0.0v 704.755n 0.0v 709.745n 0.0v 709.755n 0.0v 714.745n 0.0v 714.755n 0.0v 719.745n 0.0v 719.755n 0.0v 724.745n 0.0v 724.755n 0.0v 729.745n 0.0v 729.755n 0.0v 734.745n 0.0v 734.755n 0.0v 739.745n 0.0v 739.755n 0.0v 744.745n 0.0v 744.755n 0.0v 749.745n 0.0v 749.755n 0.0v 754.745n 0.0v 754.755n 0.0v 759.745n 0.0v 759.755n 0.0v 764.745n 0.0v 764.755n 0.0v 769.745n 0.0v 769.755n 0.0v 774.745n 0.0v 774.755n 0.0v 779.745n 0.0v 779.755n 0.0v 784.745n 0.0v 784.755n 0.0v 789.745n 0.0v 789.755n 0.0v 794.745n 0.0v 794.755n 0.0v 799.745n 0.0v 799.755n 0.0v 804.745n 0.0v 804.755n 0.0v 809.745n 0.0v 809.755n 0.0v 814.745n 0.0v 814.755n 0.0v 819.745n 0.0v 819.755n 0.0v 824.745n 0.0v 824.755n 0.0v 829.745n 0.0v 829.755n 0.0v 834.745n 0.0v 834.755n 0.0v 839.745n 0.0v 839.755n 0.0v 844.745n 0.0v 844.755n 0.0v 849.745n 0.0v 849.755n 0.0v 854.745n 0.0v 854.755n 1.0v 859.745n 1.0v 859.755n 1.0v 864.745n 1.0v 864.755n 0.0v 869.745n 0.0v 869.755n 1.0v 874.745n 1.0v 874.755n 1.0v 879.745n 1.0v 879.755n 1.0v 884.745n 1.0v 884.755n 1.0v 889.745n 1.0v 889.755n 1.0v 894.745n 1.0v 894.755n 1.0v 899.745n 1.0v 899.755n 1.0v 904.745n 1.0v 904.755n 1.0v 909.745n 1.0v 909.755n 1.0v 914.745n 1.0v 914.755n 0.0v 919.745n 0.0v 919.755n 0.0v 924.745n 0.0v 924.755n 0.0v 929.745n 0.0v 929.755n 0.0v 934.745n 0.0v 934.755n 0.0v 939.745n 0.0v 939.755n 0.0v 944.745n 0.0v 944.755n 0.0v 949.745n 0.0v 949.755n 0.0v 954.745n 0.0v 954.755n 0.0v 959.745n 0.0v 959.755n 0.0v 964.745n 0.0v 964.755n 1.0v 969.745n 1.0v 969.755n 1.0v 974.745n 1.0v 974.755n 1.0v 979.745n 1.0v 979.755n 1.0v 984.745n 1.0v 984.755n 1.0v 989.745n 1.0v 989.755n 1.0v 994.745n 1.0v 994.755n 1.0v 999.745n 1.0v 999.755n 1.0v 1004.745n 1.0v 1004.755n 1.0v 1009.745n 1.0v 1009.755n 1.0v 1014.745n 1.0v 1014.755n 1.0v 1019.745n 1.0v 1019.755n 1.0v 1024.745n 1.0v 1024.755n 1.0v )
* (time, data): [(0, 0), (5, 0), (10, 1), (15, 1), (20, 1), (25, 1), (30, 0), (35, 0), (40, 1), (45, 1), (50, 0), (55, 0), (60, 0), (65, 0), (70, 0), (75, 0), (80, 0), (85, 1), (90, 1), (95, 1), (100, 0), (105, 1), (110, 1), (115, 0), (120, 0), (125, 0), (130, 0), (135, 0), (140, 0), (145, 0), (150, 0), (155, 0), (160, 0), (165, 0), (170, 0), (175, 1), (180, 1), (185, 1), (190, 0), (195, 0), (200, 0), (205, 0), (210, 0), (215, 0), (220, 0), (225, 0), (230, 0), (235, 0), (240, 0), (245, 0), (250, 0), (255, 0), (260, 0), (265, 0), (270, 0), (275, 0), (280, 0), (285, 0), (290, 0), (295, 0), (300, 0), (305, 0), (310, 0), (315, 0), (320, 0), (325, 0), (330, 0), (335, 1), (340, 1), (345, 1), (350, 0), (355, 0), (360, 0), (365, 0), (370, 0), (375, 0), (380, 0), (385, 0), (390, 0), (395, 0), (400, 0), (405, 0), (410, 1), (415, 1), (420, 1), (425, 1), (430, 1), (435, 0), (440, 0), (445, 0), (450, 0), (455, 0), (460, 0), (465, 0), (470, 0), (475, 0), (480, 0), (485, 1), (490, 1), (495, 1), (500, 0), (505, 0), (510, 0), (515, 1), (520, 1), (525, 1), (530, 1), (535, 0), (540, 1), (545, 1), (550, 0), (555, 0), (560, 0), (565, 0), (570, 0), (575, 0), (580, 0), (585, 0), (590, 0), (595, 0), (600, 0), (605, 0), (610, 1), (615, 1), (620, 0), (625, 0), (630, 0), (635, 0), (640, 0), (645, 0), (650, 0), (655, 0), (660, 0), (665, 0), (670, 0), (675, 0), (680, 0), (685, 0), (690, 0), (695, 0), (700, 0), (705, 0), (710, 0), (715, 0), (720, 0), (725, 0), (730, 0), (735, 0), (740, 0), (745, 0), (750, 0), (755, 0), (760, 0), (765, 0), (770, 1), (775, 1), (780, 0), (785, 0), (790, 0), (795, 0), (800, 0), (805, 0), (810, 0), (815, 0), (820, 0), (825, 0), (830, 0), (835, 0), (840, 1), (845, 1), (850, 1), (855, 1), (860, 1), (865, 0), (870, 1), (875, 1), (880, 1), (885, 1), (890, 1), (895, 1), (900, 1), (905, 1), (910, 1), (915, 0), (920, 0), (925, 0), (930, 0), (935, 0), (940, 0), (945, 0), (950, 0), (955, 0), (960, 0), (965, 1), (970, 1), (975, 1), (980, 1), (985, 1), (990, 1), (995, 1), (1000, 1), (1005, 1), (1010, 1), (1015, 1), (1020, 1), (1025, 1)]
Vdin0_59  din0_59  0 PWL (0n 0.0v 4.745n 0.0v 4.755n 0.0v 9.745n 0.0v 9.755n 1.0v 14.745n 1.0v 14.755n 1.0v 19.745n 1.0v 19.755n 1.0v 24.745n 1.0v 24.755n 1.0v 29.745n 1.0v 29.755n 0.0v 34.745n 0.0v 34.755n 0.0v 39.745n 0.0v 39.755n 1.0v 44.745n 1.0v 44.755n 1.0v 49.745n 1.0v 49.755n 0.0v 54.745n 0.0v 54.755n 0.0v 59.745n 0.0v 59.755n 0.0v 64.745n 0.0v 64.755n 0.0v 69.745n 0.0v 69.755n 0.0v 74.745n 0.0v 74.755n 0.0v 79.745n 0.0v 79.755n 0.0v 84.745n 0.0v 84.755n 1.0v 89.745n 1.0v 89.755n 1.0v 94.745n 1.0v 94.755n 1.0v 99.745n 1.0v 99.755n 0.0v 104.745n 0.0v 104.755n 1.0v 109.745n 1.0v 109.755n 1.0v 114.745n 1.0v 114.755n 0.0v 119.745n 0.0v 119.755n 0.0v 124.745n 0.0v 124.755n 0.0v 129.745n 0.0v 129.755n 0.0v 134.745n 0.0v 134.755n 0.0v 139.745n 0.0v 139.755n 0.0v 144.745n 0.0v 144.755n 0.0v 149.745n 0.0v 149.755n 0.0v 154.745n 0.0v 154.755n 0.0v 159.745n 0.0v 159.755n 0.0v 164.745n 0.0v 164.755n 0.0v 169.745n 0.0v 169.755n 0.0v 174.745n 0.0v 174.755n 1.0v 179.745n 1.0v 179.755n 1.0v 184.745n 1.0v 184.755n 1.0v 189.745n 1.0v 189.755n 0.0v 194.745n 0.0v 194.755n 0.0v 199.745n 0.0v 199.755n 0.0v 204.745n 0.0v 204.755n 0.0v 209.745n 0.0v 209.755n 0.0v 214.745n 0.0v 214.755n 0.0v 219.745n 0.0v 219.755n 0.0v 224.745n 0.0v 224.755n 0.0v 229.745n 0.0v 229.755n 0.0v 234.745n 0.0v 234.755n 0.0v 239.745n 0.0v 239.755n 0.0v 244.745n 0.0v 244.755n 0.0v 249.745n 0.0v 249.755n 0.0v 254.745n 0.0v 254.755n 0.0v 259.745n 0.0v 259.755n 0.0v 264.745n 0.0v 264.755n 0.0v 269.745n 0.0v 269.755n 0.0v 274.745n 0.0v 274.755n 0.0v 279.745n 0.0v 279.755n 0.0v 284.745n 0.0v 284.755n 0.0v 289.745n 0.0v 289.755n 0.0v 294.745n 0.0v 294.755n 0.0v 299.745n 0.0v 299.755n 0.0v 304.745n 0.0v 304.755n 0.0v 309.745n 0.0v 309.755n 0.0v 314.745n 0.0v 314.755n 0.0v 319.745n 0.0v 319.755n 0.0v 324.745n 0.0v 324.755n 0.0v 329.745n 0.0v 329.755n 0.0v 334.745n 0.0v 334.755n 1.0v 339.745n 1.0v 339.755n 1.0v 344.745n 1.0v 344.755n 1.0v 349.745n 1.0v 349.755n 0.0v 354.745n 0.0v 354.755n 0.0v 359.745n 0.0v 359.755n 0.0v 364.745n 0.0v 364.755n 0.0v 369.745n 0.0v 369.755n 0.0v 374.745n 0.0v 374.755n 0.0v 379.745n 0.0v 379.755n 0.0v 384.745n 0.0v 384.755n 0.0v 389.745n 0.0v 389.755n 0.0v 394.745n 0.0v 394.755n 0.0v 399.745n 0.0v 399.755n 0.0v 404.745n 0.0v 404.755n 0.0v 409.745n 0.0v 409.755n 1.0v 414.745n 1.0v 414.755n 1.0v 419.745n 1.0v 419.755n 1.0v 424.745n 1.0v 424.755n 1.0v 429.745n 1.0v 429.755n 1.0v 434.745n 1.0v 434.755n 0.0v 439.745n 0.0v 439.755n 0.0v 444.745n 0.0v 444.755n 0.0v 449.745n 0.0v 449.755n 0.0v 454.745n 0.0v 454.755n 0.0v 459.745n 0.0v 459.755n 0.0v 464.745n 0.0v 464.755n 0.0v 469.745n 0.0v 469.755n 0.0v 474.745n 0.0v 474.755n 0.0v 479.745n 0.0v 479.755n 0.0v 484.745n 0.0v 484.755n 1.0v 489.745n 1.0v 489.755n 1.0v 494.745n 1.0v 494.755n 1.0v 499.745n 1.0v 499.755n 0.0v 504.745n 0.0v 504.755n 0.0v 509.745n 0.0v 509.755n 0.0v 514.745n 0.0v 514.755n 1.0v 519.745n 1.0v 519.755n 1.0v 524.745n 1.0v 524.755n 1.0v 529.745n 1.0v 529.755n 1.0v 534.745n 1.0v 534.755n 0.0v 539.745n 0.0v 539.755n 1.0v 544.745n 1.0v 544.755n 1.0v 549.745n 1.0v 549.755n 0.0v 554.745n 0.0v 554.755n 0.0v 559.745n 0.0v 559.755n 0.0v 564.745n 0.0v 564.755n 0.0v 569.745n 0.0v 569.755n 0.0v 574.745n 0.0v 574.755n 0.0v 579.745n 0.0v 579.755n 0.0v 584.745n 0.0v 584.755n 0.0v 589.745n 0.0v 589.755n 0.0v 594.745n 0.0v 594.755n 0.0v 599.745n 0.0v 599.755n 0.0v 604.745n 0.0v 604.755n 0.0v 609.745n 0.0v 609.755n 1.0v 614.745n 1.0v 614.755n 1.0v 619.745n 1.0v 619.755n 0.0v 624.745n 0.0v 624.755n 0.0v 629.745n 0.0v 629.755n 0.0v 634.745n 0.0v 634.755n 0.0v 639.745n 0.0v 639.755n 0.0v 644.745n 0.0v 644.755n 0.0v 649.745n 0.0v 649.755n 0.0v 654.745n 0.0v 654.755n 0.0v 659.745n 0.0v 659.755n 0.0v 664.745n 0.0v 664.755n 0.0v 669.745n 0.0v 669.755n 0.0v 674.745n 0.0v 674.755n 0.0v 679.745n 0.0v 679.755n 0.0v 684.745n 0.0v 684.755n 0.0v 689.745n 0.0v 689.755n 0.0v 694.745n 0.0v 694.755n 0.0v 699.745n 0.0v 699.755n 0.0v 704.745n 0.0v 704.755n 0.0v 709.745n 0.0v 709.755n 0.0v 714.745n 0.0v 714.755n 0.0v 719.745n 0.0v 719.755n 0.0v 724.745n 0.0v 724.755n 0.0v 729.745n 0.0v 729.755n 0.0v 734.745n 0.0v 734.755n 0.0v 739.745n 0.0v 739.755n 0.0v 744.745n 0.0v 744.755n 0.0v 749.745n 0.0v 749.755n 0.0v 754.745n 0.0v 754.755n 0.0v 759.745n 0.0v 759.755n 0.0v 764.745n 0.0v 764.755n 0.0v 769.745n 0.0v 769.755n 1.0v 774.745n 1.0v 774.755n 1.0v 779.745n 1.0v 779.755n 0.0v 784.745n 0.0v 784.755n 0.0v 789.745n 0.0v 789.755n 0.0v 794.745n 0.0v 794.755n 0.0v 799.745n 0.0v 799.755n 0.0v 804.745n 0.0v 804.755n 0.0v 809.745n 0.0v 809.755n 0.0v 814.745n 0.0v 814.755n 0.0v 819.745n 0.0v 819.755n 0.0v 824.745n 0.0v 824.755n 0.0v 829.745n 0.0v 829.755n 0.0v 834.745n 0.0v 834.755n 0.0v 839.745n 0.0v 839.755n 1.0v 844.745n 1.0v 844.755n 1.0v 849.745n 1.0v 849.755n 1.0v 854.745n 1.0v 854.755n 1.0v 859.745n 1.0v 859.755n 1.0v 864.745n 1.0v 864.755n 0.0v 869.745n 0.0v 869.755n 1.0v 874.745n 1.0v 874.755n 1.0v 879.745n 1.0v 879.755n 1.0v 884.745n 1.0v 884.755n 1.0v 889.745n 1.0v 889.755n 1.0v 894.745n 1.0v 894.755n 1.0v 899.745n 1.0v 899.755n 1.0v 904.745n 1.0v 904.755n 1.0v 909.745n 1.0v 909.755n 1.0v 914.745n 1.0v 914.755n 0.0v 919.745n 0.0v 919.755n 0.0v 924.745n 0.0v 924.755n 0.0v 929.745n 0.0v 929.755n 0.0v 934.745n 0.0v 934.755n 0.0v 939.745n 0.0v 939.755n 0.0v 944.745n 0.0v 944.755n 0.0v 949.745n 0.0v 949.755n 0.0v 954.745n 0.0v 954.755n 0.0v 959.745n 0.0v 959.755n 0.0v 964.745n 0.0v 964.755n 1.0v 969.745n 1.0v 969.755n 1.0v 974.745n 1.0v 974.755n 1.0v 979.745n 1.0v 979.755n 1.0v 984.745n 1.0v 984.755n 1.0v 989.745n 1.0v 989.755n 1.0v 994.745n 1.0v 994.755n 1.0v 999.745n 1.0v 999.755n 1.0v 1004.745n 1.0v 1004.755n 1.0v 1009.745n 1.0v 1009.755n 1.0v 1014.745n 1.0v 1014.755n 1.0v 1019.745n 1.0v 1019.755n 1.0v 1024.745n 1.0v 1024.755n 1.0v )
* (time, data): [(0, 0), (5, 1), (10, 0), (15, 1), (20, 1), (25, 1), (30, 0), (35, 0), (40, 0), (45, 0), (50, 0), (55, 0), (60, 0), (65, 1), (70, 1), (75, 1), (80, 1), (85, 1), (90, 1), (95, 1), (100, 0), (105, 1), (110, 1), (115, 1), (120, 1), (125, 1), (130, 1), (135, 1), (140, 1), (145, 1), (150, 1), (155, 0), (160, 0), (165, 0), (170, 0), (175, 1), (180, 1), (185, 1), (190, 0), (195, 0), (200, 0), (205, 0), (210, 0), (215, 0), (220, 0), (225, 0), (230, 0), (235, 0), (240, 0), (245, 1), (250, 1), (255, 1), (260, 1), (265, 1), (270, 1), (275, 1), (280, 1), (285, 1), (290, 1), (295, 1), (300, 1), (305, 1), (310, 1), (315, 1), (320, 1), (325, 1), (330, 1), (335, 1), (340, 1), (345, 1), (350, 1), (355, 1), (360, 1), (365, 1), (370, 1), (375, 1), (380, 1), (385, 1), (390, 1), (395, 1), (400, 1), (405, 1), (410, 1), (415, 1), (420, 1), (425, 1), (430, 1), (435, 1), (440, 1), (445, 1), (450, 1), (455, 1), (460, 1), (465, 1), (470, 1), (475, 1), (480, 1), (485, 1), (490, 0), (495, 0), (500, 1), (505, 1), (510, 1), (515, 0), (520, 0), (525, 0), (530, 0), (535, 1), (540, 1), (545, 1), (550, 1), (555, 1), (560, 0), (565, 0), (570, 0), (575, 0), (580, 0), (585, 0), (590, 0), (595, 0), (600, 0), (605, 0), (610, 1), (615, 1), (620, 0), (625, 0), (630, 0), (635, 0), (640, 0), (645, 0), (650, 1), (655, 0), (660, 0), (665, 0), (670, 1), (675, 1), (680, 1), (685, 1), (690, 1), (695, 1), (700, 1), (705, 1), (710, 1), (715, 1), (720, 1), (725, 1), (730, 1), (735, 1), (740, 0), (745, 0), (750, 0), (755, 0), (760, 0), (765, 0), (770, 1), (775, 1), (780, 1), (785, 1), (790, 1), (795, 1), (800, 1), (805, 1), (810, 1), (815, 1), (820, 1), (825, 1), (830, 1), (835, 1), (840, 0), (845, 0), (850, 1), (855, 0), (860, 0), (865, 1), (870, 1), (875, 1), (880, 1), (885, 1), (890, 1), (895, 1), (900, 1), (905, 1), (910, 0), (915, 1), (920, 1), (925, 1), (930, 1), (935, 1), (940, 1), (945, 1), (950, 1), (955, 1), (960, 1), (965, 0), (970, 0), (975, 0), (980, 0), (985, 0), (990, 0), (995, 0), (1000, 0), (1005, 0), (1010, 0), (1015, 0), (1020, 1), (1025, 1)]
Vdin0_60  din0_60  0 PWL (0n 0.0v 4.745n 0.0v 4.755n 1.0v 9.745n 1.0v 9.755n 0.0v 14.745n 0.0v 14.755n 1.0v 19.745n 1.0v 19.755n 1.0v 24.745n 1.0v 24.755n 1.0v 29.745n 1.0v 29.755n 0.0v 34.745n 0.0v 34.755n 0.0v 39.745n 0.0v 39.755n 0.0v 44.745n 0.0v 44.755n 0.0v 49.745n 0.0v 49.755n 0.0v 54.745n 0.0v 54.755n 0.0v 59.745n 0.0v 59.755n 0.0v 64.745n 0.0v 64.755n 1.0v 69.745n 1.0v 69.755n 1.0v 74.745n 1.0v 74.755n 1.0v 79.745n 1.0v 79.755n 1.0v 84.745n 1.0v 84.755n 1.0v 89.745n 1.0v 89.755n 1.0v 94.745n 1.0v 94.755n 1.0v 99.745n 1.0v 99.755n 0.0v 104.745n 0.0v 104.755n 1.0v 109.745n 1.0v 109.755n 1.0v 114.745n 1.0v 114.755n 1.0v 119.745n 1.0v 119.755n 1.0v 124.745n 1.0v 124.755n 1.0v 129.745n 1.0v 129.755n 1.0v 134.745n 1.0v 134.755n 1.0v 139.745n 1.0v 139.755n 1.0v 144.745n 1.0v 144.755n 1.0v 149.745n 1.0v 149.755n 1.0v 154.745n 1.0v 154.755n 0.0v 159.745n 0.0v 159.755n 0.0v 164.745n 0.0v 164.755n 0.0v 169.745n 0.0v 169.755n 0.0v 174.745n 0.0v 174.755n 1.0v 179.745n 1.0v 179.755n 1.0v 184.745n 1.0v 184.755n 1.0v 189.745n 1.0v 189.755n 0.0v 194.745n 0.0v 194.755n 0.0v 199.745n 0.0v 199.755n 0.0v 204.745n 0.0v 204.755n 0.0v 209.745n 0.0v 209.755n 0.0v 214.745n 0.0v 214.755n 0.0v 219.745n 0.0v 219.755n 0.0v 224.745n 0.0v 224.755n 0.0v 229.745n 0.0v 229.755n 0.0v 234.745n 0.0v 234.755n 0.0v 239.745n 0.0v 239.755n 0.0v 244.745n 0.0v 244.755n 1.0v 249.745n 1.0v 249.755n 1.0v 254.745n 1.0v 254.755n 1.0v 259.745n 1.0v 259.755n 1.0v 264.745n 1.0v 264.755n 1.0v 269.745n 1.0v 269.755n 1.0v 274.745n 1.0v 274.755n 1.0v 279.745n 1.0v 279.755n 1.0v 284.745n 1.0v 284.755n 1.0v 289.745n 1.0v 289.755n 1.0v 294.745n 1.0v 294.755n 1.0v 299.745n 1.0v 299.755n 1.0v 304.745n 1.0v 304.755n 1.0v 309.745n 1.0v 309.755n 1.0v 314.745n 1.0v 314.755n 1.0v 319.745n 1.0v 319.755n 1.0v 324.745n 1.0v 324.755n 1.0v 329.745n 1.0v 329.755n 1.0v 334.745n 1.0v 334.755n 1.0v 339.745n 1.0v 339.755n 1.0v 344.745n 1.0v 344.755n 1.0v 349.745n 1.0v 349.755n 1.0v 354.745n 1.0v 354.755n 1.0v 359.745n 1.0v 359.755n 1.0v 364.745n 1.0v 364.755n 1.0v 369.745n 1.0v 369.755n 1.0v 374.745n 1.0v 374.755n 1.0v 379.745n 1.0v 379.755n 1.0v 384.745n 1.0v 384.755n 1.0v 389.745n 1.0v 389.755n 1.0v 394.745n 1.0v 394.755n 1.0v 399.745n 1.0v 399.755n 1.0v 404.745n 1.0v 404.755n 1.0v 409.745n 1.0v 409.755n 1.0v 414.745n 1.0v 414.755n 1.0v 419.745n 1.0v 419.755n 1.0v 424.745n 1.0v 424.755n 1.0v 429.745n 1.0v 429.755n 1.0v 434.745n 1.0v 434.755n 1.0v 439.745n 1.0v 439.755n 1.0v 444.745n 1.0v 444.755n 1.0v 449.745n 1.0v 449.755n 1.0v 454.745n 1.0v 454.755n 1.0v 459.745n 1.0v 459.755n 1.0v 464.745n 1.0v 464.755n 1.0v 469.745n 1.0v 469.755n 1.0v 474.745n 1.0v 474.755n 1.0v 479.745n 1.0v 479.755n 1.0v 484.745n 1.0v 484.755n 1.0v 489.745n 1.0v 489.755n 0.0v 494.745n 0.0v 494.755n 0.0v 499.745n 0.0v 499.755n 1.0v 504.745n 1.0v 504.755n 1.0v 509.745n 1.0v 509.755n 1.0v 514.745n 1.0v 514.755n 0.0v 519.745n 0.0v 519.755n 0.0v 524.745n 0.0v 524.755n 0.0v 529.745n 0.0v 529.755n 0.0v 534.745n 0.0v 534.755n 1.0v 539.745n 1.0v 539.755n 1.0v 544.745n 1.0v 544.755n 1.0v 549.745n 1.0v 549.755n 1.0v 554.745n 1.0v 554.755n 1.0v 559.745n 1.0v 559.755n 0.0v 564.745n 0.0v 564.755n 0.0v 569.745n 0.0v 569.755n 0.0v 574.745n 0.0v 574.755n 0.0v 579.745n 0.0v 579.755n 0.0v 584.745n 0.0v 584.755n 0.0v 589.745n 0.0v 589.755n 0.0v 594.745n 0.0v 594.755n 0.0v 599.745n 0.0v 599.755n 0.0v 604.745n 0.0v 604.755n 0.0v 609.745n 0.0v 609.755n 1.0v 614.745n 1.0v 614.755n 1.0v 619.745n 1.0v 619.755n 0.0v 624.745n 0.0v 624.755n 0.0v 629.745n 0.0v 629.755n 0.0v 634.745n 0.0v 634.755n 0.0v 639.745n 0.0v 639.755n 0.0v 644.745n 0.0v 644.755n 0.0v 649.745n 0.0v 649.755n 1.0v 654.745n 1.0v 654.755n 0.0v 659.745n 0.0v 659.755n 0.0v 664.745n 0.0v 664.755n 0.0v 669.745n 0.0v 669.755n 1.0v 674.745n 1.0v 674.755n 1.0v 679.745n 1.0v 679.755n 1.0v 684.745n 1.0v 684.755n 1.0v 689.745n 1.0v 689.755n 1.0v 694.745n 1.0v 694.755n 1.0v 699.745n 1.0v 699.755n 1.0v 704.745n 1.0v 704.755n 1.0v 709.745n 1.0v 709.755n 1.0v 714.745n 1.0v 714.755n 1.0v 719.745n 1.0v 719.755n 1.0v 724.745n 1.0v 724.755n 1.0v 729.745n 1.0v 729.755n 1.0v 734.745n 1.0v 734.755n 1.0v 739.745n 1.0v 739.755n 0.0v 744.745n 0.0v 744.755n 0.0v 749.745n 0.0v 749.755n 0.0v 754.745n 0.0v 754.755n 0.0v 759.745n 0.0v 759.755n 0.0v 764.745n 0.0v 764.755n 0.0v 769.745n 0.0v 769.755n 1.0v 774.745n 1.0v 774.755n 1.0v 779.745n 1.0v 779.755n 1.0v 784.745n 1.0v 784.755n 1.0v 789.745n 1.0v 789.755n 1.0v 794.745n 1.0v 794.755n 1.0v 799.745n 1.0v 799.755n 1.0v 804.745n 1.0v 804.755n 1.0v 809.745n 1.0v 809.755n 1.0v 814.745n 1.0v 814.755n 1.0v 819.745n 1.0v 819.755n 1.0v 824.745n 1.0v 824.755n 1.0v 829.745n 1.0v 829.755n 1.0v 834.745n 1.0v 834.755n 1.0v 839.745n 1.0v 839.755n 0.0v 844.745n 0.0v 844.755n 0.0v 849.745n 0.0v 849.755n 1.0v 854.745n 1.0v 854.755n 0.0v 859.745n 0.0v 859.755n 0.0v 864.745n 0.0v 864.755n 1.0v 869.745n 1.0v 869.755n 1.0v 874.745n 1.0v 874.755n 1.0v 879.745n 1.0v 879.755n 1.0v 884.745n 1.0v 884.755n 1.0v 889.745n 1.0v 889.755n 1.0v 894.745n 1.0v 894.755n 1.0v 899.745n 1.0v 899.755n 1.0v 904.745n 1.0v 904.755n 1.0v 909.745n 1.0v 909.755n 0.0v 914.745n 0.0v 914.755n 1.0v 919.745n 1.0v 919.755n 1.0v 924.745n 1.0v 924.755n 1.0v 929.745n 1.0v 929.755n 1.0v 934.745n 1.0v 934.755n 1.0v 939.745n 1.0v 939.755n 1.0v 944.745n 1.0v 944.755n 1.0v 949.745n 1.0v 949.755n 1.0v 954.745n 1.0v 954.755n 1.0v 959.745n 1.0v 959.755n 1.0v 964.745n 1.0v 964.755n 0.0v 969.745n 0.0v 969.755n 0.0v 974.745n 0.0v 974.755n 0.0v 979.745n 0.0v 979.755n 0.0v 984.745n 0.0v 984.755n 0.0v 989.745n 0.0v 989.755n 0.0v 994.745n 0.0v 994.755n 0.0v 999.745n 0.0v 999.755n 0.0v 1004.745n 0.0v 1004.755n 0.0v 1009.745n 0.0v 1009.755n 0.0v 1014.745n 0.0v 1014.755n 0.0v 1019.745n 0.0v 1019.755n 1.0v 1024.745n 1.0v 1024.755n 1.0v )
* (time, data): [(0, 0), (5, 0), (10, 0), (15, 1), (20, 1), (25, 1), (30, 0), (35, 0), (40, 0), (45, 0), (50, 1), (55, 1), (60, 1), (65, 0), (70, 0), (75, 0), (80, 0), (85, 0), (90, 0), (95, 0), (100, 1), (105, 0), (110, 0), (115, 1), (120, 1), (125, 1), (130, 1), (135, 1), (140, 1), (145, 1), (150, 1), (155, 0), (160, 0), (165, 0), (170, 0), (175, 1), (180, 1), (185, 1), (190, 0), (195, 1), (200, 1), (205, 1), (210, 1), (215, 1), (220, 1), (225, 1), (230, 1), (235, 1), (240, 1), (245, 0), (250, 0), (255, 0), (260, 0), (265, 0), (270, 0), (275, 0), (280, 0), (285, 0), (290, 1), (295, 1), (300, 1), (305, 1), (310, 1), (315, 1), (320, 1), (325, 1), (330, 1), (335, 0), (340, 0), (345, 0), (350, 0), (355, 0), (360, 0), (365, 0), (370, 0), (375, 0), (380, 0), (385, 0), (390, 0), (395, 0), (400, 0), (405, 0), (410, 0), (415, 0), (420, 0), (425, 0), (430, 0), (435, 0), (440, 0), (445, 1), (450, 1), (455, 1), (460, 1), (465, 1), (470, 1), (475, 1), (480, 1), (485, 0), (490, 0), (495, 0), (500, 1), (505, 1), (510, 1), (515, 0), (520, 0), (525, 0), (530, 0), (535, 1), (540, 1), (545, 1), (550, 0), (555, 0), (560, 0), (565, 0), (570, 0), (575, 0), (580, 0), (585, 0), (590, 0), (595, 0), (600, 1), (605, 1), (610, 1), (615, 1), (620, 0), (625, 0), (630, 0), (635, 0), (640, 0), (645, 0), (650, 1), (655, 1), (660, 1), (665, 1), (670, 1), (675, 1), (680, 1), (685, 1), (690, 1), (695, 1), (700, 1), (705, 1), (710, 1), (715, 1), (720, 1), (725, 1), (730, 1), (735, 1), (740, 0), (745, 0), (750, 0), (755, 0), (760, 0), (765, 0), (770, 0), (775, 0), (780, 1), (785, 1), (790, 1), (795, 1), (800, 1), (805, 1), (810, 1), (815, 1), (820, 1), (825, 1), (830, 1), (835, 1), (840, 0), (845, 0), (850, 0), (855, 0), (860, 0), (865, 0), (870, 1), (875, 1), (880, 1), (885, 1), (890, 1), (895, 1), (900, 1), (905, 1), (910, 1), (915, 0), (920, 0), (925, 0), (930, 1), (935, 1), (940, 1), (945, 1), (950, 1), (955, 1), (960, 1), (965, 1), (970, 1), (975, 1), (980, 1), (985, 1), (990, 1), (995, 1), (1000, 1), (1005, 1), (1010, 1), (1015, 1), (1020, 0), (1025, 0)]
Vdin0_61  din0_61  0 PWL (0n 0.0v 4.745n 0.0v 4.755n 0.0v 9.745n 0.0v 9.755n 0.0v 14.745n 0.0v 14.755n 1.0v 19.745n 1.0v 19.755n 1.0v 24.745n 1.0v 24.755n 1.0v 29.745n 1.0v 29.755n 0.0v 34.745n 0.0v 34.755n 0.0v 39.745n 0.0v 39.755n 0.0v 44.745n 0.0v 44.755n 0.0v 49.745n 0.0v 49.755n 1.0v 54.745n 1.0v 54.755n 1.0v 59.745n 1.0v 59.755n 1.0v 64.745n 1.0v 64.755n 0.0v 69.745n 0.0v 69.755n 0.0v 74.745n 0.0v 74.755n 0.0v 79.745n 0.0v 79.755n 0.0v 84.745n 0.0v 84.755n 0.0v 89.745n 0.0v 89.755n 0.0v 94.745n 0.0v 94.755n 0.0v 99.745n 0.0v 99.755n 1.0v 104.745n 1.0v 104.755n 0.0v 109.745n 0.0v 109.755n 0.0v 114.745n 0.0v 114.755n 1.0v 119.745n 1.0v 119.755n 1.0v 124.745n 1.0v 124.755n 1.0v 129.745n 1.0v 129.755n 1.0v 134.745n 1.0v 134.755n 1.0v 139.745n 1.0v 139.755n 1.0v 144.745n 1.0v 144.755n 1.0v 149.745n 1.0v 149.755n 1.0v 154.745n 1.0v 154.755n 0.0v 159.745n 0.0v 159.755n 0.0v 164.745n 0.0v 164.755n 0.0v 169.745n 0.0v 169.755n 0.0v 174.745n 0.0v 174.755n 1.0v 179.745n 1.0v 179.755n 1.0v 184.745n 1.0v 184.755n 1.0v 189.745n 1.0v 189.755n 0.0v 194.745n 0.0v 194.755n 1.0v 199.745n 1.0v 199.755n 1.0v 204.745n 1.0v 204.755n 1.0v 209.745n 1.0v 209.755n 1.0v 214.745n 1.0v 214.755n 1.0v 219.745n 1.0v 219.755n 1.0v 224.745n 1.0v 224.755n 1.0v 229.745n 1.0v 229.755n 1.0v 234.745n 1.0v 234.755n 1.0v 239.745n 1.0v 239.755n 1.0v 244.745n 1.0v 244.755n 0.0v 249.745n 0.0v 249.755n 0.0v 254.745n 0.0v 254.755n 0.0v 259.745n 0.0v 259.755n 0.0v 264.745n 0.0v 264.755n 0.0v 269.745n 0.0v 269.755n 0.0v 274.745n 0.0v 274.755n 0.0v 279.745n 0.0v 279.755n 0.0v 284.745n 0.0v 284.755n 0.0v 289.745n 0.0v 289.755n 1.0v 294.745n 1.0v 294.755n 1.0v 299.745n 1.0v 299.755n 1.0v 304.745n 1.0v 304.755n 1.0v 309.745n 1.0v 309.755n 1.0v 314.745n 1.0v 314.755n 1.0v 319.745n 1.0v 319.755n 1.0v 324.745n 1.0v 324.755n 1.0v 329.745n 1.0v 329.755n 1.0v 334.745n 1.0v 334.755n 0.0v 339.745n 0.0v 339.755n 0.0v 344.745n 0.0v 344.755n 0.0v 349.745n 0.0v 349.755n 0.0v 354.745n 0.0v 354.755n 0.0v 359.745n 0.0v 359.755n 0.0v 364.745n 0.0v 364.755n 0.0v 369.745n 0.0v 369.755n 0.0v 374.745n 0.0v 374.755n 0.0v 379.745n 0.0v 379.755n 0.0v 384.745n 0.0v 384.755n 0.0v 389.745n 0.0v 389.755n 0.0v 394.745n 0.0v 394.755n 0.0v 399.745n 0.0v 399.755n 0.0v 404.745n 0.0v 404.755n 0.0v 409.745n 0.0v 409.755n 0.0v 414.745n 0.0v 414.755n 0.0v 419.745n 0.0v 419.755n 0.0v 424.745n 0.0v 424.755n 0.0v 429.745n 0.0v 429.755n 0.0v 434.745n 0.0v 434.755n 0.0v 439.745n 0.0v 439.755n 0.0v 444.745n 0.0v 444.755n 1.0v 449.745n 1.0v 449.755n 1.0v 454.745n 1.0v 454.755n 1.0v 459.745n 1.0v 459.755n 1.0v 464.745n 1.0v 464.755n 1.0v 469.745n 1.0v 469.755n 1.0v 474.745n 1.0v 474.755n 1.0v 479.745n 1.0v 479.755n 1.0v 484.745n 1.0v 484.755n 0.0v 489.745n 0.0v 489.755n 0.0v 494.745n 0.0v 494.755n 0.0v 499.745n 0.0v 499.755n 1.0v 504.745n 1.0v 504.755n 1.0v 509.745n 1.0v 509.755n 1.0v 514.745n 1.0v 514.755n 0.0v 519.745n 0.0v 519.755n 0.0v 524.745n 0.0v 524.755n 0.0v 529.745n 0.0v 529.755n 0.0v 534.745n 0.0v 534.755n 1.0v 539.745n 1.0v 539.755n 1.0v 544.745n 1.0v 544.755n 1.0v 549.745n 1.0v 549.755n 0.0v 554.745n 0.0v 554.755n 0.0v 559.745n 0.0v 559.755n 0.0v 564.745n 0.0v 564.755n 0.0v 569.745n 0.0v 569.755n 0.0v 574.745n 0.0v 574.755n 0.0v 579.745n 0.0v 579.755n 0.0v 584.745n 0.0v 584.755n 0.0v 589.745n 0.0v 589.755n 0.0v 594.745n 0.0v 594.755n 0.0v 599.745n 0.0v 599.755n 1.0v 604.745n 1.0v 604.755n 1.0v 609.745n 1.0v 609.755n 1.0v 614.745n 1.0v 614.755n 1.0v 619.745n 1.0v 619.755n 0.0v 624.745n 0.0v 624.755n 0.0v 629.745n 0.0v 629.755n 0.0v 634.745n 0.0v 634.755n 0.0v 639.745n 0.0v 639.755n 0.0v 644.745n 0.0v 644.755n 0.0v 649.745n 0.0v 649.755n 1.0v 654.745n 1.0v 654.755n 1.0v 659.745n 1.0v 659.755n 1.0v 664.745n 1.0v 664.755n 1.0v 669.745n 1.0v 669.755n 1.0v 674.745n 1.0v 674.755n 1.0v 679.745n 1.0v 679.755n 1.0v 684.745n 1.0v 684.755n 1.0v 689.745n 1.0v 689.755n 1.0v 694.745n 1.0v 694.755n 1.0v 699.745n 1.0v 699.755n 1.0v 704.745n 1.0v 704.755n 1.0v 709.745n 1.0v 709.755n 1.0v 714.745n 1.0v 714.755n 1.0v 719.745n 1.0v 719.755n 1.0v 724.745n 1.0v 724.755n 1.0v 729.745n 1.0v 729.755n 1.0v 734.745n 1.0v 734.755n 1.0v 739.745n 1.0v 739.755n 0.0v 744.745n 0.0v 744.755n 0.0v 749.745n 0.0v 749.755n 0.0v 754.745n 0.0v 754.755n 0.0v 759.745n 0.0v 759.755n 0.0v 764.745n 0.0v 764.755n 0.0v 769.745n 0.0v 769.755n 0.0v 774.745n 0.0v 774.755n 0.0v 779.745n 0.0v 779.755n 1.0v 784.745n 1.0v 784.755n 1.0v 789.745n 1.0v 789.755n 1.0v 794.745n 1.0v 794.755n 1.0v 799.745n 1.0v 799.755n 1.0v 804.745n 1.0v 804.755n 1.0v 809.745n 1.0v 809.755n 1.0v 814.745n 1.0v 814.755n 1.0v 819.745n 1.0v 819.755n 1.0v 824.745n 1.0v 824.755n 1.0v 829.745n 1.0v 829.755n 1.0v 834.745n 1.0v 834.755n 1.0v 839.745n 1.0v 839.755n 0.0v 844.745n 0.0v 844.755n 0.0v 849.745n 0.0v 849.755n 0.0v 854.745n 0.0v 854.755n 0.0v 859.745n 0.0v 859.755n 0.0v 864.745n 0.0v 864.755n 0.0v 869.745n 0.0v 869.755n 1.0v 874.745n 1.0v 874.755n 1.0v 879.745n 1.0v 879.755n 1.0v 884.745n 1.0v 884.755n 1.0v 889.745n 1.0v 889.755n 1.0v 894.745n 1.0v 894.755n 1.0v 899.745n 1.0v 899.755n 1.0v 904.745n 1.0v 904.755n 1.0v 909.745n 1.0v 909.755n 1.0v 914.745n 1.0v 914.755n 0.0v 919.745n 0.0v 919.755n 0.0v 924.745n 0.0v 924.755n 0.0v 929.745n 0.0v 929.755n 1.0v 934.745n 1.0v 934.755n 1.0v 939.745n 1.0v 939.755n 1.0v 944.745n 1.0v 944.755n 1.0v 949.745n 1.0v 949.755n 1.0v 954.745n 1.0v 954.755n 1.0v 959.745n 1.0v 959.755n 1.0v 964.745n 1.0v 964.755n 1.0v 969.745n 1.0v 969.755n 1.0v 974.745n 1.0v 974.755n 1.0v 979.745n 1.0v 979.755n 1.0v 984.745n 1.0v 984.755n 1.0v 989.745n 1.0v 989.755n 1.0v 994.745n 1.0v 994.755n 1.0v 999.745n 1.0v 999.755n 1.0v 1004.745n 1.0v 1004.755n 1.0v 1009.745n 1.0v 1009.755n 1.0v 1014.745n 1.0v 1014.755n 1.0v 1019.745n 1.0v 1019.755n 0.0v 1024.745n 0.0v 1024.755n 0.0v )
* (time, data): [(0, 0), (5, 1), (10, 0), (15, 1), (20, 1), (25, 1), (30, 0), (35, 0), (40, 0), (45, 0), (50, 0), (55, 0), (60, 0), (65, 0), (70, 0), (75, 0), (80, 0), (85, 1), (90, 1), (95, 1), (100, 0), (105, 1), (110, 1), (115, 0), (120, 0), (125, 0), (130, 0), (135, 0), (140, 0), (145, 0), (150, 0), (155, 1), (160, 1), (165, 1), (170, 1), (175, 1), (180, 1), (185, 1), (190, 1), (195, 0), (200, 0), (205, 0), (210, 0), (215, 0), (220, 0), (225, 0), (230, 0), (235, 0), (240, 0), (245, 1), (250, 1), (255, 1), (260, 1), (265, 1), (270, 1), (275, 1), (280, 1), (285, 1), (290, 0), (295, 0), (300, 0), (305, 0), (310, 0), (315, 0), (320, 0), (325, 0), (330, 0), (335, 1), (340, 1), (345, 1), (350, 1), (355, 1), (360, 1), (365, 1), (370, 1), (375, 1), (380, 1), (385, 1), (390, 1), (395, 1), (400, 1), (405, 1), (410, 0), (415, 0), (420, 0), (425, 0), (430, 0), (435, 0), (440, 0), (445, 0), (450, 0), (455, 0), (460, 0), (465, 0), (470, 0), (475, 0), (480, 0), (485, 0), (490, 0), (495, 0), (500, 0), (505, 0), (510, 0), (515, 1), (520, 1), (525, 1), (530, 1), (535, 0), (540, 0), (545, 1), (550, 1), (555, 1), (560, 0), (565, 0), (570, 0), (575, 0), (580, 0), (585, 0), (590, 0), (595, 0), (600, 1), (605, 1), (610, 1), (615, 1), (620, 1), (625, 1), (630, 1), (635, 1), (640, 1), (645, 1), (650, 1), (655, 0), (660, 0), (665, 0), (670, 1), (675, 1), (680, 1), (685, 1), (690, 1), (695, 1), (700, 1), (705, 1), (710, 1), (715, 1), (720, 1), (725, 1), (730, 1), (735, 1), (740, 1), (745, 1), (750, 1), (755, 1), (760, 1), (765, 1), (770, 1), (775, 1), (780, 1), (785, 1), (790, 1), (795, 1), (800, 1), (805, 1), (810, 1), (815, 1), (820, 1), (825, 1), (830, 1), (835, 1), (840, 0), (845, 0), (850, 1), (855, 0), (860, 0), (865, 1), (870, 1), (875, 1), (880, 1), (885, 1), (890, 1), (895, 1), (900, 1), (905, 1), (910, 1), (915, 1), (920, 1), (925, 1), (930, 1), (935, 1), (940, 1), (945, 1), (950, 1), (955, 1), (960, 1), (965, 1), (970, 1), (975, 1), (980, 1), (985, 1), (990, 1), (995, 1), (1000, 1), (1005, 1), (1010, 1), (1015, 1), (1020, 1), (1025, 1)]
Vdin0_62  din0_62  0 PWL (0n 0.0v 4.745n 0.0v 4.755n 1.0v 9.745n 1.0v 9.755n 0.0v 14.745n 0.0v 14.755n 1.0v 19.745n 1.0v 19.755n 1.0v 24.745n 1.0v 24.755n 1.0v 29.745n 1.0v 29.755n 0.0v 34.745n 0.0v 34.755n 0.0v 39.745n 0.0v 39.755n 0.0v 44.745n 0.0v 44.755n 0.0v 49.745n 0.0v 49.755n 0.0v 54.745n 0.0v 54.755n 0.0v 59.745n 0.0v 59.755n 0.0v 64.745n 0.0v 64.755n 0.0v 69.745n 0.0v 69.755n 0.0v 74.745n 0.0v 74.755n 0.0v 79.745n 0.0v 79.755n 0.0v 84.745n 0.0v 84.755n 1.0v 89.745n 1.0v 89.755n 1.0v 94.745n 1.0v 94.755n 1.0v 99.745n 1.0v 99.755n 0.0v 104.745n 0.0v 104.755n 1.0v 109.745n 1.0v 109.755n 1.0v 114.745n 1.0v 114.755n 0.0v 119.745n 0.0v 119.755n 0.0v 124.745n 0.0v 124.755n 0.0v 129.745n 0.0v 129.755n 0.0v 134.745n 0.0v 134.755n 0.0v 139.745n 0.0v 139.755n 0.0v 144.745n 0.0v 144.755n 0.0v 149.745n 0.0v 149.755n 0.0v 154.745n 0.0v 154.755n 1.0v 159.745n 1.0v 159.755n 1.0v 164.745n 1.0v 164.755n 1.0v 169.745n 1.0v 169.755n 1.0v 174.745n 1.0v 174.755n 1.0v 179.745n 1.0v 179.755n 1.0v 184.745n 1.0v 184.755n 1.0v 189.745n 1.0v 189.755n 1.0v 194.745n 1.0v 194.755n 0.0v 199.745n 0.0v 199.755n 0.0v 204.745n 0.0v 204.755n 0.0v 209.745n 0.0v 209.755n 0.0v 214.745n 0.0v 214.755n 0.0v 219.745n 0.0v 219.755n 0.0v 224.745n 0.0v 224.755n 0.0v 229.745n 0.0v 229.755n 0.0v 234.745n 0.0v 234.755n 0.0v 239.745n 0.0v 239.755n 0.0v 244.745n 0.0v 244.755n 1.0v 249.745n 1.0v 249.755n 1.0v 254.745n 1.0v 254.755n 1.0v 259.745n 1.0v 259.755n 1.0v 264.745n 1.0v 264.755n 1.0v 269.745n 1.0v 269.755n 1.0v 274.745n 1.0v 274.755n 1.0v 279.745n 1.0v 279.755n 1.0v 284.745n 1.0v 284.755n 1.0v 289.745n 1.0v 289.755n 0.0v 294.745n 0.0v 294.755n 0.0v 299.745n 0.0v 299.755n 0.0v 304.745n 0.0v 304.755n 0.0v 309.745n 0.0v 309.755n 0.0v 314.745n 0.0v 314.755n 0.0v 319.745n 0.0v 319.755n 0.0v 324.745n 0.0v 324.755n 0.0v 329.745n 0.0v 329.755n 0.0v 334.745n 0.0v 334.755n 1.0v 339.745n 1.0v 339.755n 1.0v 344.745n 1.0v 344.755n 1.0v 349.745n 1.0v 349.755n 1.0v 354.745n 1.0v 354.755n 1.0v 359.745n 1.0v 359.755n 1.0v 364.745n 1.0v 364.755n 1.0v 369.745n 1.0v 369.755n 1.0v 374.745n 1.0v 374.755n 1.0v 379.745n 1.0v 379.755n 1.0v 384.745n 1.0v 384.755n 1.0v 389.745n 1.0v 389.755n 1.0v 394.745n 1.0v 394.755n 1.0v 399.745n 1.0v 399.755n 1.0v 404.745n 1.0v 404.755n 1.0v 409.745n 1.0v 409.755n 0.0v 414.745n 0.0v 414.755n 0.0v 419.745n 0.0v 419.755n 0.0v 424.745n 0.0v 424.755n 0.0v 429.745n 0.0v 429.755n 0.0v 434.745n 0.0v 434.755n 0.0v 439.745n 0.0v 439.755n 0.0v 444.745n 0.0v 444.755n 0.0v 449.745n 0.0v 449.755n 0.0v 454.745n 0.0v 454.755n 0.0v 459.745n 0.0v 459.755n 0.0v 464.745n 0.0v 464.755n 0.0v 469.745n 0.0v 469.755n 0.0v 474.745n 0.0v 474.755n 0.0v 479.745n 0.0v 479.755n 0.0v 484.745n 0.0v 484.755n 0.0v 489.745n 0.0v 489.755n 0.0v 494.745n 0.0v 494.755n 0.0v 499.745n 0.0v 499.755n 0.0v 504.745n 0.0v 504.755n 0.0v 509.745n 0.0v 509.755n 0.0v 514.745n 0.0v 514.755n 1.0v 519.745n 1.0v 519.755n 1.0v 524.745n 1.0v 524.755n 1.0v 529.745n 1.0v 529.755n 1.0v 534.745n 1.0v 534.755n 0.0v 539.745n 0.0v 539.755n 0.0v 544.745n 0.0v 544.755n 1.0v 549.745n 1.0v 549.755n 1.0v 554.745n 1.0v 554.755n 1.0v 559.745n 1.0v 559.755n 0.0v 564.745n 0.0v 564.755n 0.0v 569.745n 0.0v 569.755n 0.0v 574.745n 0.0v 574.755n 0.0v 579.745n 0.0v 579.755n 0.0v 584.745n 0.0v 584.755n 0.0v 589.745n 0.0v 589.755n 0.0v 594.745n 0.0v 594.755n 0.0v 599.745n 0.0v 599.755n 1.0v 604.745n 1.0v 604.755n 1.0v 609.745n 1.0v 609.755n 1.0v 614.745n 1.0v 614.755n 1.0v 619.745n 1.0v 619.755n 1.0v 624.745n 1.0v 624.755n 1.0v 629.745n 1.0v 629.755n 1.0v 634.745n 1.0v 634.755n 1.0v 639.745n 1.0v 639.755n 1.0v 644.745n 1.0v 644.755n 1.0v 649.745n 1.0v 649.755n 1.0v 654.745n 1.0v 654.755n 0.0v 659.745n 0.0v 659.755n 0.0v 664.745n 0.0v 664.755n 0.0v 669.745n 0.0v 669.755n 1.0v 674.745n 1.0v 674.755n 1.0v 679.745n 1.0v 679.755n 1.0v 684.745n 1.0v 684.755n 1.0v 689.745n 1.0v 689.755n 1.0v 694.745n 1.0v 694.755n 1.0v 699.745n 1.0v 699.755n 1.0v 704.745n 1.0v 704.755n 1.0v 709.745n 1.0v 709.755n 1.0v 714.745n 1.0v 714.755n 1.0v 719.745n 1.0v 719.755n 1.0v 724.745n 1.0v 724.755n 1.0v 729.745n 1.0v 729.755n 1.0v 734.745n 1.0v 734.755n 1.0v 739.745n 1.0v 739.755n 1.0v 744.745n 1.0v 744.755n 1.0v 749.745n 1.0v 749.755n 1.0v 754.745n 1.0v 754.755n 1.0v 759.745n 1.0v 759.755n 1.0v 764.745n 1.0v 764.755n 1.0v 769.745n 1.0v 769.755n 1.0v 774.745n 1.0v 774.755n 1.0v 779.745n 1.0v 779.755n 1.0v 784.745n 1.0v 784.755n 1.0v 789.745n 1.0v 789.755n 1.0v 794.745n 1.0v 794.755n 1.0v 799.745n 1.0v 799.755n 1.0v 804.745n 1.0v 804.755n 1.0v 809.745n 1.0v 809.755n 1.0v 814.745n 1.0v 814.755n 1.0v 819.745n 1.0v 819.755n 1.0v 824.745n 1.0v 824.755n 1.0v 829.745n 1.0v 829.755n 1.0v 834.745n 1.0v 834.755n 1.0v 839.745n 1.0v 839.755n 0.0v 844.745n 0.0v 844.755n 0.0v 849.745n 0.0v 849.755n 1.0v 854.745n 1.0v 854.755n 0.0v 859.745n 0.0v 859.755n 0.0v 864.745n 0.0v 864.755n 1.0v 869.745n 1.0v 869.755n 1.0v 874.745n 1.0v 874.755n 1.0v 879.745n 1.0v 879.755n 1.0v 884.745n 1.0v 884.755n 1.0v 889.745n 1.0v 889.755n 1.0v 894.745n 1.0v 894.755n 1.0v 899.745n 1.0v 899.755n 1.0v 904.745n 1.0v 904.755n 1.0v 909.745n 1.0v 909.755n 1.0v 914.745n 1.0v 914.755n 1.0v 919.745n 1.0v 919.755n 1.0v 924.745n 1.0v 924.755n 1.0v 929.745n 1.0v 929.755n 1.0v 934.745n 1.0v 934.755n 1.0v 939.745n 1.0v 939.755n 1.0v 944.745n 1.0v 944.755n 1.0v 949.745n 1.0v 949.755n 1.0v 954.745n 1.0v 954.755n 1.0v 959.745n 1.0v 959.755n 1.0v 964.745n 1.0v 964.755n 1.0v 969.745n 1.0v 969.755n 1.0v 974.745n 1.0v 974.755n 1.0v 979.745n 1.0v 979.755n 1.0v 984.745n 1.0v 984.755n 1.0v 989.745n 1.0v 989.755n 1.0v 994.745n 1.0v 994.755n 1.0v 999.745n 1.0v 999.755n 1.0v 1004.745n 1.0v 1004.755n 1.0v 1009.745n 1.0v 1009.755n 1.0v 1014.745n 1.0v 1014.755n 1.0v 1019.745n 1.0v 1019.755n 1.0v 1024.745n 1.0v 1024.755n 1.0v )
* (time, data): [(0, 0), (5, 1), (10, 0), (15, 0), (20, 0), (25, 0), (30, 1), (35, 1), (40, 0), (45, 0), (50, 0), (55, 0), (60, 0), (65, 0), (70, 0), (75, 0), (80, 0), (85, 0), (90, 0), (95, 0), (100, 0), (105, 0), (110, 0), (115, 0), (120, 0), (125, 0), (130, 0), (135, 0), (140, 0), (145, 0), (150, 0), (155, 0), (160, 0), (165, 0), (170, 0), (175, 0), (180, 0), (185, 0), (190, 1), (195, 1), (200, 1), (205, 1), (210, 1), (215, 1), (220, 1), (225, 1), (230, 1), (235, 1), (240, 1), (245, 0), (250, 0), (255, 0), (260, 0), (265, 0), (270, 0), (275, 0), (280, 0), (285, 0), (290, 0), (295, 0), (300, 0), (305, 0), (310, 0), (315, 0), (320, 0), (325, 0), (330, 0), (335, 1), (340, 1), (345, 1), (350, 0), (355, 0), (360, 0), (365, 0), (370, 0), (375, 0), (380, 0), (385, 0), (390, 0), (395, 0), (400, 0), (405, 0), (410, 0), (415, 0), (420, 0), (425, 0), (430, 0), (435, 0), (440, 0), (445, 0), (450, 0), (455, 0), (460, 0), (465, 0), (470, 0), (475, 0), (480, 0), (485, 0), (490, 1), (495, 1), (500, 0), (505, 0), (510, 0), (515, 0), (520, 0), (525, 0), (530, 0), (535, 0), (540, 0), (545, 0), (550, 1), (555, 1), (560, 0), (565, 0), (570, 0), (575, 0), (580, 0), (585, 0), (590, 0), (595, 0), (600, 1), (605, 1), (610, 1), (615, 1), (620, 0), (625, 0), (630, 0), (635, 0), (640, 0), (645, 0), (650, 1), (655, 1), (660, 1), (665, 1), (670, 0), (675, 0), (680, 0), (685, 0), (690, 0), (695, 0), (700, 0), (705, 0), (710, 0), (715, 0), (720, 0), (725, 0), (730, 0), (735, 0), (740, 1), (745, 1), (750, 1), (755, 1), (760, 1), (765, 1), (770, 1), (775, 1), (780, 0), (785, 0), (790, 0), (795, 0), (800, 0), (805, 0), (810, 0), (815, 0), (820, 0), (825, 0), (830, 0), (835, 0), (840, 1), (845, 1), (850, 1), (855, 0), (860, 0), (865, 1), (870, 0), (875, 0), (880, 0), (885, 0), (890, 0), (895, 0), (900, 0), (905, 0), (910, 0), (915, 0), (920, 0), (925, 0), (930, 1), (935, 1), (940, 1), (945, 1), (950, 1), (955, 1), (960, 1), (965, 1), (970, 1), (975, 1), (980, 1), (985, 1), (990, 1), (995, 1), (1000, 1), (1005, 1), (1010, 1), (1015, 1), (1020, 0), (1025, 0)]
Vdin0_63  din0_63  0 PWL (0n 0.0v 4.745n 0.0v 4.755n 1.0v 9.745n 1.0v 9.755n 0.0v 14.745n 0.0v 14.755n 0.0v 19.745n 0.0v 19.755n 0.0v 24.745n 0.0v 24.755n 0.0v 29.745n 0.0v 29.755n 1.0v 34.745n 1.0v 34.755n 1.0v 39.745n 1.0v 39.755n 0.0v 44.745n 0.0v 44.755n 0.0v 49.745n 0.0v 49.755n 0.0v 54.745n 0.0v 54.755n 0.0v 59.745n 0.0v 59.755n 0.0v 64.745n 0.0v 64.755n 0.0v 69.745n 0.0v 69.755n 0.0v 74.745n 0.0v 74.755n 0.0v 79.745n 0.0v 79.755n 0.0v 84.745n 0.0v 84.755n 0.0v 89.745n 0.0v 89.755n 0.0v 94.745n 0.0v 94.755n 0.0v 99.745n 0.0v 99.755n 0.0v 104.745n 0.0v 104.755n 0.0v 109.745n 0.0v 109.755n 0.0v 114.745n 0.0v 114.755n 0.0v 119.745n 0.0v 119.755n 0.0v 124.745n 0.0v 124.755n 0.0v 129.745n 0.0v 129.755n 0.0v 134.745n 0.0v 134.755n 0.0v 139.745n 0.0v 139.755n 0.0v 144.745n 0.0v 144.755n 0.0v 149.745n 0.0v 149.755n 0.0v 154.745n 0.0v 154.755n 0.0v 159.745n 0.0v 159.755n 0.0v 164.745n 0.0v 164.755n 0.0v 169.745n 0.0v 169.755n 0.0v 174.745n 0.0v 174.755n 0.0v 179.745n 0.0v 179.755n 0.0v 184.745n 0.0v 184.755n 0.0v 189.745n 0.0v 189.755n 1.0v 194.745n 1.0v 194.755n 1.0v 199.745n 1.0v 199.755n 1.0v 204.745n 1.0v 204.755n 1.0v 209.745n 1.0v 209.755n 1.0v 214.745n 1.0v 214.755n 1.0v 219.745n 1.0v 219.755n 1.0v 224.745n 1.0v 224.755n 1.0v 229.745n 1.0v 229.755n 1.0v 234.745n 1.0v 234.755n 1.0v 239.745n 1.0v 239.755n 1.0v 244.745n 1.0v 244.755n 0.0v 249.745n 0.0v 249.755n 0.0v 254.745n 0.0v 254.755n 0.0v 259.745n 0.0v 259.755n 0.0v 264.745n 0.0v 264.755n 0.0v 269.745n 0.0v 269.755n 0.0v 274.745n 0.0v 274.755n 0.0v 279.745n 0.0v 279.755n 0.0v 284.745n 0.0v 284.755n 0.0v 289.745n 0.0v 289.755n 0.0v 294.745n 0.0v 294.755n 0.0v 299.745n 0.0v 299.755n 0.0v 304.745n 0.0v 304.755n 0.0v 309.745n 0.0v 309.755n 0.0v 314.745n 0.0v 314.755n 0.0v 319.745n 0.0v 319.755n 0.0v 324.745n 0.0v 324.755n 0.0v 329.745n 0.0v 329.755n 0.0v 334.745n 0.0v 334.755n 1.0v 339.745n 1.0v 339.755n 1.0v 344.745n 1.0v 344.755n 1.0v 349.745n 1.0v 349.755n 0.0v 354.745n 0.0v 354.755n 0.0v 359.745n 0.0v 359.755n 0.0v 364.745n 0.0v 364.755n 0.0v 369.745n 0.0v 369.755n 0.0v 374.745n 0.0v 374.755n 0.0v 379.745n 0.0v 379.755n 0.0v 384.745n 0.0v 384.755n 0.0v 389.745n 0.0v 389.755n 0.0v 394.745n 0.0v 394.755n 0.0v 399.745n 0.0v 399.755n 0.0v 404.745n 0.0v 404.755n 0.0v 409.745n 0.0v 409.755n 0.0v 414.745n 0.0v 414.755n 0.0v 419.745n 0.0v 419.755n 0.0v 424.745n 0.0v 424.755n 0.0v 429.745n 0.0v 429.755n 0.0v 434.745n 0.0v 434.755n 0.0v 439.745n 0.0v 439.755n 0.0v 444.745n 0.0v 444.755n 0.0v 449.745n 0.0v 449.755n 0.0v 454.745n 0.0v 454.755n 0.0v 459.745n 0.0v 459.755n 0.0v 464.745n 0.0v 464.755n 0.0v 469.745n 0.0v 469.755n 0.0v 474.745n 0.0v 474.755n 0.0v 479.745n 0.0v 479.755n 0.0v 484.745n 0.0v 484.755n 0.0v 489.745n 0.0v 489.755n 1.0v 494.745n 1.0v 494.755n 1.0v 499.745n 1.0v 499.755n 0.0v 504.745n 0.0v 504.755n 0.0v 509.745n 0.0v 509.755n 0.0v 514.745n 0.0v 514.755n 0.0v 519.745n 0.0v 519.755n 0.0v 524.745n 0.0v 524.755n 0.0v 529.745n 0.0v 529.755n 0.0v 534.745n 0.0v 534.755n 0.0v 539.745n 0.0v 539.755n 0.0v 544.745n 0.0v 544.755n 0.0v 549.745n 0.0v 549.755n 1.0v 554.745n 1.0v 554.755n 1.0v 559.745n 1.0v 559.755n 0.0v 564.745n 0.0v 564.755n 0.0v 569.745n 0.0v 569.755n 0.0v 574.745n 0.0v 574.755n 0.0v 579.745n 0.0v 579.755n 0.0v 584.745n 0.0v 584.755n 0.0v 589.745n 0.0v 589.755n 0.0v 594.745n 0.0v 594.755n 0.0v 599.745n 0.0v 599.755n 1.0v 604.745n 1.0v 604.755n 1.0v 609.745n 1.0v 609.755n 1.0v 614.745n 1.0v 614.755n 1.0v 619.745n 1.0v 619.755n 0.0v 624.745n 0.0v 624.755n 0.0v 629.745n 0.0v 629.755n 0.0v 634.745n 0.0v 634.755n 0.0v 639.745n 0.0v 639.755n 0.0v 644.745n 0.0v 644.755n 0.0v 649.745n 0.0v 649.755n 1.0v 654.745n 1.0v 654.755n 1.0v 659.745n 1.0v 659.755n 1.0v 664.745n 1.0v 664.755n 1.0v 669.745n 1.0v 669.755n 0.0v 674.745n 0.0v 674.755n 0.0v 679.745n 0.0v 679.755n 0.0v 684.745n 0.0v 684.755n 0.0v 689.745n 0.0v 689.755n 0.0v 694.745n 0.0v 694.755n 0.0v 699.745n 0.0v 699.755n 0.0v 704.745n 0.0v 704.755n 0.0v 709.745n 0.0v 709.755n 0.0v 714.745n 0.0v 714.755n 0.0v 719.745n 0.0v 719.755n 0.0v 724.745n 0.0v 724.755n 0.0v 729.745n 0.0v 729.755n 0.0v 734.745n 0.0v 734.755n 0.0v 739.745n 0.0v 739.755n 1.0v 744.745n 1.0v 744.755n 1.0v 749.745n 1.0v 749.755n 1.0v 754.745n 1.0v 754.755n 1.0v 759.745n 1.0v 759.755n 1.0v 764.745n 1.0v 764.755n 1.0v 769.745n 1.0v 769.755n 1.0v 774.745n 1.0v 774.755n 1.0v 779.745n 1.0v 779.755n 0.0v 784.745n 0.0v 784.755n 0.0v 789.745n 0.0v 789.755n 0.0v 794.745n 0.0v 794.755n 0.0v 799.745n 0.0v 799.755n 0.0v 804.745n 0.0v 804.755n 0.0v 809.745n 0.0v 809.755n 0.0v 814.745n 0.0v 814.755n 0.0v 819.745n 0.0v 819.755n 0.0v 824.745n 0.0v 824.755n 0.0v 829.745n 0.0v 829.755n 0.0v 834.745n 0.0v 834.755n 0.0v 839.745n 0.0v 839.755n 1.0v 844.745n 1.0v 844.755n 1.0v 849.745n 1.0v 849.755n 1.0v 854.745n 1.0v 854.755n 0.0v 859.745n 0.0v 859.755n 0.0v 864.745n 0.0v 864.755n 1.0v 869.745n 1.0v 869.755n 0.0v 874.745n 0.0v 874.755n 0.0v 879.745n 0.0v 879.755n 0.0v 884.745n 0.0v 884.755n 0.0v 889.745n 0.0v 889.755n 0.0v 894.745n 0.0v 894.755n 0.0v 899.745n 0.0v 899.755n 0.0v 904.745n 0.0v 904.755n 0.0v 909.745n 0.0v 909.755n 0.0v 914.745n 0.0v 914.755n 0.0v 919.745n 0.0v 919.755n 0.0v 924.745n 0.0v 924.755n 0.0v 929.745n 0.0v 929.755n 1.0v 934.745n 1.0v 934.755n 1.0v 939.745n 1.0v 939.755n 1.0v 944.745n 1.0v 944.755n 1.0v 949.745n 1.0v 949.755n 1.0v 954.745n 1.0v 954.755n 1.0v 959.745n 1.0v 959.755n 1.0v 964.745n 1.0v 964.755n 1.0v 969.745n 1.0v 969.755n 1.0v 974.745n 1.0v 974.755n 1.0v 979.745n 1.0v 979.755n 1.0v 984.745n 1.0v 984.755n 1.0v 989.745n 1.0v 989.755n 1.0v 994.745n 1.0v 994.755n 1.0v 999.745n 1.0v 999.755n 1.0v 1004.745n 1.0v 1004.755n 1.0v 1009.745n 1.0v 1009.755n 1.0v 1014.745n 1.0v 1014.755n 1.0v 1019.745n 1.0v 1019.755n 0.0v 1024.745n 0.0v 1024.755n 0.0v )
* (time, data): [(0, 0), (5, 0), (10, 1), (15, 0), (20, 0), (25, 0), (30, 0), (35, 0), (40, 0), (45, 0), (50, 0), (55, 0), (60, 1), (65, 1), (70, 1), (75, 1), (80, 1), (85, 1), (90, 0), (95, 0), (100, 0), (105, 0), (110, 0), (115, 0), (120, 0), (125, 0), (130, 0), (135, 0), (140, 0), (145, 0), (150, 0), (155, 0), (160, 0), (165, 0), (170, 0), (175, 1), (180, 1), (185, 1), (190, 1), (195, 1), (200, 1), (205, 1), (210, 1), (215, 1), (220, 1), (225, 1), (230, 1), (235, 1), (240, 1), (245, 0), (250, 1), (255, 1), (260, 1), (265, 1), (270, 1), (275, 1), (280, 1), (285, 0), (290, 0), (295, 0), (300, 0), (305, 0), (310, 0), (315, 0), (320, 0), (325, 0), (330, 0), (335, 0), (340, 0), (345, 0), (350, 0), (355, 0), (360, 0), (365, 1), (370, 1), (375, 1), (380, 1), (385, 1), (390, 0), (395, 0), (400, 0), (405, 0), (410, 0), (415, 0), (420, 1), (425, 1), (430, 1), (435, 1), (440, 1), (445, 1), (450, 1), (455, 1), (460, 1), (465, 1), (470, 1), (475, 1), (480, 1), (485, 1), (490, 1), (495, 1), (500, 1), (505, 1), (510, 1), (515, 1), (520, 0), (525, 0), (530, 0), (535, 0), (540, 0), (545, 0), (550, 0), (555, 0), (560, 0), (565, 0), (570, 0), (575, 0), (580, 1), (585, 0), (590, 0), (595, 0), (600, 0), (605, 0), (610, 0), (615, 1), (620, 1), (625, 1), (630, 1), (635, 1), (640, 1), (645, 1), (650, 1), (655, 1), (660, 1), (665, 1), (670, 1), (675, 1), (680, 1), (685, 1), (690, 1), (695, 1), (700, 1), (705, 1), (710, 1), (715, 1), (720, 1), (725, 1), (730, 0), (735, 1), (740, 1), (745, 1), (750, 1), (755, 1), (760, 0), (765, 1), (770, 1), (775, 1), (780, 1), (785, 1), (790, 1), (795, 1), (800, 1), (805, 1), (810, 0), (815, 0), (820, 0), (825, 0), (830, 0), (835, 0), (840, 0), (845, 0), (850, 0), (855, 0), (860, 0), (865, 0), (870, 0), (875, 0), (880, 0), (885, 0), (890, 0), (895, 0), (900, 1), (905, 1), (910, 1), (915, 1), (920, 1), (925, 1), (930, 0), (935, 0), (940, 0), (945, 1), (950, 1), (955, 1), (960, 1), (965, 1), (970, 1), (975, 1), (980, 1), (985, 1), (990, 1), (995, 1), (1000, 1), (1005, 1), (1010, 1), (1015, 1), (1020, 0), (1025, 0)]
Vdin1_0  din1_0  0 PWL (0n 0.0v 4.745n 0.0v 4.755n 0.0v 9.745n 0.0v 9.755n 1.0v 14.745n 1.0v 14.755n 0.0v 19.745n 0.0v 19.755n 0.0v 24.745n 0.0v 24.755n 0.0v 29.745n 0.0v 29.755n 0.0v 34.745n 0.0v 34.755n 0.0v 39.745n 0.0v 39.755n 0.0v 44.745n 0.0v 44.755n 0.0v 49.745n 0.0v 49.755n 0.0v 54.745n 0.0v 54.755n 0.0v 59.745n 0.0v 59.755n 1.0v 64.745n 1.0v 64.755n 1.0v 69.745n 1.0v 69.755n 1.0v 74.745n 1.0v 74.755n 1.0v 79.745n 1.0v 79.755n 1.0v 84.745n 1.0v 84.755n 1.0v 89.745n 1.0v 89.755n 0.0v 94.745n 0.0v 94.755n 0.0v 99.745n 0.0v 99.755n 0.0v 104.745n 0.0v 104.755n 0.0v 109.745n 0.0v 109.755n 0.0v 114.745n 0.0v 114.755n 0.0v 119.745n 0.0v 119.755n 0.0v 124.745n 0.0v 124.755n 0.0v 129.745n 0.0v 129.755n 0.0v 134.745n 0.0v 134.755n 0.0v 139.745n 0.0v 139.755n 0.0v 144.745n 0.0v 144.755n 0.0v 149.745n 0.0v 149.755n 0.0v 154.745n 0.0v 154.755n 0.0v 159.745n 0.0v 159.755n 0.0v 164.745n 0.0v 164.755n 0.0v 169.745n 0.0v 169.755n 0.0v 174.745n 0.0v 174.755n 1.0v 179.745n 1.0v 179.755n 1.0v 184.745n 1.0v 184.755n 1.0v 189.745n 1.0v 189.755n 1.0v 194.745n 1.0v 194.755n 1.0v 199.745n 1.0v 199.755n 1.0v 204.745n 1.0v 204.755n 1.0v 209.745n 1.0v 209.755n 1.0v 214.745n 1.0v 214.755n 1.0v 219.745n 1.0v 219.755n 1.0v 224.745n 1.0v 224.755n 1.0v 229.745n 1.0v 229.755n 1.0v 234.745n 1.0v 234.755n 1.0v 239.745n 1.0v 239.755n 1.0v 244.745n 1.0v 244.755n 0.0v 249.745n 0.0v 249.755n 1.0v 254.745n 1.0v 254.755n 1.0v 259.745n 1.0v 259.755n 1.0v 264.745n 1.0v 264.755n 1.0v 269.745n 1.0v 269.755n 1.0v 274.745n 1.0v 274.755n 1.0v 279.745n 1.0v 279.755n 1.0v 284.745n 1.0v 284.755n 0.0v 289.745n 0.0v 289.755n 0.0v 294.745n 0.0v 294.755n 0.0v 299.745n 0.0v 299.755n 0.0v 304.745n 0.0v 304.755n 0.0v 309.745n 0.0v 309.755n 0.0v 314.745n 0.0v 314.755n 0.0v 319.745n 0.0v 319.755n 0.0v 324.745n 0.0v 324.755n 0.0v 329.745n 0.0v 329.755n 0.0v 334.745n 0.0v 334.755n 0.0v 339.745n 0.0v 339.755n 0.0v 344.745n 0.0v 344.755n 0.0v 349.745n 0.0v 349.755n 0.0v 354.745n 0.0v 354.755n 0.0v 359.745n 0.0v 359.755n 0.0v 364.745n 0.0v 364.755n 1.0v 369.745n 1.0v 369.755n 1.0v 374.745n 1.0v 374.755n 1.0v 379.745n 1.0v 379.755n 1.0v 384.745n 1.0v 384.755n 1.0v 389.745n 1.0v 389.755n 0.0v 394.745n 0.0v 394.755n 0.0v 399.745n 0.0v 399.755n 0.0v 404.745n 0.0v 404.755n 0.0v 409.745n 0.0v 409.755n 0.0v 414.745n 0.0v 414.755n 0.0v 419.745n 0.0v 419.755n 1.0v 424.745n 1.0v 424.755n 1.0v 429.745n 1.0v 429.755n 1.0v 434.745n 1.0v 434.755n 1.0v 439.745n 1.0v 439.755n 1.0v 444.745n 1.0v 444.755n 1.0v 449.745n 1.0v 449.755n 1.0v 454.745n 1.0v 454.755n 1.0v 459.745n 1.0v 459.755n 1.0v 464.745n 1.0v 464.755n 1.0v 469.745n 1.0v 469.755n 1.0v 474.745n 1.0v 474.755n 1.0v 479.745n 1.0v 479.755n 1.0v 484.745n 1.0v 484.755n 1.0v 489.745n 1.0v 489.755n 1.0v 494.745n 1.0v 494.755n 1.0v 499.745n 1.0v 499.755n 1.0v 504.745n 1.0v 504.755n 1.0v 509.745n 1.0v 509.755n 1.0v 514.745n 1.0v 514.755n 1.0v 519.745n 1.0v 519.755n 0.0v 524.745n 0.0v 524.755n 0.0v 529.745n 0.0v 529.755n 0.0v 534.745n 0.0v 534.755n 0.0v 539.745n 0.0v 539.755n 0.0v 544.745n 0.0v 544.755n 0.0v 549.745n 0.0v 549.755n 0.0v 554.745n 0.0v 554.755n 0.0v 559.745n 0.0v 559.755n 0.0v 564.745n 0.0v 564.755n 0.0v 569.745n 0.0v 569.755n 0.0v 574.745n 0.0v 574.755n 0.0v 579.745n 0.0v 579.755n 1.0v 584.745n 1.0v 584.755n 0.0v 589.745n 0.0v 589.755n 0.0v 594.745n 0.0v 594.755n 0.0v 599.745n 0.0v 599.755n 0.0v 604.745n 0.0v 604.755n 0.0v 609.745n 0.0v 609.755n 0.0v 614.745n 0.0v 614.755n 1.0v 619.745n 1.0v 619.755n 1.0v 624.745n 1.0v 624.755n 1.0v 629.745n 1.0v 629.755n 1.0v 634.745n 1.0v 634.755n 1.0v 639.745n 1.0v 639.755n 1.0v 644.745n 1.0v 644.755n 1.0v 649.745n 1.0v 649.755n 1.0v 654.745n 1.0v 654.755n 1.0v 659.745n 1.0v 659.755n 1.0v 664.745n 1.0v 664.755n 1.0v 669.745n 1.0v 669.755n 1.0v 674.745n 1.0v 674.755n 1.0v 679.745n 1.0v 679.755n 1.0v 684.745n 1.0v 684.755n 1.0v 689.745n 1.0v 689.755n 1.0v 694.745n 1.0v 694.755n 1.0v 699.745n 1.0v 699.755n 1.0v 704.745n 1.0v 704.755n 1.0v 709.745n 1.0v 709.755n 1.0v 714.745n 1.0v 714.755n 1.0v 719.745n 1.0v 719.755n 1.0v 724.745n 1.0v 724.755n 1.0v 729.745n 1.0v 729.755n 0.0v 734.745n 0.0v 734.755n 1.0v 739.745n 1.0v 739.755n 1.0v 744.745n 1.0v 744.755n 1.0v 749.745n 1.0v 749.755n 1.0v 754.745n 1.0v 754.755n 1.0v 759.745n 1.0v 759.755n 0.0v 764.745n 0.0v 764.755n 1.0v 769.745n 1.0v 769.755n 1.0v 774.745n 1.0v 774.755n 1.0v 779.745n 1.0v 779.755n 1.0v 784.745n 1.0v 784.755n 1.0v 789.745n 1.0v 789.755n 1.0v 794.745n 1.0v 794.755n 1.0v 799.745n 1.0v 799.755n 1.0v 804.745n 1.0v 804.755n 1.0v 809.745n 1.0v 809.755n 0.0v 814.745n 0.0v 814.755n 0.0v 819.745n 0.0v 819.755n 0.0v 824.745n 0.0v 824.755n 0.0v 829.745n 0.0v 829.755n 0.0v 834.745n 0.0v 834.755n 0.0v 839.745n 0.0v 839.755n 0.0v 844.745n 0.0v 844.755n 0.0v 849.745n 0.0v 849.755n 0.0v 854.745n 0.0v 854.755n 0.0v 859.745n 0.0v 859.755n 0.0v 864.745n 0.0v 864.755n 0.0v 869.745n 0.0v 869.755n 0.0v 874.745n 0.0v 874.755n 0.0v 879.745n 0.0v 879.755n 0.0v 884.745n 0.0v 884.755n 0.0v 889.745n 0.0v 889.755n 0.0v 894.745n 0.0v 894.755n 0.0v 899.745n 0.0v 899.755n 1.0v 904.745n 1.0v 904.755n 1.0v 909.745n 1.0v 909.755n 1.0v 914.745n 1.0v 914.755n 1.0v 919.745n 1.0v 919.755n 1.0v 924.745n 1.0v 924.755n 1.0v 929.745n 1.0v 929.755n 0.0v 934.745n 0.0v 934.755n 0.0v 939.745n 0.0v 939.755n 0.0v 944.745n 0.0v 944.755n 1.0v 949.745n 1.0v 949.755n 1.0v 954.745n 1.0v 954.755n 1.0v 959.745n 1.0v 959.755n 1.0v 964.745n 1.0v 964.755n 1.0v 969.745n 1.0v 969.755n 1.0v 974.745n 1.0v 974.755n 1.0v 979.745n 1.0v 979.755n 1.0v 984.745n 1.0v 984.755n 1.0v 989.745n 1.0v 989.755n 1.0v 994.745n 1.0v 994.755n 1.0v 999.745n 1.0v 999.755n 1.0v 1004.745n 1.0v 1004.755n 1.0v 1009.745n 1.0v 1009.755n 1.0v 1014.745n 1.0v 1014.755n 1.0v 1019.745n 1.0v 1019.755n 0.0v 1024.745n 0.0v 1024.755n 0.0v )
* (time, data): [(0, 0), (5, 0), (10, 0), (15, 0), (20, 0), (25, 0), (30, 0), (35, 0), (40, 0), (45, 0), (50, 0), (55, 0), (60, 0), (65, 0), (70, 0), (75, 0), (80, 1), (85, 1), (90, 1), (95, 1), (100, 1), (105, 1), (110, 1), (115, 1), (120, 1), (125, 1), (130, 0), (135, 0), (140, 0), (145, 1), (150, 1), (155, 1), (160, 1), (165, 1), (170, 1), (175, 0), (180, 1), (185, 1), (190, 1), (195, 1), (200, 1), (205, 1), (210, 1), (215, 1), (220, 1), (225, 1), (230, 1), (235, 1), (240, 1), (245, 0), (250, 0), (255, 0), (260, 0), (265, 0), (270, 0), (275, 0), (280, 0), (285, 1), (290, 1), (295, 1), (300, 1), (305, 1), (310, 1), (315, 1), (320, 1), (325, 1), (330, 1), (335, 1), (340, 1), (345, 1), (350, 1), (355, 1), (360, 1), (365, 0), (370, 0), (375, 0), (380, 1), (385, 1), (390, 1), (395, 1), (400, 1), (405, 1), (410, 1), (415, 1), (420, 1), (425, 1), (430, 1), (435, 1), (440, 1), (445, 1), (450, 1), (455, 1), (460, 1), (465, 1), (470, 1), (475, 1), (480, 1), (485, 1), (490, 1), (495, 1), (500, 1), (505, 0), (510, 0), (515, 0), (520, 0), (525, 0), (530, 0), (535, 0), (540, 0), (545, 0), (550, 0), (555, 0), (560, 0), (565, 0), (570, 0), (575, 0), (580, 0), (585, 1), (590, 1), (595, 1), (600, 1), (605, 0), (610, 0), (615, 0), (620, 0), (625, 0), (630, 0), (635, 0), (640, 0), (645, 0), (650, 0), (655, 0), (660, 0), (665, 0), (670, 0), (675, 0), (680, 0), (685, 0), (690, 1), (695, 1), (700, 1), (705, 1), (710, 1), (715, 1), (720, 1), (725, 1), (730, 1), (735, 0), (740, 0), (745, 0), (750, 0), (755, 0), (760, 0), (765, 0), (770, 0), (775, 0), (780, 0), (785, 0), (790, 0), (795, 0), (800, 0), (805, 0), (810, 0), (815, 0), (820, 0), (825, 0), (830, 0), (835, 0), (840, 0), (845, 0), (850, 0), (855, 0), (860, 0), (865, 0), (870, 0), (875, 0), (880, 0), (885, 0), (890, 0), (895, 0), (900, 1), (905, 1), (910, 1), (915, 1), (920, 1), (925, 1), (930, 1), (935, 1), (940, 1), (945, 1), (950, 1), (955, 1), (960, 1), (965, 1), (970, 1), (975, 1), (980, 1), (985, 1), (990, 1), (995, 1), (1000, 0), (1005, 0), (1010, 0), (1015, 0), (1020, 0), (1025, 0)]
Vdin1_1  din1_1  0 PWL (0n 0.0v 4.745n 0.0v 4.755n 0.0v 9.745n 0.0v 9.755n 0.0v 14.745n 0.0v 14.755n 0.0v 19.745n 0.0v 19.755n 0.0v 24.745n 0.0v 24.755n 0.0v 29.745n 0.0v 29.755n 0.0v 34.745n 0.0v 34.755n 0.0v 39.745n 0.0v 39.755n 0.0v 44.745n 0.0v 44.755n 0.0v 49.745n 0.0v 49.755n 0.0v 54.745n 0.0v 54.755n 0.0v 59.745n 0.0v 59.755n 0.0v 64.745n 0.0v 64.755n 0.0v 69.745n 0.0v 69.755n 0.0v 74.745n 0.0v 74.755n 0.0v 79.745n 0.0v 79.755n 1.0v 84.745n 1.0v 84.755n 1.0v 89.745n 1.0v 89.755n 1.0v 94.745n 1.0v 94.755n 1.0v 99.745n 1.0v 99.755n 1.0v 104.745n 1.0v 104.755n 1.0v 109.745n 1.0v 109.755n 1.0v 114.745n 1.0v 114.755n 1.0v 119.745n 1.0v 119.755n 1.0v 124.745n 1.0v 124.755n 1.0v 129.745n 1.0v 129.755n 0.0v 134.745n 0.0v 134.755n 0.0v 139.745n 0.0v 139.755n 0.0v 144.745n 0.0v 144.755n 1.0v 149.745n 1.0v 149.755n 1.0v 154.745n 1.0v 154.755n 1.0v 159.745n 1.0v 159.755n 1.0v 164.745n 1.0v 164.755n 1.0v 169.745n 1.0v 169.755n 1.0v 174.745n 1.0v 174.755n 0.0v 179.745n 0.0v 179.755n 1.0v 184.745n 1.0v 184.755n 1.0v 189.745n 1.0v 189.755n 1.0v 194.745n 1.0v 194.755n 1.0v 199.745n 1.0v 199.755n 1.0v 204.745n 1.0v 204.755n 1.0v 209.745n 1.0v 209.755n 1.0v 214.745n 1.0v 214.755n 1.0v 219.745n 1.0v 219.755n 1.0v 224.745n 1.0v 224.755n 1.0v 229.745n 1.0v 229.755n 1.0v 234.745n 1.0v 234.755n 1.0v 239.745n 1.0v 239.755n 1.0v 244.745n 1.0v 244.755n 0.0v 249.745n 0.0v 249.755n 0.0v 254.745n 0.0v 254.755n 0.0v 259.745n 0.0v 259.755n 0.0v 264.745n 0.0v 264.755n 0.0v 269.745n 0.0v 269.755n 0.0v 274.745n 0.0v 274.755n 0.0v 279.745n 0.0v 279.755n 0.0v 284.745n 0.0v 284.755n 1.0v 289.745n 1.0v 289.755n 1.0v 294.745n 1.0v 294.755n 1.0v 299.745n 1.0v 299.755n 1.0v 304.745n 1.0v 304.755n 1.0v 309.745n 1.0v 309.755n 1.0v 314.745n 1.0v 314.755n 1.0v 319.745n 1.0v 319.755n 1.0v 324.745n 1.0v 324.755n 1.0v 329.745n 1.0v 329.755n 1.0v 334.745n 1.0v 334.755n 1.0v 339.745n 1.0v 339.755n 1.0v 344.745n 1.0v 344.755n 1.0v 349.745n 1.0v 349.755n 1.0v 354.745n 1.0v 354.755n 1.0v 359.745n 1.0v 359.755n 1.0v 364.745n 1.0v 364.755n 0.0v 369.745n 0.0v 369.755n 0.0v 374.745n 0.0v 374.755n 0.0v 379.745n 0.0v 379.755n 1.0v 384.745n 1.0v 384.755n 1.0v 389.745n 1.0v 389.755n 1.0v 394.745n 1.0v 394.755n 1.0v 399.745n 1.0v 399.755n 1.0v 404.745n 1.0v 404.755n 1.0v 409.745n 1.0v 409.755n 1.0v 414.745n 1.0v 414.755n 1.0v 419.745n 1.0v 419.755n 1.0v 424.745n 1.0v 424.755n 1.0v 429.745n 1.0v 429.755n 1.0v 434.745n 1.0v 434.755n 1.0v 439.745n 1.0v 439.755n 1.0v 444.745n 1.0v 444.755n 1.0v 449.745n 1.0v 449.755n 1.0v 454.745n 1.0v 454.755n 1.0v 459.745n 1.0v 459.755n 1.0v 464.745n 1.0v 464.755n 1.0v 469.745n 1.0v 469.755n 1.0v 474.745n 1.0v 474.755n 1.0v 479.745n 1.0v 479.755n 1.0v 484.745n 1.0v 484.755n 1.0v 489.745n 1.0v 489.755n 1.0v 494.745n 1.0v 494.755n 1.0v 499.745n 1.0v 499.755n 1.0v 504.745n 1.0v 504.755n 0.0v 509.745n 0.0v 509.755n 0.0v 514.745n 0.0v 514.755n 0.0v 519.745n 0.0v 519.755n 0.0v 524.745n 0.0v 524.755n 0.0v 529.745n 0.0v 529.755n 0.0v 534.745n 0.0v 534.755n 0.0v 539.745n 0.0v 539.755n 0.0v 544.745n 0.0v 544.755n 0.0v 549.745n 0.0v 549.755n 0.0v 554.745n 0.0v 554.755n 0.0v 559.745n 0.0v 559.755n 0.0v 564.745n 0.0v 564.755n 0.0v 569.745n 0.0v 569.755n 0.0v 574.745n 0.0v 574.755n 0.0v 579.745n 0.0v 579.755n 0.0v 584.745n 0.0v 584.755n 1.0v 589.745n 1.0v 589.755n 1.0v 594.745n 1.0v 594.755n 1.0v 599.745n 1.0v 599.755n 1.0v 604.745n 1.0v 604.755n 0.0v 609.745n 0.0v 609.755n 0.0v 614.745n 0.0v 614.755n 0.0v 619.745n 0.0v 619.755n 0.0v 624.745n 0.0v 624.755n 0.0v 629.745n 0.0v 629.755n 0.0v 634.745n 0.0v 634.755n 0.0v 639.745n 0.0v 639.755n 0.0v 644.745n 0.0v 644.755n 0.0v 649.745n 0.0v 649.755n 0.0v 654.745n 0.0v 654.755n 0.0v 659.745n 0.0v 659.755n 0.0v 664.745n 0.0v 664.755n 0.0v 669.745n 0.0v 669.755n 0.0v 674.745n 0.0v 674.755n 0.0v 679.745n 0.0v 679.755n 0.0v 684.745n 0.0v 684.755n 0.0v 689.745n 0.0v 689.755n 1.0v 694.745n 1.0v 694.755n 1.0v 699.745n 1.0v 699.755n 1.0v 704.745n 1.0v 704.755n 1.0v 709.745n 1.0v 709.755n 1.0v 714.745n 1.0v 714.755n 1.0v 719.745n 1.0v 719.755n 1.0v 724.745n 1.0v 724.755n 1.0v 729.745n 1.0v 729.755n 1.0v 734.745n 1.0v 734.755n 0.0v 739.745n 0.0v 739.755n 0.0v 744.745n 0.0v 744.755n 0.0v 749.745n 0.0v 749.755n 0.0v 754.745n 0.0v 754.755n 0.0v 759.745n 0.0v 759.755n 0.0v 764.745n 0.0v 764.755n 0.0v 769.745n 0.0v 769.755n 0.0v 774.745n 0.0v 774.755n 0.0v 779.745n 0.0v 779.755n 0.0v 784.745n 0.0v 784.755n 0.0v 789.745n 0.0v 789.755n 0.0v 794.745n 0.0v 794.755n 0.0v 799.745n 0.0v 799.755n 0.0v 804.745n 0.0v 804.755n 0.0v 809.745n 0.0v 809.755n 0.0v 814.745n 0.0v 814.755n 0.0v 819.745n 0.0v 819.755n 0.0v 824.745n 0.0v 824.755n 0.0v 829.745n 0.0v 829.755n 0.0v 834.745n 0.0v 834.755n 0.0v 839.745n 0.0v 839.755n 0.0v 844.745n 0.0v 844.755n 0.0v 849.745n 0.0v 849.755n 0.0v 854.745n 0.0v 854.755n 0.0v 859.745n 0.0v 859.755n 0.0v 864.745n 0.0v 864.755n 0.0v 869.745n 0.0v 869.755n 0.0v 874.745n 0.0v 874.755n 0.0v 879.745n 0.0v 879.755n 0.0v 884.745n 0.0v 884.755n 0.0v 889.745n 0.0v 889.755n 0.0v 894.745n 0.0v 894.755n 0.0v 899.745n 0.0v 899.755n 1.0v 904.745n 1.0v 904.755n 1.0v 909.745n 1.0v 909.755n 1.0v 914.745n 1.0v 914.755n 1.0v 919.745n 1.0v 919.755n 1.0v 924.745n 1.0v 924.755n 1.0v 929.745n 1.0v 929.755n 1.0v 934.745n 1.0v 934.755n 1.0v 939.745n 1.0v 939.755n 1.0v 944.745n 1.0v 944.755n 1.0v 949.745n 1.0v 949.755n 1.0v 954.745n 1.0v 954.755n 1.0v 959.745n 1.0v 959.755n 1.0v 964.745n 1.0v 964.755n 1.0v 969.745n 1.0v 969.755n 1.0v 974.745n 1.0v 974.755n 1.0v 979.745n 1.0v 979.755n 1.0v 984.745n 1.0v 984.755n 1.0v 989.745n 1.0v 989.755n 1.0v 994.745n 1.0v 994.755n 1.0v 999.745n 1.0v 999.755n 0.0v 1004.745n 0.0v 1004.755n 0.0v 1009.745n 0.0v 1009.755n 0.0v 1014.745n 0.0v 1014.755n 0.0v 1019.745n 0.0v 1019.755n 0.0v 1024.745n 0.0v 1024.755n 0.0v )
* (time, data): [(0, 0), (5, 0), (10, 0), (15, 0), (20, 0), (25, 0), (30, 0), (35, 0), (40, 0), (45, 0), (50, 0), (55, 0), (60, 1), (65, 1), (70, 1), (75, 1), (80, 0), (85, 0), (90, 0), (95, 0), (100, 0), (105, 0), (110, 0), (115, 0), (120, 0), (125, 0), (130, 1), (135, 1), (140, 1), (145, 1), (150, 1), (155, 1), (160, 1), (165, 1), (170, 1), (175, 0), (180, 0), (185, 0), (190, 0), (195, 0), (200, 0), (205, 0), (210, 0), (215, 0), (220, 0), (225, 0), (230, 0), (235, 0), (240, 0), (245, 0), (250, 0), (255, 0), (260, 0), (265, 0), (270, 0), (275, 0), (280, 0), (285, 1), (290, 1), (295, 1), (300, 1), (305, 1), (310, 1), (315, 1), (320, 1), (325, 1), (330, 1), (335, 1), (340, 1), (345, 1), (350, 1), (355, 1), (360, 1), (365, 1), (370, 1), (375, 1), (380, 1), (385, 1), (390, 1), (395, 0), (400, 0), (405, 0), (410, 0), (415, 0), (420, 1), (425, 1), (430, 1), (435, 1), (440, 1), (445, 1), (450, 1), (455, 1), (460, 1), (465, 1), (470, 1), (475, 1), (480, 1), (485, 1), (490, 1), (495, 1), (500, 1), (505, 0), (510, 0), (515, 0), (520, 0), (525, 0), (530, 0), (535, 0), (540, 0), (545, 0), (550, 0), (555, 0), (560, 0), (565, 0), (570, 0), (575, 0), (580, 1), (585, 1), (590, 1), (595, 1), (600, 1), (605, 1), (610, 1), (615, 0), (620, 0), (625, 0), (630, 0), (635, 0), (640, 0), (645, 0), (650, 0), (655, 0), (660, 0), (665, 0), (670, 0), (675, 0), (680, 0), (685, 0), (690, 0), (695, 0), (700, 0), (705, 0), (710, 0), (715, 0), (720, 0), (725, 0), (730, 1), (735, 1), (740, 1), (745, 1), (750, 1), (755, 1), (760, 1), (765, 0), (770, 0), (775, 0), (780, 0), (785, 0), (790, 1), (795, 1), (800, 1), (805, 1), (810, 0), (815, 0), (820, 0), (825, 0), (830, 1), (835, 1), (840, 1), (845, 1), (850, 1), (855, 1), (860, 0), (865, 0), (870, 0), (875, 0), (880, 0), (885, 0), (890, 0), (895, 0), (900, 0), (905, 0), (910, 0), (915, 0), (920, 0), (925, 0), (930, 1), (935, 1), (940, 1), (945, 1), (950, 1), (955, 1), (960, 1), (965, 1), (970, 1), (975, 1), (980, 1), (985, 1), (990, 1), (995, 1), (1000, 1), (1005, 1), (1010, 0), (1015, 0), (1020, 1), (1025, 1)]
Vdin1_2  din1_2  0 PWL (0n 0.0v 4.745n 0.0v 4.755n 0.0v 9.745n 0.0v 9.755n 0.0v 14.745n 0.0v 14.755n 0.0v 19.745n 0.0v 19.755n 0.0v 24.745n 0.0v 24.755n 0.0v 29.745n 0.0v 29.755n 0.0v 34.745n 0.0v 34.755n 0.0v 39.745n 0.0v 39.755n 0.0v 44.745n 0.0v 44.755n 0.0v 49.745n 0.0v 49.755n 0.0v 54.745n 0.0v 54.755n 0.0v 59.745n 0.0v 59.755n 1.0v 64.745n 1.0v 64.755n 1.0v 69.745n 1.0v 69.755n 1.0v 74.745n 1.0v 74.755n 1.0v 79.745n 1.0v 79.755n 0.0v 84.745n 0.0v 84.755n 0.0v 89.745n 0.0v 89.755n 0.0v 94.745n 0.0v 94.755n 0.0v 99.745n 0.0v 99.755n 0.0v 104.745n 0.0v 104.755n 0.0v 109.745n 0.0v 109.755n 0.0v 114.745n 0.0v 114.755n 0.0v 119.745n 0.0v 119.755n 0.0v 124.745n 0.0v 124.755n 0.0v 129.745n 0.0v 129.755n 1.0v 134.745n 1.0v 134.755n 1.0v 139.745n 1.0v 139.755n 1.0v 144.745n 1.0v 144.755n 1.0v 149.745n 1.0v 149.755n 1.0v 154.745n 1.0v 154.755n 1.0v 159.745n 1.0v 159.755n 1.0v 164.745n 1.0v 164.755n 1.0v 169.745n 1.0v 169.755n 1.0v 174.745n 1.0v 174.755n 0.0v 179.745n 0.0v 179.755n 0.0v 184.745n 0.0v 184.755n 0.0v 189.745n 0.0v 189.755n 0.0v 194.745n 0.0v 194.755n 0.0v 199.745n 0.0v 199.755n 0.0v 204.745n 0.0v 204.755n 0.0v 209.745n 0.0v 209.755n 0.0v 214.745n 0.0v 214.755n 0.0v 219.745n 0.0v 219.755n 0.0v 224.745n 0.0v 224.755n 0.0v 229.745n 0.0v 229.755n 0.0v 234.745n 0.0v 234.755n 0.0v 239.745n 0.0v 239.755n 0.0v 244.745n 0.0v 244.755n 0.0v 249.745n 0.0v 249.755n 0.0v 254.745n 0.0v 254.755n 0.0v 259.745n 0.0v 259.755n 0.0v 264.745n 0.0v 264.755n 0.0v 269.745n 0.0v 269.755n 0.0v 274.745n 0.0v 274.755n 0.0v 279.745n 0.0v 279.755n 0.0v 284.745n 0.0v 284.755n 1.0v 289.745n 1.0v 289.755n 1.0v 294.745n 1.0v 294.755n 1.0v 299.745n 1.0v 299.755n 1.0v 304.745n 1.0v 304.755n 1.0v 309.745n 1.0v 309.755n 1.0v 314.745n 1.0v 314.755n 1.0v 319.745n 1.0v 319.755n 1.0v 324.745n 1.0v 324.755n 1.0v 329.745n 1.0v 329.755n 1.0v 334.745n 1.0v 334.755n 1.0v 339.745n 1.0v 339.755n 1.0v 344.745n 1.0v 344.755n 1.0v 349.745n 1.0v 349.755n 1.0v 354.745n 1.0v 354.755n 1.0v 359.745n 1.0v 359.755n 1.0v 364.745n 1.0v 364.755n 1.0v 369.745n 1.0v 369.755n 1.0v 374.745n 1.0v 374.755n 1.0v 379.745n 1.0v 379.755n 1.0v 384.745n 1.0v 384.755n 1.0v 389.745n 1.0v 389.755n 1.0v 394.745n 1.0v 394.755n 0.0v 399.745n 0.0v 399.755n 0.0v 404.745n 0.0v 404.755n 0.0v 409.745n 0.0v 409.755n 0.0v 414.745n 0.0v 414.755n 0.0v 419.745n 0.0v 419.755n 1.0v 424.745n 1.0v 424.755n 1.0v 429.745n 1.0v 429.755n 1.0v 434.745n 1.0v 434.755n 1.0v 439.745n 1.0v 439.755n 1.0v 444.745n 1.0v 444.755n 1.0v 449.745n 1.0v 449.755n 1.0v 454.745n 1.0v 454.755n 1.0v 459.745n 1.0v 459.755n 1.0v 464.745n 1.0v 464.755n 1.0v 469.745n 1.0v 469.755n 1.0v 474.745n 1.0v 474.755n 1.0v 479.745n 1.0v 479.755n 1.0v 484.745n 1.0v 484.755n 1.0v 489.745n 1.0v 489.755n 1.0v 494.745n 1.0v 494.755n 1.0v 499.745n 1.0v 499.755n 1.0v 504.745n 1.0v 504.755n 0.0v 509.745n 0.0v 509.755n 0.0v 514.745n 0.0v 514.755n 0.0v 519.745n 0.0v 519.755n 0.0v 524.745n 0.0v 524.755n 0.0v 529.745n 0.0v 529.755n 0.0v 534.745n 0.0v 534.755n 0.0v 539.745n 0.0v 539.755n 0.0v 544.745n 0.0v 544.755n 0.0v 549.745n 0.0v 549.755n 0.0v 554.745n 0.0v 554.755n 0.0v 559.745n 0.0v 559.755n 0.0v 564.745n 0.0v 564.755n 0.0v 569.745n 0.0v 569.755n 0.0v 574.745n 0.0v 574.755n 0.0v 579.745n 0.0v 579.755n 1.0v 584.745n 1.0v 584.755n 1.0v 589.745n 1.0v 589.755n 1.0v 594.745n 1.0v 594.755n 1.0v 599.745n 1.0v 599.755n 1.0v 604.745n 1.0v 604.755n 1.0v 609.745n 1.0v 609.755n 1.0v 614.745n 1.0v 614.755n 0.0v 619.745n 0.0v 619.755n 0.0v 624.745n 0.0v 624.755n 0.0v 629.745n 0.0v 629.755n 0.0v 634.745n 0.0v 634.755n 0.0v 639.745n 0.0v 639.755n 0.0v 644.745n 0.0v 644.755n 0.0v 649.745n 0.0v 649.755n 0.0v 654.745n 0.0v 654.755n 0.0v 659.745n 0.0v 659.755n 0.0v 664.745n 0.0v 664.755n 0.0v 669.745n 0.0v 669.755n 0.0v 674.745n 0.0v 674.755n 0.0v 679.745n 0.0v 679.755n 0.0v 684.745n 0.0v 684.755n 0.0v 689.745n 0.0v 689.755n 0.0v 694.745n 0.0v 694.755n 0.0v 699.745n 0.0v 699.755n 0.0v 704.745n 0.0v 704.755n 0.0v 709.745n 0.0v 709.755n 0.0v 714.745n 0.0v 714.755n 0.0v 719.745n 0.0v 719.755n 0.0v 724.745n 0.0v 724.755n 0.0v 729.745n 0.0v 729.755n 1.0v 734.745n 1.0v 734.755n 1.0v 739.745n 1.0v 739.755n 1.0v 744.745n 1.0v 744.755n 1.0v 749.745n 1.0v 749.755n 1.0v 754.745n 1.0v 754.755n 1.0v 759.745n 1.0v 759.755n 1.0v 764.745n 1.0v 764.755n 0.0v 769.745n 0.0v 769.755n 0.0v 774.745n 0.0v 774.755n 0.0v 779.745n 0.0v 779.755n 0.0v 784.745n 0.0v 784.755n 0.0v 789.745n 0.0v 789.755n 1.0v 794.745n 1.0v 794.755n 1.0v 799.745n 1.0v 799.755n 1.0v 804.745n 1.0v 804.755n 1.0v 809.745n 1.0v 809.755n 0.0v 814.745n 0.0v 814.755n 0.0v 819.745n 0.0v 819.755n 0.0v 824.745n 0.0v 824.755n 0.0v 829.745n 0.0v 829.755n 1.0v 834.745n 1.0v 834.755n 1.0v 839.745n 1.0v 839.755n 1.0v 844.745n 1.0v 844.755n 1.0v 849.745n 1.0v 849.755n 1.0v 854.745n 1.0v 854.755n 1.0v 859.745n 1.0v 859.755n 0.0v 864.745n 0.0v 864.755n 0.0v 869.745n 0.0v 869.755n 0.0v 874.745n 0.0v 874.755n 0.0v 879.745n 0.0v 879.755n 0.0v 884.745n 0.0v 884.755n 0.0v 889.745n 0.0v 889.755n 0.0v 894.745n 0.0v 894.755n 0.0v 899.745n 0.0v 899.755n 0.0v 904.745n 0.0v 904.755n 0.0v 909.745n 0.0v 909.755n 0.0v 914.745n 0.0v 914.755n 0.0v 919.745n 0.0v 919.755n 0.0v 924.745n 0.0v 924.755n 0.0v 929.745n 0.0v 929.755n 1.0v 934.745n 1.0v 934.755n 1.0v 939.745n 1.0v 939.755n 1.0v 944.745n 1.0v 944.755n 1.0v 949.745n 1.0v 949.755n 1.0v 954.745n 1.0v 954.755n 1.0v 959.745n 1.0v 959.755n 1.0v 964.745n 1.0v 964.755n 1.0v 969.745n 1.0v 969.755n 1.0v 974.745n 1.0v 974.755n 1.0v 979.745n 1.0v 979.755n 1.0v 984.745n 1.0v 984.755n 1.0v 989.745n 1.0v 989.755n 1.0v 994.745n 1.0v 994.755n 1.0v 999.745n 1.0v 999.755n 1.0v 1004.745n 1.0v 1004.755n 1.0v 1009.745n 1.0v 1009.755n 0.0v 1014.745n 0.0v 1014.755n 0.0v 1019.745n 0.0v 1019.755n 1.0v 1024.745n 1.0v 1024.755n 1.0v )
* (time, data): [(0, 0), (5, 0), (10, 0), (15, 0), (20, 0), (25, 0), (30, 0), (35, 0), (40, 0), (45, 0), (50, 0), (55, 0), (60, 0), (65, 0), (70, 0), (75, 0), (80, 1), (85, 1), (90, 1), (95, 1), (100, 1), (105, 1), (110, 1), (115, 1), (120, 1), (125, 1), (130, 0), (135, 0), (140, 0), (145, 1), (150, 1), (155, 1), (160, 1), (165, 1), (170, 1), (175, 0), (180, 1), (185, 1), (190, 1), (195, 1), (200, 1), (205, 1), (210, 1), (215, 1), (220, 1), (225, 1), (230, 1), (235, 1), (240, 1), (245, 0), (250, 1), (255, 1), (260, 1), (265, 1), (270, 1), (275, 1), (280, 1), (285, 0), (290, 0), (295, 0), (300, 0), (305, 0), (310, 0), (315, 0), (320, 0), (325, 0), (330, 0), (335, 0), (340, 0), (345, 0), (350, 0), (355, 0), (360, 0), (365, 1), (370, 1), (375, 1), (380, 0), (385, 0), (390, 1), (395, 0), (400, 1), (405, 1), (410, 1), (415, 1), (420, 0), (425, 0), (430, 0), (435, 0), (440, 0), (445, 0), (450, 0), (455, 0), (460, 0), (465, 1), (470, 1), (475, 1), (480, 1), (485, 0), (490, 0), (495, 0), (500, 0), (505, 0), (510, 0), (515, 0), (520, 1), (525, 1), (530, 1), (535, 1), (540, 1), (545, 1), (550, 1), (555, 1), (560, 1), (565, 1), (570, 1), (575, 1), (580, 0), (585, 1), (590, 1), (595, 1), (600, 1), (605, 1), (610, 1), (615, 1), (620, 1), (625, 1), (630, 1), (635, 1), (640, 1), (645, 1), (650, 1), (655, 1), (660, 1), (665, 1), (670, 1), (675, 1), (680, 1), (685, 1), (690, 0), (695, 0), (700, 0), (705, 0), (710, 0), (715, 0), (720, 0), (725, 0), (730, 1), (735, 0), (740, 0), (745, 0), (750, 0), (755, 0), (760, 1), (765, 0), (770, 0), (775, 0), (780, 0), (785, 0), (790, 1), (795, 1), (800, 1), (805, 1), (810, 1), (815, 1), (820, 1), (825, 1), (830, 1), (835, 1), (840, 1), (845, 1), (850, 1), (855, 1), (860, 0), (865, 0), (870, 0), (875, 0), (880, 1), (885, 1), (890, 1), (895, 1), (900, 0), (905, 1), (910, 1), (915, 1), (920, 1), (925, 1), (930, 0), (935, 0), (940, 0), (945, 0), (950, 0), (955, 0), (960, 0), (965, 0), (970, 0), (975, 0), (980, 0), (985, 0), (990, 0), (995, 0), (1000, 1), (1005, 1), (1010, 1), (1015, 1), (1020, 1), (1025, 1)]
Vdin1_3  din1_3  0 PWL (0n 0.0v 4.745n 0.0v 4.755n 0.0v 9.745n 0.0v 9.755n 0.0v 14.745n 0.0v 14.755n 0.0v 19.745n 0.0v 19.755n 0.0v 24.745n 0.0v 24.755n 0.0v 29.745n 0.0v 29.755n 0.0v 34.745n 0.0v 34.755n 0.0v 39.745n 0.0v 39.755n 0.0v 44.745n 0.0v 44.755n 0.0v 49.745n 0.0v 49.755n 0.0v 54.745n 0.0v 54.755n 0.0v 59.745n 0.0v 59.755n 0.0v 64.745n 0.0v 64.755n 0.0v 69.745n 0.0v 69.755n 0.0v 74.745n 0.0v 74.755n 0.0v 79.745n 0.0v 79.755n 1.0v 84.745n 1.0v 84.755n 1.0v 89.745n 1.0v 89.755n 1.0v 94.745n 1.0v 94.755n 1.0v 99.745n 1.0v 99.755n 1.0v 104.745n 1.0v 104.755n 1.0v 109.745n 1.0v 109.755n 1.0v 114.745n 1.0v 114.755n 1.0v 119.745n 1.0v 119.755n 1.0v 124.745n 1.0v 124.755n 1.0v 129.745n 1.0v 129.755n 0.0v 134.745n 0.0v 134.755n 0.0v 139.745n 0.0v 139.755n 0.0v 144.745n 0.0v 144.755n 1.0v 149.745n 1.0v 149.755n 1.0v 154.745n 1.0v 154.755n 1.0v 159.745n 1.0v 159.755n 1.0v 164.745n 1.0v 164.755n 1.0v 169.745n 1.0v 169.755n 1.0v 174.745n 1.0v 174.755n 0.0v 179.745n 0.0v 179.755n 1.0v 184.745n 1.0v 184.755n 1.0v 189.745n 1.0v 189.755n 1.0v 194.745n 1.0v 194.755n 1.0v 199.745n 1.0v 199.755n 1.0v 204.745n 1.0v 204.755n 1.0v 209.745n 1.0v 209.755n 1.0v 214.745n 1.0v 214.755n 1.0v 219.745n 1.0v 219.755n 1.0v 224.745n 1.0v 224.755n 1.0v 229.745n 1.0v 229.755n 1.0v 234.745n 1.0v 234.755n 1.0v 239.745n 1.0v 239.755n 1.0v 244.745n 1.0v 244.755n 0.0v 249.745n 0.0v 249.755n 1.0v 254.745n 1.0v 254.755n 1.0v 259.745n 1.0v 259.755n 1.0v 264.745n 1.0v 264.755n 1.0v 269.745n 1.0v 269.755n 1.0v 274.745n 1.0v 274.755n 1.0v 279.745n 1.0v 279.755n 1.0v 284.745n 1.0v 284.755n 0.0v 289.745n 0.0v 289.755n 0.0v 294.745n 0.0v 294.755n 0.0v 299.745n 0.0v 299.755n 0.0v 304.745n 0.0v 304.755n 0.0v 309.745n 0.0v 309.755n 0.0v 314.745n 0.0v 314.755n 0.0v 319.745n 0.0v 319.755n 0.0v 324.745n 0.0v 324.755n 0.0v 329.745n 0.0v 329.755n 0.0v 334.745n 0.0v 334.755n 0.0v 339.745n 0.0v 339.755n 0.0v 344.745n 0.0v 344.755n 0.0v 349.745n 0.0v 349.755n 0.0v 354.745n 0.0v 354.755n 0.0v 359.745n 0.0v 359.755n 0.0v 364.745n 0.0v 364.755n 1.0v 369.745n 1.0v 369.755n 1.0v 374.745n 1.0v 374.755n 1.0v 379.745n 1.0v 379.755n 0.0v 384.745n 0.0v 384.755n 0.0v 389.745n 0.0v 389.755n 1.0v 394.745n 1.0v 394.755n 0.0v 399.745n 0.0v 399.755n 1.0v 404.745n 1.0v 404.755n 1.0v 409.745n 1.0v 409.755n 1.0v 414.745n 1.0v 414.755n 1.0v 419.745n 1.0v 419.755n 0.0v 424.745n 0.0v 424.755n 0.0v 429.745n 0.0v 429.755n 0.0v 434.745n 0.0v 434.755n 0.0v 439.745n 0.0v 439.755n 0.0v 444.745n 0.0v 444.755n 0.0v 449.745n 0.0v 449.755n 0.0v 454.745n 0.0v 454.755n 0.0v 459.745n 0.0v 459.755n 0.0v 464.745n 0.0v 464.755n 1.0v 469.745n 1.0v 469.755n 1.0v 474.745n 1.0v 474.755n 1.0v 479.745n 1.0v 479.755n 1.0v 484.745n 1.0v 484.755n 0.0v 489.745n 0.0v 489.755n 0.0v 494.745n 0.0v 494.755n 0.0v 499.745n 0.0v 499.755n 0.0v 504.745n 0.0v 504.755n 0.0v 509.745n 0.0v 509.755n 0.0v 514.745n 0.0v 514.755n 0.0v 519.745n 0.0v 519.755n 1.0v 524.745n 1.0v 524.755n 1.0v 529.745n 1.0v 529.755n 1.0v 534.745n 1.0v 534.755n 1.0v 539.745n 1.0v 539.755n 1.0v 544.745n 1.0v 544.755n 1.0v 549.745n 1.0v 549.755n 1.0v 554.745n 1.0v 554.755n 1.0v 559.745n 1.0v 559.755n 1.0v 564.745n 1.0v 564.755n 1.0v 569.745n 1.0v 569.755n 1.0v 574.745n 1.0v 574.755n 1.0v 579.745n 1.0v 579.755n 0.0v 584.745n 0.0v 584.755n 1.0v 589.745n 1.0v 589.755n 1.0v 594.745n 1.0v 594.755n 1.0v 599.745n 1.0v 599.755n 1.0v 604.745n 1.0v 604.755n 1.0v 609.745n 1.0v 609.755n 1.0v 614.745n 1.0v 614.755n 1.0v 619.745n 1.0v 619.755n 1.0v 624.745n 1.0v 624.755n 1.0v 629.745n 1.0v 629.755n 1.0v 634.745n 1.0v 634.755n 1.0v 639.745n 1.0v 639.755n 1.0v 644.745n 1.0v 644.755n 1.0v 649.745n 1.0v 649.755n 1.0v 654.745n 1.0v 654.755n 1.0v 659.745n 1.0v 659.755n 1.0v 664.745n 1.0v 664.755n 1.0v 669.745n 1.0v 669.755n 1.0v 674.745n 1.0v 674.755n 1.0v 679.745n 1.0v 679.755n 1.0v 684.745n 1.0v 684.755n 1.0v 689.745n 1.0v 689.755n 0.0v 694.745n 0.0v 694.755n 0.0v 699.745n 0.0v 699.755n 0.0v 704.745n 0.0v 704.755n 0.0v 709.745n 0.0v 709.755n 0.0v 714.745n 0.0v 714.755n 0.0v 719.745n 0.0v 719.755n 0.0v 724.745n 0.0v 724.755n 0.0v 729.745n 0.0v 729.755n 1.0v 734.745n 1.0v 734.755n 0.0v 739.745n 0.0v 739.755n 0.0v 744.745n 0.0v 744.755n 0.0v 749.745n 0.0v 749.755n 0.0v 754.745n 0.0v 754.755n 0.0v 759.745n 0.0v 759.755n 1.0v 764.745n 1.0v 764.755n 0.0v 769.745n 0.0v 769.755n 0.0v 774.745n 0.0v 774.755n 0.0v 779.745n 0.0v 779.755n 0.0v 784.745n 0.0v 784.755n 0.0v 789.745n 0.0v 789.755n 1.0v 794.745n 1.0v 794.755n 1.0v 799.745n 1.0v 799.755n 1.0v 804.745n 1.0v 804.755n 1.0v 809.745n 1.0v 809.755n 1.0v 814.745n 1.0v 814.755n 1.0v 819.745n 1.0v 819.755n 1.0v 824.745n 1.0v 824.755n 1.0v 829.745n 1.0v 829.755n 1.0v 834.745n 1.0v 834.755n 1.0v 839.745n 1.0v 839.755n 1.0v 844.745n 1.0v 844.755n 1.0v 849.745n 1.0v 849.755n 1.0v 854.745n 1.0v 854.755n 1.0v 859.745n 1.0v 859.755n 0.0v 864.745n 0.0v 864.755n 0.0v 869.745n 0.0v 869.755n 0.0v 874.745n 0.0v 874.755n 0.0v 879.745n 0.0v 879.755n 1.0v 884.745n 1.0v 884.755n 1.0v 889.745n 1.0v 889.755n 1.0v 894.745n 1.0v 894.755n 1.0v 899.745n 1.0v 899.755n 0.0v 904.745n 0.0v 904.755n 1.0v 909.745n 1.0v 909.755n 1.0v 914.745n 1.0v 914.755n 1.0v 919.745n 1.0v 919.755n 1.0v 924.745n 1.0v 924.755n 1.0v 929.745n 1.0v 929.755n 0.0v 934.745n 0.0v 934.755n 0.0v 939.745n 0.0v 939.755n 0.0v 944.745n 0.0v 944.755n 0.0v 949.745n 0.0v 949.755n 0.0v 954.745n 0.0v 954.755n 0.0v 959.745n 0.0v 959.755n 0.0v 964.745n 0.0v 964.755n 0.0v 969.745n 0.0v 969.755n 0.0v 974.745n 0.0v 974.755n 0.0v 979.745n 0.0v 979.755n 0.0v 984.745n 0.0v 984.755n 0.0v 989.745n 0.0v 989.755n 0.0v 994.745n 0.0v 994.755n 0.0v 999.745n 0.0v 999.755n 1.0v 1004.745n 1.0v 1004.755n 1.0v 1009.745n 1.0v 1009.755n 1.0v 1014.745n 1.0v 1014.755n 1.0v 1019.745n 1.0v 1019.755n 1.0v 1024.745n 1.0v 1024.755n 1.0v )
* (time, data): [(0, 0), (5, 0), (10, 1), (15, 1), (20, 1), (25, 1), (30, 1), (35, 1), (40, 1), (45, 1), (50, 1), (55, 1), (60, 0), (65, 0), (70, 0), (75, 0), (80, 0), (85, 0), (90, 0), (95, 0), (100, 0), (105, 0), (110, 0), (115, 0), (120, 0), (125, 0), (130, 0), (135, 0), (140, 0), (145, 1), (150, 1), (155, 1), (160, 1), (165, 1), (170, 1), (175, 0), (180, 0), (185, 0), (190, 0), (195, 0), (200, 0), (205, 0), (210, 0), (215, 0), (220, 0), (225, 0), (230, 0), (235, 0), (240, 0), (245, 0), (250, 1), (255, 1), (260, 1), (265, 1), (270, 1), (275, 1), (280, 1), (285, 0), (290, 0), (295, 0), (300, 1), (305, 1), (310, 1), (315, 1), (320, 1), (325, 1), (330, 1), (335, 1), (340, 1), (345, 1), (350, 1), (355, 1), (360, 1), (365, 1), (370, 1), (375, 1), (380, 0), (385, 0), (390, 0), (395, 0), (400, 0), (405, 0), (410, 0), (415, 0), (420, 1), (425, 1), (430, 1), (435, 1), (440, 1), (445, 1), (450, 1), (455, 1), (460, 1), (465, 1), (470, 1), (475, 1), (480, 1), (485, 0), (490, 0), (495, 0), (500, 0), (505, 0), (510, 0), (515, 0), (520, 0), (525, 0), (530, 0), (535, 0), (540, 0), (545, 0), (550, 0), (555, 0), (560, 0), (565, 0), (570, 0), (575, 0), (580, 0), (585, 0), (590, 0), (595, 0), (600, 0), (605, 1), (610, 1), (615, 0), (620, 0), (625, 0), (630, 0), (635, 0), (640, 0), (645, 0), (650, 0), (655, 0), (660, 0), (665, 0), (670, 0), (675, 0), (680, 0), (685, 0), (690, 0), (695, 0), (700, 0), (705, 0), (710, 0), (715, 0), (720, 0), (725, 0), (730, 0), (735, 1), (740, 1), (745, 1), (750, 1), (755, 1), (760, 0), (765, 1), (770, 0), (775, 0), (780, 0), (785, 0), (790, 0), (795, 0), (800, 0), (805, 0), (810, 0), (815, 0), (820, 0), (825, 0), (830, 0), (835, 0), (840, 0), (845, 0), (850, 0), (855, 0), (860, 1), (865, 1), (870, 1), (875, 1), (880, 1), (885, 1), (890, 1), (895, 1), (900, 1), (905, 0), (910, 0), (915, 0), (920, 0), (925, 1), (930, 0), (935, 0), (940, 0), (945, 1), (950, 1), (955, 1), (960, 1), (965, 1), (970, 1), (975, 1), (980, 1), (985, 1), (990, 1), (995, 1), (1000, 0), (1005, 0), (1010, 1), (1015, 1), (1020, 0), (1025, 0)]
Vdin1_4  din1_4  0 PWL (0n 0.0v 4.745n 0.0v 4.755n 0.0v 9.745n 0.0v 9.755n 1.0v 14.745n 1.0v 14.755n 1.0v 19.745n 1.0v 19.755n 1.0v 24.745n 1.0v 24.755n 1.0v 29.745n 1.0v 29.755n 1.0v 34.745n 1.0v 34.755n 1.0v 39.745n 1.0v 39.755n 1.0v 44.745n 1.0v 44.755n 1.0v 49.745n 1.0v 49.755n 1.0v 54.745n 1.0v 54.755n 1.0v 59.745n 1.0v 59.755n 0.0v 64.745n 0.0v 64.755n 0.0v 69.745n 0.0v 69.755n 0.0v 74.745n 0.0v 74.755n 0.0v 79.745n 0.0v 79.755n 0.0v 84.745n 0.0v 84.755n 0.0v 89.745n 0.0v 89.755n 0.0v 94.745n 0.0v 94.755n 0.0v 99.745n 0.0v 99.755n 0.0v 104.745n 0.0v 104.755n 0.0v 109.745n 0.0v 109.755n 0.0v 114.745n 0.0v 114.755n 0.0v 119.745n 0.0v 119.755n 0.0v 124.745n 0.0v 124.755n 0.0v 129.745n 0.0v 129.755n 0.0v 134.745n 0.0v 134.755n 0.0v 139.745n 0.0v 139.755n 0.0v 144.745n 0.0v 144.755n 1.0v 149.745n 1.0v 149.755n 1.0v 154.745n 1.0v 154.755n 1.0v 159.745n 1.0v 159.755n 1.0v 164.745n 1.0v 164.755n 1.0v 169.745n 1.0v 169.755n 1.0v 174.745n 1.0v 174.755n 0.0v 179.745n 0.0v 179.755n 0.0v 184.745n 0.0v 184.755n 0.0v 189.745n 0.0v 189.755n 0.0v 194.745n 0.0v 194.755n 0.0v 199.745n 0.0v 199.755n 0.0v 204.745n 0.0v 204.755n 0.0v 209.745n 0.0v 209.755n 0.0v 214.745n 0.0v 214.755n 0.0v 219.745n 0.0v 219.755n 0.0v 224.745n 0.0v 224.755n 0.0v 229.745n 0.0v 229.755n 0.0v 234.745n 0.0v 234.755n 0.0v 239.745n 0.0v 239.755n 0.0v 244.745n 0.0v 244.755n 0.0v 249.745n 0.0v 249.755n 1.0v 254.745n 1.0v 254.755n 1.0v 259.745n 1.0v 259.755n 1.0v 264.745n 1.0v 264.755n 1.0v 269.745n 1.0v 269.755n 1.0v 274.745n 1.0v 274.755n 1.0v 279.745n 1.0v 279.755n 1.0v 284.745n 1.0v 284.755n 0.0v 289.745n 0.0v 289.755n 0.0v 294.745n 0.0v 294.755n 0.0v 299.745n 0.0v 299.755n 1.0v 304.745n 1.0v 304.755n 1.0v 309.745n 1.0v 309.755n 1.0v 314.745n 1.0v 314.755n 1.0v 319.745n 1.0v 319.755n 1.0v 324.745n 1.0v 324.755n 1.0v 329.745n 1.0v 329.755n 1.0v 334.745n 1.0v 334.755n 1.0v 339.745n 1.0v 339.755n 1.0v 344.745n 1.0v 344.755n 1.0v 349.745n 1.0v 349.755n 1.0v 354.745n 1.0v 354.755n 1.0v 359.745n 1.0v 359.755n 1.0v 364.745n 1.0v 364.755n 1.0v 369.745n 1.0v 369.755n 1.0v 374.745n 1.0v 374.755n 1.0v 379.745n 1.0v 379.755n 0.0v 384.745n 0.0v 384.755n 0.0v 389.745n 0.0v 389.755n 0.0v 394.745n 0.0v 394.755n 0.0v 399.745n 0.0v 399.755n 0.0v 404.745n 0.0v 404.755n 0.0v 409.745n 0.0v 409.755n 0.0v 414.745n 0.0v 414.755n 0.0v 419.745n 0.0v 419.755n 1.0v 424.745n 1.0v 424.755n 1.0v 429.745n 1.0v 429.755n 1.0v 434.745n 1.0v 434.755n 1.0v 439.745n 1.0v 439.755n 1.0v 444.745n 1.0v 444.755n 1.0v 449.745n 1.0v 449.755n 1.0v 454.745n 1.0v 454.755n 1.0v 459.745n 1.0v 459.755n 1.0v 464.745n 1.0v 464.755n 1.0v 469.745n 1.0v 469.755n 1.0v 474.745n 1.0v 474.755n 1.0v 479.745n 1.0v 479.755n 1.0v 484.745n 1.0v 484.755n 0.0v 489.745n 0.0v 489.755n 0.0v 494.745n 0.0v 494.755n 0.0v 499.745n 0.0v 499.755n 0.0v 504.745n 0.0v 504.755n 0.0v 509.745n 0.0v 509.755n 0.0v 514.745n 0.0v 514.755n 0.0v 519.745n 0.0v 519.755n 0.0v 524.745n 0.0v 524.755n 0.0v 529.745n 0.0v 529.755n 0.0v 534.745n 0.0v 534.755n 0.0v 539.745n 0.0v 539.755n 0.0v 544.745n 0.0v 544.755n 0.0v 549.745n 0.0v 549.755n 0.0v 554.745n 0.0v 554.755n 0.0v 559.745n 0.0v 559.755n 0.0v 564.745n 0.0v 564.755n 0.0v 569.745n 0.0v 569.755n 0.0v 574.745n 0.0v 574.755n 0.0v 579.745n 0.0v 579.755n 0.0v 584.745n 0.0v 584.755n 0.0v 589.745n 0.0v 589.755n 0.0v 594.745n 0.0v 594.755n 0.0v 599.745n 0.0v 599.755n 0.0v 604.745n 0.0v 604.755n 1.0v 609.745n 1.0v 609.755n 1.0v 614.745n 1.0v 614.755n 0.0v 619.745n 0.0v 619.755n 0.0v 624.745n 0.0v 624.755n 0.0v 629.745n 0.0v 629.755n 0.0v 634.745n 0.0v 634.755n 0.0v 639.745n 0.0v 639.755n 0.0v 644.745n 0.0v 644.755n 0.0v 649.745n 0.0v 649.755n 0.0v 654.745n 0.0v 654.755n 0.0v 659.745n 0.0v 659.755n 0.0v 664.745n 0.0v 664.755n 0.0v 669.745n 0.0v 669.755n 0.0v 674.745n 0.0v 674.755n 0.0v 679.745n 0.0v 679.755n 0.0v 684.745n 0.0v 684.755n 0.0v 689.745n 0.0v 689.755n 0.0v 694.745n 0.0v 694.755n 0.0v 699.745n 0.0v 699.755n 0.0v 704.745n 0.0v 704.755n 0.0v 709.745n 0.0v 709.755n 0.0v 714.745n 0.0v 714.755n 0.0v 719.745n 0.0v 719.755n 0.0v 724.745n 0.0v 724.755n 0.0v 729.745n 0.0v 729.755n 0.0v 734.745n 0.0v 734.755n 1.0v 739.745n 1.0v 739.755n 1.0v 744.745n 1.0v 744.755n 1.0v 749.745n 1.0v 749.755n 1.0v 754.745n 1.0v 754.755n 1.0v 759.745n 1.0v 759.755n 0.0v 764.745n 0.0v 764.755n 1.0v 769.745n 1.0v 769.755n 0.0v 774.745n 0.0v 774.755n 0.0v 779.745n 0.0v 779.755n 0.0v 784.745n 0.0v 784.755n 0.0v 789.745n 0.0v 789.755n 0.0v 794.745n 0.0v 794.755n 0.0v 799.745n 0.0v 799.755n 0.0v 804.745n 0.0v 804.755n 0.0v 809.745n 0.0v 809.755n 0.0v 814.745n 0.0v 814.755n 0.0v 819.745n 0.0v 819.755n 0.0v 824.745n 0.0v 824.755n 0.0v 829.745n 0.0v 829.755n 0.0v 834.745n 0.0v 834.755n 0.0v 839.745n 0.0v 839.755n 0.0v 844.745n 0.0v 844.755n 0.0v 849.745n 0.0v 849.755n 0.0v 854.745n 0.0v 854.755n 0.0v 859.745n 0.0v 859.755n 1.0v 864.745n 1.0v 864.755n 1.0v 869.745n 1.0v 869.755n 1.0v 874.745n 1.0v 874.755n 1.0v 879.745n 1.0v 879.755n 1.0v 884.745n 1.0v 884.755n 1.0v 889.745n 1.0v 889.755n 1.0v 894.745n 1.0v 894.755n 1.0v 899.745n 1.0v 899.755n 1.0v 904.745n 1.0v 904.755n 0.0v 909.745n 0.0v 909.755n 0.0v 914.745n 0.0v 914.755n 0.0v 919.745n 0.0v 919.755n 0.0v 924.745n 0.0v 924.755n 1.0v 929.745n 1.0v 929.755n 0.0v 934.745n 0.0v 934.755n 0.0v 939.745n 0.0v 939.755n 0.0v 944.745n 0.0v 944.755n 1.0v 949.745n 1.0v 949.755n 1.0v 954.745n 1.0v 954.755n 1.0v 959.745n 1.0v 959.755n 1.0v 964.745n 1.0v 964.755n 1.0v 969.745n 1.0v 969.755n 1.0v 974.745n 1.0v 974.755n 1.0v 979.745n 1.0v 979.755n 1.0v 984.745n 1.0v 984.755n 1.0v 989.745n 1.0v 989.755n 1.0v 994.745n 1.0v 994.755n 1.0v 999.745n 1.0v 999.755n 0.0v 1004.745n 0.0v 1004.755n 0.0v 1009.745n 0.0v 1009.755n 1.0v 1014.745n 1.0v 1014.755n 1.0v 1019.745n 1.0v 1019.755n 0.0v 1024.745n 0.0v 1024.755n 0.0v )
* (time, data): [(0, 0), (5, 1), (10, 0), (15, 0), (20, 0), (25, 0), (30, 0), (35, 0), (40, 0), (45, 0), (50, 0), (55, 0), (60, 0), (65, 0), (70, 0), (75, 0), (80, 1), (85, 1), (90, 0), (95, 0), (100, 0), (105, 0), (110, 0), (115, 0), (120, 0), (125, 0), (130, 0), (135, 0), (140, 0), (145, 1), (150, 1), (155, 1), (160, 1), (165, 1), (170, 1), (175, 1), (180, 1), (185, 1), (190, 1), (195, 1), (200, 1), (205, 1), (210, 1), (215, 1), (220, 1), (225, 1), (230, 1), (235, 1), (240, 1), (245, 0), (250, 1), (255, 1), (260, 1), (265, 1), (270, 1), (275, 1), (280, 1), (285, 1), (290, 1), (295, 1), (300, 0), (305, 0), (310, 0), (315, 0), (320, 0), (325, 0), (330, 0), (335, 0), (340, 0), (345, 0), (350, 0), (355, 0), (360, 0), (365, 1), (370, 1), (375, 1), (380, 0), (385, 0), (390, 1), (395, 1), (400, 0), (405, 0), (410, 0), (415, 0), (420, 0), (425, 0), (430, 0), (435, 0), (440, 0), (445, 0), (450, 0), (455, 0), (460, 0), (465, 0), (470, 0), (475, 0), (480, 0), (485, 0), (490, 0), (495, 0), (500, 0), (505, 1), (510, 1), (515, 1), (520, 0), (525, 0), (530, 0), (535, 0), (540, 0), (545, 0), (550, 0), (555, 0), (560, 0), (565, 0), (570, 0), (575, 0), (580, 0), (585, 1), (590, 1), (595, 1), (600, 1), (605, 0), (610, 0), (615, 1), (620, 1), (625, 1), (630, 1), (635, 1), (640, 1), (645, 1), (650, 1), (655, 1), (660, 1), (665, 1), (670, 1), (675, 1), (680, 1), (685, 1), (690, 1), (695, 1), (700, 1), (705, 1), (710, 1), (715, 1), (720, 1), (725, 1), (730, 1), (735, 1), (740, 1), (745, 1), (750, 1), (755, 1), (760, 0), (765, 0), (770, 1), (775, 1), (780, 1), (785, 1), (790, 1), (795, 1), (800, 1), (805, 1), (810, 0), (815, 0), (820, 0), (825, 0), (830, 0), (835, 0), (840, 0), (845, 0), (850, 0), (855, 0), (860, 1), (865, 1), (870, 1), (875, 1), (880, 1), (885, 1), (890, 1), (895, 1), (900, 1), (905, 1), (910, 1), (915, 1), (920, 1), (925, 0), (930, 0), (935, 0), (940, 0), (945, 1), (950, 1), (955, 1), (960, 1), (965, 1), (970, 1), (975, 1), (980, 1), (985, 1), (990, 1), (995, 1), (1000, 1), (1005, 1), (1010, 1), (1015, 1), (1020, 0), (1025, 0)]
Vdin1_5  din1_5  0 PWL (0n 0.0v 4.745n 0.0v 4.755n 1.0v 9.745n 1.0v 9.755n 0.0v 14.745n 0.0v 14.755n 0.0v 19.745n 0.0v 19.755n 0.0v 24.745n 0.0v 24.755n 0.0v 29.745n 0.0v 29.755n 0.0v 34.745n 0.0v 34.755n 0.0v 39.745n 0.0v 39.755n 0.0v 44.745n 0.0v 44.755n 0.0v 49.745n 0.0v 49.755n 0.0v 54.745n 0.0v 54.755n 0.0v 59.745n 0.0v 59.755n 0.0v 64.745n 0.0v 64.755n 0.0v 69.745n 0.0v 69.755n 0.0v 74.745n 0.0v 74.755n 0.0v 79.745n 0.0v 79.755n 1.0v 84.745n 1.0v 84.755n 1.0v 89.745n 1.0v 89.755n 0.0v 94.745n 0.0v 94.755n 0.0v 99.745n 0.0v 99.755n 0.0v 104.745n 0.0v 104.755n 0.0v 109.745n 0.0v 109.755n 0.0v 114.745n 0.0v 114.755n 0.0v 119.745n 0.0v 119.755n 0.0v 124.745n 0.0v 124.755n 0.0v 129.745n 0.0v 129.755n 0.0v 134.745n 0.0v 134.755n 0.0v 139.745n 0.0v 139.755n 0.0v 144.745n 0.0v 144.755n 1.0v 149.745n 1.0v 149.755n 1.0v 154.745n 1.0v 154.755n 1.0v 159.745n 1.0v 159.755n 1.0v 164.745n 1.0v 164.755n 1.0v 169.745n 1.0v 169.755n 1.0v 174.745n 1.0v 174.755n 1.0v 179.745n 1.0v 179.755n 1.0v 184.745n 1.0v 184.755n 1.0v 189.745n 1.0v 189.755n 1.0v 194.745n 1.0v 194.755n 1.0v 199.745n 1.0v 199.755n 1.0v 204.745n 1.0v 204.755n 1.0v 209.745n 1.0v 209.755n 1.0v 214.745n 1.0v 214.755n 1.0v 219.745n 1.0v 219.755n 1.0v 224.745n 1.0v 224.755n 1.0v 229.745n 1.0v 229.755n 1.0v 234.745n 1.0v 234.755n 1.0v 239.745n 1.0v 239.755n 1.0v 244.745n 1.0v 244.755n 0.0v 249.745n 0.0v 249.755n 1.0v 254.745n 1.0v 254.755n 1.0v 259.745n 1.0v 259.755n 1.0v 264.745n 1.0v 264.755n 1.0v 269.745n 1.0v 269.755n 1.0v 274.745n 1.0v 274.755n 1.0v 279.745n 1.0v 279.755n 1.0v 284.745n 1.0v 284.755n 1.0v 289.745n 1.0v 289.755n 1.0v 294.745n 1.0v 294.755n 1.0v 299.745n 1.0v 299.755n 0.0v 304.745n 0.0v 304.755n 0.0v 309.745n 0.0v 309.755n 0.0v 314.745n 0.0v 314.755n 0.0v 319.745n 0.0v 319.755n 0.0v 324.745n 0.0v 324.755n 0.0v 329.745n 0.0v 329.755n 0.0v 334.745n 0.0v 334.755n 0.0v 339.745n 0.0v 339.755n 0.0v 344.745n 0.0v 344.755n 0.0v 349.745n 0.0v 349.755n 0.0v 354.745n 0.0v 354.755n 0.0v 359.745n 0.0v 359.755n 0.0v 364.745n 0.0v 364.755n 1.0v 369.745n 1.0v 369.755n 1.0v 374.745n 1.0v 374.755n 1.0v 379.745n 1.0v 379.755n 0.0v 384.745n 0.0v 384.755n 0.0v 389.745n 0.0v 389.755n 1.0v 394.745n 1.0v 394.755n 1.0v 399.745n 1.0v 399.755n 0.0v 404.745n 0.0v 404.755n 0.0v 409.745n 0.0v 409.755n 0.0v 414.745n 0.0v 414.755n 0.0v 419.745n 0.0v 419.755n 0.0v 424.745n 0.0v 424.755n 0.0v 429.745n 0.0v 429.755n 0.0v 434.745n 0.0v 434.755n 0.0v 439.745n 0.0v 439.755n 0.0v 444.745n 0.0v 444.755n 0.0v 449.745n 0.0v 449.755n 0.0v 454.745n 0.0v 454.755n 0.0v 459.745n 0.0v 459.755n 0.0v 464.745n 0.0v 464.755n 0.0v 469.745n 0.0v 469.755n 0.0v 474.745n 0.0v 474.755n 0.0v 479.745n 0.0v 479.755n 0.0v 484.745n 0.0v 484.755n 0.0v 489.745n 0.0v 489.755n 0.0v 494.745n 0.0v 494.755n 0.0v 499.745n 0.0v 499.755n 0.0v 504.745n 0.0v 504.755n 1.0v 509.745n 1.0v 509.755n 1.0v 514.745n 1.0v 514.755n 1.0v 519.745n 1.0v 519.755n 0.0v 524.745n 0.0v 524.755n 0.0v 529.745n 0.0v 529.755n 0.0v 534.745n 0.0v 534.755n 0.0v 539.745n 0.0v 539.755n 0.0v 544.745n 0.0v 544.755n 0.0v 549.745n 0.0v 549.755n 0.0v 554.745n 0.0v 554.755n 0.0v 559.745n 0.0v 559.755n 0.0v 564.745n 0.0v 564.755n 0.0v 569.745n 0.0v 569.755n 0.0v 574.745n 0.0v 574.755n 0.0v 579.745n 0.0v 579.755n 0.0v 584.745n 0.0v 584.755n 1.0v 589.745n 1.0v 589.755n 1.0v 594.745n 1.0v 594.755n 1.0v 599.745n 1.0v 599.755n 1.0v 604.745n 1.0v 604.755n 0.0v 609.745n 0.0v 609.755n 0.0v 614.745n 0.0v 614.755n 1.0v 619.745n 1.0v 619.755n 1.0v 624.745n 1.0v 624.755n 1.0v 629.745n 1.0v 629.755n 1.0v 634.745n 1.0v 634.755n 1.0v 639.745n 1.0v 639.755n 1.0v 644.745n 1.0v 644.755n 1.0v 649.745n 1.0v 649.755n 1.0v 654.745n 1.0v 654.755n 1.0v 659.745n 1.0v 659.755n 1.0v 664.745n 1.0v 664.755n 1.0v 669.745n 1.0v 669.755n 1.0v 674.745n 1.0v 674.755n 1.0v 679.745n 1.0v 679.755n 1.0v 684.745n 1.0v 684.755n 1.0v 689.745n 1.0v 689.755n 1.0v 694.745n 1.0v 694.755n 1.0v 699.745n 1.0v 699.755n 1.0v 704.745n 1.0v 704.755n 1.0v 709.745n 1.0v 709.755n 1.0v 714.745n 1.0v 714.755n 1.0v 719.745n 1.0v 719.755n 1.0v 724.745n 1.0v 724.755n 1.0v 729.745n 1.0v 729.755n 1.0v 734.745n 1.0v 734.755n 1.0v 739.745n 1.0v 739.755n 1.0v 744.745n 1.0v 744.755n 1.0v 749.745n 1.0v 749.755n 1.0v 754.745n 1.0v 754.755n 1.0v 759.745n 1.0v 759.755n 0.0v 764.745n 0.0v 764.755n 0.0v 769.745n 0.0v 769.755n 1.0v 774.745n 1.0v 774.755n 1.0v 779.745n 1.0v 779.755n 1.0v 784.745n 1.0v 784.755n 1.0v 789.745n 1.0v 789.755n 1.0v 794.745n 1.0v 794.755n 1.0v 799.745n 1.0v 799.755n 1.0v 804.745n 1.0v 804.755n 1.0v 809.745n 1.0v 809.755n 0.0v 814.745n 0.0v 814.755n 0.0v 819.745n 0.0v 819.755n 0.0v 824.745n 0.0v 824.755n 0.0v 829.745n 0.0v 829.755n 0.0v 834.745n 0.0v 834.755n 0.0v 839.745n 0.0v 839.755n 0.0v 844.745n 0.0v 844.755n 0.0v 849.745n 0.0v 849.755n 0.0v 854.745n 0.0v 854.755n 0.0v 859.745n 0.0v 859.755n 1.0v 864.745n 1.0v 864.755n 1.0v 869.745n 1.0v 869.755n 1.0v 874.745n 1.0v 874.755n 1.0v 879.745n 1.0v 879.755n 1.0v 884.745n 1.0v 884.755n 1.0v 889.745n 1.0v 889.755n 1.0v 894.745n 1.0v 894.755n 1.0v 899.745n 1.0v 899.755n 1.0v 904.745n 1.0v 904.755n 1.0v 909.745n 1.0v 909.755n 1.0v 914.745n 1.0v 914.755n 1.0v 919.745n 1.0v 919.755n 1.0v 924.745n 1.0v 924.755n 0.0v 929.745n 0.0v 929.755n 0.0v 934.745n 0.0v 934.755n 0.0v 939.745n 0.0v 939.755n 0.0v 944.745n 0.0v 944.755n 1.0v 949.745n 1.0v 949.755n 1.0v 954.745n 1.0v 954.755n 1.0v 959.745n 1.0v 959.755n 1.0v 964.745n 1.0v 964.755n 1.0v 969.745n 1.0v 969.755n 1.0v 974.745n 1.0v 974.755n 1.0v 979.745n 1.0v 979.755n 1.0v 984.745n 1.0v 984.755n 1.0v 989.745n 1.0v 989.755n 1.0v 994.745n 1.0v 994.755n 1.0v 999.745n 1.0v 999.755n 1.0v 1004.745n 1.0v 1004.755n 1.0v 1009.745n 1.0v 1009.755n 1.0v 1014.745n 1.0v 1014.755n 1.0v 1019.745n 1.0v 1019.755n 0.0v 1024.745n 0.0v 1024.755n 0.0v )
* (time, data): [(0, 0), (5, 1), (10, 1), (15, 0), (20, 0), (25, 0), (30, 0), (35, 0), (40, 0), (45, 0), (50, 0), (55, 0), (60, 1), (65, 1), (70, 1), (75, 1), (80, 0), (85, 0), (90, 0), (95, 0), (100, 0), (105, 0), (110, 0), (115, 0), (120, 0), (125, 0), (130, 1), (135, 1), (140, 1), (145, 1), (150, 1), (155, 1), (160, 1), (165, 1), (170, 1), (175, 0), (180, 0), (185, 0), (190, 0), (195, 0), (200, 0), (205, 0), (210, 0), (215, 0), (220, 0), (225, 0), (230, 0), (235, 0), (240, 0), (245, 1), (250, 1), (255, 1), (260, 1), (265, 1), (270, 1), (275, 1), (280, 1), (285, 1), (290, 1), (295, 1), (300, 0), (305, 0), (310, 0), (315, 0), (320, 0), (325, 0), (330, 0), (335, 0), (340, 0), (345, 0), (350, 0), (355, 0), (360, 0), (365, 1), (370, 1), (375, 1), (380, 1), (385, 1), (390, 1), (395, 0), (400, 1), (405, 1), (410, 1), (415, 1), (420, 0), (425, 0), (430, 0), (435, 0), (440, 0), (445, 0), (450, 0), (455, 0), (460, 0), (465, 0), (470, 0), (475, 0), (480, 0), (485, 1), (490, 1), (495, 1), (500, 1), (505, 0), (510, 0), (515, 0), (520, 1), (525, 1), (530, 1), (535, 1), (540, 1), (545, 1), (550, 1), (555, 1), (560, 1), (565, 1), (570, 1), (575, 1), (580, 1), (585, 1), (590, 1), (595, 1), (600, 1), (605, 0), (610, 0), (615, 1), (620, 1), (625, 1), (630, 1), (635, 1), (640, 1), (645, 1), (650, 1), (655, 1), (660, 1), (665, 1), (670, 1), (675, 1), (680, 1), (685, 1), (690, 0), (695, 0), (700, 0), (705, 0), (710, 0), (715, 0), (720, 0), (725, 0), (730, 0), (735, 0), (740, 0), (745, 0), (750, 0), (755, 0), (760, 0), (765, 1), (770, 1), (775, 1), (780, 1), (785, 1), (790, 1), (795, 1), (800, 1), (805, 1), (810, 0), (815, 0), (820, 0), (825, 0), (830, 1), (835, 1), (840, 1), (845, 1), (850, 1), (855, 1), (860, 0), (865, 0), (870, 0), (875, 0), (880, 0), (885, 0), (890, 0), (895, 0), (900, 1), (905, 0), (910, 0), (915, 0), (920, 0), (925, 1), (930, 1), (935, 1), (940, 1), (945, 0), (950, 0), (955, 0), (960, 0), (965, 0), (970, 0), (975, 0), (980, 0), (985, 0), (990, 0), (995, 0), (1000, 0), (1005, 0), (1010, 1), (1015, 1), (1020, 0), (1025, 0)]
Vdin1_6  din1_6  0 PWL (0n 0.0v 4.745n 0.0v 4.755n 1.0v 9.745n 1.0v 9.755n 1.0v 14.745n 1.0v 14.755n 0.0v 19.745n 0.0v 19.755n 0.0v 24.745n 0.0v 24.755n 0.0v 29.745n 0.0v 29.755n 0.0v 34.745n 0.0v 34.755n 0.0v 39.745n 0.0v 39.755n 0.0v 44.745n 0.0v 44.755n 0.0v 49.745n 0.0v 49.755n 0.0v 54.745n 0.0v 54.755n 0.0v 59.745n 0.0v 59.755n 1.0v 64.745n 1.0v 64.755n 1.0v 69.745n 1.0v 69.755n 1.0v 74.745n 1.0v 74.755n 1.0v 79.745n 1.0v 79.755n 0.0v 84.745n 0.0v 84.755n 0.0v 89.745n 0.0v 89.755n 0.0v 94.745n 0.0v 94.755n 0.0v 99.745n 0.0v 99.755n 0.0v 104.745n 0.0v 104.755n 0.0v 109.745n 0.0v 109.755n 0.0v 114.745n 0.0v 114.755n 0.0v 119.745n 0.0v 119.755n 0.0v 124.745n 0.0v 124.755n 0.0v 129.745n 0.0v 129.755n 1.0v 134.745n 1.0v 134.755n 1.0v 139.745n 1.0v 139.755n 1.0v 144.745n 1.0v 144.755n 1.0v 149.745n 1.0v 149.755n 1.0v 154.745n 1.0v 154.755n 1.0v 159.745n 1.0v 159.755n 1.0v 164.745n 1.0v 164.755n 1.0v 169.745n 1.0v 169.755n 1.0v 174.745n 1.0v 174.755n 0.0v 179.745n 0.0v 179.755n 0.0v 184.745n 0.0v 184.755n 0.0v 189.745n 0.0v 189.755n 0.0v 194.745n 0.0v 194.755n 0.0v 199.745n 0.0v 199.755n 0.0v 204.745n 0.0v 204.755n 0.0v 209.745n 0.0v 209.755n 0.0v 214.745n 0.0v 214.755n 0.0v 219.745n 0.0v 219.755n 0.0v 224.745n 0.0v 224.755n 0.0v 229.745n 0.0v 229.755n 0.0v 234.745n 0.0v 234.755n 0.0v 239.745n 0.0v 239.755n 0.0v 244.745n 0.0v 244.755n 1.0v 249.745n 1.0v 249.755n 1.0v 254.745n 1.0v 254.755n 1.0v 259.745n 1.0v 259.755n 1.0v 264.745n 1.0v 264.755n 1.0v 269.745n 1.0v 269.755n 1.0v 274.745n 1.0v 274.755n 1.0v 279.745n 1.0v 279.755n 1.0v 284.745n 1.0v 284.755n 1.0v 289.745n 1.0v 289.755n 1.0v 294.745n 1.0v 294.755n 1.0v 299.745n 1.0v 299.755n 0.0v 304.745n 0.0v 304.755n 0.0v 309.745n 0.0v 309.755n 0.0v 314.745n 0.0v 314.755n 0.0v 319.745n 0.0v 319.755n 0.0v 324.745n 0.0v 324.755n 0.0v 329.745n 0.0v 329.755n 0.0v 334.745n 0.0v 334.755n 0.0v 339.745n 0.0v 339.755n 0.0v 344.745n 0.0v 344.755n 0.0v 349.745n 0.0v 349.755n 0.0v 354.745n 0.0v 354.755n 0.0v 359.745n 0.0v 359.755n 0.0v 364.745n 0.0v 364.755n 1.0v 369.745n 1.0v 369.755n 1.0v 374.745n 1.0v 374.755n 1.0v 379.745n 1.0v 379.755n 1.0v 384.745n 1.0v 384.755n 1.0v 389.745n 1.0v 389.755n 1.0v 394.745n 1.0v 394.755n 0.0v 399.745n 0.0v 399.755n 1.0v 404.745n 1.0v 404.755n 1.0v 409.745n 1.0v 409.755n 1.0v 414.745n 1.0v 414.755n 1.0v 419.745n 1.0v 419.755n 0.0v 424.745n 0.0v 424.755n 0.0v 429.745n 0.0v 429.755n 0.0v 434.745n 0.0v 434.755n 0.0v 439.745n 0.0v 439.755n 0.0v 444.745n 0.0v 444.755n 0.0v 449.745n 0.0v 449.755n 0.0v 454.745n 0.0v 454.755n 0.0v 459.745n 0.0v 459.755n 0.0v 464.745n 0.0v 464.755n 0.0v 469.745n 0.0v 469.755n 0.0v 474.745n 0.0v 474.755n 0.0v 479.745n 0.0v 479.755n 0.0v 484.745n 0.0v 484.755n 1.0v 489.745n 1.0v 489.755n 1.0v 494.745n 1.0v 494.755n 1.0v 499.745n 1.0v 499.755n 1.0v 504.745n 1.0v 504.755n 0.0v 509.745n 0.0v 509.755n 0.0v 514.745n 0.0v 514.755n 0.0v 519.745n 0.0v 519.755n 1.0v 524.745n 1.0v 524.755n 1.0v 529.745n 1.0v 529.755n 1.0v 534.745n 1.0v 534.755n 1.0v 539.745n 1.0v 539.755n 1.0v 544.745n 1.0v 544.755n 1.0v 549.745n 1.0v 549.755n 1.0v 554.745n 1.0v 554.755n 1.0v 559.745n 1.0v 559.755n 1.0v 564.745n 1.0v 564.755n 1.0v 569.745n 1.0v 569.755n 1.0v 574.745n 1.0v 574.755n 1.0v 579.745n 1.0v 579.755n 1.0v 584.745n 1.0v 584.755n 1.0v 589.745n 1.0v 589.755n 1.0v 594.745n 1.0v 594.755n 1.0v 599.745n 1.0v 599.755n 1.0v 604.745n 1.0v 604.755n 0.0v 609.745n 0.0v 609.755n 0.0v 614.745n 0.0v 614.755n 1.0v 619.745n 1.0v 619.755n 1.0v 624.745n 1.0v 624.755n 1.0v 629.745n 1.0v 629.755n 1.0v 634.745n 1.0v 634.755n 1.0v 639.745n 1.0v 639.755n 1.0v 644.745n 1.0v 644.755n 1.0v 649.745n 1.0v 649.755n 1.0v 654.745n 1.0v 654.755n 1.0v 659.745n 1.0v 659.755n 1.0v 664.745n 1.0v 664.755n 1.0v 669.745n 1.0v 669.755n 1.0v 674.745n 1.0v 674.755n 1.0v 679.745n 1.0v 679.755n 1.0v 684.745n 1.0v 684.755n 1.0v 689.745n 1.0v 689.755n 0.0v 694.745n 0.0v 694.755n 0.0v 699.745n 0.0v 699.755n 0.0v 704.745n 0.0v 704.755n 0.0v 709.745n 0.0v 709.755n 0.0v 714.745n 0.0v 714.755n 0.0v 719.745n 0.0v 719.755n 0.0v 724.745n 0.0v 724.755n 0.0v 729.745n 0.0v 729.755n 0.0v 734.745n 0.0v 734.755n 0.0v 739.745n 0.0v 739.755n 0.0v 744.745n 0.0v 744.755n 0.0v 749.745n 0.0v 749.755n 0.0v 754.745n 0.0v 754.755n 0.0v 759.745n 0.0v 759.755n 0.0v 764.745n 0.0v 764.755n 1.0v 769.745n 1.0v 769.755n 1.0v 774.745n 1.0v 774.755n 1.0v 779.745n 1.0v 779.755n 1.0v 784.745n 1.0v 784.755n 1.0v 789.745n 1.0v 789.755n 1.0v 794.745n 1.0v 794.755n 1.0v 799.745n 1.0v 799.755n 1.0v 804.745n 1.0v 804.755n 1.0v 809.745n 1.0v 809.755n 0.0v 814.745n 0.0v 814.755n 0.0v 819.745n 0.0v 819.755n 0.0v 824.745n 0.0v 824.755n 0.0v 829.745n 0.0v 829.755n 1.0v 834.745n 1.0v 834.755n 1.0v 839.745n 1.0v 839.755n 1.0v 844.745n 1.0v 844.755n 1.0v 849.745n 1.0v 849.755n 1.0v 854.745n 1.0v 854.755n 1.0v 859.745n 1.0v 859.755n 0.0v 864.745n 0.0v 864.755n 0.0v 869.745n 0.0v 869.755n 0.0v 874.745n 0.0v 874.755n 0.0v 879.745n 0.0v 879.755n 0.0v 884.745n 0.0v 884.755n 0.0v 889.745n 0.0v 889.755n 0.0v 894.745n 0.0v 894.755n 0.0v 899.745n 0.0v 899.755n 1.0v 904.745n 1.0v 904.755n 0.0v 909.745n 0.0v 909.755n 0.0v 914.745n 0.0v 914.755n 0.0v 919.745n 0.0v 919.755n 0.0v 924.745n 0.0v 924.755n 1.0v 929.745n 1.0v 929.755n 1.0v 934.745n 1.0v 934.755n 1.0v 939.745n 1.0v 939.755n 1.0v 944.745n 1.0v 944.755n 0.0v 949.745n 0.0v 949.755n 0.0v 954.745n 0.0v 954.755n 0.0v 959.745n 0.0v 959.755n 0.0v 964.745n 0.0v 964.755n 0.0v 969.745n 0.0v 969.755n 0.0v 974.745n 0.0v 974.755n 0.0v 979.745n 0.0v 979.755n 0.0v 984.745n 0.0v 984.755n 0.0v 989.745n 0.0v 989.755n 0.0v 994.745n 0.0v 994.755n 0.0v 999.745n 0.0v 999.755n 0.0v 1004.745n 0.0v 1004.755n 0.0v 1009.745n 0.0v 1009.755n 1.0v 1014.745n 1.0v 1014.755n 1.0v 1019.745n 1.0v 1019.755n 0.0v 1024.745n 0.0v 1024.755n 0.0v )
* (time, data): [(0, 0), (5, 1), (10, 0), (15, 1), (20, 1), (25, 1), (30, 1), (35, 1), (40, 1), (45, 1), (50, 1), (55, 1), (60, 0), (65, 0), (70, 0), (75, 0), (80, 0), (85, 0), (90, 1), (95, 1), (100, 1), (105, 1), (110, 1), (115, 1), (120, 1), (125, 1), (130, 0), (135, 0), (140, 0), (145, 0), (150, 0), (155, 0), (160, 0), (165, 0), (170, 0), (175, 0), (180, 0), (185, 0), (190, 0), (195, 0), (200, 0), (205, 0), (210, 0), (215, 0), (220, 0), (225, 0), (230, 0), (235, 0), (240, 0), (245, 0), (250, 1), (255, 1), (260, 1), (265, 1), (270, 1), (275, 1), (280, 1), (285, 1), (290, 1), (295, 1), (300, 1), (305, 1), (310, 1), (315, 1), (320, 1), (325, 1), (330, 1), (335, 1), (340, 1), (345, 1), (350, 1), (355, 1), (360, 1), (365, 1), (370, 1), (375, 1), (380, 0), (385, 0), (390, 1), (395, 0), (400, 0), (405, 0), (410, 0), (415, 0), (420, 1), (425, 1), (430, 1), (435, 1), (440, 1), (445, 1), (450, 1), (455, 1), (460, 1), (465, 1), (470, 1), (475, 1), (480, 1), (485, 1), (490, 1), (495, 1), (500, 1), (505, 0), (510, 0), (515, 0), (520, 1), (525, 1), (530, 1), (535, 1), (540, 1), (545, 1), (550, 1), (555, 1), (560, 1), (565, 1), (570, 1), (575, 1), (580, 0), (585, 0), (590, 0), (595, 0), (600, 0), (605, 1), (610, 1), (615, 0), (620, 0), (625, 0), (630, 0), (635, 0), (640, 0), (645, 0), (650, 0), (655, 0), (660, 0), (665, 0), (670, 0), (675, 0), (680, 0), (685, 0), (690, 1), (695, 1), (700, 1), (705, 1), (710, 1), (715, 1), (720, 1), (725, 1), (730, 1), (735, 1), (740, 1), (745, 1), (750, 1), (755, 1), (760, 1), (765, 1), (770, 1), (775, 1), (780, 1), (785, 1), (790, 1), (795, 1), (800, 1), (805, 1), (810, 0), (815, 0), (820, 0), (825, 0), (830, 1), (835, 1), (840, 1), (845, 1), (850, 1), (855, 1), (860, 0), (865, 0), (870, 0), (875, 0), (880, 0), (885, 0), (890, 0), (895, 0), (900, 0), (905, 1), (910, 1), (915, 1), (920, 1), (925, 1), (930, 1), (935, 1), (940, 1), (945, 1), (950, 1), (955, 1), (960, 1), (965, 1), (970, 1), (975, 1), (980, 1), (985, 1), (990, 1), (995, 1), (1000, 0), (1005, 0), (1010, 1), (1015, 1), (1020, 1), (1025, 1)]
Vdin1_7  din1_7  0 PWL (0n 0.0v 4.745n 0.0v 4.755n 1.0v 9.745n 1.0v 9.755n 0.0v 14.745n 0.0v 14.755n 1.0v 19.745n 1.0v 19.755n 1.0v 24.745n 1.0v 24.755n 1.0v 29.745n 1.0v 29.755n 1.0v 34.745n 1.0v 34.755n 1.0v 39.745n 1.0v 39.755n 1.0v 44.745n 1.0v 44.755n 1.0v 49.745n 1.0v 49.755n 1.0v 54.745n 1.0v 54.755n 1.0v 59.745n 1.0v 59.755n 0.0v 64.745n 0.0v 64.755n 0.0v 69.745n 0.0v 69.755n 0.0v 74.745n 0.0v 74.755n 0.0v 79.745n 0.0v 79.755n 0.0v 84.745n 0.0v 84.755n 0.0v 89.745n 0.0v 89.755n 1.0v 94.745n 1.0v 94.755n 1.0v 99.745n 1.0v 99.755n 1.0v 104.745n 1.0v 104.755n 1.0v 109.745n 1.0v 109.755n 1.0v 114.745n 1.0v 114.755n 1.0v 119.745n 1.0v 119.755n 1.0v 124.745n 1.0v 124.755n 1.0v 129.745n 1.0v 129.755n 0.0v 134.745n 0.0v 134.755n 0.0v 139.745n 0.0v 139.755n 0.0v 144.745n 0.0v 144.755n 0.0v 149.745n 0.0v 149.755n 0.0v 154.745n 0.0v 154.755n 0.0v 159.745n 0.0v 159.755n 0.0v 164.745n 0.0v 164.755n 0.0v 169.745n 0.0v 169.755n 0.0v 174.745n 0.0v 174.755n 0.0v 179.745n 0.0v 179.755n 0.0v 184.745n 0.0v 184.755n 0.0v 189.745n 0.0v 189.755n 0.0v 194.745n 0.0v 194.755n 0.0v 199.745n 0.0v 199.755n 0.0v 204.745n 0.0v 204.755n 0.0v 209.745n 0.0v 209.755n 0.0v 214.745n 0.0v 214.755n 0.0v 219.745n 0.0v 219.755n 0.0v 224.745n 0.0v 224.755n 0.0v 229.745n 0.0v 229.755n 0.0v 234.745n 0.0v 234.755n 0.0v 239.745n 0.0v 239.755n 0.0v 244.745n 0.0v 244.755n 0.0v 249.745n 0.0v 249.755n 1.0v 254.745n 1.0v 254.755n 1.0v 259.745n 1.0v 259.755n 1.0v 264.745n 1.0v 264.755n 1.0v 269.745n 1.0v 269.755n 1.0v 274.745n 1.0v 274.755n 1.0v 279.745n 1.0v 279.755n 1.0v 284.745n 1.0v 284.755n 1.0v 289.745n 1.0v 289.755n 1.0v 294.745n 1.0v 294.755n 1.0v 299.745n 1.0v 299.755n 1.0v 304.745n 1.0v 304.755n 1.0v 309.745n 1.0v 309.755n 1.0v 314.745n 1.0v 314.755n 1.0v 319.745n 1.0v 319.755n 1.0v 324.745n 1.0v 324.755n 1.0v 329.745n 1.0v 329.755n 1.0v 334.745n 1.0v 334.755n 1.0v 339.745n 1.0v 339.755n 1.0v 344.745n 1.0v 344.755n 1.0v 349.745n 1.0v 349.755n 1.0v 354.745n 1.0v 354.755n 1.0v 359.745n 1.0v 359.755n 1.0v 364.745n 1.0v 364.755n 1.0v 369.745n 1.0v 369.755n 1.0v 374.745n 1.0v 374.755n 1.0v 379.745n 1.0v 379.755n 0.0v 384.745n 0.0v 384.755n 0.0v 389.745n 0.0v 389.755n 1.0v 394.745n 1.0v 394.755n 0.0v 399.745n 0.0v 399.755n 0.0v 404.745n 0.0v 404.755n 0.0v 409.745n 0.0v 409.755n 0.0v 414.745n 0.0v 414.755n 0.0v 419.745n 0.0v 419.755n 1.0v 424.745n 1.0v 424.755n 1.0v 429.745n 1.0v 429.755n 1.0v 434.745n 1.0v 434.755n 1.0v 439.745n 1.0v 439.755n 1.0v 444.745n 1.0v 444.755n 1.0v 449.745n 1.0v 449.755n 1.0v 454.745n 1.0v 454.755n 1.0v 459.745n 1.0v 459.755n 1.0v 464.745n 1.0v 464.755n 1.0v 469.745n 1.0v 469.755n 1.0v 474.745n 1.0v 474.755n 1.0v 479.745n 1.0v 479.755n 1.0v 484.745n 1.0v 484.755n 1.0v 489.745n 1.0v 489.755n 1.0v 494.745n 1.0v 494.755n 1.0v 499.745n 1.0v 499.755n 1.0v 504.745n 1.0v 504.755n 0.0v 509.745n 0.0v 509.755n 0.0v 514.745n 0.0v 514.755n 0.0v 519.745n 0.0v 519.755n 1.0v 524.745n 1.0v 524.755n 1.0v 529.745n 1.0v 529.755n 1.0v 534.745n 1.0v 534.755n 1.0v 539.745n 1.0v 539.755n 1.0v 544.745n 1.0v 544.755n 1.0v 549.745n 1.0v 549.755n 1.0v 554.745n 1.0v 554.755n 1.0v 559.745n 1.0v 559.755n 1.0v 564.745n 1.0v 564.755n 1.0v 569.745n 1.0v 569.755n 1.0v 574.745n 1.0v 574.755n 1.0v 579.745n 1.0v 579.755n 0.0v 584.745n 0.0v 584.755n 0.0v 589.745n 0.0v 589.755n 0.0v 594.745n 0.0v 594.755n 0.0v 599.745n 0.0v 599.755n 0.0v 604.745n 0.0v 604.755n 1.0v 609.745n 1.0v 609.755n 1.0v 614.745n 1.0v 614.755n 0.0v 619.745n 0.0v 619.755n 0.0v 624.745n 0.0v 624.755n 0.0v 629.745n 0.0v 629.755n 0.0v 634.745n 0.0v 634.755n 0.0v 639.745n 0.0v 639.755n 0.0v 644.745n 0.0v 644.755n 0.0v 649.745n 0.0v 649.755n 0.0v 654.745n 0.0v 654.755n 0.0v 659.745n 0.0v 659.755n 0.0v 664.745n 0.0v 664.755n 0.0v 669.745n 0.0v 669.755n 0.0v 674.745n 0.0v 674.755n 0.0v 679.745n 0.0v 679.755n 0.0v 684.745n 0.0v 684.755n 0.0v 689.745n 0.0v 689.755n 1.0v 694.745n 1.0v 694.755n 1.0v 699.745n 1.0v 699.755n 1.0v 704.745n 1.0v 704.755n 1.0v 709.745n 1.0v 709.755n 1.0v 714.745n 1.0v 714.755n 1.0v 719.745n 1.0v 719.755n 1.0v 724.745n 1.0v 724.755n 1.0v 729.745n 1.0v 729.755n 1.0v 734.745n 1.0v 734.755n 1.0v 739.745n 1.0v 739.755n 1.0v 744.745n 1.0v 744.755n 1.0v 749.745n 1.0v 749.755n 1.0v 754.745n 1.0v 754.755n 1.0v 759.745n 1.0v 759.755n 1.0v 764.745n 1.0v 764.755n 1.0v 769.745n 1.0v 769.755n 1.0v 774.745n 1.0v 774.755n 1.0v 779.745n 1.0v 779.755n 1.0v 784.745n 1.0v 784.755n 1.0v 789.745n 1.0v 789.755n 1.0v 794.745n 1.0v 794.755n 1.0v 799.745n 1.0v 799.755n 1.0v 804.745n 1.0v 804.755n 1.0v 809.745n 1.0v 809.755n 0.0v 814.745n 0.0v 814.755n 0.0v 819.745n 0.0v 819.755n 0.0v 824.745n 0.0v 824.755n 0.0v 829.745n 0.0v 829.755n 1.0v 834.745n 1.0v 834.755n 1.0v 839.745n 1.0v 839.755n 1.0v 844.745n 1.0v 844.755n 1.0v 849.745n 1.0v 849.755n 1.0v 854.745n 1.0v 854.755n 1.0v 859.745n 1.0v 859.755n 0.0v 864.745n 0.0v 864.755n 0.0v 869.745n 0.0v 869.755n 0.0v 874.745n 0.0v 874.755n 0.0v 879.745n 0.0v 879.755n 0.0v 884.745n 0.0v 884.755n 0.0v 889.745n 0.0v 889.755n 0.0v 894.745n 0.0v 894.755n 0.0v 899.745n 0.0v 899.755n 0.0v 904.745n 0.0v 904.755n 1.0v 909.745n 1.0v 909.755n 1.0v 914.745n 1.0v 914.755n 1.0v 919.745n 1.0v 919.755n 1.0v 924.745n 1.0v 924.755n 1.0v 929.745n 1.0v 929.755n 1.0v 934.745n 1.0v 934.755n 1.0v 939.745n 1.0v 939.755n 1.0v 944.745n 1.0v 944.755n 1.0v 949.745n 1.0v 949.755n 1.0v 954.745n 1.0v 954.755n 1.0v 959.745n 1.0v 959.755n 1.0v 964.745n 1.0v 964.755n 1.0v 969.745n 1.0v 969.755n 1.0v 974.745n 1.0v 974.755n 1.0v 979.745n 1.0v 979.755n 1.0v 984.745n 1.0v 984.755n 1.0v 989.745n 1.0v 989.755n 1.0v 994.745n 1.0v 994.755n 1.0v 999.745n 1.0v 999.755n 0.0v 1004.745n 0.0v 1004.755n 0.0v 1009.745n 0.0v 1009.755n 1.0v 1014.745n 1.0v 1014.755n 1.0v 1019.745n 1.0v 1019.755n 1.0v 1024.745n 1.0v 1024.755n 1.0v )
* (time, data): [(0, 0), (5, 0), (10, 0), (15, 0), (20, 0), (25, 0), (30, 0), (35, 0), (40, 0), (45, 0), (50, 0), (55, 0), (60, 0), (65, 0), (70, 0), (75, 0), (80, 0), (85, 0), (90, 1), (95, 1), (100, 1), (105, 1), (110, 1), (115, 1), (120, 1), (125, 1), (130, 0), (135, 0), (140, 0), (145, 1), (150, 1), (155, 1), (160, 1), (165, 1), (170, 1), (175, 0), (180, 0), (185, 0), (190, 0), (195, 0), (200, 0), (205, 0), (210, 0), (215, 0), (220, 0), (225, 0), (230, 0), (235, 0), (240, 0), (245, 0), (250, 0), (255, 0), (260, 0), (265, 0), (270, 0), (275, 0), (280, 0), (285, 0), (290, 0), (295, 0), (300, 1), (305, 1), (310, 1), (315, 1), (320, 1), (325, 1), (330, 1), (335, 1), (340, 1), (345, 1), (350, 1), (355, 1), (360, 1), (365, 0), (370, 0), (375, 0), (380, 1), (385, 1), (390, 0), (395, 0), (400, 1), (405, 1), (410, 1), (415, 1), (420, 0), (425, 0), (430, 0), (435, 0), (440, 0), (445, 0), (450, 0), (455, 0), (460, 0), (465, 1), (470, 1), (475, 1), (480, 1), (485, 0), (490, 0), (495, 0), (500, 0), (505, 1), (510, 1), (515, 1), (520, 1), (525, 1), (530, 1), (535, 1), (540, 1), (545, 1), (550, 1), (555, 1), (560, 1), (565, 1), (570, 1), (575, 1), (580, 0), (585, 0), (590, 0), (595, 0), (600, 0), (605, 0), (610, 0), (615, 1), (620, 1), (625, 1), (630, 1), (635, 1), (640, 1), (645, 1), (650, 1), (655, 1), (660, 1), (665, 1), (670, 1), (675, 1), (680, 1), (685, 1), (690, 0), (695, 0), (700, 0), (705, 0), (710, 0), (715, 0), (720, 0), (725, 0), (730, 0), (735, 0), (740, 0), (745, 0), (750, 0), (755, 0), (760, 1), (765, 0), (770, 0), (775, 0), (780, 0), (785, 0), (790, 1), (795, 1), (800, 1), (805, 1), (810, 0), (815, 0), (820, 0), (825, 0), (830, 1), (835, 1), (840, 1), (845, 1), (850, 1), (855, 1), (860, 0), (865, 0), (870, 0), (875, 0), (880, 0), (885, 0), (890, 0), (895, 0), (900, 1), (905, 1), (910, 1), (915, 1), (920, 1), (925, 1), (930, 1), (935, 1), (940, 1), (945, 1), (950, 1), (955, 1), (960, 1), (965, 1), (970, 1), (975, 1), (980, 1), (985, 1), (990, 1), (995, 1), (1000, 1), (1005, 1), (1010, 1), (1015, 1), (1020, 1), (1025, 1)]
Vdin1_8  din1_8  0 PWL (0n 0.0v 4.745n 0.0v 4.755n 0.0v 9.745n 0.0v 9.755n 0.0v 14.745n 0.0v 14.755n 0.0v 19.745n 0.0v 19.755n 0.0v 24.745n 0.0v 24.755n 0.0v 29.745n 0.0v 29.755n 0.0v 34.745n 0.0v 34.755n 0.0v 39.745n 0.0v 39.755n 0.0v 44.745n 0.0v 44.755n 0.0v 49.745n 0.0v 49.755n 0.0v 54.745n 0.0v 54.755n 0.0v 59.745n 0.0v 59.755n 0.0v 64.745n 0.0v 64.755n 0.0v 69.745n 0.0v 69.755n 0.0v 74.745n 0.0v 74.755n 0.0v 79.745n 0.0v 79.755n 0.0v 84.745n 0.0v 84.755n 0.0v 89.745n 0.0v 89.755n 1.0v 94.745n 1.0v 94.755n 1.0v 99.745n 1.0v 99.755n 1.0v 104.745n 1.0v 104.755n 1.0v 109.745n 1.0v 109.755n 1.0v 114.745n 1.0v 114.755n 1.0v 119.745n 1.0v 119.755n 1.0v 124.745n 1.0v 124.755n 1.0v 129.745n 1.0v 129.755n 0.0v 134.745n 0.0v 134.755n 0.0v 139.745n 0.0v 139.755n 0.0v 144.745n 0.0v 144.755n 1.0v 149.745n 1.0v 149.755n 1.0v 154.745n 1.0v 154.755n 1.0v 159.745n 1.0v 159.755n 1.0v 164.745n 1.0v 164.755n 1.0v 169.745n 1.0v 169.755n 1.0v 174.745n 1.0v 174.755n 0.0v 179.745n 0.0v 179.755n 0.0v 184.745n 0.0v 184.755n 0.0v 189.745n 0.0v 189.755n 0.0v 194.745n 0.0v 194.755n 0.0v 199.745n 0.0v 199.755n 0.0v 204.745n 0.0v 204.755n 0.0v 209.745n 0.0v 209.755n 0.0v 214.745n 0.0v 214.755n 0.0v 219.745n 0.0v 219.755n 0.0v 224.745n 0.0v 224.755n 0.0v 229.745n 0.0v 229.755n 0.0v 234.745n 0.0v 234.755n 0.0v 239.745n 0.0v 239.755n 0.0v 244.745n 0.0v 244.755n 0.0v 249.745n 0.0v 249.755n 0.0v 254.745n 0.0v 254.755n 0.0v 259.745n 0.0v 259.755n 0.0v 264.745n 0.0v 264.755n 0.0v 269.745n 0.0v 269.755n 0.0v 274.745n 0.0v 274.755n 0.0v 279.745n 0.0v 279.755n 0.0v 284.745n 0.0v 284.755n 0.0v 289.745n 0.0v 289.755n 0.0v 294.745n 0.0v 294.755n 0.0v 299.745n 0.0v 299.755n 1.0v 304.745n 1.0v 304.755n 1.0v 309.745n 1.0v 309.755n 1.0v 314.745n 1.0v 314.755n 1.0v 319.745n 1.0v 319.755n 1.0v 324.745n 1.0v 324.755n 1.0v 329.745n 1.0v 329.755n 1.0v 334.745n 1.0v 334.755n 1.0v 339.745n 1.0v 339.755n 1.0v 344.745n 1.0v 344.755n 1.0v 349.745n 1.0v 349.755n 1.0v 354.745n 1.0v 354.755n 1.0v 359.745n 1.0v 359.755n 1.0v 364.745n 1.0v 364.755n 0.0v 369.745n 0.0v 369.755n 0.0v 374.745n 0.0v 374.755n 0.0v 379.745n 0.0v 379.755n 1.0v 384.745n 1.0v 384.755n 1.0v 389.745n 1.0v 389.755n 0.0v 394.745n 0.0v 394.755n 0.0v 399.745n 0.0v 399.755n 1.0v 404.745n 1.0v 404.755n 1.0v 409.745n 1.0v 409.755n 1.0v 414.745n 1.0v 414.755n 1.0v 419.745n 1.0v 419.755n 0.0v 424.745n 0.0v 424.755n 0.0v 429.745n 0.0v 429.755n 0.0v 434.745n 0.0v 434.755n 0.0v 439.745n 0.0v 439.755n 0.0v 444.745n 0.0v 444.755n 0.0v 449.745n 0.0v 449.755n 0.0v 454.745n 0.0v 454.755n 0.0v 459.745n 0.0v 459.755n 0.0v 464.745n 0.0v 464.755n 1.0v 469.745n 1.0v 469.755n 1.0v 474.745n 1.0v 474.755n 1.0v 479.745n 1.0v 479.755n 1.0v 484.745n 1.0v 484.755n 0.0v 489.745n 0.0v 489.755n 0.0v 494.745n 0.0v 494.755n 0.0v 499.745n 0.0v 499.755n 0.0v 504.745n 0.0v 504.755n 1.0v 509.745n 1.0v 509.755n 1.0v 514.745n 1.0v 514.755n 1.0v 519.745n 1.0v 519.755n 1.0v 524.745n 1.0v 524.755n 1.0v 529.745n 1.0v 529.755n 1.0v 534.745n 1.0v 534.755n 1.0v 539.745n 1.0v 539.755n 1.0v 544.745n 1.0v 544.755n 1.0v 549.745n 1.0v 549.755n 1.0v 554.745n 1.0v 554.755n 1.0v 559.745n 1.0v 559.755n 1.0v 564.745n 1.0v 564.755n 1.0v 569.745n 1.0v 569.755n 1.0v 574.745n 1.0v 574.755n 1.0v 579.745n 1.0v 579.755n 0.0v 584.745n 0.0v 584.755n 0.0v 589.745n 0.0v 589.755n 0.0v 594.745n 0.0v 594.755n 0.0v 599.745n 0.0v 599.755n 0.0v 604.745n 0.0v 604.755n 0.0v 609.745n 0.0v 609.755n 0.0v 614.745n 0.0v 614.755n 1.0v 619.745n 1.0v 619.755n 1.0v 624.745n 1.0v 624.755n 1.0v 629.745n 1.0v 629.755n 1.0v 634.745n 1.0v 634.755n 1.0v 639.745n 1.0v 639.755n 1.0v 644.745n 1.0v 644.755n 1.0v 649.745n 1.0v 649.755n 1.0v 654.745n 1.0v 654.755n 1.0v 659.745n 1.0v 659.755n 1.0v 664.745n 1.0v 664.755n 1.0v 669.745n 1.0v 669.755n 1.0v 674.745n 1.0v 674.755n 1.0v 679.745n 1.0v 679.755n 1.0v 684.745n 1.0v 684.755n 1.0v 689.745n 1.0v 689.755n 0.0v 694.745n 0.0v 694.755n 0.0v 699.745n 0.0v 699.755n 0.0v 704.745n 0.0v 704.755n 0.0v 709.745n 0.0v 709.755n 0.0v 714.745n 0.0v 714.755n 0.0v 719.745n 0.0v 719.755n 0.0v 724.745n 0.0v 724.755n 0.0v 729.745n 0.0v 729.755n 0.0v 734.745n 0.0v 734.755n 0.0v 739.745n 0.0v 739.755n 0.0v 744.745n 0.0v 744.755n 0.0v 749.745n 0.0v 749.755n 0.0v 754.745n 0.0v 754.755n 0.0v 759.745n 0.0v 759.755n 1.0v 764.745n 1.0v 764.755n 0.0v 769.745n 0.0v 769.755n 0.0v 774.745n 0.0v 774.755n 0.0v 779.745n 0.0v 779.755n 0.0v 784.745n 0.0v 784.755n 0.0v 789.745n 0.0v 789.755n 1.0v 794.745n 1.0v 794.755n 1.0v 799.745n 1.0v 799.755n 1.0v 804.745n 1.0v 804.755n 1.0v 809.745n 1.0v 809.755n 0.0v 814.745n 0.0v 814.755n 0.0v 819.745n 0.0v 819.755n 0.0v 824.745n 0.0v 824.755n 0.0v 829.745n 0.0v 829.755n 1.0v 834.745n 1.0v 834.755n 1.0v 839.745n 1.0v 839.755n 1.0v 844.745n 1.0v 844.755n 1.0v 849.745n 1.0v 849.755n 1.0v 854.745n 1.0v 854.755n 1.0v 859.745n 1.0v 859.755n 0.0v 864.745n 0.0v 864.755n 0.0v 869.745n 0.0v 869.755n 0.0v 874.745n 0.0v 874.755n 0.0v 879.745n 0.0v 879.755n 0.0v 884.745n 0.0v 884.755n 0.0v 889.745n 0.0v 889.755n 0.0v 894.745n 0.0v 894.755n 0.0v 899.745n 0.0v 899.755n 1.0v 904.745n 1.0v 904.755n 1.0v 909.745n 1.0v 909.755n 1.0v 914.745n 1.0v 914.755n 1.0v 919.745n 1.0v 919.755n 1.0v 924.745n 1.0v 924.755n 1.0v 929.745n 1.0v 929.755n 1.0v 934.745n 1.0v 934.755n 1.0v 939.745n 1.0v 939.755n 1.0v 944.745n 1.0v 944.755n 1.0v 949.745n 1.0v 949.755n 1.0v 954.745n 1.0v 954.755n 1.0v 959.745n 1.0v 959.755n 1.0v 964.745n 1.0v 964.755n 1.0v 969.745n 1.0v 969.755n 1.0v 974.745n 1.0v 974.755n 1.0v 979.745n 1.0v 979.755n 1.0v 984.745n 1.0v 984.755n 1.0v 989.745n 1.0v 989.755n 1.0v 994.745n 1.0v 994.755n 1.0v 999.745n 1.0v 999.755n 1.0v 1004.745n 1.0v 1004.755n 1.0v 1009.745n 1.0v 1009.755n 1.0v 1014.745n 1.0v 1014.755n 1.0v 1019.745n 1.0v 1019.755n 1.0v 1024.745n 1.0v 1024.755n 1.0v )
* (time, data): [(0, 0), (5, 1), (10, 1), (15, 1), (20, 1), (25, 1), (30, 1), (35, 1), (40, 1), (45, 1), (50, 1), (55, 1), (60, 0), (65, 0), (70, 0), (75, 0), (80, 0), (85, 0), (90, 0), (95, 0), (100, 0), (105, 0), (110, 0), (115, 0), (120, 0), (125, 0), (130, 1), (135, 1), (140, 1), (145, 0), (150, 0), (155, 0), (160, 0), (165, 0), (170, 0), (175, 0), (180, 1), (185, 1), (190, 1), (195, 1), (200, 1), (205, 1), (210, 1), (215, 1), (220, 1), (225, 1), (230, 1), (235, 1), (240, 1), (245, 0), (250, 0), (255, 0), (260, 0), (265, 0), (270, 0), (275, 0), (280, 0), (285, 1), (290, 1), (295, 1), (300, 1), (305, 1), (310, 1), (315, 1), (320, 1), (325, 1), (330, 1), (335, 1), (340, 1), (345, 1), (350, 1), (355, 1), (360, 1), (365, 1), (370, 1), (375, 1), (380, 0), (385, 0), (390, 0), (395, 0), (400, 1), (405, 1), (410, 1), (415, 1), (420, 0), (425, 0), (430, 0), (435, 0), (440, 0), (445, 0), (450, 0), (455, 0), (460, 0), (465, 0), (470, 0), (475, 0), (480, 0), (485, 0), (490, 0), (495, 0), (500, 0), (505, 1), (510, 1), (515, 1), (520, 0), (525, 0), (530, 0), (535, 0), (540, 0), (545, 0), (550, 0), (555, 0), (560, 0), (565, 0), (570, 0), (575, 0), (580, 1), (585, 0), (590, 0), (595, 0), (600, 0), (605, 1), (610, 1), (615, 1), (620, 1), (625, 1), (630, 1), (635, 1), (640, 1), (645, 1), (650, 1), (655, 1), (660, 1), (665, 1), (670, 1), (675, 1), (680, 1), (685, 1), (690, 1), (695, 1), (700, 1), (705, 1), (710, 1), (715, 1), (720, 1), (725, 1), (730, 0), (735, 0), (740, 0), (745, 0), (750, 0), (755, 0), (760, 0), (765, 0), (770, 1), (775, 1), (780, 1), (785, 1), (790, 1), (795, 1), (800, 1), (805, 1), (810, 0), (815, 0), (820, 0), (825, 0), (830, 0), (835, 0), (840, 0), (845, 0), (850, 0), (855, 0), (860, 0), (865, 0), (870, 0), (875, 0), (880, 1), (885, 1), (890, 1), (895, 1), (900, 0), (905, 1), (910, 1), (915, 1), (920, 1), (925, 0), (930, 1), (935, 1), (940, 1), (945, 0), (950, 0), (955, 0), (960, 0), (965, 0), (970, 0), (975, 0), (980, 0), (985, 0), (990, 0), (995, 0), (1000, 1), (1005, 1), (1010, 0), (1015, 0), (1020, 1), (1025, 1)]
Vdin1_9  din1_9  0 PWL (0n 0.0v 4.745n 0.0v 4.755n 1.0v 9.745n 1.0v 9.755n 1.0v 14.745n 1.0v 14.755n 1.0v 19.745n 1.0v 19.755n 1.0v 24.745n 1.0v 24.755n 1.0v 29.745n 1.0v 29.755n 1.0v 34.745n 1.0v 34.755n 1.0v 39.745n 1.0v 39.755n 1.0v 44.745n 1.0v 44.755n 1.0v 49.745n 1.0v 49.755n 1.0v 54.745n 1.0v 54.755n 1.0v 59.745n 1.0v 59.755n 0.0v 64.745n 0.0v 64.755n 0.0v 69.745n 0.0v 69.755n 0.0v 74.745n 0.0v 74.755n 0.0v 79.745n 0.0v 79.755n 0.0v 84.745n 0.0v 84.755n 0.0v 89.745n 0.0v 89.755n 0.0v 94.745n 0.0v 94.755n 0.0v 99.745n 0.0v 99.755n 0.0v 104.745n 0.0v 104.755n 0.0v 109.745n 0.0v 109.755n 0.0v 114.745n 0.0v 114.755n 0.0v 119.745n 0.0v 119.755n 0.0v 124.745n 0.0v 124.755n 0.0v 129.745n 0.0v 129.755n 1.0v 134.745n 1.0v 134.755n 1.0v 139.745n 1.0v 139.755n 1.0v 144.745n 1.0v 144.755n 0.0v 149.745n 0.0v 149.755n 0.0v 154.745n 0.0v 154.755n 0.0v 159.745n 0.0v 159.755n 0.0v 164.745n 0.0v 164.755n 0.0v 169.745n 0.0v 169.755n 0.0v 174.745n 0.0v 174.755n 0.0v 179.745n 0.0v 179.755n 1.0v 184.745n 1.0v 184.755n 1.0v 189.745n 1.0v 189.755n 1.0v 194.745n 1.0v 194.755n 1.0v 199.745n 1.0v 199.755n 1.0v 204.745n 1.0v 204.755n 1.0v 209.745n 1.0v 209.755n 1.0v 214.745n 1.0v 214.755n 1.0v 219.745n 1.0v 219.755n 1.0v 224.745n 1.0v 224.755n 1.0v 229.745n 1.0v 229.755n 1.0v 234.745n 1.0v 234.755n 1.0v 239.745n 1.0v 239.755n 1.0v 244.745n 1.0v 244.755n 0.0v 249.745n 0.0v 249.755n 0.0v 254.745n 0.0v 254.755n 0.0v 259.745n 0.0v 259.755n 0.0v 264.745n 0.0v 264.755n 0.0v 269.745n 0.0v 269.755n 0.0v 274.745n 0.0v 274.755n 0.0v 279.745n 0.0v 279.755n 0.0v 284.745n 0.0v 284.755n 1.0v 289.745n 1.0v 289.755n 1.0v 294.745n 1.0v 294.755n 1.0v 299.745n 1.0v 299.755n 1.0v 304.745n 1.0v 304.755n 1.0v 309.745n 1.0v 309.755n 1.0v 314.745n 1.0v 314.755n 1.0v 319.745n 1.0v 319.755n 1.0v 324.745n 1.0v 324.755n 1.0v 329.745n 1.0v 329.755n 1.0v 334.745n 1.0v 334.755n 1.0v 339.745n 1.0v 339.755n 1.0v 344.745n 1.0v 344.755n 1.0v 349.745n 1.0v 349.755n 1.0v 354.745n 1.0v 354.755n 1.0v 359.745n 1.0v 359.755n 1.0v 364.745n 1.0v 364.755n 1.0v 369.745n 1.0v 369.755n 1.0v 374.745n 1.0v 374.755n 1.0v 379.745n 1.0v 379.755n 0.0v 384.745n 0.0v 384.755n 0.0v 389.745n 0.0v 389.755n 0.0v 394.745n 0.0v 394.755n 0.0v 399.745n 0.0v 399.755n 1.0v 404.745n 1.0v 404.755n 1.0v 409.745n 1.0v 409.755n 1.0v 414.745n 1.0v 414.755n 1.0v 419.745n 1.0v 419.755n 0.0v 424.745n 0.0v 424.755n 0.0v 429.745n 0.0v 429.755n 0.0v 434.745n 0.0v 434.755n 0.0v 439.745n 0.0v 439.755n 0.0v 444.745n 0.0v 444.755n 0.0v 449.745n 0.0v 449.755n 0.0v 454.745n 0.0v 454.755n 0.0v 459.745n 0.0v 459.755n 0.0v 464.745n 0.0v 464.755n 0.0v 469.745n 0.0v 469.755n 0.0v 474.745n 0.0v 474.755n 0.0v 479.745n 0.0v 479.755n 0.0v 484.745n 0.0v 484.755n 0.0v 489.745n 0.0v 489.755n 0.0v 494.745n 0.0v 494.755n 0.0v 499.745n 0.0v 499.755n 0.0v 504.745n 0.0v 504.755n 1.0v 509.745n 1.0v 509.755n 1.0v 514.745n 1.0v 514.755n 1.0v 519.745n 1.0v 519.755n 0.0v 524.745n 0.0v 524.755n 0.0v 529.745n 0.0v 529.755n 0.0v 534.745n 0.0v 534.755n 0.0v 539.745n 0.0v 539.755n 0.0v 544.745n 0.0v 544.755n 0.0v 549.745n 0.0v 549.755n 0.0v 554.745n 0.0v 554.755n 0.0v 559.745n 0.0v 559.755n 0.0v 564.745n 0.0v 564.755n 0.0v 569.745n 0.0v 569.755n 0.0v 574.745n 0.0v 574.755n 0.0v 579.745n 0.0v 579.755n 1.0v 584.745n 1.0v 584.755n 0.0v 589.745n 0.0v 589.755n 0.0v 594.745n 0.0v 594.755n 0.0v 599.745n 0.0v 599.755n 0.0v 604.745n 0.0v 604.755n 1.0v 609.745n 1.0v 609.755n 1.0v 614.745n 1.0v 614.755n 1.0v 619.745n 1.0v 619.755n 1.0v 624.745n 1.0v 624.755n 1.0v 629.745n 1.0v 629.755n 1.0v 634.745n 1.0v 634.755n 1.0v 639.745n 1.0v 639.755n 1.0v 644.745n 1.0v 644.755n 1.0v 649.745n 1.0v 649.755n 1.0v 654.745n 1.0v 654.755n 1.0v 659.745n 1.0v 659.755n 1.0v 664.745n 1.0v 664.755n 1.0v 669.745n 1.0v 669.755n 1.0v 674.745n 1.0v 674.755n 1.0v 679.745n 1.0v 679.755n 1.0v 684.745n 1.0v 684.755n 1.0v 689.745n 1.0v 689.755n 1.0v 694.745n 1.0v 694.755n 1.0v 699.745n 1.0v 699.755n 1.0v 704.745n 1.0v 704.755n 1.0v 709.745n 1.0v 709.755n 1.0v 714.745n 1.0v 714.755n 1.0v 719.745n 1.0v 719.755n 1.0v 724.745n 1.0v 724.755n 1.0v 729.745n 1.0v 729.755n 0.0v 734.745n 0.0v 734.755n 0.0v 739.745n 0.0v 739.755n 0.0v 744.745n 0.0v 744.755n 0.0v 749.745n 0.0v 749.755n 0.0v 754.745n 0.0v 754.755n 0.0v 759.745n 0.0v 759.755n 0.0v 764.745n 0.0v 764.755n 0.0v 769.745n 0.0v 769.755n 1.0v 774.745n 1.0v 774.755n 1.0v 779.745n 1.0v 779.755n 1.0v 784.745n 1.0v 784.755n 1.0v 789.745n 1.0v 789.755n 1.0v 794.745n 1.0v 794.755n 1.0v 799.745n 1.0v 799.755n 1.0v 804.745n 1.0v 804.755n 1.0v 809.745n 1.0v 809.755n 0.0v 814.745n 0.0v 814.755n 0.0v 819.745n 0.0v 819.755n 0.0v 824.745n 0.0v 824.755n 0.0v 829.745n 0.0v 829.755n 0.0v 834.745n 0.0v 834.755n 0.0v 839.745n 0.0v 839.755n 0.0v 844.745n 0.0v 844.755n 0.0v 849.745n 0.0v 849.755n 0.0v 854.745n 0.0v 854.755n 0.0v 859.745n 0.0v 859.755n 0.0v 864.745n 0.0v 864.755n 0.0v 869.745n 0.0v 869.755n 0.0v 874.745n 0.0v 874.755n 0.0v 879.745n 0.0v 879.755n 1.0v 884.745n 1.0v 884.755n 1.0v 889.745n 1.0v 889.755n 1.0v 894.745n 1.0v 894.755n 1.0v 899.745n 1.0v 899.755n 0.0v 904.745n 0.0v 904.755n 1.0v 909.745n 1.0v 909.755n 1.0v 914.745n 1.0v 914.755n 1.0v 919.745n 1.0v 919.755n 1.0v 924.745n 1.0v 924.755n 0.0v 929.745n 0.0v 929.755n 1.0v 934.745n 1.0v 934.755n 1.0v 939.745n 1.0v 939.755n 1.0v 944.745n 1.0v 944.755n 0.0v 949.745n 0.0v 949.755n 0.0v 954.745n 0.0v 954.755n 0.0v 959.745n 0.0v 959.755n 0.0v 964.745n 0.0v 964.755n 0.0v 969.745n 0.0v 969.755n 0.0v 974.745n 0.0v 974.755n 0.0v 979.745n 0.0v 979.755n 0.0v 984.745n 0.0v 984.755n 0.0v 989.745n 0.0v 989.755n 0.0v 994.745n 0.0v 994.755n 0.0v 999.745n 0.0v 999.755n 1.0v 1004.745n 1.0v 1004.755n 1.0v 1009.745n 1.0v 1009.755n 0.0v 1014.745n 0.0v 1014.755n 0.0v 1019.745n 0.0v 1019.755n 1.0v 1024.745n 1.0v 1024.755n 1.0v )
* (time, data): [(0, 0), (5, 0), (10, 1), (15, 0), (20, 0), (25, 0), (30, 0), (35, 0), (40, 0), (45, 0), (50, 0), (55, 0), (60, 1), (65, 1), (70, 1), (75, 1), (80, 0), (85, 0), (90, 1), (95, 1), (100, 1), (105, 1), (110, 1), (115, 1), (120, 1), (125, 1), (130, 1), (135, 1), (140, 1), (145, 1), (150, 1), (155, 1), (160, 1), (165, 1), (170, 1), (175, 1), (180, 0), (185, 0), (190, 0), (195, 0), (200, 0), (205, 0), (210, 0), (215, 0), (220, 0), (225, 0), (230, 0), (235, 0), (240, 0), (245, 1), (250, 1), (255, 1), (260, 1), (265, 1), (270, 1), (275, 1), (280, 1), (285, 1), (290, 1), (295, 1), (300, 1), (305, 1), (310, 1), (315, 1), (320, 1), (325, 1), (330, 1), (335, 1), (340, 1), (345, 1), (350, 1), (355, 1), (360, 1), (365, 1), (370, 1), (375, 1), (380, 1), (385, 1), (390, 0), (395, 1), (400, 1), (405, 1), (410, 1), (415, 1), (420, 0), (425, 0), (430, 0), (435, 0), (440, 0), (445, 0), (450, 0), (455, 0), (460, 0), (465, 0), (470, 0), (475, 0), (480, 0), (485, 0), (490, 0), (495, 0), (500, 0), (505, 1), (510, 1), (515, 1), (520, 0), (525, 0), (530, 0), (535, 0), (540, 0), (545, 0), (550, 0), (555, 0), (560, 0), (565, 0), (570, 0), (575, 0), (580, 0), (585, 1), (590, 1), (595, 1), (600, 1), (605, 0), (610, 0), (615, 0), (620, 0), (625, 0), (630, 0), (635, 0), (640, 0), (645, 0), (650, 0), (655, 0), (660, 0), (665, 0), (670, 0), (675, 0), (680, 0), (685, 0), (690, 0), (695, 0), (700, 0), (705, 0), (710, 0), (715, 0), (720, 0), (725, 0), (730, 0), (735, 0), (740, 0), (745, 0), (750, 0), (755, 0), (760, 0), (765, 0), (770, 0), (775, 0), (780, 0), (785, 0), (790, 0), (795, 0), (800, 0), (805, 0), (810, 1), (815, 1), (820, 1), (825, 1), (830, 1), (835, 1), (840, 1), (845, 1), (850, 1), (855, 1), (860, 1), (865, 1), (870, 1), (875, 1), (880, 0), (885, 0), (890, 0), (895, 0), (900, 1), (905, 1), (910, 1), (915, 1), (920, 1), (925, 0), (930, 0), (935, 0), (940, 0), (945, 0), (950, 0), (955, 0), (960, 0), (965, 0), (970, 0), (975, 0), (980, 0), (985, 0), (990, 0), (995, 0), (1000, 1), (1005, 1), (1010, 1), (1015, 1), (1020, 1), (1025, 1)]
Vdin1_10  din1_10  0 PWL (0n 0.0v 4.745n 0.0v 4.755n 0.0v 9.745n 0.0v 9.755n 1.0v 14.745n 1.0v 14.755n 0.0v 19.745n 0.0v 19.755n 0.0v 24.745n 0.0v 24.755n 0.0v 29.745n 0.0v 29.755n 0.0v 34.745n 0.0v 34.755n 0.0v 39.745n 0.0v 39.755n 0.0v 44.745n 0.0v 44.755n 0.0v 49.745n 0.0v 49.755n 0.0v 54.745n 0.0v 54.755n 0.0v 59.745n 0.0v 59.755n 1.0v 64.745n 1.0v 64.755n 1.0v 69.745n 1.0v 69.755n 1.0v 74.745n 1.0v 74.755n 1.0v 79.745n 1.0v 79.755n 0.0v 84.745n 0.0v 84.755n 0.0v 89.745n 0.0v 89.755n 1.0v 94.745n 1.0v 94.755n 1.0v 99.745n 1.0v 99.755n 1.0v 104.745n 1.0v 104.755n 1.0v 109.745n 1.0v 109.755n 1.0v 114.745n 1.0v 114.755n 1.0v 119.745n 1.0v 119.755n 1.0v 124.745n 1.0v 124.755n 1.0v 129.745n 1.0v 129.755n 1.0v 134.745n 1.0v 134.755n 1.0v 139.745n 1.0v 139.755n 1.0v 144.745n 1.0v 144.755n 1.0v 149.745n 1.0v 149.755n 1.0v 154.745n 1.0v 154.755n 1.0v 159.745n 1.0v 159.755n 1.0v 164.745n 1.0v 164.755n 1.0v 169.745n 1.0v 169.755n 1.0v 174.745n 1.0v 174.755n 1.0v 179.745n 1.0v 179.755n 0.0v 184.745n 0.0v 184.755n 0.0v 189.745n 0.0v 189.755n 0.0v 194.745n 0.0v 194.755n 0.0v 199.745n 0.0v 199.755n 0.0v 204.745n 0.0v 204.755n 0.0v 209.745n 0.0v 209.755n 0.0v 214.745n 0.0v 214.755n 0.0v 219.745n 0.0v 219.755n 0.0v 224.745n 0.0v 224.755n 0.0v 229.745n 0.0v 229.755n 0.0v 234.745n 0.0v 234.755n 0.0v 239.745n 0.0v 239.755n 0.0v 244.745n 0.0v 244.755n 1.0v 249.745n 1.0v 249.755n 1.0v 254.745n 1.0v 254.755n 1.0v 259.745n 1.0v 259.755n 1.0v 264.745n 1.0v 264.755n 1.0v 269.745n 1.0v 269.755n 1.0v 274.745n 1.0v 274.755n 1.0v 279.745n 1.0v 279.755n 1.0v 284.745n 1.0v 284.755n 1.0v 289.745n 1.0v 289.755n 1.0v 294.745n 1.0v 294.755n 1.0v 299.745n 1.0v 299.755n 1.0v 304.745n 1.0v 304.755n 1.0v 309.745n 1.0v 309.755n 1.0v 314.745n 1.0v 314.755n 1.0v 319.745n 1.0v 319.755n 1.0v 324.745n 1.0v 324.755n 1.0v 329.745n 1.0v 329.755n 1.0v 334.745n 1.0v 334.755n 1.0v 339.745n 1.0v 339.755n 1.0v 344.745n 1.0v 344.755n 1.0v 349.745n 1.0v 349.755n 1.0v 354.745n 1.0v 354.755n 1.0v 359.745n 1.0v 359.755n 1.0v 364.745n 1.0v 364.755n 1.0v 369.745n 1.0v 369.755n 1.0v 374.745n 1.0v 374.755n 1.0v 379.745n 1.0v 379.755n 1.0v 384.745n 1.0v 384.755n 1.0v 389.745n 1.0v 389.755n 0.0v 394.745n 0.0v 394.755n 1.0v 399.745n 1.0v 399.755n 1.0v 404.745n 1.0v 404.755n 1.0v 409.745n 1.0v 409.755n 1.0v 414.745n 1.0v 414.755n 1.0v 419.745n 1.0v 419.755n 0.0v 424.745n 0.0v 424.755n 0.0v 429.745n 0.0v 429.755n 0.0v 434.745n 0.0v 434.755n 0.0v 439.745n 0.0v 439.755n 0.0v 444.745n 0.0v 444.755n 0.0v 449.745n 0.0v 449.755n 0.0v 454.745n 0.0v 454.755n 0.0v 459.745n 0.0v 459.755n 0.0v 464.745n 0.0v 464.755n 0.0v 469.745n 0.0v 469.755n 0.0v 474.745n 0.0v 474.755n 0.0v 479.745n 0.0v 479.755n 0.0v 484.745n 0.0v 484.755n 0.0v 489.745n 0.0v 489.755n 0.0v 494.745n 0.0v 494.755n 0.0v 499.745n 0.0v 499.755n 0.0v 504.745n 0.0v 504.755n 1.0v 509.745n 1.0v 509.755n 1.0v 514.745n 1.0v 514.755n 1.0v 519.745n 1.0v 519.755n 0.0v 524.745n 0.0v 524.755n 0.0v 529.745n 0.0v 529.755n 0.0v 534.745n 0.0v 534.755n 0.0v 539.745n 0.0v 539.755n 0.0v 544.745n 0.0v 544.755n 0.0v 549.745n 0.0v 549.755n 0.0v 554.745n 0.0v 554.755n 0.0v 559.745n 0.0v 559.755n 0.0v 564.745n 0.0v 564.755n 0.0v 569.745n 0.0v 569.755n 0.0v 574.745n 0.0v 574.755n 0.0v 579.745n 0.0v 579.755n 0.0v 584.745n 0.0v 584.755n 1.0v 589.745n 1.0v 589.755n 1.0v 594.745n 1.0v 594.755n 1.0v 599.745n 1.0v 599.755n 1.0v 604.745n 1.0v 604.755n 0.0v 609.745n 0.0v 609.755n 0.0v 614.745n 0.0v 614.755n 0.0v 619.745n 0.0v 619.755n 0.0v 624.745n 0.0v 624.755n 0.0v 629.745n 0.0v 629.755n 0.0v 634.745n 0.0v 634.755n 0.0v 639.745n 0.0v 639.755n 0.0v 644.745n 0.0v 644.755n 0.0v 649.745n 0.0v 649.755n 0.0v 654.745n 0.0v 654.755n 0.0v 659.745n 0.0v 659.755n 0.0v 664.745n 0.0v 664.755n 0.0v 669.745n 0.0v 669.755n 0.0v 674.745n 0.0v 674.755n 0.0v 679.745n 0.0v 679.755n 0.0v 684.745n 0.0v 684.755n 0.0v 689.745n 0.0v 689.755n 0.0v 694.745n 0.0v 694.755n 0.0v 699.745n 0.0v 699.755n 0.0v 704.745n 0.0v 704.755n 0.0v 709.745n 0.0v 709.755n 0.0v 714.745n 0.0v 714.755n 0.0v 719.745n 0.0v 719.755n 0.0v 724.745n 0.0v 724.755n 0.0v 729.745n 0.0v 729.755n 0.0v 734.745n 0.0v 734.755n 0.0v 739.745n 0.0v 739.755n 0.0v 744.745n 0.0v 744.755n 0.0v 749.745n 0.0v 749.755n 0.0v 754.745n 0.0v 754.755n 0.0v 759.745n 0.0v 759.755n 0.0v 764.745n 0.0v 764.755n 0.0v 769.745n 0.0v 769.755n 0.0v 774.745n 0.0v 774.755n 0.0v 779.745n 0.0v 779.755n 0.0v 784.745n 0.0v 784.755n 0.0v 789.745n 0.0v 789.755n 0.0v 794.745n 0.0v 794.755n 0.0v 799.745n 0.0v 799.755n 0.0v 804.745n 0.0v 804.755n 0.0v 809.745n 0.0v 809.755n 1.0v 814.745n 1.0v 814.755n 1.0v 819.745n 1.0v 819.755n 1.0v 824.745n 1.0v 824.755n 1.0v 829.745n 1.0v 829.755n 1.0v 834.745n 1.0v 834.755n 1.0v 839.745n 1.0v 839.755n 1.0v 844.745n 1.0v 844.755n 1.0v 849.745n 1.0v 849.755n 1.0v 854.745n 1.0v 854.755n 1.0v 859.745n 1.0v 859.755n 1.0v 864.745n 1.0v 864.755n 1.0v 869.745n 1.0v 869.755n 1.0v 874.745n 1.0v 874.755n 1.0v 879.745n 1.0v 879.755n 0.0v 884.745n 0.0v 884.755n 0.0v 889.745n 0.0v 889.755n 0.0v 894.745n 0.0v 894.755n 0.0v 899.745n 0.0v 899.755n 1.0v 904.745n 1.0v 904.755n 1.0v 909.745n 1.0v 909.755n 1.0v 914.745n 1.0v 914.755n 1.0v 919.745n 1.0v 919.755n 1.0v 924.745n 1.0v 924.755n 0.0v 929.745n 0.0v 929.755n 0.0v 934.745n 0.0v 934.755n 0.0v 939.745n 0.0v 939.755n 0.0v 944.745n 0.0v 944.755n 0.0v 949.745n 0.0v 949.755n 0.0v 954.745n 0.0v 954.755n 0.0v 959.745n 0.0v 959.755n 0.0v 964.745n 0.0v 964.755n 0.0v 969.745n 0.0v 969.755n 0.0v 974.745n 0.0v 974.755n 0.0v 979.745n 0.0v 979.755n 0.0v 984.745n 0.0v 984.755n 0.0v 989.745n 0.0v 989.755n 0.0v 994.745n 0.0v 994.755n 0.0v 999.745n 0.0v 999.755n 1.0v 1004.745n 1.0v 1004.755n 1.0v 1009.745n 1.0v 1009.755n 1.0v 1014.745n 1.0v 1014.755n 1.0v 1019.745n 1.0v 1019.755n 1.0v 1024.745n 1.0v 1024.755n 1.0v )
* (time, data): [(0, 0), (5, 1), (10, 0), (15, 0), (20, 0), (25, 0), (30, 0), (35, 0), (40, 0), (45, 0), (50, 0), (55, 0), (60, 1), (65, 1), (70, 1), (75, 1), (80, 1), (85, 1), (90, 0), (95, 0), (100, 0), (105, 0), (110, 0), (115, 0), (120, 0), (125, 0), (130, 1), (135, 1), (140, 1), (145, 1), (150, 1), (155, 1), (160, 1), (165, 1), (170, 1), (175, 0), (180, 0), (185, 0), (190, 0), (195, 0), (200, 0), (205, 0), (210, 0), (215, 0), (220, 0), (225, 0), (230, 0), (235, 0), (240, 0), (245, 1), (250, 0), (255, 0), (260, 0), (265, 0), (270, 0), (275, 0), (280, 0), (285, 1), (290, 1), (295, 1), (300, 1), (305, 1), (310, 1), (315, 1), (320, 1), (325, 1), (330, 1), (335, 1), (340, 1), (345, 1), (350, 1), (355, 1), (360, 1), (365, 1), (370, 1), (375, 1), (380, 1), (385, 1), (390, 0), (395, 1), (400, 0), (405, 0), (410, 0), (415, 0), (420, 1), (425, 1), (430, 1), (435, 1), (440, 1), (445, 1), (450, 1), (455, 1), (460, 1), (465, 1), (470, 1), (475, 1), (480, 1), (485, 0), (490, 0), (495, 0), (500, 0), (505, 1), (510, 1), (515, 1), (520, 0), (525, 0), (530, 0), (535, 0), (540, 0), (545, 0), (550, 0), (555, 0), (560, 0), (565, 0), (570, 0), (575, 0), (580, 0), (585, 1), (590, 1), (595, 1), (600, 1), (605, 0), (610, 0), (615, 1), (620, 1), (625, 1), (630, 1), (635, 1), (640, 1), (645, 1), (650, 1), (655, 1), (660, 1), (665, 1), (670, 1), (675, 1), (680, 1), (685, 1), (690, 1), (695, 1), (700, 1), (705, 1), (710, 1), (715, 1), (720, 1), (725, 1), (730, 1), (735, 1), (740, 1), (745, 1), (750, 1), (755, 1), (760, 1), (765, 0), (770, 0), (775, 0), (780, 0), (785, 0), (790, 1), (795, 1), (800, 1), (805, 1), (810, 0), (815, 0), (820, 0), (825, 0), (830, 1), (835, 1), (840, 1), (845, 1), (850, 1), (855, 1), (860, 1), (865, 1), (870, 1), (875, 1), (880, 0), (885, 0), (890, 0), (895, 0), (900, 1), (905, 1), (910, 1), (915, 1), (920, 1), (925, 1), (930, 0), (935, 0), (940, 0), (945, 0), (950, 0), (955, 0), (960, 0), (965, 0), (970, 0), (975, 0), (980, 0), (985, 0), (990, 0), (995, 0), (1000, 0), (1005, 0), (1010, 0), (1015, 0), (1020, 0), (1025, 0)]
Vdin1_11  din1_11  0 PWL (0n 0.0v 4.745n 0.0v 4.755n 1.0v 9.745n 1.0v 9.755n 0.0v 14.745n 0.0v 14.755n 0.0v 19.745n 0.0v 19.755n 0.0v 24.745n 0.0v 24.755n 0.0v 29.745n 0.0v 29.755n 0.0v 34.745n 0.0v 34.755n 0.0v 39.745n 0.0v 39.755n 0.0v 44.745n 0.0v 44.755n 0.0v 49.745n 0.0v 49.755n 0.0v 54.745n 0.0v 54.755n 0.0v 59.745n 0.0v 59.755n 1.0v 64.745n 1.0v 64.755n 1.0v 69.745n 1.0v 69.755n 1.0v 74.745n 1.0v 74.755n 1.0v 79.745n 1.0v 79.755n 1.0v 84.745n 1.0v 84.755n 1.0v 89.745n 1.0v 89.755n 0.0v 94.745n 0.0v 94.755n 0.0v 99.745n 0.0v 99.755n 0.0v 104.745n 0.0v 104.755n 0.0v 109.745n 0.0v 109.755n 0.0v 114.745n 0.0v 114.755n 0.0v 119.745n 0.0v 119.755n 0.0v 124.745n 0.0v 124.755n 0.0v 129.745n 0.0v 129.755n 1.0v 134.745n 1.0v 134.755n 1.0v 139.745n 1.0v 139.755n 1.0v 144.745n 1.0v 144.755n 1.0v 149.745n 1.0v 149.755n 1.0v 154.745n 1.0v 154.755n 1.0v 159.745n 1.0v 159.755n 1.0v 164.745n 1.0v 164.755n 1.0v 169.745n 1.0v 169.755n 1.0v 174.745n 1.0v 174.755n 0.0v 179.745n 0.0v 179.755n 0.0v 184.745n 0.0v 184.755n 0.0v 189.745n 0.0v 189.755n 0.0v 194.745n 0.0v 194.755n 0.0v 199.745n 0.0v 199.755n 0.0v 204.745n 0.0v 204.755n 0.0v 209.745n 0.0v 209.755n 0.0v 214.745n 0.0v 214.755n 0.0v 219.745n 0.0v 219.755n 0.0v 224.745n 0.0v 224.755n 0.0v 229.745n 0.0v 229.755n 0.0v 234.745n 0.0v 234.755n 0.0v 239.745n 0.0v 239.755n 0.0v 244.745n 0.0v 244.755n 1.0v 249.745n 1.0v 249.755n 0.0v 254.745n 0.0v 254.755n 0.0v 259.745n 0.0v 259.755n 0.0v 264.745n 0.0v 264.755n 0.0v 269.745n 0.0v 269.755n 0.0v 274.745n 0.0v 274.755n 0.0v 279.745n 0.0v 279.755n 0.0v 284.745n 0.0v 284.755n 1.0v 289.745n 1.0v 289.755n 1.0v 294.745n 1.0v 294.755n 1.0v 299.745n 1.0v 299.755n 1.0v 304.745n 1.0v 304.755n 1.0v 309.745n 1.0v 309.755n 1.0v 314.745n 1.0v 314.755n 1.0v 319.745n 1.0v 319.755n 1.0v 324.745n 1.0v 324.755n 1.0v 329.745n 1.0v 329.755n 1.0v 334.745n 1.0v 334.755n 1.0v 339.745n 1.0v 339.755n 1.0v 344.745n 1.0v 344.755n 1.0v 349.745n 1.0v 349.755n 1.0v 354.745n 1.0v 354.755n 1.0v 359.745n 1.0v 359.755n 1.0v 364.745n 1.0v 364.755n 1.0v 369.745n 1.0v 369.755n 1.0v 374.745n 1.0v 374.755n 1.0v 379.745n 1.0v 379.755n 1.0v 384.745n 1.0v 384.755n 1.0v 389.745n 1.0v 389.755n 0.0v 394.745n 0.0v 394.755n 1.0v 399.745n 1.0v 399.755n 0.0v 404.745n 0.0v 404.755n 0.0v 409.745n 0.0v 409.755n 0.0v 414.745n 0.0v 414.755n 0.0v 419.745n 0.0v 419.755n 1.0v 424.745n 1.0v 424.755n 1.0v 429.745n 1.0v 429.755n 1.0v 434.745n 1.0v 434.755n 1.0v 439.745n 1.0v 439.755n 1.0v 444.745n 1.0v 444.755n 1.0v 449.745n 1.0v 449.755n 1.0v 454.745n 1.0v 454.755n 1.0v 459.745n 1.0v 459.755n 1.0v 464.745n 1.0v 464.755n 1.0v 469.745n 1.0v 469.755n 1.0v 474.745n 1.0v 474.755n 1.0v 479.745n 1.0v 479.755n 1.0v 484.745n 1.0v 484.755n 0.0v 489.745n 0.0v 489.755n 0.0v 494.745n 0.0v 494.755n 0.0v 499.745n 0.0v 499.755n 0.0v 504.745n 0.0v 504.755n 1.0v 509.745n 1.0v 509.755n 1.0v 514.745n 1.0v 514.755n 1.0v 519.745n 1.0v 519.755n 0.0v 524.745n 0.0v 524.755n 0.0v 529.745n 0.0v 529.755n 0.0v 534.745n 0.0v 534.755n 0.0v 539.745n 0.0v 539.755n 0.0v 544.745n 0.0v 544.755n 0.0v 549.745n 0.0v 549.755n 0.0v 554.745n 0.0v 554.755n 0.0v 559.745n 0.0v 559.755n 0.0v 564.745n 0.0v 564.755n 0.0v 569.745n 0.0v 569.755n 0.0v 574.745n 0.0v 574.755n 0.0v 579.745n 0.0v 579.755n 0.0v 584.745n 0.0v 584.755n 1.0v 589.745n 1.0v 589.755n 1.0v 594.745n 1.0v 594.755n 1.0v 599.745n 1.0v 599.755n 1.0v 604.745n 1.0v 604.755n 0.0v 609.745n 0.0v 609.755n 0.0v 614.745n 0.0v 614.755n 1.0v 619.745n 1.0v 619.755n 1.0v 624.745n 1.0v 624.755n 1.0v 629.745n 1.0v 629.755n 1.0v 634.745n 1.0v 634.755n 1.0v 639.745n 1.0v 639.755n 1.0v 644.745n 1.0v 644.755n 1.0v 649.745n 1.0v 649.755n 1.0v 654.745n 1.0v 654.755n 1.0v 659.745n 1.0v 659.755n 1.0v 664.745n 1.0v 664.755n 1.0v 669.745n 1.0v 669.755n 1.0v 674.745n 1.0v 674.755n 1.0v 679.745n 1.0v 679.755n 1.0v 684.745n 1.0v 684.755n 1.0v 689.745n 1.0v 689.755n 1.0v 694.745n 1.0v 694.755n 1.0v 699.745n 1.0v 699.755n 1.0v 704.745n 1.0v 704.755n 1.0v 709.745n 1.0v 709.755n 1.0v 714.745n 1.0v 714.755n 1.0v 719.745n 1.0v 719.755n 1.0v 724.745n 1.0v 724.755n 1.0v 729.745n 1.0v 729.755n 1.0v 734.745n 1.0v 734.755n 1.0v 739.745n 1.0v 739.755n 1.0v 744.745n 1.0v 744.755n 1.0v 749.745n 1.0v 749.755n 1.0v 754.745n 1.0v 754.755n 1.0v 759.745n 1.0v 759.755n 1.0v 764.745n 1.0v 764.755n 0.0v 769.745n 0.0v 769.755n 0.0v 774.745n 0.0v 774.755n 0.0v 779.745n 0.0v 779.755n 0.0v 784.745n 0.0v 784.755n 0.0v 789.745n 0.0v 789.755n 1.0v 794.745n 1.0v 794.755n 1.0v 799.745n 1.0v 799.755n 1.0v 804.745n 1.0v 804.755n 1.0v 809.745n 1.0v 809.755n 0.0v 814.745n 0.0v 814.755n 0.0v 819.745n 0.0v 819.755n 0.0v 824.745n 0.0v 824.755n 0.0v 829.745n 0.0v 829.755n 1.0v 834.745n 1.0v 834.755n 1.0v 839.745n 1.0v 839.755n 1.0v 844.745n 1.0v 844.755n 1.0v 849.745n 1.0v 849.755n 1.0v 854.745n 1.0v 854.755n 1.0v 859.745n 1.0v 859.755n 1.0v 864.745n 1.0v 864.755n 1.0v 869.745n 1.0v 869.755n 1.0v 874.745n 1.0v 874.755n 1.0v 879.745n 1.0v 879.755n 0.0v 884.745n 0.0v 884.755n 0.0v 889.745n 0.0v 889.755n 0.0v 894.745n 0.0v 894.755n 0.0v 899.745n 0.0v 899.755n 1.0v 904.745n 1.0v 904.755n 1.0v 909.745n 1.0v 909.755n 1.0v 914.745n 1.0v 914.755n 1.0v 919.745n 1.0v 919.755n 1.0v 924.745n 1.0v 924.755n 1.0v 929.745n 1.0v 929.755n 0.0v 934.745n 0.0v 934.755n 0.0v 939.745n 0.0v 939.755n 0.0v 944.745n 0.0v 944.755n 0.0v 949.745n 0.0v 949.755n 0.0v 954.745n 0.0v 954.755n 0.0v 959.745n 0.0v 959.755n 0.0v 964.745n 0.0v 964.755n 0.0v 969.745n 0.0v 969.755n 0.0v 974.745n 0.0v 974.755n 0.0v 979.745n 0.0v 979.755n 0.0v 984.745n 0.0v 984.755n 0.0v 989.745n 0.0v 989.755n 0.0v 994.745n 0.0v 994.755n 0.0v 999.745n 0.0v 999.755n 0.0v 1004.745n 0.0v 1004.755n 0.0v 1009.745n 0.0v 1009.755n 0.0v 1014.745n 0.0v 1014.755n 0.0v 1019.745n 0.0v 1019.755n 0.0v 1024.745n 0.0v 1024.755n 0.0v )
* (time, data): [(0, 0), (5, 0), (10, 0), (15, 0), (20, 0), (25, 0), (30, 0), (35, 0), (40, 0), (45, 0), (50, 0), (55, 0), (60, 0), (65, 0), (70, 0), (75, 0), (80, 1), (85, 1), (90, 1), (95, 1), (100, 1), (105, 1), (110, 1), (115, 1), (120, 1), (125, 1), (130, 0), (135, 0), (140, 0), (145, 1), (150, 1), (155, 1), (160, 1), (165, 1), (170, 1), (175, 1), (180, 1), (185, 1), (190, 1), (195, 1), (200, 1), (205, 1), (210, 1), (215, 1), (220, 1), (225, 1), (230, 1), (235, 1), (240, 1), (245, 0), (250, 1), (255, 1), (260, 1), (265, 1), (270, 1), (275, 1), (280, 1), (285, 0), (290, 0), (295, 0), (300, 0), (305, 0), (310, 0), (315, 0), (320, 0), (325, 0), (330, 0), (335, 0), (340, 0), (345, 0), (350, 0), (355, 0), (360, 0), (365, 1), (370, 1), (375, 1), (380, 0), (385, 0), (390, 0), (395, 1), (400, 1), (405, 1), (410, 1), (415, 1), (420, 1), (425, 1), (430, 1), (435, 1), (440, 1), (445, 1), (450, 1), (455, 1), (460, 1), (465, 1), (470, 1), (475, 1), (480, 1), (485, 1), (490, 1), (495, 1), (500, 1), (505, 1), (510, 1), (515, 1), (520, 0), (525, 0), (530, 0), (535, 0), (540, 0), (545, 0), (550, 0), (555, 0), (560, 0), (565, 0), (570, 0), (575, 0), (580, 1), (585, 0), (590, 0), (595, 0), (600, 0), (605, 0), (610, 0), (615, 0), (620, 0), (625, 0), (630, 0), (635, 0), (640, 0), (645, 0), (650, 0), (655, 0), (660, 0), (665, 0), (670, 0), (675, 0), (680, 0), (685, 0), (690, 0), (695, 0), (700, 0), (705, 0), (710, 0), (715, 0), (720, 0), (725, 0), (730, 0), (735, 1), (740, 1), (745, 1), (750, 1), (755, 1), (760, 0), (765, 1), (770, 0), (775, 0), (780, 0), (785, 0), (790, 0), (795, 0), (800, 0), (805, 0), (810, 0), (815, 0), (820, 0), (825, 0), (830, 1), (835, 1), (840, 1), (845, 1), (850, 1), (855, 1), (860, 1), (865, 1), (870, 1), (875, 1), (880, 1), (885, 1), (890, 1), (895, 1), (900, 1), (905, 0), (910, 0), (915, 0), (920, 0), (925, 1), (930, 0), (935, 0), (940, 0), (945, 0), (950, 0), (955, 0), (960, 0), (965, 0), (970, 0), (975, 0), (980, 0), (985, 0), (990, 0), (995, 0), (1000, 1), (1005, 1), (1010, 1), (1015, 1), (1020, 0), (1025, 0)]
Vdin1_12  din1_12  0 PWL (0n 0.0v 4.745n 0.0v 4.755n 0.0v 9.745n 0.0v 9.755n 0.0v 14.745n 0.0v 14.755n 0.0v 19.745n 0.0v 19.755n 0.0v 24.745n 0.0v 24.755n 0.0v 29.745n 0.0v 29.755n 0.0v 34.745n 0.0v 34.755n 0.0v 39.745n 0.0v 39.755n 0.0v 44.745n 0.0v 44.755n 0.0v 49.745n 0.0v 49.755n 0.0v 54.745n 0.0v 54.755n 0.0v 59.745n 0.0v 59.755n 0.0v 64.745n 0.0v 64.755n 0.0v 69.745n 0.0v 69.755n 0.0v 74.745n 0.0v 74.755n 0.0v 79.745n 0.0v 79.755n 1.0v 84.745n 1.0v 84.755n 1.0v 89.745n 1.0v 89.755n 1.0v 94.745n 1.0v 94.755n 1.0v 99.745n 1.0v 99.755n 1.0v 104.745n 1.0v 104.755n 1.0v 109.745n 1.0v 109.755n 1.0v 114.745n 1.0v 114.755n 1.0v 119.745n 1.0v 119.755n 1.0v 124.745n 1.0v 124.755n 1.0v 129.745n 1.0v 129.755n 0.0v 134.745n 0.0v 134.755n 0.0v 139.745n 0.0v 139.755n 0.0v 144.745n 0.0v 144.755n 1.0v 149.745n 1.0v 149.755n 1.0v 154.745n 1.0v 154.755n 1.0v 159.745n 1.0v 159.755n 1.0v 164.745n 1.0v 164.755n 1.0v 169.745n 1.0v 169.755n 1.0v 174.745n 1.0v 174.755n 1.0v 179.745n 1.0v 179.755n 1.0v 184.745n 1.0v 184.755n 1.0v 189.745n 1.0v 189.755n 1.0v 194.745n 1.0v 194.755n 1.0v 199.745n 1.0v 199.755n 1.0v 204.745n 1.0v 204.755n 1.0v 209.745n 1.0v 209.755n 1.0v 214.745n 1.0v 214.755n 1.0v 219.745n 1.0v 219.755n 1.0v 224.745n 1.0v 224.755n 1.0v 229.745n 1.0v 229.755n 1.0v 234.745n 1.0v 234.755n 1.0v 239.745n 1.0v 239.755n 1.0v 244.745n 1.0v 244.755n 0.0v 249.745n 0.0v 249.755n 1.0v 254.745n 1.0v 254.755n 1.0v 259.745n 1.0v 259.755n 1.0v 264.745n 1.0v 264.755n 1.0v 269.745n 1.0v 269.755n 1.0v 274.745n 1.0v 274.755n 1.0v 279.745n 1.0v 279.755n 1.0v 284.745n 1.0v 284.755n 0.0v 289.745n 0.0v 289.755n 0.0v 294.745n 0.0v 294.755n 0.0v 299.745n 0.0v 299.755n 0.0v 304.745n 0.0v 304.755n 0.0v 309.745n 0.0v 309.755n 0.0v 314.745n 0.0v 314.755n 0.0v 319.745n 0.0v 319.755n 0.0v 324.745n 0.0v 324.755n 0.0v 329.745n 0.0v 329.755n 0.0v 334.745n 0.0v 334.755n 0.0v 339.745n 0.0v 339.755n 0.0v 344.745n 0.0v 344.755n 0.0v 349.745n 0.0v 349.755n 0.0v 354.745n 0.0v 354.755n 0.0v 359.745n 0.0v 359.755n 0.0v 364.745n 0.0v 364.755n 1.0v 369.745n 1.0v 369.755n 1.0v 374.745n 1.0v 374.755n 1.0v 379.745n 1.0v 379.755n 0.0v 384.745n 0.0v 384.755n 0.0v 389.745n 0.0v 389.755n 0.0v 394.745n 0.0v 394.755n 1.0v 399.745n 1.0v 399.755n 1.0v 404.745n 1.0v 404.755n 1.0v 409.745n 1.0v 409.755n 1.0v 414.745n 1.0v 414.755n 1.0v 419.745n 1.0v 419.755n 1.0v 424.745n 1.0v 424.755n 1.0v 429.745n 1.0v 429.755n 1.0v 434.745n 1.0v 434.755n 1.0v 439.745n 1.0v 439.755n 1.0v 444.745n 1.0v 444.755n 1.0v 449.745n 1.0v 449.755n 1.0v 454.745n 1.0v 454.755n 1.0v 459.745n 1.0v 459.755n 1.0v 464.745n 1.0v 464.755n 1.0v 469.745n 1.0v 469.755n 1.0v 474.745n 1.0v 474.755n 1.0v 479.745n 1.0v 479.755n 1.0v 484.745n 1.0v 484.755n 1.0v 489.745n 1.0v 489.755n 1.0v 494.745n 1.0v 494.755n 1.0v 499.745n 1.0v 499.755n 1.0v 504.745n 1.0v 504.755n 1.0v 509.745n 1.0v 509.755n 1.0v 514.745n 1.0v 514.755n 1.0v 519.745n 1.0v 519.755n 0.0v 524.745n 0.0v 524.755n 0.0v 529.745n 0.0v 529.755n 0.0v 534.745n 0.0v 534.755n 0.0v 539.745n 0.0v 539.755n 0.0v 544.745n 0.0v 544.755n 0.0v 549.745n 0.0v 549.755n 0.0v 554.745n 0.0v 554.755n 0.0v 559.745n 0.0v 559.755n 0.0v 564.745n 0.0v 564.755n 0.0v 569.745n 0.0v 569.755n 0.0v 574.745n 0.0v 574.755n 0.0v 579.745n 0.0v 579.755n 1.0v 584.745n 1.0v 584.755n 0.0v 589.745n 0.0v 589.755n 0.0v 594.745n 0.0v 594.755n 0.0v 599.745n 0.0v 599.755n 0.0v 604.745n 0.0v 604.755n 0.0v 609.745n 0.0v 609.755n 0.0v 614.745n 0.0v 614.755n 0.0v 619.745n 0.0v 619.755n 0.0v 624.745n 0.0v 624.755n 0.0v 629.745n 0.0v 629.755n 0.0v 634.745n 0.0v 634.755n 0.0v 639.745n 0.0v 639.755n 0.0v 644.745n 0.0v 644.755n 0.0v 649.745n 0.0v 649.755n 0.0v 654.745n 0.0v 654.755n 0.0v 659.745n 0.0v 659.755n 0.0v 664.745n 0.0v 664.755n 0.0v 669.745n 0.0v 669.755n 0.0v 674.745n 0.0v 674.755n 0.0v 679.745n 0.0v 679.755n 0.0v 684.745n 0.0v 684.755n 0.0v 689.745n 0.0v 689.755n 0.0v 694.745n 0.0v 694.755n 0.0v 699.745n 0.0v 699.755n 0.0v 704.745n 0.0v 704.755n 0.0v 709.745n 0.0v 709.755n 0.0v 714.745n 0.0v 714.755n 0.0v 719.745n 0.0v 719.755n 0.0v 724.745n 0.0v 724.755n 0.0v 729.745n 0.0v 729.755n 0.0v 734.745n 0.0v 734.755n 1.0v 739.745n 1.0v 739.755n 1.0v 744.745n 1.0v 744.755n 1.0v 749.745n 1.0v 749.755n 1.0v 754.745n 1.0v 754.755n 1.0v 759.745n 1.0v 759.755n 0.0v 764.745n 0.0v 764.755n 1.0v 769.745n 1.0v 769.755n 0.0v 774.745n 0.0v 774.755n 0.0v 779.745n 0.0v 779.755n 0.0v 784.745n 0.0v 784.755n 0.0v 789.745n 0.0v 789.755n 0.0v 794.745n 0.0v 794.755n 0.0v 799.745n 0.0v 799.755n 0.0v 804.745n 0.0v 804.755n 0.0v 809.745n 0.0v 809.755n 0.0v 814.745n 0.0v 814.755n 0.0v 819.745n 0.0v 819.755n 0.0v 824.745n 0.0v 824.755n 0.0v 829.745n 0.0v 829.755n 1.0v 834.745n 1.0v 834.755n 1.0v 839.745n 1.0v 839.755n 1.0v 844.745n 1.0v 844.755n 1.0v 849.745n 1.0v 849.755n 1.0v 854.745n 1.0v 854.755n 1.0v 859.745n 1.0v 859.755n 1.0v 864.745n 1.0v 864.755n 1.0v 869.745n 1.0v 869.755n 1.0v 874.745n 1.0v 874.755n 1.0v 879.745n 1.0v 879.755n 1.0v 884.745n 1.0v 884.755n 1.0v 889.745n 1.0v 889.755n 1.0v 894.745n 1.0v 894.755n 1.0v 899.745n 1.0v 899.755n 1.0v 904.745n 1.0v 904.755n 0.0v 909.745n 0.0v 909.755n 0.0v 914.745n 0.0v 914.755n 0.0v 919.745n 0.0v 919.755n 0.0v 924.745n 0.0v 924.755n 1.0v 929.745n 1.0v 929.755n 0.0v 934.745n 0.0v 934.755n 0.0v 939.745n 0.0v 939.755n 0.0v 944.745n 0.0v 944.755n 0.0v 949.745n 0.0v 949.755n 0.0v 954.745n 0.0v 954.755n 0.0v 959.745n 0.0v 959.755n 0.0v 964.745n 0.0v 964.755n 0.0v 969.745n 0.0v 969.755n 0.0v 974.745n 0.0v 974.755n 0.0v 979.745n 0.0v 979.755n 0.0v 984.745n 0.0v 984.755n 0.0v 989.745n 0.0v 989.755n 0.0v 994.745n 0.0v 994.755n 0.0v 999.745n 0.0v 999.755n 1.0v 1004.745n 1.0v 1004.755n 1.0v 1009.745n 1.0v 1009.755n 1.0v 1014.745n 1.0v 1014.755n 1.0v 1019.745n 1.0v 1019.755n 0.0v 1024.745n 0.0v 1024.755n 0.0v )
* (time, data): [(0, 0), (5, 0), (10, 0), (15, 0), (20, 0), (25, 0), (30, 0), (35, 0), (40, 0), (45, 0), (50, 0), (55, 0), (60, 0), (65, 0), (70, 0), (75, 0), (80, 0), (85, 0), (90, 0), (95, 0), (100, 0), (105, 0), (110, 0), (115, 0), (120, 0), (125, 0), (130, 1), (135, 1), (140, 1), (145, 1), (150, 1), (155, 1), (160, 1), (165, 1), (170, 1), (175, 0), (180, 1), (185, 1), (190, 1), (195, 1), (200, 1), (205, 1), (210, 1), (215, 1), (220, 1), (225, 1), (230, 1), (235, 1), (240, 1), (245, 1), (250, 0), (255, 0), (260, 0), (265, 0), (270, 0), (275, 0), (280, 0), (285, 1), (290, 1), (295, 1), (300, 0), (305, 0), (310, 0), (315, 0), (320, 0), (325, 0), (330, 0), (335, 0), (340, 0), (345, 0), (350, 0), (355, 0), (360, 0), (365, 0), (370, 0), (375, 0), (380, 0), (385, 0), (390, 0), (395, 0), (400, 1), (405, 1), (410, 1), (415, 1), (420, 1), (425, 1), (430, 1), (435, 1), (440, 1), (445, 1), (450, 1), (455, 1), (460, 1), (465, 0), (470, 0), (475, 0), (480, 0), (485, 1), (490, 1), (495, 1), (500, 1), (505, 1), (510, 1), (515, 1), (520, 1), (525, 1), (530, 1), (535, 1), (540, 1), (545, 1), (550, 1), (555, 1), (560, 1), (565, 1), (570, 1), (575, 1), (580, 1), (585, 0), (590, 0), (595, 0), (600, 0), (605, 0), (610, 0), (615, 1), (620, 1), (625, 1), (630, 1), (635, 1), (640, 1), (645, 1), (650, 1), (655, 1), (660, 1), (665, 1), (670, 1), (675, 1), (680, 1), (685, 1), (690, 1), (695, 1), (700, 1), (705, 1), (710, 1), (715, 1), (720, 1), (725, 1), (730, 1), (735, 0), (740, 0), (745, 0), (750, 0), (755, 0), (760, 0), (765, 0), (770, 0), (775, 0), (780, 0), (785, 0), (790, 0), (795, 0), (800, 0), (805, 0), (810, 1), (815, 1), (820, 1), (825, 1), (830, 0), (835, 0), (840, 0), (845, 0), (850, 0), (855, 0), (860, 0), (865, 0), (870, 0), (875, 0), (880, 1), (885, 1), (890, 1), (895, 1), (900, 1), (905, 1), (910, 1), (915, 1), (920, 1), (925, 0), (930, 0), (935, 0), (940, 0), (945, 0), (950, 0), (955, 0), (960, 0), (965, 0), (970, 0), (975, 0), (980, 0), (985, 0), (990, 0), (995, 0), (1000, 1), (1005, 1), (1010, 0), (1015, 0), (1020, 0), (1025, 0)]
Vdin1_13  din1_13  0 PWL (0n 0.0v 4.745n 0.0v 4.755n 0.0v 9.745n 0.0v 9.755n 0.0v 14.745n 0.0v 14.755n 0.0v 19.745n 0.0v 19.755n 0.0v 24.745n 0.0v 24.755n 0.0v 29.745n 0.0v 29.755n 0.0v 34.745n 0.0v 34.755n 0.0v 39.745n 0.0v 39.755n 0.0v 44.745n 0.0v 44.755n 0.0v 49.745n 0.0v 49.755n 0.0v 54.745n 0.0v 54.755n 0.0v 59.745n 0.0v 59.755n 0.0v 64.745n 0.0v 64.755n 0.0v 69.745n 0.0v 69.755n 0.0v 74.745n 0.0v 74.755n 0.0v 79.745n 0.0v 79.755n 0.0v 84.745n 0.0v 84.755n 0.0v 89.745n 0.0v 89.755n 0.0v 94.745n 0.0v 94.755n 0.0v 99.745n 0.0v 99.755n 0.0v 104.745n 0.0v 104.755n 0.0v 109.745n 0.0v 109.755n 0.0v 114.745n 0.0v 114.755n 0.0v 119.745n 0.0v 119.755n 0.0v 124.745n 0.0v 124.755n 0.0v 129.745n 0.0v 129.755n 1.0v 134.745n 1.0v 134.755n 1.0v 139.745n 1.0v 139.755n 1.0v 144.745n 1.0v 144.755n 1.0v 149.745n 1.0v 149.755n 1.0v 154.745n 1.0v 154.755n 1.0v 159.745n 1.0v 159.755n 1.0v 164.745n 1.0v 164.755n 1.0v 169.745n 1.0v 169.755n 1.0v 174.745n 1.0v 174.755n 0.0v 179.745n 0.0v 179.755n 1.0v 184.745n 1.0v 184.755n 1.0v 189.745n 1.0v 189.755n 1.0v 194.745n 1.0v 194.755n 1.0v 199.745n 1.0v 199.755n 1.0v 204.745n 1.0v 204.755n 1.0v 209.745n 1.0v 209.755n 1.0v 214.745n 1.0v 214.755n 1.0v 219.745n 1.0v 219.755n 1.0v 224.745n 1.0v 224.755n 1.0v 229.745n 1.0v 229.755n 1.0v 234.745n 1.0v 234.755n 1.0v 239.745n 1.0v 239.755n 1.0v 244.745n 1.0v 244.755n 1.0v 249.745n 1.0v 249.755n 0.0v 254.745n 0.0v 254.755n 0.0v 259.745n 0.0v 259.755n 0.0v 264.745n 0.0v 264.755n 0.0v 269.745n 0.0v 269.755n 0.0v 274.745n 0.0v 274.755n 0.0v 279.745n 0.0v 279.755n 0.0v 284.745n 0.0v 284.755n 1.0v 289.745n 1.0v 289.755n 1.0v 294.745n 1.0v 294.755n 1.0v 299.745n 1.0v 299.755n 0.0v 304.745n 0.0v 304.755n 0.0v 309.745n 0.0v 309.755n 0.0v 314.745n 0.0v 314.755n 0.0v 319.745n 0.0v 319.755n 0.0v 324.745n 0.0v 324.755n 0.0v 329.745n 0.0v 329.755n 0.0v 334.745n 0.0v 334.755n 0.0v 339.745n 0.0v 339.755n 0.0v 344.745n 0.0v 344.755n 0.0v 349.745n 0.0v 349.755n 0.0v 354.745n 0.0v 354.755n 0.0v 359.745n 0.0v 359.755n 0.0v 364.745n 0.0v 364.755n 0.0v 369.745n 0.0v 369.755n 0.0v 374.745n 0.0v 374.755n 0.0v 379.745n 0.0v 379.755n 0.0v 384.745n 0.0v 384.755n 0.0v 389.745n 0.0v 389.755n 0.0v 394.745n 0.0v 394.755n 0.0v 399.745n 0.0v 399.755n 1.0v 404.745n 1.0v 404.755n 1.0v 409.745n 1.0v 409.755n 1.0v 414.745n 1.0v 414.755n 1.0v 419.745n 1.0v 419.755n 1.0v 424.745n 1.0v 424.755n 1.0v 429.745n 1.0v 429.755n 1.0v 434.745n 1.0v 434.755n 1.0v 439.745n 1.0v 439.755n 1.0v 444.745n 1.0v 444.755n 1.0v 449.745n 1.0v 449.755n 1.0v 454.745n 1.0v 454.755n 1.0v 459.745n 1.0v 459.755n 1.0v 464.745n 1.0v 464.755n 0.0v 469.745n 0.0v 469.755n 0.0v 474.745n 0.0v 474.755n 0.0v 479.745n 0.0v 479.755n 0.0v 484.745n 0.0v 484.755n 1.0v 489.745n 1.0v 489.755n 1.0v 494.745n 1.0v 494.755n 1.0v 499.745n 1.0v 499.755n 1.0v 504.745n 1.0v 504.755n 1.0v 509.745n 1.0v 509.755n 1.0v 514.745n 1.0v 514.755n 1.0v 519.745n 1.0v 519.755n 1.0v 524.745n 1.0v 524.755n 1.0v 529.745n 1.0v 529.755n 1.0v 534.745n 1.0v 534.755n 1.0v 539.745n 1.0v 539.755n 1.0v 544.745n 1.0v 544.755n 1.0v 549.745n 1.0v 549.755n 1.0v 554.745n 1.0v 554.755n 1.0v 559.745n 1.0v 559.755n 1.0v 564.745n 1.0v 564.755n 1.0v 569.745n 1.0v 569.755n 1.0v 574.745n 1.0v 574.755n 1.0v 579.745n 1.0v 579.755n 1.0v 584.745n 1.0v 584.755n 0.0v 589.745n 0.0v 589.755n 0.0v 594.745n 0.0v 594.755n 0.0v 599.745n 0.0v 599.755n 0.0v 604.745n 0.0v 604.755n 0.0v 609.745n 0.0v 609.755n 0.0v 614.745n 0.0v 614.755n 1.0v 619.745n 1.0v 619.755n 1.0v 624.745n 1.0v 624.755n 1.0v 629.745n 1.0v 629.755n 1.0v 634.745n 1.0v 634.755n 1.0v 639.745n 1.0v 639.755n 1.0v 644.745n 1.0v 644.755n 1.0v 649.745n 1.0v 649.755n 1.0v 654.745n 1.0v 654.755n 1.0v 659.745n 1.0v 659.755n 1.0v 664.745n 1.0v 664.755n 1.0v 669.745n 1.0v 669.755n 1.0v 674.745n 1.0v 674.755n 1.0v 679.745n 1.0v 679.755n 1.0v 684.745n 1.0v 684.755n 1.0v 689.745n 1.0v 689.755n 1.0v 694.745n 1.0v 694.755n 1.0v 699.745n 1.0v 699.755n 1.0v 704.745n 1.0v 704.755n 1.0v 709.745n 1.0v 709.755n 1.0v 714.745n 1.0v 714.755n 1.0v 719.745n 1.0v 719.755n 1.0v 724.745n 1.0v 724.755n 1.0v 729.745n 1.0v 729.755n 1.0v 734.745n 1.0v 734.755n 0.0v 739.745n 0.0v 739.755n 0.0v 744.745n 0.0v 744.755n 0.0v 749.745n 0.0v 749.755n 0.0v 754.745n 0.0v 754.755n 0.0v 759.745n 0.0v 759.755n 0.0v 764.745n 0.0v 764.755n 0.0v 769.745n 0.0v 769.755n 0.0v 774.745n 0.0v 774.755n 0.0v 779.745n 0.0v 779.755n 0.0v 784.745n 0.0v 784.755n 0.0v 789.745n 0.0v 789.755n 0.0v 794.745n 0.0v 794.755n 0.0v 799.745n 0.0v 799.755n 0.0v 804.745n 0.0v 804.755n 0.0v 809.745n 0.0v 809.755n 1.0v 814.745n 1.0v 814.755n 1.0v 819.745n 1.0v 819.755n 1.0v 824.745n 1.0v 824.755n 1.0v 829.745n 1.0v 829.755n 0.0v 834.745n 0.0v 834.755n 0.0v 839.745n 0.0v 839.755n 0.0v 844.745n 0.0v 844.755n 0.0v 849.745n 0.0v 849.755n 0.0v 854.745n 0.0v 854.755n 0.0v 859.745n 0.0v 859.755n 0.0v 864.745n 0.0v 864.755n 0.0v 869.745n 0.0v 869.755n 0.0v 874.745n 0.0v 874.755n 0.0v 879.745n 0.0v 879.755n 1.0v 884.745n 1.0v 884.755n 1.0v 889.745n 1.0v 889.755n 1.0v 894.745n 1.0v 894.755n 1.0v 899.745n 1.0v 899.755n 1.0v 904.745n 1.0v 904.755n 1.0v 909.745n 1.0v 909.755n 1.0v 914.745n 1.0v 914.755n 1.0v 919.745n 1.0v 919.755n 1.0v 924.745n 1.0v 924.755n 0.0v 929.745n 0.0v 929.755n 0.0v 934.745n 0.0v 934.755n 0.0v 939.745n 0.0v 939.755n 0.0v 944.745n 0.0v 944.755n 0.0v 949.745n 0.0v 949.755n 0.0v 954.745n 0.0v 954.755n 0.0v 959.745n 0.0v 959.755n 0.0v 964.745n 0.0v 964.755n 0.0v 969.745n 0.0v 969.755n 0.0v 974.745n 0.0v 974.755n 0.0v 979.745n 0.0v 979.755n 0.0v 984.745n 0.0v 984.755n 0.0v 989.745n 0.0v 989.755n 0.0v 994.745n 0.0v 994.755n 0.0v 999.745n 0.0v 999.755n 1.0v 1004.745n 1.0v 1004.755n 1.0v 1009.745n 1.0v 1009.755n 0.0v 1014.745n 0.0v 1014.755n 0.0v 1019.745n 0.0v 1019.755n 0.0v 1024.745n 0.0v 1024.755n 0.0v )
* (time, data): [(0, 0), (5, 0), (10, 1), (15, 1), (20, 1), (25, 1), (30, 1), (35, 1), (40, 1), (45, 1), (50, 1), (55, 1), (60, 1), (65, 1), (70, 1), (75, 1), (80, 0), (85, 0), (90, 1), (95, 1), (100, 1), (105, 1), (110, 1), (115, 1), (120, 1), (125, 1), (130, 0), (135, 0), (140, 0), (145, 0), (150, 0), (155, 0), (160, 0), (165, 0), (170, 0), (175, 1), (180, 1), (185, 1), (190, 1), (195, 1), (200, 1), (205, 1), (210, 1), (215, 1), (220, 1), (225, 1), (230, 1), (235, 1), (240, 1), (245, 1), (250, 0), (255, 0), (260, 0), (265, 0), (270, 0), (275, 0), (280, 0), (285, 1), (290, 1), (295, 1), (300, 0), (305, 0), (310, 0), (315, 0), (320, 0), (325, 0), (330, 0), (335, 0), (340, 0), (345, 0), (350, 0), (355, 0), (360, 0), (365, 0), (370, 0), (375, 0), (380, 0), (385, 0), (390, 0), (395, 1), (400, 0), (405, 0), (410, 0), (415, 0), (420, 1), (425, 1), (430, 1), (435, 1), (440, 1), (445, 1), (450, 1), (455, 1), (460, 1), (465, 1), (470, 1), (475, 1), (480, 1), (485, 1), (490, 1), (495, 1), (500, 1), (505, 1), (510, 1), (515, 1), (520, 0), (525, 0), (530, 0), (535, 0), (540, 0), (545, 0), (550, 0), (555, 0), (560, 0), (565, 0), (570, 0), (575, 0), (580, 1), (585, 0), (590, 0), (595, 0), (600, 0), (605, 1), (610, 1), (615, 1), (620, 1), (625, 1), (630, 1), (635, 1), (640, 1), (645, 1), (650, 1), (655, 1), (660, 1), (665, 1), (670, 1), (675, 1), (680, 1), (685, 1), (690, 0), (695, 0), (700, 0), (705, 0), (710, 0), (715, 0), (720, 0), (725, 0), (730, 0), (735, 0), (740, 0), (745, 0), (750, 0), (755, 0), (760, 1), (765, 0), (770, 0), (775, 0), (780, 0), (785, 0), (790, 0), (795, 0), (800, 0), (805, 0), (810, 0), (815, 0), (820, 0), (825, 0), (830, 1), (835, 1), (840, 1), (845, 1), (850, 1), (855, 1), (860, 0), (865, 0), (870, 0), (875, 0), (880, 0), (885, 0), (890, 0), (895, 0), (900, 1), (905, 0), (910, 0), (915, 0), (920, 0), (925, 0), (930, 1), (935, 1), (940, 1), (945, 0), (950, 0), (955, 0), (960, 0), (965, 0), (970, 0), (975, 0), (980, 0), (985, 0), (990, 0), (995, 0), (1000, 0), (1005, 0), (1010, 0), (1015, 0), (1020, 0), (1025, 0)]
Vdin1_14  din1_14  0 PWL (0n 0.0v 4.745n 0.0v 4.755n 0.0v 9.745n 0.0v 9.755n 1.0v 14.745n 1.0v 14.755n 1.0v 19.745n 1.0v 19.755n 1.0v 24.745n 1.0v 24.755n 1.0v 29.745n 1.0v 29.755n 1.0v 34.745n 1.0v 34.755n 1.0v 39.745n 1.0v 39.755n 1.0v 44.745n 1.0v 44.755n 1.0v 49.745n 1.0v 49.755n 1.0v 54.745n 1.0v 54.755n 1.0v 59.745n 1.0v 59.755n 1.0v 64.745n 1.0v 64.755n 1.0v 69.745n 1.0v 69.755n 1.0v 74.745n 1.0v 74.755n 1.0v 79.745n 1.0v 79.755n 0.0v 84.745n 0.0v 84.755n 0.0v 89.745n 0.0v 89.755n 1.0v 94.745n 1.0v 94.755n 1.0v 99.745n 1.0v 99.755n 1.0v 104.745n 1.0v 104.755n 1.0v 109.745n 1.0v 109.755n 1.0v 114.745n 1.0v 114.755n 1.0v 119.745n 1.0v 119.755n 1.0v 124.745n 1.0v 124.755n 1.0v 129.745n 1.0v 129.755n 0.0v 134.745n 0.0v 134.755n 0.0v 139.745n 0.0v 139.755n 0.0v 144.745n 0.0v 144.755n 0.0v 149.745n 0.0v 149.755n 0.0v 154.745n 0.0v 154.755n 0.0v 159.745n 0.0v 159.755n 0.0v 164.745n 0.0v 164.755n 0.0v 169.745n 0.0v 169.755n 0.0v 174.745n 0.0v 174.755n 1.0v 179.745n 1.0v 179.755n 1.0v 184.745n 1.0v 184.755n 1.0v 189.745n 1.0v 189.755n 1.0v 194.745n 1.0v 194.755n 1.0v 199.745n 1.0v 199.755n 1.0v 204.745n 1.0v 204.755n 1.0v 209.745n 1.0v 209.755n 1.0v 214.745n 1.0v 214.755n 1.0v 219.745n 1.0v 219.755n 1.0v 224.745n 1.0v 224.755n 1.0v 229.745n 1.0v 229.755n 1.0v 234.745n 1.0v 234.755n 1.0v 239.745n 1.0v 239.755n 1.0v 244.745n 1.0v 244.755n 1.0v 249.745n 1.0v 249.755n 0.0v 254.745n 0.0v 254.755n 0.0v 259.745n 0.0v 259.755n 0.0v 264.745n 0.0v 264.755n 0.0v 269.745n 0.0v 269.755n 0.0v 274.745n 0.0v 274.755n 0.0v 279.745n 0.0v 279.755n 0.0v 284.745n 0.0v 284.755n 1.0v 289.745n 1.0v 289.755n 1.0v 294.745n 1.0v 294.755n 1.0v 299.745n 1.0v 299.755n 0.0v 304.745n 0.0v 304.755n 0.0v 309.745n 0.0v 309.755n 0.0v 314.745n 0.0v 314.755n 0.0v 319.745n 0.0v 319.755n 0.0v 324.745n 0.0v 324.755n 0.0v 329.745n 0.0v 329.755n 0.0v 334.745n 0.0v 334.755n 0.0v 339.745n 0.0v 339.755n 0.0v 344.745n 0.0v 344.755n 0.0v 349.745n 0.0v 349.755n 0.0v 354.745n 0.0v 354.755n 0.0v 359.745n 0.0v 359.755n 0.0v 364.745n 0.0v 364.755n 0.0v 369.745n 0.0v 369.755n 0.0v 374.745n 0.0v 374.755n 0.0v 379.745n 0.0v 379.755n 0.0v 384.745n 0.0v 384.755n 0.0v 389.745n 0.0v 389.755n 0.0v 394.745n 0.0v 394.755n 1.0v 399.745n 1.0v 399.755n 0.0v 404.745n 0.0v 404.755n 0.0v 409.745n 0.0v 409.755n 0.0v 414.745n 0.0v 414.755n 0.0v 419.745n 0.0v 419.755n 1.0v 424.745n 1.0v 424.755n 1.0v 429.745n 1.0v 429.755n 1.0v 434.745n 1.0v 434.755n 1.0v 439.745n 1.0v 439.755n 1.0v 444.745n 1.0v 444.755n 1.0v 449.745n 1.0v 449.755n 1.0v 454.745n 1.0v 454.755n 1.0v 459.745n 1.0v 459.755n 1.0v 464.745n 1.0v 464.755n 1.0v 469.745n 1.0v 469.755n 1.0v 474.745n 1.0v 474.755n 1.0v 479.745n 1.0v 479.755n 1.0v 484.745n 1.0v 484.755n 1.0v 489.745n 1.0v 489.755n 1.0v 494.745n 1.0v 494.755n 1.0v 499.745n 1.0v 499.755n 1.0v 504.745n 1.0v 504.755n 1.0v 509.745n 1.0v 509.755n 1.0v 514.745n 1.0v 514.755n 1.0v 519.745n 1.0v 519.755n 0.0v 524.745n 0.0v 524.755n 0.0v 529.745n 0.0v 529.755n 0.0v 534.745n 0.0v 534.755n 0.0v 539.745n 0.0v 539.755n 0.0v 544.745n 0.0v 544.755n 0.0v 549.745n 0.0v 549.755n 0.0v 554.745n 0.0v 554.755n 0.0v 559.745n 0.0v 559.755n 0.0v 564.745n 0.0v 564.755n 0.0v 569.745n 0.0v 569.755n 0.0v 574.745n 0.0v 574.755n 0.0v 579.745n 0.0v 579.755n 1.0v 584.745n 1.0v 584.755n 0.0v 589.745n 0.0v 589.755n 0.0v 594.745n 0.0v 594.755n 0.0v 599.745n 0.0v 599.755n 0.0v 604.745n 0.0v 604.755n 1.0v 609.745n 1.0v 609.755n 1.0v 614.745n 1.0v 614.755n 1.0v 619.745n 1.0v 619.755n 1.0v 624.745n 1.0v 624.755n 1.0v 629.745n 1.0v 629.755n 1.0v 634.745n 1.0v 634.755n 1.0v 639.745n 1.0v 639.755n 1.0v 644.745n 1.0v 644.755n 1.0v 649.745n 1.0v 649.755n 1.0v 654.745n 1.0v 654.755n 1.0v 659.745n 1.0v 659.755n 1.0v 664.745n 1.0v 664.755n 1.0v 669.745n 1.0v 669.755n 1.0v 674.745n 1.0v 674.755n 1.0v 679.745n 1.0v 679.755n 1.0v 684.745n 1.0v 684.755n 1.0v 689.745n 1.0v 689.755n 0.0v 694.745n 0.0v 694.755n 0.0v 699.745n 0.0v 699.755n 0.0v 704.745n 0.0v 704.755n 0.0v 709.745n 0.0v 709.755n 0.0v 714.745n 0.0v 714.755n 0.0v 719.745n 0.0v 719.755n 0.0v 724.745n 0.0v 724.755n 0.0v 729.745n 0.0v 729.755n 0.0v 734.745n 0.0v 734.755n 0.0v 739.745n 0.0v 739.755n 0.0v 744.745n 0.0v 744.755n 0.0v 749.745n 0.0v 749.755n 0.0v 754.745n 0.0v 754.755n 0.0v 759.745n 0.0v 759.755n 1.0v 764.745n 1.0v 764.755n 0.0v 769.745n 0.0v 769.755n 0.0v 774.745n 0.0v 774.755n 0.0v 779.745n 0.0v 779.755n 0.0v 784.745n 0.0v 784.755n 0.0v 789.745n 0.0v 789.755n 0.0v 794.745n 0.0v 794.755n 0.0v 799.745n 0.0v 799.755n 0.0v 804.745n 0.0v 804.755n 0.0v 809.745n 0.0v 809.755n 0.0v 814.745n 0.0v 814.755n 0.0v 819.745n 0.0v 819.755n 0.0v 824.745n 0.0v 824.755n 0.0v 829.745n 0.0v 829.755n 1.0v 834.745n 1.0v 834.755n 1.0v 839.745n 1.0v 839.755n 1.0v 844.745n 1.0v 844.755n 1.0v 849.745n 1.0v 849.755n 1.0v 854.745n 1.0v 854.755n 1.0v 859.745n 1.0v 859.755n 0.0v 864.745n 0.0v 864.755n 0.0v 869.745n 0.0v 869.755n 0.0v 874.745n 0.0v 874.755n 0.0v 879.745n 0.0v 879.755n 0.0v 884.745n 0.0v 884.755n 0.0v 889.745n 0.0v 889.755n 0.0v 894.745n 0.0v 894.755n 0.0v 899.745n 0.0v 899.755n 1.0v 904.745n 1.0v 904.755n 0.0v 909.745n 0.0v 909.755n 0.0v 914.745n 0.0v 914.755n 0.0v 919.745n 0.0v 919.755n 0.0v 924.745n 0.0v 924.755n 0.0v 929.745n 0.0v 929.755n 1.0v 934.745n 1.0v 934.755n 1.0v 939.745n 1.0v 939.755n 1.0v 944.745n 1.0v 944.755n 0.0v 949.745n 0.0v 949.755n 0.0v 954.745n 0.0v 954.755n 0.0v 959.745n 0.0v 959.755n 0.0v 964.745n 0.0v 964.755n 0.0v 969.745n 0.0v 969.755n 0.0v 974.745n 0.0v 974.755n 0.0v 979.745n 0.0v 979.755n 0.0v 984.745n 0.0v 984.755n 0.0v 989.745n 0.0v 989.755n 0.0v 994.745n 0.0v 994.755n 0.0v 999.745n 0.0v 999.755n 0.0v 1004.745n 0.0v 1004.755n 0.0v 1009.745n 0.0v 1009.755n 0.0v 1014.745n 0.0v 1014.755n 0.0v 1019.745n 0.0v 1019.755n 0.0v 1024.745n 0.0v 1024.755n 0.0v )
* (time, data): [(0, 0), (5, 0), (10, 0), (15, 1), (20, 1), (25, 1), (30, 1), (35, 1), (40, 1), (45, 1), (50, 1), (55, 1), (60, 0), (65, 0), (70, 0), (75, 0), (80, 1), (85, 1), (90, 0), (95, 0), (100, 0), (105, 0), (110, 0), (115, 0), (120, 0), (125, 0), (130, 0), (135, 0), (140, 0), (145, 0), (150, 0), (155, 0), (160, 0), (165, 0), (170, 0), (175, 0), (180, 0), (185, 0), (190, 0), (195, 0), (200, 0), (205, 0), (210, 0), (215, 0), (220, 0), (225, 0), (230, 0), (235, 0), (240, 0), (245, 0), (250, 1), (255, 1), (260, 1), (265, 1), (270, 1), (275, 1), (280, 1), (285, 0), (290, 0), (295, 0), (300, 1), (305, 1), (310, 1), (315, 1), (320, 1), (325, 1), (330, 1), (335, 1), (340, 1), (345, 1), (350, 1), (355, 1), (360, 1), (365, 1), (370, 1), (375, 1), (380, 0), (385, 0), (390, 1), (395, 0), (400, 1), (405, 1), (410, 1), (415, 1), (420, 1), (425, 1), (430, 1), (435, 1), (440, 1), (445, 1), (450, 1), (455, 1), (460, 1), (465, 0), (470, 0), (475, 0), (480, 0), (485, 0), (490, 0), (495, 0), (500, 0), (505, 0), (510, 0), (515, 0), (520, 0), (525, 0), (530, 0), (535, 0), (540, 0), (545, 0), (550, 0), (555, 0), (560, 0), (565, 0), (570, 0), (575, 0), (580, 1), (585, 1), (590, 1), (595, 1), (600, 1), (605, 1), (610, 1), (615, 0), (620, 0), (625, 0), (630, 0), (635, 0), (640, 0), (645, 0), (650, 0), (655, 0), (660, 0), (665, 0), (670, 0), (675, 0), (680, 0), (685, 0), (690, 0), (695, 0), (700, 0), (705, 0), (710, 0), (715, 0), (720, 0), (725, 0), (730, 0), (735, 0), (740, 0), (745, 0), (750, 0), (755, 0), (760, 1), (765, 1), (770, 0), (775, 0), (780, 0), (785, 0), (790, 0), (795, 0), (800, 0), (805, 0), (810, 1), (815, 1), (820, 1), (825, 1), (830, 0), (835, 0), (840, 0), (845, 0), (850, 0), (855, 0), (860, 0), (865, 0), (870, 0), (875, 0), (880, 1), (885, 1), (890, 1), (895, 1), (900, 1), (905, 1), (910, 1), (915, 1), (920, 1), (925, 0), (930, 1), (935, 1), (940, 1), (945, 1), (950, 1), (955, 1), (960, 1), (965, 1), (970, 1), (975, 1), (980, 1), (985, 1), (990, 1), (995, 1), (1000, 1), (1005, 1), (1010, 0), (1015, 0), (1020, 1), (1025, 1)]
Vdin1_15  din1_15  0 PWL (0n 0.0v 4.745n 0.0v 4.755n 0.0v 9.745n 0.0v 9.755n 0.0v 14.745n 0.0v 14.755n 1.0v 19.745n 1.0v 19.755n 1.0v 24.745n 1.0v 24.755n 1.0v 29.745n 1.0v 29.755n 1.0v 34.745n 1.0v 34.755n 1.0v 39.745n 1.0v 39.755n 1.0v 44.745n 1.0v 44.755n 1.0v 49.745n 1.0v 49.755n 1.0v 54.745n 1.0v 54.755n 1.0v 59.745n 1.0v 59.755n 0.0v 64.745n 0.0v 64.755n 0.0v 69.745n 0.0v 69.755n 0.0v 74.745n 0.0v 74.755n 0.0v 79.745n 0.0v 79.755n 1.0v 84.745n 1.0v 84.755n 1.0v 89.745n 1.0v 89.755n 0.0v 94.745n 0.0v 94.755n 0.0v 99.745n 0.0v 99.755n 0.0v 104.745n 0.0v 104.755n 0.0v 109.745n 0.0v 109.755n 0.0v 114.745n 0.0v 114.755n 0.0v 119.745n 0.0v 119.755n 0.0v 124.745n 0.0v 124.755n 0.0v 129.745n 0.0v 129.755n 0.0v 134.745n 0.0v 134.755n 0.0v 139.745n 0.0v 139.755n 0.0v 144.745n 0.0v 144.755n 0.0v 149.745n 0.0v 149.755n 0.0v 154.745n 0.0v 154.755n 0.0v 159.745n 0.0v 159.755n 0.0v 164.745n 0.0v 164.755n 0.0v 169.745n 0.0v 169.755n 0.0v 174.745n 0.0v 174.755n 0.0v 179.745n 0.0v 179.755n 0.0v 184.745n 0.0v 184.755n 0.0v 189.745n 0.0v 189.755n 0.0v 194.745n 0.0v 194.755n 0.0v 199.745n 0.0v 199.755n 0.0v 204.745n 0.0v 204.755n 0.0v 209.745n 0.0v 209.755n 0.0v 214.745n 0.0v 214.755n 0.0v 219.745n 0.0v 219.755n 0.0v 224.745n 0.0v 224.755n 0.0v 229.745n 0.0v 229.755n 0.0v 234.745n 0.0v 234.755n 0.0v 239.745n 0.0v 239.755n 0.0v 244.745n 0.0v 244.755n 0.0v 249.745n 0.0v 249.755n 1.0v 254.745n 1.0v 254.755n 1.0v 259.745n 1.0v 259.755n 1.0v 264.745n 1.0v 264.755n 1.0v 269.745n 1.0v 269.755n 1.0v 274.745n 1.0v 274.755n 1.0v 279.745n 1.0v 279.755n 1.0v 284.745n 1.0v 284.755n 0.0v 289.745n 0.0v 289.755n 0.0v 294.745n 0.0v 294.755n 0.0v 299.745n 0.0v 299.755n 1.0v 304.745n 1.0v 304.755n 1.0v 309.745n 1.0v 309.755n 1.0v 314.745n 1.0v 314.755n 1.0v 319.745n 1.0v 319.755n 1.0v 324.745n 1.0v 324.755n 1.0v 329.745n 1.0v 329.755n 1.0v 334.745n 1.0v 334.755n 1.0v 339.745n 1.0v 339.755n 1.0v 344.745n 1.0v 344.755n 1.0v 349.745n 1.0v 349.755n 1.0v 354.745n 1.0v 354.755n 1.0v 359.745n 1.0v 359.755n 1.0v 364.745n 1.0v 364.755n 1.0v 369.745n 1.0v 369.755n 1.0v 374.745n 1.0v 374.755n 1.0v 379.745n 1.0v 379.755n 0.0v 384.745n 0.0v 384.755n 0.0v 389.745n 0.0v 389.755n 1.0v 394.745n 1.0v 394.755n 0.0v 399.745n 0.0v 399.755n 1.0v 404.745n 1.0v 404.755n 1.0v 409.745n 1.0v 409.755n 1.0v 414.745n 1.0v 414.755n 1.0v 419.745n 1.0v 419.755n 1.0v 424.745n 1.0v 424.755n 1.0v 429.745n 1.0v 429.755n 1.0v 434.745n 1.0v 434.755n 1.0v 439.745n 1.0v 439.755n 1.0v 444.745n 1.0v 444.755n 1.0v 449.745n 1.0v 449.755n 1.0v 454.745n 1.0v 454.755n 1.0v 459.745n 1.0v 459.755n 1.0v 464.745n 1.0v 464.755n 0.0v 469.745n 0.0v 469.755n 0.0v 474.745n 0.0v 474.755n 0.0v 479.745n 0.0v 479.755n 0.0v 484.745n 0.0v 484.755n 0.0v 489.745n 0.0v 489.755n 0.0v 494.745n 0.0v 494.755n 0.0v 499.745n 0.0v 499.755n 0.0v 504.745n 0.0v 504.755n 0.0v 509.745n 0.0v 509.755n 0.0v 514.745n 0.0v 514.755n 0.0v 519.745n 0.0v 519.755n 0.0v 524.745n 0.0v 524.755n 0.0v 529.745n 0.0v 529.755n 0.0v 534.745n 0.0v 534.755n 0.0v 539.745n 0.0v 539.755n 0.0v 544.745n 0.0v 544.755n 0.0v 549.745n 0.0v 549.755n 0.0v 554.745n 0.0v 554.755n 0.0v 559.745n 0.0v 559.755n 0.0v 564.745n 0.0v 564.755n 0.0v 569.745n 0.0v 569.755n 0.0v 574.745n 0.0v 574.755n 0.0v 579.745n 0.0v 579.755n 1.0v 584.745n 1.0v 584.755n 1.0v 589.745n 1.0v 589.755n 1.0v 594.745n 1.0v 594.755n 1.0v 599.745n 1.0v 599.755n 1.0v 604.745n 1.0v 604.755n 1.0v 609.745n 1.0v 609.755n 1.0v 614.745n 1.0v 614.755n 0.0v 619.745n 0.0v 619.755n 0.0v 624.745n 0.0v 624.755n 0.0v 629.745n 0.0v 629.755n 0.0v 634.745n 0.0v 634.755n 0.0v 639.745n 0.0v 639.755n 0.0v 644.745n 0.0v 644.755n 0.0v 649.745n 0.0v 649.755n 0.0v 654.745n 0.0v 654.755n 0.0v 659.745n 0.0v 659.755n 0.0v 664.745n 0.0v 664.755n 0.0v 669.745n 0.0v 669.755n 0.0v 674.745n 0.0v 674.755n 0.0v 679.745n 0.0v 679.755n 0.0v 684.745n 0.0v 684.755n 0.0v 689.745n 0.0v 689.755n 0.0v 694.745n 0.0v 694.755n 0.0v 699.745n 0.0v 699.755n 0.0v 704.745n 0.0v 704.755n 0.0v 709.745n 0.0v 709.755n 0.0v 714.745n 0.0v 714.755n 0.0v 719.745n 0.0v 719.755n 0.0v 724.745n 0.0v 724.755n 0.0v 729.745n 0.0v 729.755n 0.0v 734.745n 0.0v 734.755n 0.0v 739.745n 0.0v 739.755n 0.0v 744.745n 0.0v 744.755n 0.0v 749.745n 0.0v 749.755n 0.0v 754.745n 0.0v 754.755n 0.0v 759.745n 0.0v 759.755n 1.0v 764.745n 1.0v 764.755n 1.0v 769.745n 1.0v 769.755n 0.0v 774.745n 0.0v 774.755n 0.0v 779.745n 0.0v 779.755n 0.0v 784.745n 0.0v 784.755n 0.0v 789.745n 0.0v 789.755n 0.0v 794.745n 0.0v 794.755n 0.0v 799.745n 0.0v 799.755n 0.0v 804.745n 0.0v 804.755n 0.0v 809.745n 0.0v 809.755n 1.0v 814.745n 1.0v 814.755n 1.0v 819.745n 1.0v 819.755n 1.0v 824.745n 1.0v 824.755n 1.0v 829.745n 1.0v 829.755n 0.0v 834.745n 0.0v 834.755n 0.0v 839.745n 0.0v 839.755n 0.0v 844.745n 0.0v 844.755n 0.0v 849.745n 0.0v 849.755n 0.0v 854.745n 0.0v 854.755n 0.0v 859.745n 0.0v 859.755n 0.0v 864.745n 0.0v 864.755n 0.0v 869.745n 0.0v 869.755n 0.0v 874.745n 0.0v 874.755n 0.0v 879.745n 0.0v 879.755n 1.0v 884.745n 1.0v 884.755n 1.0v 889.745n 1.0v 889.755n 1.0v 894.745n 1.0v 894.755n 1.0v 899.745n 1.0v 899.755n 1.0v 904.745n 1.0v 904.755n 1.0v 909.745n 1.0v 909.755n 1.0v 914.745n 1.0v 914.755n 1.0v 919.745n 1.0v 919.755n 1.0v 924.745n 1.0v 924.755n 0.0v 929.745n 0.0v 929.755n 1.0v 934.745n 1.0v 934.755n 1.0v 939.745n 1.0v 939.755n 1.0v 944.745n 1.0v 944.755n 1.0v 949.745n 1.0v 949.755n 1.0v 954.745n 1.0v 954.755n 1.0v 959.745n 1.0v 959.755n 1.0v 964.745n 1.0v 964.755n 1.0v 969.745n 1.0v 969.755n 1.0v 974.745n 1.0v 974.755n 1.0v 979.745n 1.0v 979.755n 1.0v 984.745n 1.0v 984.755n 1.0v 989.745n 1.0v 989.755n 1.0v 994.745n 1.0v 994.755n 1.0v 999.745n 1.0v 999.755n 1.0v 1004.745n 1.0v 1004.755n 1.0v 1009.745n 1.0v 1009.755n 0.0v 1014.745n 0.0v 1014.755n 0.0v 1019.745n 0.0v 1019.755n 1.0v 1024.745n 1.0v 1024.755n 1.0v )
* (time, data): [(0, 0), (5, 0), (10, 0), (15, 0), (20, 0), (25, 0), (30, 0), (35, 0), (40, 0), (45, 0), (50, 0), (55, 0), (60, 1), (65, 1), (70, 1), (75, 1), (80, 0), (85, 0), (90, 1), (95, 1), (100, 1), (105, 1), (110, 1), (115, 1), (120, 1), (125, 1), (130, 1), (135, 1), (140, 1), (145, 1), (150, 1), (155, 1), (160, 1), (165, 1), (170, 1), (175, 0), (180, 1), (185, 1), (190, 1), (195, 1), (200, 1), (205, 1), (210, 1), (215, 1), (220, 1), (225, 1), (230, 1), (235, 1), (240, 1), (245, 0), (250, 0), (255, 0), (260, 0), (265, 0), (270, 0), (275, 0), (280, 0), (285, 0), (290, 0), (295, 0), (300, 1), (305, 1), (310, 1), (315, 1), (320, 1), (325, 1), (330, 1), (335, 1), (340, 1), (345, 1), (350, 1), (355, 1), (360, 1), (365, 0), (370, 0), (375, 0), (380, 1), (385, 1), (390, 0), (395, 1), (400, 1), (405, 1), (410, 1), (415, 1), (420, 1), (425, 1), (430, 1), (435, 1), (440, 1), (445, 1), (450, 1), (455, 1), (460, 1), (465, 1), (470, 1), (475, 1), (480, 1), (485, 0), (490, 0), (495, 0), (500, 0), (505, 0), (510, 0), (515, 0), (520, 1), (525, 1), (530, 1), (535, 1), (540, 1), (545, 1), (550, 1), (555, 1), (560, 1), (565, 1), (570, 1), (575, 1), (580, 1), (585, 1), (590, 1), (595, 1), (600, 1), (605, 0), (610, 0), (615, 1), (620, 1), (625, 1), (630, 1), (635, 1), (640, 1), (645, 1), (650, 1), (655, 1), (660, 1), (665, 1), (670, 1), (675, 1), (680, 1), (685, 1), (690, 1), (695, 1), (700, 1), (705, 1), (710, 1), (715, 1), (720, 1), (725, 1), (730, 1), (735, 1), (740, 1), (745, 1), (750, 1), (755, 1), (760, 1), (765, 0), (770, 0), (775, 0), (780, 0), (785, 0), (790, 0), (795, 0), (800, 0), (805, 0), (810, 0), (815, 0), (820, 0), (825, 0), (830, 0), (835, 0), (840, 0), (845, 0), (850, 0), (855, 0), (860, 1), (865, 1), (870, 1), (875, 1), (880, 1), (885, 1), (890, 1), (895, 1), (900, 1), (905, 1), (910, 1), (915, 1), (920, 1), (925, 0), (930, 0), (935, 0), (940, 0), (945, 1), (950, 1), (955, 1), (960, 1), (965, 1), (970, 1), (975, 1), (980, 1), (985, 1), (990, 1), (995, 1), (1000, 0), (1005, 0), (1010, 1), (1015, 1), (1020, 1), (1025, 1)]
Vdin1_16  din1_16  0 PWL (0n 0.0v 4.745n 0.0v 4.755n 0.0v 9.745n 0.0v 9.755n 0.0v 14.745n 0.0v 14.755n 0.0v 19.745n 0.0v 19.755n 0.0v 24.745n 0.0v 24.755n 0.0v 29.745n 0.0v 29.755n 0.0v 34.745n 0.0v 34.755n 0.0v 39.745n 0.0v 39.755n 0.0v 44.745n 0.0v 44.755n 0.0v 49.745n 0.0v 49.755n 0.0v 54.745n 0.0v 54.755n 0.0v 59.745n 0.0v 59.755n 1.0v 64.745n 1.0v 64.755n 1.0v 69.745n 1.0v 69.755n 1.0v 74.745n 1.0v 74.755n 1.0v 79.745n 1.0v 79.755n 0.0v 84.745n 0.0v 84.755n 0.0v 89.745n 0.0v 89.755n 1.0v 94.745n 1.0v 94.755n 1.0v 99.745n 1.0v 99.755n 1.0v 104.745n 1.0v 104.755n 1.0v 109.745n 1.0v 109.755n 1.0v 114.745n 1.0v 114.755n 1.0v 119.745n 1.0v 119.755n 1.0v 124.745n 1.0v 124.755n 1.0v 129.745n 1.0v 129.755n 1.0v 134.745n 1.0v 134.755n 1.0v 139.745n 1.0v 139.755n 1.0v 144.745n 1.0v 144.755n 1.0v 149.745n 1.0v 149.755n 1.0v 154.745n 1.0v 154.755n 1.0v 159.745n 1.0v 159.755n 1.0v 164.745n 1.0v 164.755n 1.0v 169.745n 1.0v 169.755n 1.0v 174.745n 1.0v 174.755n 0.0v 179.745n 0.0v 179.755n 1.0v 184.745n 1.0v 184.755n 1.0v 189.745n 1.0v 189.755n 1.0v 194.745n 1.0v 194.755n 1.0v 199.745n 1.0v 199.755n 1.0v 204.745n 1.0v 204.755n 1.0v 209.745n 1.0v 209.755n 1.0v 214.745n 1.0v 214.755n 1.0v 219.745n 1.0v 219.755n 1.0v 224.745n 1.0v 224.755n 1.0v 229.745n 1.0v 229.755n 1.0v 234.745n 1.0v 234.755n 1.0v 239.745n 1.0v 239.755n 1.0v 244.745n 1.0v 244.755n 0.0v 249.745n 0.0v 249.755n 0.0v 254.745n 0.0v 254.755n 0.0v 259.745n 0.0v 259.755n 0.0v 264.745n 0.0v 264.755n 0.0v 269.745n 0.0v 269.755n 0.0v 274.745n 0.0v 274.755n 0.0v 279.745n 0.0v 279.755n 0.0v 284.745n 0.0v 284.755n 0.0v 289.745n 0.0v 289.755n 0.0v 294.745n 0.0v 294.755n 0.0v 299.745n 0.0v 299.755n 1.0v 304.745n 1.0v 304.755n 1.0v 309.745n 1.0v 309.755n 1.0v 314.745n 1.0v 314.755n 1.0v 319.745n 1.0v 319.755n 1.0v 324.745n 1.0v 324.755n 1.0v 329.745n 1.0v 329.755n 1.0v 334.745n 1.0v 334.755n 1.0v 339.745n 1.0v 339.755n 1.0v 344.745n 1.0v 344.755n 1.0v 349.745n 1.0v 349.755n 1.0v 354.745n 1.0v 354.755n 1.0v 359.745n 1.0v 359.755n 1.0v 364.745n 1.0v 364.755n 0.0v 369.745n 0.0v 369.755n 0.0v 374.745n 0.0v 374.755n 0.0v 379.745n 0.0v 379.755n 1.0v 384.745n 1.0v 384.755n 1.0v 389.745n 1.0v 389.755n 0.0v 394.745n 0.0v 394.755n 1.0v 399.745n 1.0v 399.755n 1.0v 404.745n 1.0v 404.755n 1.0v 409.745n 1.0v 409.755n 1.0v 414.745n 1.0v 414.755n 1.0v 419.745n 1.0v 419.755n 1.0v 424.745n 1.0v 424.755n 1.0v 429.745n 1.0v 429.755n 1.0v 434.745n 1.0v 434.755n 1.0v 439.745n 1.0v 439.755n 1.0v 444.745n 1.0v 444.755n 1.0v 449.745n 1.0v 449.755n 1.0v 454.745n 1.0v 454.755n 1.0v 459.745n 1.0v 459.755n 1.0v 464.745n 1.0v 464.755n 1.0v 469.745n 1.0v 469.755n 1.0v 474.745n 1.0v 474.755n 1.0v 479.745n 1.0v 479.755n 1.0v 484.745n 1.0v 484.755n 0.0v 489.745n 0.0v 489.755n 0.0v 494.745n 0.0v 494.755n 0.0v 499.745n 0.0v 499.755n 0.0v 504.745n 0.0v 504.755n 0.0v 509.745n 0.0v 509.755n 0.0v 514.745n 0.0v 514.755n 0.0v 519.745n 0.0v 519.755n 1.0v 524.745n 1.0v 524.755n 1.0v 529.745n 1.0v 529.755n 1.0v 534.745n 1.0v 534.755n 1.0v 539.745n 1.0v 539.755n 1.0v 544.745n 1.0v 544.755n 1.0v 549.745n 1.0v 549.755n 1.0v 554.745n 1.0v 554.755n 1.0v 559.745n 1.0v 559.755n 1.0v 564.745n 1.0v 564.755n 1.0v 569.745n 1.0v 569.755n 1.0v 574.745n 1.0v 574.755n 1.0v 579.745n 1.0v 579.755n 1.0v 584.745n 1.0v 584.755n 1.0v 589.745n 1.0v 589.755n 1.0v 594.745n 1.0v 594.755n 1.0v 599.745n 1.0v 599.755n 1.0v 604.745n 1.0v 604.755n 0.0v 609.745n 0.0v 609.755n 0.0v 614.745n 0.0v 614.755n 1.0v 619.745n 1.0v 619.755n 1.0v 624.745n 1.0v 624.755n 1.0v 629.745n 1.0v 629.755n 1.0v 634.745n 1.0v 634.755n 1.0v 639.745n 1.0v 639.755n 1.0v 644.745n 1.0v 644.755n 1.0v 649.745n 1.0v 649.755n 1.0v 654.745n 1.0v 654.755n 1.0v 659.745n 1.0v 659.755n 1.0v 664.745n 1.0v 664.755n 1.0v 669.745n 1.0v 669.755n 1.0v 674.745n 1.0v 674.755n 1.0v 679.745n 1.0v 679.755n 1.0v 684.745n 1.0v 684.755n 1.0v 689.745n 1.0v 689.755n 1.0v 694.745n 1.0v 694.755n 1.0v 699.745n 1.0v 699.755n 1.0v 704.745n 1.0v 704.755n 1.0v 709.745n 1.0v 709.755n 1.0v 714.745n 1.0v 714.755n 1.0v 719.745n 1.0v 719.755n 1.0v 724.745n 1.0v 724.755n 1.0v 729.745n 1.0v 729.755n 1.0v 734.745n 1.0v 734.755n 1.0v 739.745n 1.0v 739.755n 1.0v 744.745n 1.0v 744.755n 1.0v 749.745n 1.0v 749.755n 1.0v 754.745n 1.0v 754.755n 1.0v 759.745n 1.0v 759.755n 1.0v 764.745n 1.0v 764.755n 0.0v 769.745n 0.0v 769.755n 0.0v 774.745n 0.0v 774.755n 0.0v 779.745n 0.0v 779.755n 0.0v 784.745n 0.0v 784.755n 0.0v 789.745n 0.0v 789.755n 0.0v 794.745n 0.0v 794.755n 0.0v 799.745n 0.0v 799.755n 0.0v 804.745n 0.0v 804.755n 0.0v 809.745n 0.0v 809.755n 0.0v 814.745n 0.0v 814.755n 0.0v 819.745n 0.0v 819.755n 0.0v 824.745n 0.0v 824.755n 0.0v 829.745n 0.0v 829.755n 0.0v 834.745n 0.0v 834.755n 0.0v 839.745n 0.0v 839.755n 0.0v 844.745n 0.0v 844.755n 0.0v 849.745n 0.0v 849.755n 0.0v 854.745n 0.0v 854.755n 0.0v 859.745n 0.0v 859.755n 1.0v 864.745n 1.0v 864.755n 1.0v 869.745n 1.0v 869.755n 1.0v 874.745n 1.0v 874.755n 1.0v 879.745n 1.0v 879.755n 1.0v 884.745n 1.0v 884.755n 1.0v 889.745n 1.0v 889.755n 1.0v 894.745n 1.0v 894.755n 1.0v 899.745n 1.0v 899.755n 1.0v 904.745n 1.0v 904.755n 1.0v 909.745n 1.0v 909.755n 1.0v 914.745n 1.0v 914.755n 1.0v 919.745n 1.0v 919.755n 1.0v 924.745n 1.0v 924.755n 0.0v 929.745n 0.0v 929.755n 0.0v 934.745n 0.0v 934.755n 0.0v 939.745n 0.0v 939.755n 0.0v 944.745n 0.0v 944.755n 1.0v 949.745n 1.0v 949.755n 1.0v 954.745n 1.0v 954.755n 1.0v 959.745n 1.0v 959.755n 1.0v 964.745n 1.0v 964.755n 1.0v 969.745n 1.0v 969.755n 1.0v 974.745n 1.0v 974.755n 1.0v 979.745n 1.0v 979.755n 1.0v 984.745n 1.0v 984.755n 1.0v 989.745n 1.0v 989.755n 1.0v 994.745n 1.0v 994.755n 1.0v 999.745n 1.0v 999.755n 0.0v 1004.745n 0.0v 1004.755n 0.0v 1009.745n 0.0v 1009.755n 1.0v 1014.745n 1.0v 1014.755n 1.0v 1019.745n 1.0v 1019.755n 1.0v 1024.745n 1.0v 1024.755n 1.0v )
* (time, data): [(0, 0), (5, 1), (10, 0), (15, 0), (20, 0), (25, 0), (30, 0), (35, 0), (40, 0), (45, 0), (50, 0), (55, 0), (60, 1), (65, 1), (70, 1), (75, 1), (80, 0), (85, 0), (90, 1), (95, 1), (100, 1), (105, 1), (110, 1), (115, 1), (120, 1), (125, 1), (130, 1), (135, 1), (140, 1), (145, 1), (150, 1), (155, 1), (160, 1), (165, 1), (170, 1), (175, 0), (180, 0), (185, 0), (190, 0), (195, 0), (200, 0), (205, 0), (210, 0), (215, 0), (220, 0), (225, 0), (230, 0), (235, 0), (240, 0), (245, 0), (250, 0), (255, 0), (260, 0), (265, 0), (270, 0), (275, 0), (280, 0), (285, 0), (290, 0), (295, 0), (300, 0), (305, 0), (310, 0), (315, 0), (320, 0), (325, 0), (330, 0), (335, 0), (340, 0), (345, 0), (350, 0), (355, 0), (360, 0), (365, 0), (370, 0), (375, 0), (380, 1), (385, 1), (390, 1), (395, 0), (400, 1), (405, 1), (410, 1), (415, 1), (420, 1), (425, 1), (430, 1), (435, 1), (440, 1), (445, 1), (450, 1), (455, 1), (460, 1), (465, 0), (470, 0), (475, 0), (480, 0), (485, 1), (490, 1), (495, 1), (500, 1), (505, 0), (510, 0), (515, 0), (520, 0), (525, 0), (530, 0), (535, 0), (540, 0), (545, 0), (550, 0), (555, 0), (560, 0), (565, 0), (570, 0), (575, 0), (580, 1), (585, 0), (590, 0), (595, 0), (600, 0), (605, 1), (610, 1), (615, 0), (620, 0), (625, 0), (630, 0), (635, 0), (640, 0), (645, 0), (650, 0), (655, 0), (660, 0), (665, 0), (670, 0), (675, 0), (680, 0), (685, 0), (690, 1), (695, 1), (700, 1), (705, 1), (710, 1), (715, 1), (720, 1), (725, 1), (730, 1), (735, 1), (740, 1), (745, 1), (750, 1), (755, 1), (760, 1), (765, 0), (770, 1), (775, 1), (780, 1), (785, 1), (790, 0), (795, 0), (800, 0), (805, 0), (810, 1), (815, 1), (820, 1), (825, 1), (830, 1), (835, 1), (840, 1), (845, 1), (850, 1), (855, 1), (860, 0), (865, 0), (870, 0), (875, 0), (880, 0), (885, 0), (890, 0), (895, 0), (900, 0), (905, 1), (910, 1), (915, 1), (920, 1), (925, 1), (930, 1), (935, 1), (940, 1), (945, 0), (950, 0), (955, 0), (960, 0), (965, 0), (970, 0), (975, 0), (980, 0), (985, 0), (990, 0), (995, 0), (1000, 1), (1005, 1), (1010, 1), (1015, 1), (1020, 1), (1025, 1)]
Vdin1_17  din1_17  0 PWL (0n 0.0v 4.745n 0.0v 4.755n 1.0v 9.745n 1.0v 9.755n 0.0v 14.745n 0.0v 14.755n 0.0v 19.745n 0.0v 19.755n 0.0v 24.745n 0.0v 24.755n 0.0v 29.745n 0.0v 29.755n 0.0v 34.745n 0.0v 34.755n 0.0v 39.745n 0.0v 39.755n 0.0v 44.745n 0.0v 44.755n 0.0v 49.745n 0.0v 49.755n 0.0v 54.745n 0.0v 54.755n 0.0v 59.745n 0.0v 59.755n 1.0v 64.745n 1.0v 64.755n 1.0v 69.745n 1.0v 69.755n 1.0v 74.745n 1.0v 74.755n 1.0v 79.745n 1.0v 79.755n 0.0v 84.745n 0.0v 84.755n 0.0v 89.745n 0.0v 89.755n 1.0v 94.745n 1.0v 94.755n 1.0v 99.745n 1.0v 99.755n 1.0v 104.745n 1.0v 104.755n 1.0v 109.745n 1.0v 109.755n 1.0v 114.745n 1.0v 114.755n 1.0v 119.745n 1.0v 119.755n 1.0v 124.745n 1.0v 124.755n 1.0v 129.745n 1.0v 129.755n 1.0v 134.745n 1.0v 134.755n 1.0v 139.745n 1.0v 139.755n 1.0v 144.745n 1.0v 144.755n 1.0v 149.745n 1.0v 149.755n 1.0v 154.745n 1.0v 154.755n 1.0v 159.745n 1.0v 159.755n 1.0v 164.745n 1.0v 164.755n 1.0v 169.745n 1.0v 169.755n 1.0v 174.745n 1.0v 174.755n 0.0v 179.745n 0.0v 179.755n 0.0v 184.745n 0.0v 184.755n 0.0v 189.745n 0.0v 189.755n 0.0v 194.745n 0.0v 194.755n 0.0v 199.745n 0.0v 199.755n 0.0v 204.745n 0.0v 204.755n 0.0v 209.745n 0.0v 209.755n 0.0v 214.745n 0.0v 214.755n 0.0v 219.745n 0.0v 219.755n 0.0v 224.745n 0.0v 224.755n 0.0v 229.745n 0.0v 229.755n 0.0v 234.745n 0.0v 234.755n 0.0v 239.745n 0.0v 239.755n 0.0v 244.745n 0.0v 244.755n 0.0v 249.745n 0.0v 249.755n 0.0v 254.745n 0.0v 254.755n 0.0v 259.745n 0.0v 259.755n 0.0v 264.745n 0.0v 264.755n 0.0v 269.745n 0.0v 269.755n 0.0v 274.745n 0.0v 274.755n 0.0v 279.745n 0.0v 279.755n 0.0v 284.745n 0.0v 284.755n 0.0v 289.745n 0.0v 289.755n 0.0v 294.745n 0.0v 294.755n 0.0v 299.745n 0.0v 299.755n 0.0v 304.745n 0.0v 304.755n 0.0v 309.745n 0.0v 309.755n 0.0v 314.745n 0.0v 314.755n 0.0v 319.745n 0.0v 319.755n 0.0v 324.745n 0.0v 324.755n 0.0v 329.745n 0.0v 329.755n 0.0v 334.745n 0.0v 334.755n 0.0v 339.745n 0.0v 339.755n 0.0v 344.745n 0.0v 344.755n 0.0v 349.745n 0.0v 349.755n 0.0v 354.745n 0.0v 354.755n 0.0v 359.745n 0.0v 359.755n 0.0v 364.745n 0.0v 364.755n 0.0v 369.745n 0.0v 369.755n 0.0v 374.745n 0.0v 374.755n 0.0v 379.745n 0.0v 379.755n 1.0v 384.745n 1.0v 384.755n 1.0v 389.745n 1.0v 389.755n 1.0v 394.745n 1.0v 394.755n 0.0v 399.745n 0.0v 399.755n 1.0v 404.745n 1.0v 404.755n 1.0v 409.745n 1.0v 409.755n 1.0v 414.745n 1.0v 414.755n 1.0v 419.745n 1.0v 419.755n 1.0v 424.745n 1.0v 424.755n 1.0v 429.745n 1.0v 429.755n 1.0v 434.745n 1.0v 434.755n 1.0v 439.745n 1.0v 439.755n 1.0v 444.745n 1.0v 444.755n 1.0v 449.745n 1.0v 449.755n 1.0v 454.745n 1.0v 454.755n 1.0v 459.745n 1.0v 459.755n 1.0v 464.745n 1.0v 464.755n 0.0v 469.745n 0.0v 469.755n 0.0v 474.745n 0.0v 474.755n 0.0v 479.745n 0.0v 479.755n 0.0v 484.745n 0.0v 484.755n 1.0v 489.745n 1.0v 489.755n 1.0v 494.745n 1.0v 494.755n 1.0v 499.745n 1.0v 499.755n 1.0v 504.745n 1.0v 504.755n 0.0v 509.745n 0.0v 509.755n 0.0v 514.745n 0.0v 514.755n 0.0v 519.745n 0.0v 519.755n 0.0v 524.745n 0.0v 524.755n 0.0v 529.745n 0.0v 529.755n 0.0v 534.745n 0.0v 534.755n 0.0v 539.745n 0.0v 539.755n 0.0v 544.745n 0.0v 544.755n 0.0v 549.745n 0.0v 549.755n 0.0v 554.745n 0.0v 554.755n 0.0v 559.745n 0.0v 559.755n 0.0v 564.745n 0.0v 564.755n 0.0v 569.745n 0.0v 569.755n 0.0v 574.745n 0.0v 574.755n 0.0v 579.745n 0.0v 579.755n 1.0v 584.745n 1.0v 584.755n 0.0v 589.745n 0.0v 589.755n 0.0v 594.745n 0.0v 594.755n 0.0v 599.745n 0.0v 599.755n 0.0v 604.745n 0.0v 604.755n 1.0v 609.745n 1.0v 609.755n 1.0v 614.745n 1.0v 614.755n 0.0v 619.745n 0.0v 619.755n 0.0v 624.745n 0.0v 624.755n 0.0v 629.745n 0.0v 629.755n 0.0v 634.745n 0.0v 634.755n 0.0v 639.745n 0.0v 639.755n 0.0v 644.745n 0.0v 644.755n 0.0v 649.745n 0.0v 649.755n 0.0v 654.745n 0.0v 654.755n 0.0v 659.745n 0.0v 659.755n 0.0v 664.745n 0.0v 664.755n 0.0v 669.745n 0.0v 669.755n 0.0v 674.745n 0.0v 674.755n 0.0v 679.745n 0.0v 679.755n 0.0v 684.745n 0.0v 684.755n 0.0v 689.745n 0.0v 689.755n 1.0v 694.745n 1.0v 694.755n 1.0v 699.745n 1.0v 699.755n 1.0v 704.745n 1.0v 704.755n 1.0v 709.745n 1.0v 709.755n 1.0v 714.745n 1.0v 714.755n 1.0v 719.745n 1.0v 719.755n 1.0v 724.745n 1.0v 724.755n 1.0v 729.745n 1.0v 729.755n 1.0v 734.745n 1.0v 734.755n 1.0v 739.745n 1.0v 739.755n 1.0v 744.745n 1.0v 744.755n 1.0v 749.745n 1.0v 749.755n 1.0v 754.745n 1.0v 754.755n 1.0v 759.745n 1.0v 759.755n 1.0v 764.745n 1.0v 764.755n 0.0v 769.745n 0.0v 769.755n 1.0v 774.745n 1.0v 774.755n 1.0v 779.745n 1.0v 779.755n 1.0v 784.745n 1.0v 784.755n 1.0v 789.745n 1.0v 789.755n 0.0v 794.745n 0.0v 794.755n 0.0v 799.745n 0.0v 799.755n 0.0v 804.745n 0.0v 804.755n 0.0v 809.745n 0.0v 809.755n 1.0v 814.745n 1.0v 814.755n 1.0v 819.745n 1.0v 819.755n 1.0v 824.745n 1.0v 824.755n 1.0v 829.745n 1.0v 829.755n 1.0v 834.745n 1.0v 834.755n 1.0v 839.745n 1.0v 839.755n 1.0v 844.745n 1.0v 844.755n 1.0v 849.745n 1.0v 849.755n 1.0v 854.745n 1.0v 854.755n 1.0v 859.745n 1.0v 859.755n 0.0v 864.745n 0.0v 864.755n 0.0v 869.745n 0.0v 869.755n 0.0v 874.745n 0.0v 874.755n 0.0v 879.745n 0.0v 879.755n 0.0v 884.745n 0.0v 884.755n 0.0v 889.745n 0.0v 889.755n 0.0v 894.745n 0.0v 894.755n 0.0v 899.745n 0.0v 899.755n 0.0v 904.745n 0.0v 904.755n 1.0v 909.745n 1.0v 909.755n 1.0v 914.745n 1.0v 914.755n 1.0v 919.745n 1.0v 919.755n 1.0v 924.745n 1.0v 924.755n 1.0v 929.745n 1.0v 929.755n 1.0v 934.745n 1.0v 934.755n 1.0v 939.745n 1.0v 939.755n 1.0v 944.745n 1.0v 944.755n 0.0v 949.745n 0.0v 949.755n 0.0v 954.745n 0.0v 954.755n 0.0v 959.745n 0.0v 959.755n 0.0v 964.745n 0.0v 964.755n 0.0v 969.745n 0.0v 969.755n 0.0v 974.745n 0.0v 974.755n 0.0v 979.745n 0.0v 979.755n 0.0v 984.745n 0.0v 984.755n 0.0v 989.745n 0.0v 989.755n 0.0v 994.745n 0.0v 994.755n 0.0v 999.745n 0.0v 999.755n 1.0v 1004.745n 1.0v 1004.755n 1.0v 1009.745n 1.0v 1009.755n 1.0v 1014.745n 1.0v 1014.755n 1.0v 1019.745n 1.0v 1019.755n 1.0v 1024.745n 1.0v 1024.755n 1.0v )
* (time, data): [(0, 0), (5, 0), (10, 0), (15, 1), (20, 1), (25, 1), (30, 1), (35, 1), (40, 1), (45, 1), (50, 1), (55, 1), (60, 1), (65, 1), (70, 1), (75, 1), (80, 0), (85, 0), (90, 1), (95, 1), (100, 1), (105, 1), (110, 1), (115, 1), (120, 1), (125, 1), (130, 1), (135, 1), (140, 1), (145, 1), (150, 1), (155, 1), (160, 1), (165, 1), (170, 1), (175, 1), (180, 0), (185, 0), (190, 0), (195, 0), (200, 0), (205, 0), (210, 0), (215, 0), (220, 0), (225, 0), (230, 0), (235, 0), (240, 0), (245, 1), (250, 1), (255, 1), (260, 1), (265, 1), (270, 1), (275, 1), (280, 1), (285, 1), (290, 1), (295, 1), (300, 0), (305, 0), (310, 0), (315, 0), (320, 0), (325, 0), (330, 0), (335, 0), (340, 0), (345, 0), (350, 0), (355, 0), (360, 0), (365, 0), (370, 0), (375, 0), (380, 1), (385, 1), (390, 0), (395, 0), (400, 1), (405, 1), (410, 1), (415, 1), (420, 1), (425, 1), (430, 1), (435, 1), (440, 1), (445, 1), (450, 1), (455, 1), (460, 1), (465, 0), (470, 0), (475, 0), (480, 0), (485, 1), (490, 1), (495, 1), (500, 1), (505, 1), (510, 1), (515, 1), (520, 1), (525, 1), (530, 1), (535, 1), (540, 1), (545, 1), (550, 1), (555, 1), (560, 1), (565, 1), (570, 1), (575, 1), (580, 1), (585, 0), (590, 0), (595, 0), (600, 0), (605, 0), (610, 0), (615, 0), (620, 0), (625, 0), (630, 0), (635, 0), (640, 0), (645, 0), (650, 0), (655, 0), (660, 0), (665, 0), (670, 0), (675, 0), (680, 0), (685, 0), (690, 0), (695, 0), (700, 0), (705, 0), (710, 0), (715, 0), (720, 0), (725, 0), (730, 1), (735, 0), (740, 0), (745, 0), (750, 0), (755, 0), (760, 1), (765, 1), (770, 0), (775, 0), (780, 0), (785, 0), (790, 1), (795, 1), (800, 1), (805, 1), (810, 0), (815, 0), (820, 0), (825, 0), (830, 0), (835, 0), (840, 0), (845, 0), (850, 0), (855, 0), (860, 1), (865, 1), (870, 1), (875, 1), (880, 1), (885, 1), (890, 1), (895, 1), (900, 1), (905, 1), (910, 1), (915, 1), (920, 1), (925, 0), (930, 0), (935, 0), (940, 0), (945, 1), (950, 1), (955, 1), (960, 1), (965, 1), (970, 1), (975, 1), (980, 1), (985, 1), (990, 1), (995, 1), (1000, 1), (1005, 1), (1010, 1), (1015, 1), (1020, 1), (1025, 1)]
Vdin1_18  din1_18  0 PWL (0n 0.0v 4.745n 0.0v 4.755n 0.0v 9.745n 0.0v 9.755n 0.0v 14.745n 0.0v 14.755n 1.0v 19.745n 1.0v 19.755n 1.0v 24.745n 1.0v 24.755n 1.0v 29.745n 1.0v 29.755n 1.0v 34.745n 1.0v 34.755n 1.0v 39.745n 1.0v 39.755n 1.0v 44.745n 1.0v 44.755n 1.0v 49.745n 1.0v 49.755n 1.0v 54.745n 1.0v 54.755n 1.0v 59.745n 1.0v 59.755n 1.0v 64.745n 1.0v 64.755n 1.0v 69.745n 1.0v 69.755n 1.0v 74.745n 1.0v 74.755n 1.0v 79.745n 1.0v 79.755n 0.0v 84.745n 0.0v 84.755n 0.0v 89.745n 0.0v 89.755n 1.0v 94.745n 1.0v 94.755n 1.0v 99.745n 1.0v 99.755n 1.0v 104.745n 1.0v 104.755n 1.0v 109.745n 1.0v 109.755n 1.0v 114.745n 1.0v 114.755n 1.0v 119.745n 1.0v 119.755n 1.0v 124.745n 1.0v 124.755n 1.0v 129.745n 1.0v 129.755n 1.0v 134.745n 1.0v 134.755n 1.0v 139.745n 1.0v 139.755n 1.0v 144.745n 1.0v 144.755n 1.0v 149.745n 1.0v 149.755n 1.0v 154.745n 1.0v 154.755n 1.0v 159.745n 1.0v 159.755n 1.0v 164.745n 1.0v 164.755n 1.0v 169.745n 1.0v 169.755n 1.0v 174.745n 1.0v 174.755n 1.0v 179.745n 1.0v 179.755n 0.0v 184.745n 0.0v 184.755n 0.0v 189.745n 0.0v 189.755n 0.0v 194.745n 0.0v 194.755n 0.0v 199.745n 0.0v 199.755n 0.0v 204.745n 0.0v 204.755n 0.0v 209.745n 0.0v 209.755n 0.0v 214.745n 0.0v 214.755n 0.0v 219.745n 0.0v 219.755n 0.0v 224.745n 0.0v 224.755n 0.0v 229.745n 0.0v 229.755n 0.0v 234.745n 0.0v 234.755n 0.0v 239.745n 0.0v 239.755n 0.0v 244.745n 0.0v 244.755n 1.0v 249.745n 1.0v 249.755n 1.0v 254.745n 1.0v 254.755n 1.0v 259.745n 1.0v 259.755n 1.0v 264.745n 1.0v 264.755n 1.0v 269.745n 1.0v 269.755n 1.0v 274.745n 1.0v 274.755n 1.0v 279.745n 1.0v 279.755n 1.0v 284.745n 1.0v 284.755n 1.0v 289.745n 1.0v 289.755n 1.0v 294.745n 1.0v 294.755n 1.0v 299.745n 1.0v 299.755n 0.0v 304.745n 0.0v 304.755n 0.0v 309.745n 0.0v 309.755n 0.0v 314.745n 0.0v 314.755n 0.0v 319.745n 0.0v 319.755n 0.0v 324.745n 0.0v 324.755n 0.0v 329.745n 0.0v 329.755n 0.0v 334.745n 0.0v 334.755n 0.0v 339.745n 0.0v 339.755n 0.0v 344.745n 0.0v 344.755n 0.0v 349.745n 0.0v 349.755n 0.0v 354.745n 0.0v 354.755n 0.0v 359.745n 0.0v 359.755n 0.0v 364.745n 0.0v 364.755n 0.0v 369.745n 0.0v 369.755n 0.0v 374.745n 0.0v 374.755n 0.0v 379.745n 0.0v 379.755n 1.0v 384.745n 1.0v 384.755n 1.0v 389.745n 1.0v 389.755n 0.0v 394.745n 0.0v 394.755n 0.0v 399.745n 0.0v 399.755n 1.0v 404.745n 1.0v 404.755n 1.0v 409.745n 1.0v 409.755n 1.0v 414.745n 1.0v 414.755n 1.0v 419.745n 1.0v 419.755n 1.0v 424.745n 1.0v 424.755n 1.0v 429.745n 1.0v 429.755n 1.0v 434.745n 1.0v 434.755n 1.0v 439.745n 1.0v 439.755n 1.0v 444.745n 1.0v 444.755n 1.0v 449.745n 1.0v 449.755n 1.0v 454.745n 1.0v 454.755n 1.0v 459.745n 1.0v 459.755n 1.0v 464.745n 1.0v 464.755n 0.0v 469.745n 0.0v 469.755n 0.0v 474.745n 0.0v 474.755n 0.0v 479.745n 0.0v 479.755n 0.0v 484.745n 0.0v 484.755n 1.0v 489.745n 1.0v 489.755n 1.0v 494.745n 1.0v 494.755n 1.0v 499.745n 1.0v 499.755n 1.0v 504.745n 1.0v 504.755n 1.0v 509.745n 1.0v 509.755n 1.0v 514.745n 1.0v 514.755n 1.0v 519.745n 1.0v 519.755n 1.0v 524.745n 1.0v 524.755n 1.0v 529.745n 1.0v 529.755n 1.0v 534.745n 1.0v 534.755n 1.0v 539.745n 1.0v 539.755n 1.0v 544.745n 1.0v 544.755n 1.0v 549.745n 1.0v 549.755n 1.0v 554.745n 1.0v 554.755n 1.0v 559.745n 1.0v 559.755n 1.0v 564.745n 1.0v 564.755n 1.0v 569.745n 1.0v 569.755n 1.0v 574.745n 1.0v 574.755n 1.0v 579.745n 1.0v 579.755n 1.0v 584.745n 1.0v 584.755n 0.0v 589.745n 0.0v 589.755n 0.0v 594.745n 0.0v 594.755n 0.0v 599.745n 0.0v 599.755n 0.0v 604.745n 0.0v 604.755n 0.0v 609.745n 0.0v 609.755n 0.0v 614.745n 0.0v 614.755n 0.0v 619.745n 0.0v 619.755n 0.0v 624.745n 0.0v 624.755n 0.0v 629.745n 0.0v 629.755n 0.0v 634.745n 0.0v 634.755n 0.0v 639.745n 0.0v 639.755n 0.0v 644.745n 0.0v 644.755n 0.0v 649.745n 0.0v 649.755n 0.0v 654.745n 0.0v 654.755n 0.0v 659.745n 0.0v 659.755n 0.0v 664.745n 0.0v 664.755n 0.0v 669.745n 0.0v 669.755n 0.0v 674.745n 0.0v 674.755n 0.0v 679.745n 0.0v 679.755n 0.0v 684.745n 0.0v 684.755n 0.0v 689.745n 0.0v 689.755n 0.0v 694.745n 0.0v 694.755n 0.0v 699.745n 0.0v 699.755n 0.0v 704.745n 0.0v 704.755n 0.0v 709.745n 0.0v 709.755n 0.0v 714.745n 0.0v 714.755n 0.0v 719.745n 0.0v 719.755n 0.0v 724.745n 0.0v 724.755n 0.0v 729.745n 0.0v 729.755n 1.0v 734.745n 1.0v 734.755n 0.0v 739.745n 0.0v 739.755n 0.0v 744.745n 0.0v 744.755n 0.0v 749.745n 0.0v 749.755n 0.0v 754.745n 0.0v 754.755n 0.0v 759.745n 0.0v 759.755n 1.0v 764.745n 1.0v 764.755n 1.0v 769.745n 1.0v 769.755n 0.0v 774.745n 0.0v 774.755n 0.0v 779.745n 0.0v 779.755n 0.0v 784.745n 0.0v 784.755n 0.0v 789.745n 0.0v 789.755n 1.0v 794.745n 1.0v 794.755n 1.0v 799.745n 1.0v 799.755n 1.0v 804.745n 1.0v 804.755n 1.0v 809.745n 1.0v 809.755n 0.0v 814.745n 0.0v 814.755n 0.0v 819.745n 0.0v 819.755n 0.0v 824.745n 0.0v 824.755n 0.0v 829.745n 0.0v 829.755n 0.0v 834.745n 0.0v 834.755n 0.0v 839.745n 0.0v 839.755n 0.0v 844.745n 0.0v 844.755n 0.0v 849.745n 0.0v 849.755n 0.0v 854.745n 0.0v 854.755n 0.0v 859.745n 0.0v 859.755n 1.0v 864.745n 1.0v 864.755n 1.0v 869.745n 1.0v 869.755n 1.0v 874.745n 1.0v 874.755n 1.0v 879.745n 1.0v 879.755n 1.0v 884.745n 1.0v 884.755n 1.0v 889.745n 1.0v 889.755n 1.0v 894.745n 1.0v 894.755n 1.0v 899.745n 1.0v 899.755n 1.0v 904.745n 1.0v 904.755n 1.0v 909.745n 1.0v 909.755n 1.0v 914.745n 1.0v 914.755n 1.0v 919.745n 1.0v 919.755n 1.0v 924.745n 1.0v 924.755n 0.0v 929.745n 0.0v 929.755n 0.0v 934.745n 0.0v 934.755n 0.0v 939.745n 0.0v 939.755n 0.0v 944.745n 0.0v 944.755n 1.0v 949.745n 1.0v 949.755n 1.0v 954.745n 1.0v 954.755n 1.0v 959.745n 1.0v 959.755n 1.0v 964.745n 1.0v 964.755n 1.0v 969.745n 1.0v 969.755n 1.0v 974.745n 1.0v 974.755n 1.0v 979.745n 1.0v 979.755n 1.0v 984.745n 1.0v 984.755n 1.0v 989.745n 1.0v 989.755n 1.0v 994.745n 1.0v 994.755n 1.0v 999.745n 1.0v 999.755n 1.0v 1004.745n 1.0v 1004.755n 1.0v 1009.745n 1.0v 1009.755n 1.0v 1014.745n 1.0v 1014.755n 1.0v 1019.745n 1.0v 1019.755n 1.0v 1024.745n 1.0v 1024.755n 1.0v )
* (time, data): [(0, 0), (5, 0), (10, 1), (15, 1), (20, 1), (25, 1), (30, 1), (35, 1), (40, 1), (45, 1), (50, 1), (55, 1), (60, 1), (65, 1), (70, 1), (75, 1), (80, 0), (85, 0), (90, 1), (95, 1), (100, 1), (105, 1), (110, 1), (115, 1), (120, 1), (125, 1), (130, 1), (135, 1), (140, 1), (145, 1), (150, 1), (155, 1), (160, 1), (165, 1), (170, 1), (175, 1), (180, 1), (185, 1), (190, 1), (195, 1), (200, 1), (205, 1), (210, 1), (215, 1), (220, 1), (225, 1), (230, 1), (235, 1), (240, 1), (245, 0), (250, 0), (255, 0), (260, 0), (265, 0), (270, 0), (275, 0), (280, 0), (285, 1), (290, 1), (295, 1), (300, 1), (305, 1), (310, 1), (315, 1), (320, 1), (325, 1), (330, 1), (335, 1), (340, 1), (345, 1), (350, 1), (355, 1), (360, 1), (365, 0), (370, 0), (375, 0), (380, 1), (385, 1), (390, 0), (395, 1), (400, 1), (405, 1), (410, 1), (415, 1), (420, 0), (425, 0), (430, 0), (435, 0), (440, 0), (445, 0), (450, 0), (455, 0), (460, 0), (465, 1), (470, 1), (475, 1), (480, 1), (485, 1), (490, 1), (495, 1), (500, 1), (505, 0), (510, 0), (515, 0), (520, 0), (525, 0), (530, 0), (535, 0), (540, 0), (545, 0), (550, 0), (555, 0), (560, 0), (565, 0), (570, 0), (575, 0), (580, 1), (585, 0), (590, 0), (595, 0), (600, 0), (605, 0), (610, 0), (615, 0), (620, 0), (625, 0), (630, 0), (635, 0), (640, 0), (645, 0), (650, 0), (655, 0), (660, 0), (665, 0), (670, 0), (675, 0), (680, 0), (685, 0), (690, 0), (695, 0), (700, 0), (705, 0), (710, 0), (715, 0), (720, 0), (725, 0), (730, 1), (735, 1), (740, 1), (745, 1), (750, 1), (755, 1), (760, 1), (765, 1), (770, 1), (775, 1), (780, 1), (785, 1), (790, 1), (795, 1), (800, 1), (805, 1), (810, 1), (815, 1), (820, 1), (825, 1), (830, 0), (835, 0), (840, 0), (845, 0), (850, 0), (855, 0), (860, 1), (865, 1), (870, 1), (875, 1), (880, 0), (885, 0), (890, 0), (895, 0), (900, 0), (905, 1), (910, 1), (915, 1), (920, 1), (925, 0), (930, 1), (935, 1), (940, 1), (945, 0), (950, 0), (955, 0), (960, 0), (965, 0), (970, 0), (975, 0), (980, 0), (985, 0), (990, 0), (995, 0), (1000, 0), (1005, 0), (1010, 0), (1015, 0), (1020, 1), (1025, 1)]
Vdin1_19  din1_19  0 PWL (0n 0.0v 4.745n 0.0v 4.755n 0.0v 9.745n 0.0v 9.755n 1.0v 14.745n 1.0v 14.755n 1.0v 19.745n 1.0v 19.755n 1.0v 24.745n 1.0v 24.755n 1.0v 29.745n 1.0v 29.755n 1.0v 34.745n 1.0v 34.755n 1.0v 39.745n 1.0v 39.755n 1.0v 44.745n 1.0v 44.755n 1.0v 49.745n 1.0v 49.755n 1.0v 54.745n 1.0v 54.755n 1.0v 59.745n 1.0v 59.755n 1.0v 64.745n 1.0v 64.755n 1.0v 69.745n 1.0v 69.755n 1.0v 74.745n 1.0v 74.755n 1.0v 79.745n 1.0v 79.755n 0.0v 84.745n 0.0v 84.755n 0.0v 89.745n 0.0v 89.755n 1.0v 94.745n 1.0v 94.755n 1.0v 99.745n 1.0v 99.755n 1.0v 104.745n 1.0v 104.755n 1.0v 109.745n 1.0v 109.755n 1.0v 114.745n 1.0v 114.755n 1.0v 119.745n 1.0v 119.755n 1.0v 124.745n 1.0v 124.755n 1.0v 129.745n 1.0v 129.755n 1.0v 134.745n 1.0v 134.755n 1.0v 139.745n 1.0v 139.755n 1.0v 144.745n 1.0v 144.755n 1.0v 149.745n 1.0v 149.755n 1.0v 154.745n 1.0v 154.755n 1.0v 159.745n 1.0v 159.755n 1.0v 164.745n 1.0v 164.755n 1.0v 169.745n 1.0v 169.755n 1.0v 174.745n 1.0v 174.755n 1.0v 179.745n 1.0v 179.755n 1.0v 184.745n 1.0v 184.755n 1.0v 189.745n 1.0v 189.755n 1.0v 194.745n 1.0v 194.755n 1.0v 199.745n 1.0v 199.755n 1.0v 204.745n 1.0v 204.755n 1.0v 209.745n 1.0v 209.755n 1.0v 214.745n 1.0v 214.755n 1.0v 219.745n 1.0v 219.755n 1.0v 224.745n 1.0v 224.755n 1.0v 229.745n 1.0v 229.755n 1.0v 234.745n 1.0v 234.755n 1.0v 239.745n 1.0v 239.755n 1.0v 244.745n 1.0v 244.755n 0.0v 249.745n 0.0v 249.755n 0.0v 254.745n 0.0v 254.755n 0.0v 259.745n 0.0v 259.755n 0.0v 264.745n 0.0v 264.755n 0.0v 269.745n 0.0v 269.755n 0.0v 274.745n 0.0v 274.755n 0.0v 279.745n 0.0v 279.755n 0.0v 284.745n 0.0v 284.755n 1.0v 289.745n 1.0v 289.755n 1.0v 294.745n 1.0v 294.755n 1.0v 299.745n 1.0v 299.755n 1.0v 304.745n 1.0v 304.755n 1.0v 309.745n 1.0v 309.755n 1.0v 314.745n 1.0v 314.755n 1.0v 319.745n 1.0v 319.755n 1.0v 324.745n 1.0v 324.755n 1.0v 329.745n 1.0v 329.755n 1.0v 334.745n 1.0v 334.755n 1.0v 339.745n 1.0v 339.755n 1.0v 344.745n 1.0v 344.755n 1.0v 349.745n 1.0v 349.755n 1.0v 354.745n 1.0v 354.755n 1.0v 359.745n 1.0v 359.755n 1.0v 364.745n 1.0v 364.755n 0.0v 369.745n 0.0v 369.755n 0.0v 374.745n 0.0v 374.755n 0.0v 379.745n 0.0v 379.755n 1.0v 384.745n 1.0v 384.755n 1.0v 389.745n 1.0v 389.755n 0.0v 394.745n 0.0v 394.755n 1.0v 399.745n 1.0v 399.755n 1.0v 404.745n 1.0v 404.755n 1.0v 409.745n 1.0v 409.755n 1.0v 414.745n 1.0v 414.755n 1.0v 419.745n 1.0v 419.755n 0.0v 424.745n 0.0v 424.755n 0.0v 429.745n 0.0v 429.755n 0.0v 434.745n 0.0v 434.755n 0.0v 439.745n 0.0v 439.755n 0.0v 444.745n 0.0v 444.755n 0.0v 449.745n 0.0v 449.755n 0.0v 454.745n 0.0v 454.755n 0.0v 459.745n 0.0v 459.755n 0.0v 464.745n 0.0v 464.755n 1.0v 469.745n 1.0v 469.755n 1.0v 474.745n 1.0v 474.755n 1.0v 479.745n 1.0v 479.755n 1.0v 484.745n 1.0v 484.755n 1.0v 489.745n 1.0v 489.755n 1.0v 494.745n 1.0v 494.755n 1.0v 499.745n 1.0v 499.755n 1.0v 504.745n 1.0v 504.755n 0.0v 509.745n 0.0v 509.755n 0.0v 514.745n 0.0v 514.755n 0.0v 519.745n 0.0v 519.755n 0.0v 524.745n 0.0v 524.755n 0.0v 529.745n 0.0v 529.755n 0.0v 534.745n 0.0v 534.755n 0.0v 539.745n 0.0v 539.755n 0.0v 544.745n 0.0v 544.755n 0.0v 549.745n 0.0v 549.755n 0.0v 554.745n 0.0v 554.755n 0.0v 559.745n 0.0v 559.755n 0.0v 564.745n 0.0v 564.755n 0.0v 569.745n 0.0v 569.755n 0.0v 574.745n 0.0v 574.755n 0.0v 579.745n 0.0v 579.755n 1.0v 584.745n 1.0v 584.755n 0.0v 589.745n 0.0v 589.755n 0.0v 594.745n 0.0v 594.755n 0.0v 599.745n 0.0v 599.755n 0.0v 604.745n 0.0v 604.755n 0.0v 609.745n 0.0v 609.755n 0.0v 614.745n 0.0v 614.755n 0.0v 619.745n 0.0v 619.755n 0.0v 624.745n 0.0v 624.755n 0.0v 629.745n 0.0v 629.755n 0.0v 634.745n 0.0v 634.755n 0.0v 639.745n 0.0v 639.755n 0.0v 644.745n 0.0v 644.755n 0.0v 649.745n 0.0v 649.755n 0.0v 654.745n 0.0v 654.755n 0.0v 659.745n 0.0v 659.755n 0.0v 664.745n 0.0v 664.755n 0.0v 669.745n 0.0v 669.755n 0.0v 674.745n 0.0v 674.755n 0.0v 679.745n 0.0v 679.755n 0.0v 684.745n 0.0v 684.755n 0.0v 689.745n 0.0v 689.755n 0.0v 694.745n 0.0v 694.755n 0.0v 699.745n 0.0v 699.755n 0.0v 704.745n 0.0v 704.755n 0.0v 709.745n 0.0v 709.755n 0.0v 714.745n 0.0v 714.755n 0.0v 719.745n 0.0v 719.755n 0.0v 724.745n 0.0v 724.755n 0.0v 729.745n 0.0v 729.755n 1.0v 734.745n 1.0v 734.755n 1.0v 739.745n 1.0v 739.755n 1.0v 744.745n 1.0v 744.755n 1.0v 749.745n 1.0v 749.755n 1.0v 754.745n 1.0v 754.755n 1.0v 759.745n 1.0v 759.755n 1.0v 764.745n 1.0v 764.755n 1.0v 769.745n 1.0v 769.755n 1.0v 774.745n 1.0v 774.755n 1.0v 779.745n 1.0v 779.755n 1.0v 784.745n 1.0v 784.755n 1.0v 789.745n 1.0v 789.755n 1.0v 794.745n 1.0v 794.755n 1.0v 799.745n 1.0v 799.755n 1.0v 804.745n 1.0v 804.755n 1.0v 809.745n 1.0v 809.755n 1.0v 814.745n 1.0v 814.755n 1.0v 819.745n 1.0v 819.755n 1.0v 824.745n 1.0v 824.755n 1.0v 829.745n 1.0v 829.755n 0.0v 834.745n 0.0v 834.755n 0.0v 839.745n 0.0v 839.755n 0.0v 844.745n 0.0v 844.755n 0.0v 849.745n 0.0v 849.755n 0.0v 854.745n 0.0v 854.755n 0.0v 859.745n 0.0v 859.755n 1.0v 864.745n 1.0v 864.755n 1.0v 869.745n 1.0v 869.755n 1.0v 874.745n 1.0v 874.755n 1.0v 879.745n 1.0v 879.755n 0.0v 884.745n 0.0v 884.755n 0.0v 889.745n 0.0v 889.755n 0.0v 894.745n 0.0v 894.755n 0.0v 899.745n 0.0v 899.755n 0.0v 904.745n 0.0v 904.755n 1.0v 909.745n 1.0v 909.755n 1.0v 914.745n 1.0v 914.755n 1.0v 919.745n 1.0v 919.755n 1.0v 924.745n 1.0v 924.755n 0.0v 929.745n 0.0v 929.755n 1.0v 934.745n 1.0v 934.755n 1.0v 939.745n 1.0v 939.755n 1.0v 944.745n 1.0v 944.755n 0.0v 949.745n 0.0v 949.755n 0.0v 954.745n 0.0v 954.755n 0.0v 959.745n 0.0v 959.755n 0.0v 964.745n 0.0v 964.755n 0.0v 969.745n 0.0v 969.755n 0.0v 974.745n 0.0v 974.755n 0.0v 979.745n 0.0v 979.755n 0.0v 984.745n 0.0v 984.755n 0.0v 989.745n 0.0v 989.755n 0.0v 994.745n 0.0v 994.755n 0.0v 999.745n 0.0v 999.755n 0.0v 1004.745n 0.0v 1004.755n 0.0v 1009.745n 0.0v 1009.755n 0.0v 1014.745n 0.0v 1014.755n 0.0v 1019.745n 0.0v 1019.755n 1.0v 1024.745n 1.0v 1024.755n 1.0v )
* (time, data): [(0, 0), (5, 1), (10, 0), (15, 1), (20, 1), (25, 1), (30, 1), (35, 1), (40, 1), (45, 1), (50, 1), (55, 1), (60, 0), (65, 0), (70, 0), (75, 0), (80, 1), (85, 1), (90, 0), (95, 0), (100, 0), (105, 0), (110, 0), (115, 0), (120, 0), (125, 0), (130, 1), (135, 1), (140, 1), (145, 0), (150, 0), (155, 0), (160, 0), (165, 0), (170, 0), (175, 0), (180, 0), (185, 0), (190, 0), (195, 0), (200, 0), (205, 0), (210, 0), (215, 0), (220, 0), (225, 0), (230, 0), (235, 0), (240, 0), (245, 0), (250, 0), (255, 0), (260, 0), (265, 0), (270, 0), (275, 0), (280, 0), (285, 1), (290, 1), (295, 1), (300, 0), (305, 0), (310, 0), (315, 0), (320, 0), (325, 0), (330, 0), (335, 0), (340, 0), (345, 0), (350, 0), (355, 0), (360, 0), (365, 0), (370, 0), (375, 0), (380, 1), (385, 1), (390, 0), (395, 0), (400, 1), (405, 1), (410, 1), (415, 1), (420, 0), (425, 0), (430, 0), (435, 0), (440, 0), (445, 0), (450, 0), (455, 0), (460, 0), (465, 0), (470, 0), (475, 0), (480, 0), (485, 1), (490, 1), (495, 1), (500, 1), (505, 1), (510, 1), (515, 1), (520, 1), (525, 1), (530, 1), (535, 1), (540, 1), (545, 1), (550, 1), (555, 1), (560, 1), (565, 1), (570, 1), (575, 1), (580, 0), (585, 0), (590, 0), (595, 0), (600, 0), (605, 1), (610, 1), (615, 1), (620, 1), (625, 1), (630, 1), (635, 1), (640, 1), (645, 1), (650, 1), (655, 1), (660, 1), (665, 1), (670, 1), (675, 1), (680, 1), (685, 1), (690, 1), (695, 1), (700, 1), (705, 1), (710, 1), (715, 1), (720, 1), (725, 1), (730, 0), (735, 0), (740, 0), (745, 0), (750, 0), (755, 0), (760, 0), (765, 0), (770, 0), (775, 0), (780, 0), (785, 0), (790, 1), (795, 1), (800, 1), (805, 1), (810, 1), (815, 1), (820, 1), (825, 1), (830, 1), (835, 1), (840, 1), (845, 1), (850, 1), (855, 1), (860, 0), (865, 0), (870, 0), (875, 0), (880, 1), (885, 1), (890, 1), (895, 1), (900, 0), (905, 0), (910, 0), (915, 0), (920, 0), (925, 0), (930, 0), (935, 0), (940, 0), (945, 0), (950, 0), (955, 0), (960, 0), (965, 0), (970, 0), (975, 0), (980, 0), (985, 0), (990, 0), (995, 0), (1000, 1), (1005, 1), (1010, 1), (1015, 1), (1020, 1), (1025, 1)]
Vdin1_20  din1_20  0 PWL (0n 0.0v 4.745n 0.0v 4.755n 1.0v 9.745n 1.0v 9.755n 0.0v 14.745n 0.0v 14.755n 1.0v 19.745n 1.0v 19.755n 1.0v 24.745n 1.0v 24.755n 1.0v 29.745n 1.0v 29.755n 1.0v 34.745n 1.0v 34.755n 1.0v 39.745n 1.0v 39.755n 1.0v 44.745n 1.0v 44.755n 1.0v 49.745n 1.0v 49.755n 1.0v 54.745n 1.0v 54.755n 1.0v 59.745n 1.0v 59.755n 0.0v 64.745n 0.0v 64.755n 0.0v 69.745n 0.0v 69.755n 0.0v 74.745n 0.0v 74.755n 0.0v 79.745n 0.0v 79.755n 1.0v 84.745n 1.0v 84.755n 1.0v 89.745n 1.0v 89.755n 0.0v 94.745n 0.0v 94.755n 0.0v 99.745n 0.0v 99.755n 0.0v 104.745n 0.0v 104.755n 0.0v 109.745n 0.0v 109.755n 0.0v 114.745n 0.0v 114.755n 0.0v 119.745n 0.0v 119.755n 0.0v 124.745n 0.0v 124.755n 0.0v 129.745n 0.0v 129.755n 1.0v 134.745n 1.0v 134.755n 1.0v 139.745n 1.0v 139.755n 1.0v 144.745n 1.0v 144.755n 0.0v 149.745n 0.0v 149.755n 0.0v 154.745n 0.0v 154.755n 0.0v 159.745n 0.0v 159.755n 0.0v 164.745n 0.0v 164.755n 0.0v 169.745n 0.0v 169.755n 0.0v 174.745n 0.0v 174.755n 0.0v 179.745n 0.0v 179.755n 0.0v 184.745n 0.0v 184.755n 0.0v 189.745n 0.0v 189.755n 0.0v 194.745n 0.0v 194.755n 0.0v 199.745n 0.0v 199.755n 0.0v 204.745n 0.0v 204.755n 0.0v 209.745n 0.0v 209.755n 0.0v 214.745n 0.0v 214.755n 0.0v 219.745n 0.0v 219.755n 0.0v 224.745n 0.0v 224.755n 0.0v 229.745n 0.0v 229.755n 0.0v 234.745n 0.0v 234.755n 0.0v 239.745n 0.0v 239.755n 0.0v 244.745n 0.0v 244.755n 0.0v 249.745n 0.0v 249.755n 0.0v 254.745n 0.0v 254.755n 0.0v 259.745n 0.0v 259.755n 0.0v 264.745n 0.0v 264.755n 0.0v 269.745n 0.0v 269.755n 0.0v 274.745n 0.0v 274.755n 0.0v 279.745n 0.0v 279.755n 0.0v 284.745n 0.0v 284.755n 1.0v 289.745n 1.0v 289.755n 1.0v 294.745n 1.0v 294.755n 1.0v 299.745n 1.0v 299.755n 0.0v 304.745n 0.0v 304.755n 0.0v 309.745n 0.0v 309.755n 0.0v 314.745n 0.0v 314.755n 0.0v 319.745n 0.0v 319.755n 0.0v 324.745n 0.0v 324.755n 0.0v 329.745n 0.0v 329.755n 0.0v 334.745n 0.0v 334.755n 0.0v 339.745n 0.0v 339.755n 0.0v 344.745n 0.0v 344.755n 0.0v 349.745n 0.0v 349.755n 0.0v 354.745n 0.0v 354.755n 0.0v 359.745n 0.0v 359.755n 0.0v 364.745n 0.0v 364.755n 0.0v 369.745n 0.0v 369.755n 0.0v 374.745n 0.0v 374.755n 0.0v 379.745n 0.0v 379.755n 1.0v 384.745n 1.0v 384.755n 1.0v 389.745n 1.0v 389.755n 0.0v 394.745n 0.0v 394.755n 0.0v 399.745n 0.0v 399.755n 1.0v 404.745n 1.0v 404.755n 1.0v 409.745n 1.0v 409.755n 1.0v 414.745n 1.0v 414.755n 1.0v 419.745n 1.0v 419.755n 0.0v 424.745n 0.0v 424.755n 0.0v 429.745n 0.0v 429.755n 0.0v 434.745n 0.0v 434.755n 0.0v 439.745n 0.0v 439.755n 0.0v 444.745n 0.0v 444.755n 0.0v 449.745n 0.0v 449.755n 0.0v 454.745n 0.0v 454.755n 0.0v 459.745n 0.0v 459.755n 0.0v 464.745n 0.0v 464.755n 0.0v 469.745n 0.0v 469.755n 0.0v 474.745n 0.0v 474.755n 0.0v 479.745n 0.0v 479.755n 0.0v 484.745n 0.0v 484.755n 1.0v 489.745n 1.0v 489.755n 1.0v 494.745n 1.0v 494.755n 1.0v 499.745n 1.0v 499.755n 1.0v 504.745n 1.0v 504.755n 1.0v 509.745n 1.0v 509.755n 1.0v 514.745n 1.0v 514.755n 1.0v 519.745n 1.0v 519.755n 1.0v 524.745n 1.0v 524.755n 1.0v 529.745n 1.0v 529.755n 1.0v 534.745n 1.0v 534.755n 1.0v 539.745n 1.0v 539.755n 1.0v 544.745n 1.0v 544.755n 1.0v 549.745n 1.0v 549.755n 1.0v 554.745n 1.0v 554.755n 1.0v 559.745n 1.0v 559.755n 1.0v 564.745n 1.0v 564.755n 1.0v 569.745n 1.0v 569.755n 1.0v 574.745n 1.0v 574.755n 1.0v 579.745n 1.0v 579.755n 0.0v 584.745n 0.0v 584.755n 0.0v 589.745n 0.0v 589.755n 0.0v 594.745n 0.0v 594.755n 0.0v 599.745n 0.0v 599.755n 0.0v 604.745n 0.0v 604.755n 1.0v 609.745n 1.0v 609.755n 1.0v 614.745n 1.0v 614.755n 1.0v 619.745n 1.0v 619.755n 1.0v 624.745n 1.0v 624.755n 1.0v 629.745n 1.0v 629.755n 1.0v 634.745n 1.0v 634.755n 1.0v 639.745n 1.0v 639.755n 1.0v 644.745n 1.0v 644.755n 1.0v 649.745n 1.0v 649.755n 1.0v 654.745n 1.0v 654.755n 1.0v 659.745n 1.0v 659.755n 1.0v 664.745n 1.0v 664.755n 1.0v 669.745n 1.0v 669.755n 1.0v 674.745n 1.0v 674.755n 1.0v 679.745n 1.0v 679.755n 1.0v 684.745n 1.0v 684.755n 1.0v 689.745n 1.0v 689.755n 1.0v 694.745n 1.0v 694.755n 1.0v 699.745n 1.0v 699.755n 1.0v 704.745n 1.0v 704.755n 1.0v 709.745n 1.0v 709.755n 1.0v 714.745n 1.0v 714.755n 1.0v 719.745n 1.0v 719.755n 1.0v 724.745n 1.0v 724.755n 1.0v 729.745n 1.0v 729.755n 0.0v 734.745n 0.0v 734.755n 0.0v 739.745n 0.0v 739.755n 0.0v 744.745n 0.0v 744.755n 0.0v 749.745n 0.0v 749.755n 0.0v 754.745n 0.0v 754.755n 0.0v 759.745n 0.0v 759.755n 0.0v 764.745n 0.0v 764.755n 0.0v 769.745n 0.0v 769.755n 0.0v 774.745n 0.0v 774.755n 0.0v 779.745n 0.0v 779.755n 0.0v 784.745n 0.0v 784.755n 0.0v 789.745n 0.0v 789.755n 1.0v 794.745n 1.0v 794.755n 1.0v 799.745n 1.0v 799.755n 1.0v 804.745n 1.0v 804.755n 1.0v 809.745n 1.0v 809.755n 1.0v 814.745n 1.0v 814.755n 1.0v 819.745n 1.0v 819.755n 1.0v 824.745n 1.0v 824.755n 1.0v 829.745n 1.0v 829.755n 1.0v 834.745n 1.0v 834.755n 1.0v 839.745n 1.0v 839.755n 1.0v 844.745n 1.0v 844.755n 1.0v 849.745n 1.0v 849.755n 1.0v 854.745n 1.0v 854.755n 1.0v 859.745n 1.0v 859.755n 0.0v 864.745n 0.0v 864.755n 0.0v 869.745n 0.0v 869.755n 0.0v 874.745n 0.0v 874.755n 0.0v 879.745n 0.0v 879.755n 1.0v 884.745n 1.0v 884.755n 1.0v 889.745n 1.0v 889.755n 1.0v 894.745n 1.0v 894.755n 1.0v 899.745n 1.0v 899.755n 0.0v 904.745n 0.0v 904.755n 0.0v 909.745n 0.0v 909.755n 0.0v 914.745n 0.0v 914.755n 0.0v 919.745n 0.0v 919.755n 0.0v 924.745n 0.0v 924.755n 0.0v 929.745n 0.0v 929.755n 0.0v 934.745n 0.0v 934.755n 0.0v 939.745n 0.0v 939.755n 0.0v 944.745n 0.0v 944.755n 0.0v 949.745n 0.0v 949.755n 0.0v 954.745n 0.0v 954.755n 0.0v 959.745n 0.0v 959.755n 0.0v 964.745n 0.0v 964.755n 0.0v 969.745n 0.0v 969.755n 0.0v 974.745n 0.0v 974.755n 0.0v 979.745n 0.0v 979.755n 0.0v 984.745n 0.0v 984.755n 0.0v 989.745n 0.0v 989.755n 0.0v 994.745n 0.0v 994.755n 0.0v 999.745n 0.0v 999.755n 1.0v 1004.745n 1.0v 1004.755n 1.0v 1009.745n 1.0v 1009.755n 1.0v 1014.745n 1.0v 1014.755n 1.0v 1019.745n 1.0v 1019.755n 1.0v 1024.745n 1.0v 1024.755n 1.0v )
* (time, data): [(0, 0), (5, 1), (10, 0), (15, 0), (20, 0), (25, 0), (30, 0), (35, 0), (40, 0), (45, 0), (50, 0), (55, 0), (60, 1), (65, 1), (70, 1), (75, 1), (80, 0), (85, 0), (90, 0), (95, 0), (100, 0), (105, 0), (110, 0), (115, 0), (120, 0), (125, 0), (130, 1), (135, 1), (140, 1), (145, 0), (150, 0), (155, 0), (160, 0), (165, 0), (170, 0), (175, 1), (180, 0), (185, 0), (190, 0), (195, 0), (200, 0), (205, 0), (210, 0), (215, 0), (220, 0), (225, 0), (230, 0), (235, 0), (240, 0), (245, 0), (250, 0), (255, 0), (260, 0), (265, 0), (270, 0), (275, 0), (280, 0), (285, 1), (290, 1), (295, 1), (300, 0), (305, 0), (310, 0), (315, 0), (320, 0), (325, 0), (330, 0), (335, 0), (340, 0), (345, 0), (350, 0), (355, 0), (360, 0), (365, 0), (370, 0), (375, 0), (380, 1), (385, 1), (390, 0), (395, 0), (400, 0), (405, 0), (410, 0), (415, 0), (420, 1), (425, 1), (430, 1), (435, 1), (440, 1), (445, 1), (450, 1), (455, 1), (460, 1), (465, 0), (470, 0), (475, 0), (480, 0), (485, 1), (490, 1), (495, 1), (500, 1), (505, 1), (510, 1), (515, 1), (520, 1), (525, 1), (530, 1), (535, 1), (540, 1), (545, 1), (550, 1), (555, 1), (560, 1), (565, 1), (570, 1), (575, 1), (580, 1), (585, 0), (590, 0), (595, 0), (600, 0), (605, 1), (610, 1), (615, 0), (620, 0), (625, 0), (630, 0), (635, 0), (640, 0), (645, 0), (650, 0), (655, 0), (660, 0), (665, 0), (670, 0), (675, 0), (680, 0), (685, 0), (690, 0), (695, 0), (700, 0), (705, 0), (710, 0), (715, 0), (720, 0), (725, 0), (730, 0), (735, 0), (740, 0), (745, 0), (750, 0), (755, 0), (760, 0), (765, 1), (770, 1), (775, 1), (780, 1), (785, 1), (790, 0), (795, 0), (800, 0), (805, 0), (810, 1), (815, 1), (820, 1), (825, 1), (830, 1), (835, 1), (840, 1), (845, 1), (850, 1), (855, 1), (860, 1), (865, 1), (870, 1), (875, 1), (880, 1), (885, 1), (890, 1), (895, 1), (900, 0), (905, 1), (910, 1), (915, 1), (920, 1), (925, 0), (930, 1), (935, 1), (940, 1), (945, 0), (950, 0), (955, 0), (960, 0), (965, 0), (970, 0), (975, 0), (980, 0), (985, 0), (990, 0), (995, 0), (1000, 0), (1005, 0), (1010, 1), (1015, 1), (1020, 0), (1025, 0)]
Vdin1_21  din1_21  0 PWL (0n 0.0v 4.745n 0.0v 4.755n 1.0v 9.745n 1.0v 9.755n 0.0v 14.745n 0.0v 14.755n 0.0v 19.745n 0.0v 19.755n 0.0v 24.745n 0.0v 24.755n 0.0v 29.745n 0.0v 29.755n 0.0v 34.745n 0.0v 34.755n 0.0v 39.745n 0.0v 39.755n 0.0v 44.745n 0.0v 44.755n 0.0v 49.745n 0.0v 49.755n 0.0v 54.745n 0.0v 54.755n 0.0v 59.745n 0.0v 59.755n 1.0v 64.745n 1.0v 64.755n 1.0v 69.745n 1.0v 69.755n 1.0v 74.745n 1.0v 74.755n 1.0v 79.745n 1.0v 79.755n 0.0v 84.745n 0.0v 84.755n 0.0v 89.745n 0.0v 89.755n 0.0v 94.745n 0.0v 94.755n 0.0v 99.745n 0.0v 99.755n 0.0v 104.745n 0.0v 104.755n 0.0v 109.745n 0.0v 109.755n 0.0v 114.745n 0.0v 114.755n 0.0v 119.745n 0.0v 119.755n 0.0v 124.745n 0.0v 124.755n 0.0v 129.745n 0.0v 129.755n 1.0v 134.745n 1.0v 134.755n 1.0v 139.745n 1.0v 139.755n 1.0v 144.745n 1.0v 144.755n 0.0v 149.745n 0.0v 149.755n 0.0v 154.745n 0.0v 154.755n 0.0v 159.745n 0.0v 159.755n 0.0v 164.745n 0.0v 164.755n 0.0v 169.745n 0.0v 169.755n 0.0v 174.745n 0.0v 174.755n 1.0v 179.745n 1.0v 179.755n 0.0v 184.745n 0.0v 184.755n 0.0v 189.745n 0.0v 189.755n 0.0v 194.745n 0.0v 194.755n 0.0v 199.745n 0.0v 199.755n 0.0v 204.745n 0.0v 204.755n 0.0v 209.745n 0.0v 209.755n 0.0v 214.745n 0.0v 214.755n 0.0v 219.745n 0.0v 219.755n 0.0v 224.745n 0.0v 224.755n 0.0v 229.745n 0.0v 229.755n 0.0v 234.745n 0.0v 234.755n 0.0v 239.745n 0.0v 239.755n 0.0v 244.745n 0.0v 244.755n 0.0v 249.745n 0.0v 249.755n 0.0v 254.745n 0.0v 254.755n 0.0v 259.745n 0.0v 259.755n 0.0v 264.745n 0.0v 264.755n 0.0v 269.745n 0.0v 269.755n 0.0v 274.745n 0.0v 274.755n 0.0v 279.745n 0.0v 279.755n 0.0v 284.745n 0.0v 284.755n 1.0v 289.745n 1.0v 289.755n 1.0v 294.745n 1.0v 294.755n 1.0v 299.745n 1.0v 299.755n 0.0v 304.745n 0.0v 304.755n 0.0v 309.745n 0.0v 309.755n 0.0v 314.745n 0.0v 314.755n 0.0v 319.745n 0.0v 319.755n 0.0v 324.745n 0.0v 324.755n 0.0v 329.745n 0.0v 329.755n 0.0v 334.745n 0.0v 334.755n 0.0v 339.745n 0.0v 339.755n 0.0v 344.745n 0.0v 344.755n 0.0v 349.745n 0.0v 349.755n 0.0v 354.745n 0.0v 354.755n 0.0v 359.745n 0.0v 359.755n 0.0v 364.745n 0.0v 364.755n 0.0v 369.745n 0.0v 369.755n 0.0v 374.745n 0.0v 374.755n 0.0v 379.745n 0.0v 379.755n 1.0v 384.745n 1.0v 384.755n 1.0v 389.745n 1.0v 389.755n 0.0v 394.745n 0.0v 394.755n 0.0v 399.745n 0.0v 399.755n 0.0v 404.745n 0.0v 404.755n 0.0v 409.745n 0.0v 409.755n 0.0v 414.745n 0.0v 414.755n 0.0v 419.745n 0.0v 419.755n 1.0v 424.745n 1.0v 424.755n 1.0v 429.745n 1.0v 429.755n 1.0v 434.745n 1.0v 434.755n 1.0v 439.745n 1.0v 439.755n 1.0v 444.745n 1.0v 444.755n 1.0v 449.745n 1.0v 449.755n 1.0v 454.745n 1.0v 454.755n 1.0v 459.745n 1.0v 459.755n 1.0v 464.745n 1.0v 464.755n 0.0v 469.745n 0.0v 469.755n 0.0v 474.745n 0.0v 474.755n 0.0v 479.745n 0.0v 479.755n 0.0v 484.745n 0.0v 484.755n 1.0v 489.745n 1.0v 489.755n 1.0v 494.745n 1.0v 494.755n 1.0v 499.745n 1.0v 499.755n 1.0v 504.745n 1.0v 504.755n 1.0v 509.745n 1.0v 509.755n 1.0v 514.745n 1.0v 514.755n 1.0v 519.745n 1.0v 519.755n 1.0v 524.745n 1.0v 524.755n 1.0v 529.745n 1.0v 529.755n 1.0v 534.745n 1.0v 534.755n 1.0v 539.745n 1.0v 539.755n 1.0v 544.745n 1.0v 544.755n 1.0v 549.745n 1.0v 549.755n 1.0v 554.745n 1.0v 554.755n 1.0v 559.745n 1.0v 559.755n 1.0v 564.745n 1.0v 564.755n 1.0v 569.745n 1.0v 569.755n 1.0v 574.745n 1.0v 574.755n 1.0v 579.745n 1.0v 579.755n 1.0v 584.745n 1.0v 584.755n 0.0v 589.745n 0.0v 589.755n 0.0v 594.745n 0.0v 594.755n 0.0v 599.745n 0.0v 599.755n 0.0v 604.745n 0.0v 604.755n 1.0v 609.745n 1.0v 609.755n 1.0v 614.745n 1.0v 614.755n 0.0v 619.745n 0.0v 619.755n 0.0v 624.745n 0.0v 624.755n 0.0v 629.745n 0.0v 629.755n 0.0v 634.745n 0.0v 634.755n 0.0v 639.745n 0.0v 639.755n 0.0v 644.745n 0.0v 644.755n 0.0v 649.745n 0.0v 649.755n 0.0v 654.745n 0.0v 654.755n 0.0v 659.745n 0.0v 659.755n 0.0v 664.745n 0.0v 664.755n 0.0v 669.745n 0.0v 669.755n 0.0v 674.745n 0.0v 674.755n 0.0v 679.745n 0.0v 679.755n 0.0v 684.745n 0.0v 684.755n 0.0v 689.745n 0.0v 689.755n 0.0v 694.745n 0.0v 694.755n 0.0v 699.745n 0.0v 699.755n 0.0v 704.745n 0.0v 704.755n 0.0v 709.745n 0.0v 709.755n 0.0v 714.745n 0.0v 714.755n 0.0v 719.745n 0.0v 719.755n 0.0v 724.745n 0.0v 724.755n 0.0v 729.745n 0.0v 729.755n 0.0v 734.745n 0.0v 734.755n 0.0v 739.745n 0.0v 739.755n 0.0v 744.745n 0.0v 744.755n 0.0v 749.745n 0.0v 749.755n 0.0v 754.745n 0.0v 754.755n 0.0v 759.745n 0.0v 759.755n 0.0v 764.745n 0.0v 764.755n 1.0v 769.745n 1.0v 769.755n 1.0v 774.745n 1.0v 774.755n 1.0v 779.745n 1.0v 779.755n 1.0v 784.745n 1.0v 784.755n 1.0v 789.745n 1.0v 789.755n 0.0v 794.745n 0.0v 794.755n 0.0v 799.745n 0.0v 799.755n 0.0v 804.745n 0.0v 804.755n 0.0v 809.745n 0.0v 809.755n 1.0v 814.745n 1.0v 814.755n 1.0v 819.745n 1.0v 819.755n 1.0v 824.745n 1.0v 824.755n 1.0v 829.745n 1.0v 829.755n 1.0v 834.745n 1.0v 834.755n 1.0v 839.745n 1.0v 839.755n 1.0v 844.745n 1.0v 844.755n 1.0v 849.745n 1.0v 849.755n 1.0v 854.745n 1.0v 854.755n 1.0v 859.745n 1.0v 859.755n 1.0v 864.745n 1.0v 864.755n 1.0v 869.745n 1.0v 869.755n 1.0v 874.745n 1.0v 874.755n 1.0v 879.745n 1.0v 879.755n 1.0v 884.745n 1.0v 884.755n 1.0v 889.745n 1.0v 889.755n 1.0v 894.745n 1.0v 894.755n 1.0v 899.745n 1.0v 899.755n 0.0v 904.745n 0.0v 904.755n 1.0v 909.745n 1.0v 909.755n 1.0v 914.745n 1.0v 914.755n 1.0v 919.745n 1.0v 919.755n 1.0v 924.745n 1.0v 924.755n 0.0v 929.745n 0.0v 929.755n 1.0v 934.745n 1.0v 934.755n 1.0v 939.745n 1.0v 939.755n 1.0v 944.745n 1.0v 944.755n 0.0v 949.745n 0.0v 949.755n 0.0v 954.745n 0.0v 954.755n 0.0v 959.745n 0.0v 959.755n 0.0v 964.745n 0.0v 964.755n 0.0v 969.745n 0.0v 969.755n 0.0v 974.745n 0.0v 974.755n 0.0v 979.745n 0.0v 979.755n 0.0v 984.745n 0.0v 984.755n 0.0v 989.745n 0.0v 989.755n 0.0v 994.745n 0.0v 994.755n 0.0v 999.745n 0.0v 999.755n 0.0v 1004.745n 0.0v 1004.755n 0.0v 1009.745n 0.0v 1009.755n 1.0v 1014.745n 1.0v 1014.755n 1.0v 1019.745n 1.0v 1019.755n 0.0v 1024.745n 0.0v 1024.755n 0.0v )
* (time, data): [(0, 0), (5, 0), (10, 0), (15, 1), (20, 1), (25, 1), (30, 1), (35, 1), (40, 1), (45, 1), (50, 1), (55, 1), (60, 1), (65, 1), (70, 1), (75, 1), (80, 0), (85, 0), (90, 0), (95, 0), (100, 0), (105, 0), (110, 0), (115, 0), (120, 0), (125, 0), (130, 0), (135, 0), (140, 0), (145, 1), (150, 1), (155, 1), (160, 1), (165, 1), (170, 1), (175, 0), (180, 0), (185, 0), (190, 0), (195, 0), (200, 0), (205, 0), (210, 0), (215, 0), (220, 0), (225, 0), (230, 0), (235, 0), (240, 0), (245, 1), (250, 0), (255, 0), (260, 0), (265, 0), (270, 0), (275, 0), (280, 0), (285, 0), (290, 0), (295, 0), (300, 0), (305, 0), (310, 0), (315, 0), (320, 0), (325, 0), (330, 0), (335, 0), (340, 0), (345, 0), (350, 0), (355, 0), (360, 0), (365, 1), (370, 1), (375, 1), (380, 0), (385, 0), (390, 0), (395, 0), (400, 0), (405, 0), (410, 0), (415, 0), (420, 0), (425, 0), (430, 0), (435, 0), (440, 0), (445, 0), (450, 0), (455, 0), (460, 0), (465, 0), (470, 0), (475, 0), (480, 0), (485, 1), (490, 1), (495, 1), (500, 1), (505, 1), (510, 1), (515, 1), (520, 0), (525, 0), (530, 0), (535, 0), (540, 0), (545, 0), (550, 0), (555, 0), (560, 0), (565, 0), (570, 0), (575, 0), (580, 0), (585, 1), (590, 1), (595, 1), (600, 1), (605, 1), (610, 1), (615, 0), (620, 0), (625, 0), (630, 0), (635, 0), (640, 0), (645, 0), (650, 0), (655, 0), (660, 0), (665, 0), (670, 0), (675, 0), (680, 0), (685, 0), (690, 0), (695, 0), (700, 0), (705, 0), (710, 0), (715, 0), (720, 0), (725, 0), (730, 0), (735, 1), (740, 1), (745, 1), (750, 1), (755, 1), (760, 1), (765, 0), (770, 1), (775, 1), (780, 1), (785, 1), (790, 0), (795, 0), (800, 0), (805, 0), (810, 0), (815, 0), (820, 0), (825, 0), (830, 0), (835, 0), (840, 0), (845, 0), (850, 0), (855, 0), (860, 0), (865, 0), (870, 0), (875, 0), (880, 0), (885, 0), (890, 0), (895, 0), (900, 0), (905, 0), (910, 0), (915, 0), (920, 0), (925, 0), (930, 1), (935, 1), (940, 1), (945, 0), (950, 0), (955, 0), (960, 0), (965, 0), (970, 0), (975, 0), (980, 0), (985, 0), (990, 0), (995, 0), (1000, 0), (1005, 0), (1010, 0), (1015, 0), (1020, 0), (1025, 0)]
Vdin1_22  din1_22  0 PWL (0n 0.0v 4.745n 0.0v 4.755n 0.0v 9.745n 0.0v 9.755n 0.0v 14.745n 0.0v 14.755n 1.0v 19.745n 1.0v 19.755n 1.0v 24.745n 1.0v 24.755n 1.0v 29.745n 1.0v 29.755n 1.0v 34.745n 1.0v 34.755n 1.0v 39.745n 1.0v 39.755n 1.0v 44.745n 1.0v 44.755n 1.0v 49.745n 1.0v 49.755n 1.0v 54.745n 1.0v 54.755n 1.0v 59.745n 1.0v 59.755n 1.0v 64.745n 1.0v 64.755n 1.0v 69.745n 1.0v 69.755n 1.0v 74.745n 1.0v 74.755n 1.0v 79.745n 1.0v 79.755n 0.0v 84.745n 0.0v 84.755n 0.0v 89.745n 0.0v 89.755n 0.0v 94.745n 0.0v 94.755n 0.0v 99.745n 0.0v 99.755n 0.0v 104.745n 0.0v 104.755n 0.0v 109.745n 0.0v 109.755n 0.0v 114.745n 0.0v 114.755n 0.0v 119.745n 0.0v 119.755n 0.0v 124.745n 0.0v 124.755n 0.0v 129.745n 0.0v 129.755n 0.0v 134.745n 0.0v 134.755n 0.0v 139.745n 0.0v 139.755n 0.0v 144.745n 0.0v 144.755n 1.0v 149.745n 1.0v 149.755n 1.0v 154.745n 1.0v 154.755n 1.0v 159.745n 1.0v 159.755n 1.0v 164.745n 1.0v 164.755n 1.0v 169.745n 1.0v 169.755n 1.0v 174.745n 1.0v 174.755n 0.0v 179.745n 0.0v 179.755n 0.0v 184.745n 0.0v 184.755n 0.0v 189.745n 0.0v 189.755n 0.0v 194.745n 0.0v 194.755n 0.0v 199.745n 0.0v 199.755n 0.0v 204.745n 0.0v 204.755n 0.0v 209.745n 0.0v 209.755n 0.0v 214.745n 0.0v 214.755n 0.0v 219.745n 0.0v 219.755n 0.0v 224.745n 0.0v 224.755n 0.0v 229.745n 0.0v 229.755n 0.0v 234.745n 0.0v 234.755n 0.0v 239.745n 0.0v 239.755n 0.0v 244.745n 0.0v 244.755n 1.0v 249.745n 1.0v 249.755n 0.0v 254.745n 0.0v 254.755n 0.0v 259.745n 0.0v 259.755n 0.0v 264.745n 0.0v 264.755n 0.0v 269.745n 0.0v 269.755n 0.0v 274.745n 0.0v 274.755n 0.0v 279.745n 0.0v 279.755n 0.0v 284.745n 0.0v 284.755n 0.0v 289.745n 0.0v 289.755n 0.0v 294.745n 0.0v 294.755n 0.0v 299.745n 0.0v 299.755n 0.0v 304.745n 0.0v 304.755n 0.0v 309.745n 0.0v 309.755n 0.0v 314.745n 0.0v 314.755n 0.0v 319.745n 0.0v 319.755n 0.0v 324.745n 0.0v 324.755n 0.0v 329.745n 0.0v 329.755n 0.0v 334.745n 0.0v 334.755n 0.0v 339.745n 0.0v 339.755n 0.0v 344.745n 0.0v 344.755n 0.0v 349.745n 0.0v 349.755n 0.0v 354.745n 0.0v 354.755n 0.0v 359.745n 0.0v 359.755n 0.0v 364.745n 0.0v 364.755n 1.0v 369.745n 1.0v 369.755n 1.0v 374.745n 1.0v 374.755n 1.0v 379.745n 1.0v 379.755n 0.0v 384.745n 0.0v 384.755n 0.0v 389.745n 0.0v 389.755n 0.0v 394.745n 0.0v 394.755n 0.0v 399.745n 0.0v 399.755n 0.0v 404.745n 0.0v 404.755n 0.0v 409.745n 0.0v 409.755n 0.0v 414.745n 0.0v 414.755n 0.0v 419.745n 0.0v 419.755n 0.0v 424.745n 0.0v 424.755n 0.0v 429.745n 0.0v 429.755n 0.0v 434.745n 0.0v 434.755n 0.0v 439.745n 0.0v 439.755n 0.0v 444.745n 0.0v 444.755n 0.0v 449.745n 0.0v 449.755n 0.0v 454.745n 0.0v 454.755n 0.0v 459.745n 0.0v 459.755n 0.0v 464.745n 0.0v 464.755n 0.0v 469.745n 0.0v 469.755n 0.0v 474.745n 0.0v 474.755n 0.0v 479.745n 0.0v 479.755n 0.0v 484.745n 0.0v 484.755n 1.0v 489.745n 1.0v 489.755n 1.0v 494.745n 1.0v 494.755n 1.0v 499.745n 1.0v 499.755n 1.0v 504.745n 1.0v 504.755n 1.0v 509.745n 1.0v 509.755n 1.0v 514.745n 1.0v 514.755n 1.0v 519.745n 1.0v 519.755n 0.0v 524.745n 0.0v 524.755n 0.0v 529.745n 0.0v 529.755n 0.0v 534.745n 0.0v 534.755n 0.0v 539.745n 0.0v 539.755n 0.0v 544.745n 0.0v 544.755n 0.0v 549.745n 0.0v 549.755n 0.0v 554.745n 0.0v 554.755n 0.0v 559.745n 0.0v 559.755n 0.0v 564.745n 0.0v 564.755n 0.0v 569.745n 0.0v 569.755n 0.0v 574.745n 0.0v 574.755n 0.0v 579.745n 0.0v 579.755n 0.0v 584.745n 0.0v 584.755n 1.0v 589.745n 1.0v 589.755n 1.0v 594.745n 1.0v 594.755n 1.0v 599.745n 1.0v 599.755n 1.0v 604.745n 1.0v 604.755n 1.0v 609.745n 1.0v 609.755n 1.0v 614.745n 1.0v 614.755n 0.0v 619.745n 0.0v 619.755n 0.0v 624.745n 0.0v 624.755n 0.0v 629.745n 0.0v 629.755n 0.0v 634.745n 0.0v 634.755n 0.0v 639.745n 0.0v 639.755n 0.0v 644.745n 0.0v 644.755n 0.0v 649.745n 0.0v 649.755n 0.0v 654.745n 0.0v 654.755n 0.0v 659.745n 0.0v 659.755n 0.0v 664.745n 0.0v 664.755n 0.0v 669.745n 0.0v 669.755n 0.0v 674.745n 0.0v 674.755n 0.0v 679.745n 0.0v 679.755n 0.0v 684.745n 0.0v 684.755n 0.0v 689.745n 0.0v 689.755n 0.0v 694.745n 0.0v 694.755n 0.0v 699.745n 0.0v 699.755n 0.0v 704.745n 0.0v 704.755n 0.0v 709.745n 0.0v 709.755n 0.0v 714.745n 0.0v 714.755n 0.0v 719.745n 0.0v 719.755n 0.0v 724.745n 0.0v 724.755n 0.0v 729.745n 0.0v 729.755n 0.0v 734.745n 0.0v 734.755n 1.0v 739.745n 1.0v 739.755n 1.0v 744.745n 1.0v 744.755n 1.0v 749.745n 1.0v 749.755n 1.0v 754.745n 1.0v 754.755n 1.0v 759.745n 1.0v 759.755n 1.0v 764.745n 1.0v 764.755n 0.0v 769.745n 0.0v 769.755n 1.0v 774.745n 1.0v 774.755n 1.0v 779.745n 1.0v 779.755n 1.0v 784.745n 1.0v 784.755n 1.0v 789.745n 1.0v 789.755n 0.0v 794.745n 0.0v 794.755n 0.0v 799.745n 0.0v 799.755n 0.0v 804.745n 0.0v 804.755n 0.0v 809.745n 0.0v 809.755n 0.0v 814.745n 0.0v 814.755n 0.0v 819.745n 0.0v 819.755n 0.0v 824.745n 0.0v 824.755n 0.0v 829.745n 0.0v 829.755n 0.0v 834.745n 0.0v 834.755n 0.0v 839.745n 0.0v 839.755n 0.0v 844.745n 0.0v 844.755n 0.0v 849.745n 0.0v 849.755n 0.0v 854.745n 0.0v 854.755n 0.0v 859.745n 0.0v 859.755n 0.0v 864.745n 0.0v 864.755n 0.0v 869.745n 0.0v 869.755n 0.0v 874.745n 0.0v 874.755n 0.0v 879.745n 0.0v 879.755n 0.0v 884.745n 0.0v 884.755n 0.0v 889.745n 0.0v 889.755n 0.0v 894.745n 0.0v 894.755n 0.0v 899.745n 0.0v 899.755n 0.0v 904.745n 0.0v 904.755n 0.0v 909.745n 0.0v 909.755n 0.0v 914.745n 0.0v 914.755n 0.0v 919.745n 0.0v 919.755n 0.0v 924.745n 0.0v 924.755n 0.0v 929.745n 0.0v 929.755n 1.0v 934.745n 1.0v 934.755n 1.0v 939.745n 1.0v 939.755n 1.0v 944.745n 1.0v 944.755n 0.0v 949.745n 0.0v 949.755n 0.0v 954.745n 0.0v 954.755n 0.0v 959.745n 0.0v 959.755n 0.0v 964.745n 0.0v 964.755n 0.0v 969.745n 0.0v 969.755n 0.0v 974.745n 0.0v 974.755n 0.0v 979.745n 0.0v 979.755n 0.0v 984.745n 0.0v 984.755n 0.0v 989.745n 0.0v 989.755n 0.0v 994.745n 0.0v 994.755n 0.0v 999.745n 0.0v 999.755n 0.0v 1004.745n 0.0v 1004.755n 0.0v 1009.745n 0.0v 1009.755n 0.0v 1014.745n 0.0v 1014.755n 0.0v 1019.745n 0.0v 1019.755n 0.0v 1024.745n 0.0v 1024.755n 0.0v )
* (time, data): [(0, 0), (5, 1), (10, 0), (15, 0), (20, 0), (25, 0), (30, 0), (35, 0), (40, 0), (45, 0), (50, 0), (55, 0), (60, 0), (65, 0), (70, 0), (75, 0), (80, 1), (85, 1), (90, 1), (95, 1), (100, 1), (105, 1), (110, 1), (115, 1), (120, 1), (125, 1), (130, 0), (135, 0), (140, 0), (145, 1), (150, 1), (155, 1), (160, 1), (165, 1), (170, 1), (175, 1), (180, 1), (185, 1), (190, 1), (195, 1), (200, 1), (205, 1), (210, 1), (215, 1), (220, 1), (225, 1), (230, 1), (235, 1), (240, 1), (245, 0), (250, 1), (255, 1), (260, 1), (265, 1), (270, 1), (275, 1), (280, 1), (285, 1), (290, 1), (295, 1), (300, 1), (305, 1), (310, 1), (315, 1), (320, 1), (325, 1), (330, 1), (335, 1), (340, 1), (345, 1), (350, 1), (355, 1), (360, 1), (365, 1), (370, 1), (375, 1), (380, 1), (385, 1), (390, 0), (395, 1), (400, 1), (405, 1), (410, 1), (415, 1), (420, 1), (425, 1), (430, 1), (435, 1), (440, 1), (445, 1), (450, 1), (455, 1), (460, 1), (465, 1), (470, 1), (475, 1), (480, 1), (485, 0), (490, 0), (495, 0), (500, 0), (505, 1), (510, 1), (515, 1), (520, 0), (525, 0), (530, 0), (535, 0), (540, 0), (545, 0), (550, 0), (555, 0), (560, 0), (565, 0), (570, 0), (575, 0), (580, 1), (585, 0), (590, 0), (595, 0), (600, 0), (605, 1), (610, 1), (615, 0), (620, 0), (625, 0), (630, 0), (635, 0), (640, 0), (645, 0), (650, 0), (655, 0), (660, 0), (665, 0), (670, 0), (675, 0), (680, 0), (685, 0), (690, 0), (695, 0), (700, 0), (705, 0), (710, 0), (715, 0), (720, 0), (725, 0), (730, 0), (735, 0), (740, 0), (745, 0), (750, 0), (755, 0), (760, 0), (765, 0), (770, 1), (775, 1), (780, 1), (785, 1), (790, 1), (795, 1), (800, 1), (805, 1), (810, 1), (815, 1), (820, 1), (825, 1), (830, 0), (835, 0), (840, 0), (845, 0), (850, 0), (855, 0), (860, 1), (865, 1), (870, 1), (875, 1), (880, 0), (885, 0), (890, 0), (895, 0), (900, 0), (905, 1), (910, 1), (915, 1), (920, 1), (925, 0), (930, 1), (935, 1), (940, 1), (945, 0), (950, 0), (955, 0), (960, 0), (965, 0), (970, 0), (975, 0), (980, 0), (985, 0), (990, 0), (995, 0), (1000, 0), (1005, 0), (1010, 1), (1015, 1), (1020, 0), (1025, 0)]
Vdin1_23  din1_23  0 PWL (0n 0.0v 4.745n 0.0v 4.755n 1.0v 9.745n 1.0v 9.755n 0.0v 14.745n 0.0v 14.755n 0.0v 19.745n 0.0v 19.755n 0.0v 24.745n 0.0v 24.755n 0.0v 29.745n 0.0v 29.755n 0.0v 34.745n 0.0v 34.755n 0.0v 39.745n 0.0v 39.755n 0.0v 44.745n 0.0v 44.755n 0.0v 49.745n 0.0v 49.755n 0.0v 54.745n 0.0v 54.755n 0.0v 59.745n 0.0v 59.755n 0.0v 64.745n 0.0v 64.755n 0.0v 69.745n 0.0v 69.755n 0.0v 74.745n 0.0v 74.755n 0.0v 79.745n 0.0v 79.755n 1.0v 84.745n 1.0v 84.755n 1.0v 89.745n 1.0v 89.755n 1.0v 94.745n 1.0v 94.755n 1.0v 99.745n 1.0v 99.755n 1.0v 104.745n 1.0v 104.755n 1.0v 109.745n 1.0v 109.755n 1.0v 114.745n 1.0v 114.755n 1.0v 119.745n 1.0v 119.755n 1.0v 124.745n 1.0v 124.755n 1.0v 129.745n 1.0v 129.755n 0.0v 134.745n 0.0v 134.755n 0.0v 139.745n 0.0v 139.755n 0.0v 144.745n 0.0v 144.755n 1.0v 149.745n 1.0v 149.755n 1.0v 154.745n 1.0v 154.755n 1.0v 159.745n 1.0v 159.755n 1.0v 164.745n 1.0v 164.755n 1.0v 169.745n 1.0v 169.755n 1.0v 174.745n 1.0v 174.755n 1.0v 179.745n 1.0v 179.755n 1.0v 184.745n 1.0v 184.755n 1.0v 189.745n 1.0v 189.755n 1.0v 194.745n 1.0v 194.755n 1.0v 199.745n 1.0v 199.755n 1.0v 204.745n 1.0v 204.755n 1.0v 209.745n 1.0v 209.755n 1.0v 214.745n 1.0v 214.755n 1.0v 219.745n 1.0v 219.755n 1.0v 224.745n 1.0v 224.755n 1.0v 229.745n 1.0v 229.755n 1.0v 234.745n 1.0v 234.755n 1.0v 239.745n 1.0v 239.755n 1.0v 244.745n 1.0v 244.755n 0.0v 249.745n 0.0v 249.755n 1.0v 254.745n 1.0v 254.755n 1.0v 259.745n 1.0v 259.755n 1.0v 264.745n 1.0v 264.755n 1.0v 269.745n 1.0v 269.755n 1.0v 274.745n 1.0v 274.755n 1.0v 279.745n 1.0v 279.755n 1.0v 284.745n 1.0v 284.755n 1.0v 289.745n 1.0v 289.755n 1.0v 294.745n 1.0v 294.755n 1.0v 299.745n 1.0v 299.755n 1.0v 304.745n 1.0v 304.755n 1.0v 309.745n 1.0v 309.755n 1.0v 314.745n 1.0v 314.755n 1.0v 319.745n 1.0v 319.755n 1.0v 324.745n 1.0v 324.755n 1.0v 329.745n 1.0v 329.755n 1.0v 334.745n 1.0v 334.755n 1.0v 339.745n 1.0v 339.755n 1.0v 344.745n 1.0v 344.755n 1.0v 349.745n 1.0v 349.755n 1.0v 354.745n 1.0v 354.755n 1.0v 359.745n 1.0v 359.755n 1.0v 364.745n 1.0v 364.755n 1.0v 369.745n 1.0v 369.755n 1.0v 374.745n 1.0v 374.755n 1.0v 379.745n 1.0v 379.755n 1.0v 384.745n 1.0v 384.755n 1.0v 389.745n 1.0v 389.755n 0.0v 394.745n 0.0v 394.755n 1.0v 399.745n 1.0v 399.755n 1.0v 404.745n 1.0v 404.755n 1.0v 409.745n 1.0v 409.755n 1.0v 414.745n 1.0v 414.755n 1.0v 419.745n 1.0v 419.755n 1.0v 424.745n 1.0v 424.755n 1.0v 429.745n 1.0v 429.755n 1.0v 434.745n 1.0v 434.755n 1.0v 439.745n 1.0v 439.755n 1.0v 444.745n 1.0v 444.755n 1.0v 449.745n 1.0v 449.755n 1.0v 454.745n 1.0v 454.755n 1.0v 459.745n 1.0v 459.755n 1.0v 464.745n 1.0v 464.755n 1.0v 469.745n 1.0v 469.755n 1.0v 474.745n 1.0v 474.755n 1.0v 479.745n 1.0v 479.755n 1.0v 484.745n 1.0v 484.755n 0.0v 489.745n 0.0v 489.755n 0.0v 494.745n 0.0v 494.755n 0.0v 499.745n 0.0v 499.755n 0.0v 504.745n 0.0v 504.755n 1.0v 509.745n 1.0v 509.755n 1.0v 514.745n 1.0v 514.755n 1.0v 519.745n 1.0v 519.755n 0.0v 524.745n 0.0v 524.755n 0.0v 529.745n 0.0v 529.755n 0.0v 534.745n 0.0v 534.755n 0.0v 539.745n 0.0v 539.755n 0.0v 544.745n 0.0v 544.755n 0.0v 549.745n 0.0v 549.755n 0.0v 554.745n 0.0v 554.755n 0.0v 559.745n 0.0v 559.755n 0.0v 564.745n 0.0v 564.755n 0.0v 569.745n 0.0v 569.755n 0.0v 574.745n 0.0v 574.755n 0.0v 579.745n 0.0v 579.755n 1.0v 584.745n 1.0v 584.755n 0.0v 589.745n 0.0v 589.755n 0.0v 594.745n 0.0v 594.755n 0.0v 599.745n 0.0v 599.755n 0.0v 604.745n 0.0v 604.755n 1.0v 609.745n 1.0v 609.755n 1.0v 614.745n 1.0v 614.755n 0.0v 619.745n 0.0v 619.755n 0.0v 624.745n 0.0v 624.755n 0.0v 629.745n 0.0v 629.755n 0.0v 634.745n 0.0v 634.755n 0.0v 639.745n 0.0v 639.755n 0.0v 644.745n 0.0v 644.755n 0.0v 649.745n 0.0v 649.755n 0.0v 654.745n 0.0v 654.755n 0.0v 659.745n 0.0v 659.755n 0.0v 664.745n 0.0v 664.755n 0.0v 669.745n 0.0v 669.755n 0.0v 674.745n 0.0v 674.755n 0.0v 679.745n 0.0v 679.755n 0.0v 684.745n 0.0v 684.755n 0.0v 689.745n 0.0v 689.755n 0.0v 694.745n 0.0v 694.755n 0.0v 699.745n 0.0v 699.755n 0.0v 704.745n 0.0v 704.755n 0.0v 709.745n 0.0v 709.755n 0.0v 714.745n 0.0v 714.755n 0.0v 719.745n 0.0v 719.755n 0.0v 724.745n 0.0v 724.755n 0.0v 729.745n 0.0v 729.755n 0.0v 734.745n 0.0v 734.755n 0.0v 739.745n 0.0v 739.755n 0.0v 744.745n 0.0v 744.755n 0.0v 749.745n 0.0v 749.755n 0.0v 754.745n 0.0v 754.755n 0.0v 759.745n 0.0v 759.755n 0.0v 764.745n 0.0v 764.755n 0.0v 769.745n 0.0v 769.755n 1.0v 774.745n 1.0v 774.755n 1.0v 779.745n 1.0v 779.755n 1.0v 784.745n 1.0v 784.755n 1.0v 789.745n 1.0v 789.755n 1.0v 794.745n 1.0v 794.755n 1.0v 799.745n 1.0v 799.755n 1.0v 804.745n 1.0v 804.755n 1.0v 809.745n 1.0v 809.755n 1.0v 814.745n 1.0v 814.755n 1.0v 819.745n 1.0v 819.755n 1.0v 824.745n 1.0v 824.755n 1.0v 829.745n 1.0v 829.755n 0.0v 834.745n 0.0v 834.755n 0.0v 839.745n 0.0v 839.755n 0.0v 844.745n 0.0v 844.755n 0.0v 849.745n 0.0v 849.755n 0.0v 854.745n 0.0v 854.755n 0.0v 859.745n 0.0v 859.755n 1.0v 864.745n 1.0v 864.755n 1.0v 869.745n 1.0v 869.755n 1.0v 874.745n 1.0v 874.755n 1.0v 879.745n 1.0v 879.755n 0.0v 884.745n 0.0v 884.755n 0.0v 889.745n 0.0v 889.755n 0.0v 894.745n 0.0v 894.755n 0.0v 899.745n 0.0v 899.755n 0.0v 904.745n 0.0v 904.755n 1.0v 909.745n 1.0v 909.755n 1.0v 914.745n 1.0v 914.755n 1.0v 919.745n 1.0v 919.755n 1.0v 924.745n 1.0v 924.755n 0.0v 929.745n 0.0v 929.755n 1.0v 934.745n 1.0v 934.755n 1.0v 939.745n 1.0v 939.755n 1.0v 944.745n 1.0v 944.755n 0.0v 949.745n 0.0v 949.755n 0.0v 954.745n 0.0v 954.755n 0.0v 959.745n 0.0v 959.755n 0.0v 964.745n 0.0v 964.755n 0.0v 969.745n 0.0v 969.755n 0.0v 974.745n 0.0v 974.755n 0.0v 979.745n 0.0v 979.755n 0.0v 984.745n 0.0v 984.755n 0.0v 989.745n 0.0v 989.755n 0.0v 994.745n 0.0v 994.755n 0.0v 999.745n 0.0v 999.755n 0.0v 1004.745n 0.0v 1004.755n 0.0v 1009.745n 0.0v 1009.755n 1.0v 1014.745n 1.0v 1014.755n 1.0v 1019.745n 1.0v 1019.755n 0.0v 1024.745n 0.0v 1024.755n 0.0v )
* (time, data): [(0, 0), (5, 1), (10, 1), (15, 1), (20, 1), (25, 1), (30, 1), (35, 1), (40, 1), (45, 1), (50, 1), (55, 1), (60, 1), (65, 1), (70, 1), (75, 1), (80, 0), (85, 0), (90, 1), (95, 1), (100, 1), (105, 1), (110, 1), (115, 1), (120, 1), (125, 1), (130, 1), (135, 1), (140, 1), (145, 0), (150, 0), (155, 0), (160, 0), (165, 0), (170, 0), (175, 0), (180, 0), (185, 0), (190, 0), (195, 0), (200, 0), (205, 0), (210, 0), (215, 0), (220, 0), (225, 0), (230, 0), (235, 0), (240, 0), (245, 0), (250, 1), (255, 1), (260, 1), (265, 1), (270, 1), (275, 1), (280, 1), (285, 0), (290, 0), (295, 0), (300, 1), (305, 1), (310, 1), (315, 1), (320, 1), (325, 1), (330, 1), (335, 1), (340, 1), (345, 1), (350, 1), (355, 1), (360, 1), (365, 1), (370, 1), (375, 1), (380, 1), (385, 1), (390, 0), (395, 0), (400, 0), (405, 0), (410, 0), (415, 0), (420, 1), (425, 1), (430, 1), (435, 1), (440, 1), (445, 1), (450, 1), (455, 1), (460, 1), (465, 0), (470, 0), (475, 0), (480, 0), (485, 1), (490, 1), (495, 1), (500, 1), (505, 1), (510, 1), (515, 1), (520, 0), (525, 0), (530, 0), (535, 0), (540, 0), (545, 0), (550, 0), (555, 0), (560, 0), (565, 0), (570, 0), (575, 0), (580, 0), (585, 1), (590, 1), (595, 1), (600, 1), (605, 1), (610, 1), (615, 1), (620, 1), (625, 1), (630, 1), (635, 1), (640, 1), (645, 1), (650, 1), (655, 1), (660, 1), (665, 1), (670, 1), (675, 1), (680, 1), (685, 1), (690, 0), (695, 0), (700, 0), (705, 0), (710, 0), (715, 0), (720, 0), (725, 0), (730, 1), (735, 1), (740, 1), (745, 1), (750, 1), (755, 1), (760, 0), (765, 0), (770, 1), (775, 1), (780, 1), (785, 1), (790, 1), (795, 1), (800, 1), (805, 1), (810, 0), (815, 0), (820, 0), (825, 0), (830, 0), (835, 0), (840, 0), (845, 0), (850, 0), (855, 0), (860, 1), (865, 1), (870, 1), (875, 1), (880, 0), (885, 0), (890, 0), (895, 0), (900, 0), (905, 1), (910, 1), (915, 1), (920, 1), (925, 1), (930, 0), (935, 0), (940, 0), (945, 1), (950, 1), (955, 1), (960, 1), (965, 1), (970, 1), (975, 1), (980, 1), (985, 1), (990, 1), (995, 1), (1000, 1), (1005, 1), (1010, 0), (1015, 0), (1020, 0), (1025, 0)]
Vdin1_24  din1_24  0 PWL (0n 0.0v 4.745n 0.0v 4.755n 1.0v 9.745n 1.0v 9.755n 1.0v 14.745n 1.0v 14.755n 1.0v 19.745n 1.0v 19.755n 1.0v 24.745n 1.0v 24.755n 1.0v 29.745n 1.0v 29.755n 1.0v 34.745n 1.0v 34.755n 1.0v 39.745n 1.0v 39.755n 1.0v 44.745n 1.0v 44.755n 1.0v 49.745n 1.0v 49.755n 1.0v 54.745n 1.0v 54.755n 1.0v 59.745n 1.0v 59.755n 1.0v 64.745n 1.0v 64.755n 1.0v 69.745n 1.0v 69.755n 1.0v 74.745n 1.0v 74.755n 1.0v 79.745n 1.0v 79.755n 0.0v 84.745n 0.0v 84.755n 0.0v 89.745n 0.0v 89.755n 1.0v 94.745n 1.0v 94.755n 1.0v 99.745n 1.0v 99.755n 1.0v 104.745n 1.0v 104.755n 1.0v 109.745n 1.0v 109.755n 1.0v 114.745n 1.0v 114.755n 1.0v 119.745n 1.0v 119.755n 1.0v 124.745n 1.0v 124.755n 1.0v 129.745n 1.0v 129.755n 1.0v 134.745n 1.0v 134.755n 1.0v 139.745n 1.0v 139.755n 1.0v 144.745n 1.0v 144.755n 0.0v 149.745n 0.0v 149.755n 0.0v 154.745n 0.0v 154.755n 0.0v 159.745n 0.0v 159.755n 0.0v 164.745n 0.0v 164.755n 0.0v 169.745n 0.0v 169.755n 0.0v 174.745n 0.0v 174.755n 0.0v 179.745n 0.0v 179.755n 0.0v 184.745n 0.0v 184.755n 0.0v 189.745n 0.0v 189.755n 0.0v 194.745n 0.0v 194.755n 0.0v 199.745n 0.0v 199.755n 0.0v 204.745n 0.0v 204.755n 0.0v 209.745n 0.0v 209.755n 0.0v 214.745n 0.0v 214.755n 0.0v 219.745n 0.0v 219.755n 0.0v 224.745n 0.0v 224.755n 0.0v 229.745n 0.0v 229.755n 0.0v 234.745n 0.0v 234.755n 0.0v 239.745n 0.0v 239.755n 0.0v 244.745n 0.0v 244.755n 0.0v 249.745n 0.0v 249.755n 1.0v 254.745n 1.0v 254.755n 1.0v 259.745n 1.0v 259.755n 1.0v 264.745n 1.0v 264.755n 1.0v 269.745n 1.0v 269.755n 1.0v 274.745n 1.0v 274.755n 1.0v 279.745n 1.0v 279.755n 1.0v 284.745n 1.0v 284.755n 0.0v 289.745n 0.0v 289.755n 0.0v 294.745n 0.0v 294.755n 0.0v 299.745n 0.0v 299.755n 1.0v 304.745n 1.0v 304.755n 1.0v 309.745n 1.0v 309.755n 1.0v 314.745n 1.0v 314.755n 1.0v 319.745n 1.0v 319.755n 1.0v 324.745n 1.0v 324.755n 1.0v 329.745n 1.0v 329.755n 1.0v 334.745n 1.0v 334.755n 1.0v 339.745n 1.0v 339.755n 1.0v 344.745n 1.0v 344.755n 1.0v 349.745n 1.0v 349.755n 1.0v 354.745n 1.0v 354.755n 1.0v 359.745n 1.0v 359.755n 1.0v 364.745n 1.0v 364.755n 1.0v 369.745n 1.0v 369.755n 1.0v 374.745n 1.0v 374.755n 1.0v 379.745n 1.0v 379.755n 1.0v 384.745n 1.0v 384.755n 1.0v 389.745n 1.0v 389.755n 0.0v 394.745n 0.0v 394.755n 0.0v 399.745n 0.0v 399.755n 0.0v 404.745n 0.0v 404.755n 0.0v 409.745n 0.0v 409.755n 0.0v 414.745n 0.0v 414.755n 0.0v 419.745n 0.0v 419.755n 1.0v 424.745n 1.0v 424.755n 1.0v 429.745n 1.0v 429.755n 1.0v 434.745n 1.0v 434.755n 1.0v 439.745n 1.0v 439.755n 1.0v 444.745n 1.0v 444.755n 1.0v 449.745n 1.0v 449.755n 1.0v 454.745n 1.0v 454.755n 1.0v 459.745n 1.0v 459.755n 1.0v 464.745n 1.0v 464.755n 0.0v 469.745n 0.0v 469.755n 0.0v 474.745n 0.0v 474.755n 0.0v 479.745n 0.0v 479.755n 0.0v 484.745n 0.0v 484.755n 1.0v 489.745n 1.0v 489.755n 1.0v 494.745n 1.0v 494.755n 1.0v 499.745n 1.0v 499.755n 1.0v 504.745n 1.0v 504.755n 1.0v 509.745n 1.0v 509.755n 1.0v 514.745n 1.0v 514.755n 1.0v 519.745n 1.0v 519.755n 0.0v 524.745n 0.0v 524.755n 0.0v 529.745n 0.0v 529.755n 0.0v 534.745n 0.0v 534.755n 0.0v 539.745n 0.0v 539.755n 0.0v 544.745n 0.0v 544.755n 0.0v 549.745n 0.0v 549.755n 0.0v 554.745n 0.0v 554.755n 0.0v 559.745n 0.0v 559.755n 0.0v 564.745n 0.0v 564.755n 0.0v 569.745n 0.0v 569.755n 0.0v 574.745n 0.0v 574.755n 0.0v 579.745n 0.0v 579.755n 0.0v 584.745n 0.0v 584.755n 1.0v 589.745n 1.0v 589.755n 1.0v 594.745n 1.0v 594.755n 1.0v 599.745n 1.0v 599.755n 1.0v 604.745n 1.0v 604.755n 1.0v 609.745n 1.0v 609.755n 1.0v 614.745n 1.0v 614.755n 1.0v 619.745n 1.0v 619.755n 1.0v 624.745n 1.0v 624.755n 1.0v 629.745n 1.0v 629.755n 1.0v 634.745n 1.0v 634.755n 1.0v 639.745n 1.0v 639.755n 1.0v 644.745n 1.0v 644.755n 1.0v 649.745n 1.0v 649.755n 1.0v 654.745n 1.0v 654.755n 1.0v 659.745n 1.0v 659.755n 1.0v 664.745n 1.0v 664.755n 1.0v 669.745n 1.0v 669.755n 1.0v 674.745n 1.0v 674.755n 1.0v 679.745n 1.0v 679.755n 1.0v 684.745n 1.0v 684.755n 1.0v 689.745n 1.0v 689.755n 0.0v 694.745n 0.0v 694.755n 0.0v 699.745n 0.0v 699.755n 0.0v 704.745n 0.0v 704.755n 0.0v 709.745n 0.0v 709.755n 0.0v 714.745n 0.0v 714.755n 0.0v 719.745n 0.0v 719.755n 0.0v 724.745n 0.0v 724.755n 0.0v 729.745n 0.0v 729.755n 1.0v 734.745n 1.0v 734.755n 1.0v 739.745n 1.0v 739.755n 1.0v 744.745n 1.0v 744.755n 1.0v 749.745n 1.0v 749.755n 1.0v 754.745n 1.0v 754.755n 1.0v 759.745n 1.0v 759.755n 0.0v 764.745n 0.0v 764.755n 0.0v 769.745n 0.0v 769.755n 1.0v 774.745n 1.0v 774.755n 1.0v 779.745n 1.0v 779.755n 1.0v 784.745n 1.0v 784.755n 1.0v 789.745n 1.0v 789.755n 1.0v 794.745n 1.0v 794.755n 1.0v 799.745n 1.0v 799.755n 1.0v 804.745n 1.0v 804.755n 1.0v 809.745n 1.0v 809.755n 0.0v 814.745n 0.0v 814.755n 0.0v 819.745n 0.0v 819.755n 0.0v 824.745n 0.0v 824.755n 0.0v 829.745n 0.0v 829.755n 0.0v 834.745n 0.0v 834.755n 0.0v 839.745n 0.0v 839.755n 0.0v 844.745n 0.0v 844.755n 0.0v 849.745n 0.0v 849.755n 0.0v 854.745n 0.0v 854.755n 0.0v 859.745n 0.0v 859.755n 1.0v 864.745n 1.0v 864.755n 1.0v 869.745n 1.0v 869.755n 1.0v 874.745n 1.0v 874.755n 1.0v 879.745n 1.0v 879.755n 0.0v 884.745n 0.0v 884.755n 0.0v 889.745n 0.0v 889.755n 0.0v 894.745n 0.0v 894.755n 0.0v 899.745n 0.0v 899.755n 0.0v 904.745n 0.0v 904.755n 1.0v 909.745n 1.0v 909.755n 1.0v 914.745n 1.0v 914.755n 1.0v 919.745n 1.0v 919.755n 1.0v 924.745n 1.0v 924.755n 1.0v 929.745n 1.0v 929.755n 0.0v 934.745n 0.0v 934.755n 0.0v 939.745n 0.0v 939.755n 0.0v 944.745n 0.0v 944.755n 1.0v 949.745n 1.0v 949.755n 1.0v 954.745n 1.0v 954.755n 1.0v 959.745n 1.0v 959.755n 1.0v 964.745n 1.0v 964.755n 1.0v 969.745n 1.0v 969.755n 1.0v 974.745n 1.0v 974.755n 1.0v 979.745n 1.0v 979.755n 1.0v 984.745n 1.0v 984.755n 1.0v 989.745n 1.0v 989.755n 1.0v 994.745n 1.0v 994.755n 1.0v 999.745n 1.0v 999.755n 1.0v 1004.745n 1.0v 1004.755n 1.0v 1009.745n 1.0v 1009.755n 0.0v 1014.745n 0.0v 1014.755n 0.0v 1019.745n 0.0v 1019.755n 0.0v 1024.745n 0.0v 1024.755n 0.0v )
* (time, data): [(0, 0), (5, 0), (10, 0), (15, 1), (20, 1), (25, 1), (30, 1), (35, 1), (40, 1), (45, 1), (50, 1), (55, 1), (60, 1), (65, 1), (70, 1), (75, 1), (80, 0), (85, 0), (90, 1), (95, 1), (100, 1), (105, 1), (110, 1), (115, 1), (120, 1), (125, 1), (130, 0), (135, 0), (140, 0), (145, 1), (150, 1), (155, 1), (160, 1), (165, 1), (170, 1), (175, 0), (180, 1), (185, 1), (190, 1), (195, 1), (200, 1), (205, 1), (210, 1), (215, 1), (220, 1), (225, 1), (230, 1), (235, 1), (240, 1), (245, 1), (250, 1), (255, 1), (260, 1), (265, 1), (270, 1), (275, 1), (280, 1), (285, 0), (290, 0), (295, 0), (300, 0), (305, 0), (310, 0), (315, 0), (320, 0), (325, 0), (330, 0), (335, 0), (340, 0), (345, 0), (350, 0), (355, 0), (360, 0), (365, 1), (370, 1), (375, 1), (380, 1), (385, 1), (390, 1), (395, 0), (400, 0), (405, 0), (410, 0), (415, 0), (420, 0), (425, 0), (430, 0), (435, 0), (440, 0), (445, 0), (450, 0), (455, 0), (460, 0), (465, 0), (470, 0), (475, 0), (480, 0), (485, 1), (490, 1), (495, 1), (500, 1), (505, 1), (510, 1), (515, 1), (520, 1), (525, 1), (530, 1), (535, 1), (540, 1), (545, 1), (550, 1), (555, 1), (560, 1), (565, 1), (570, 1), (575, 1), (580, 0), (585, 1), (590, 1), (595, 1), (600, 1), (605, 0), (610, 0), (615, 1), (620, 1), (625, 1), (630, 1), (635, 1), (640, 1), (645, 1), (650, 1), (655, 1), (660, 1), (665, 1), (670, 1), (675, 1), (680, 1), (685, 1), (690, 0), (695, 0), (700, 0), (705, 0), (710, 0), (715, 0), (720, 0), (725, 0), (730, 1), (735, 0), (740, 0), (745, 0), (750, 0), (755, 0), (760, 1), (765, 1), (770, 1), (775, 1), (780, 1), (785, 1), (790, 0), (795, 0), (800, 0), (805, 0), (810, 0), (815, 0), (820, 0), (825, 0), (830, 1), (835, 1), (840, 1), (845, 1), (850, 1), (855, 1), (860, 0), (865, 0), (870, 0), (875, 0), (880, 0), (885, 0), (890, 0), (895, 0), (900, 1), (905, 0), (910, 0), (915, 0), (920, 0), (925, 0), (930, 1), (935, 1), (940, 1), (945, 1), (950, 1), (955, 1), (960, 1), (965, 1), (970, 1), (975, 1), (980, 1), (985, 1), (990, 1), (995, 1), (1000, 0), (1005, 0), (1010, 1), (1015, 1), (1020, 1), (1025, 1)]
Vdin1_25  din1_25  0 PWL (0n 0.0v 4.745n 0.0v 4.755n 0.0v 9.745n 0.0v 9.755n 0.0v 14.745n 0.0v 14.755n 1.0v 19.745n 1.0v 19.755n 1.0v 24.745n 1.0v 24.755n 1.0v 29.745n 1.0v 29.755n 1.0v 34.745n 1.0v 34.755n 1.0v 39.745n 1.0v 39.755n 1.0v 44.745n 1.0v 44.755n 1.0v 49.745n 1.0v 49.755n 1.0v 54.745n 1.0v 54.755n 1.0v 59.745n 1.0v 59.755n 1.0v 64.745n 1.0v 64.755n 1.0v 69.745n 1.0v 69.755n 1.0v 74.745n 1.0v 74.755n 1.0v 79.745n 1.0v 79.755n 0.0v 84.745n 0.0v 84.755n 0.0v 89.745n 0.0v 89.755n 1.0v 94.745n 1.0v 94.755n 1.0v 99.745n 1.0v 99.755n 1.0v 104.745n 1.0v 104.755n 1.0v 109.745n 1.0v 109.755n 1.0v 114.745n 1.0v 114.755n 1.0v 119.745n 1.0v 119.755n 1.0v 124.745n 1.0v 124.755n 1.0v 129.745n 1.0v 129.755n 0.0v 134.745n 0.0v 134.755n 0.0v 139.745n 0.0v 139.755n 0.0v 144.745n 0.0v 144.755n 1.0v 149.745n 1.0v 149.755n 1.0v 154.745n 1.0v 154.755n 1.0v 159.745n 1.0v 159.755n 1.0v 164.745n 1.0v 164.755n 1.0v 169.745n 1.0v 169.755n 1.0v 174.745n 1.0v 174.755n 0.0v 179.745n 0.0v 179.755n 1.0v 184.745n 1.0v 184.755n 1.0v 189.745n 1.0v 189.755n 1.0v 194.745n 1.0v 194.755n 1.0v 199.745n 1.0v 199.755n 1.0v 204.745n 1.0v 204.755n 1.0v 209.745n 1.0v 209.755n 1.0v 214.745n 1.0v 214.755n 1.0v 219.745n 1.0v 219.755n 1.0v 224.745n 1.0v 224.755n 1.0v 229.745n 1.0v 229.755n 1.0v 234.745n 1.0v 234.755n 1.0v 239.745n 1.0v 239.755n 1.0v 244.745n 1.0v 244.755n 1.0v 249.745n 1.0v 249.755n 1.0v 254.745n 1.0v 254.755n 1.0v 259.745n 1.0v 259.755n 1.0v 264.745n 1.0v 264.755n 1.0v 269.745n 1.0v 269.755n 1.0v 274.745n 1.0v 274.755n 1.0v 279.745n 1.0v 279.755n 1.0v 284.745n 1.0v 284.755n 0.0v 289.745n 0.0v 289.755n 0.0v 294.745n 0.0v 294.755n 0.0v 299.745n 0.0v 299.755n 0.0v 304.745n 0.0v 304.755n 0.0v 309.745n 0.0v 309.755n 0.0v 314.745n 0.0v 314.755n 0.0v 319.745n 0.0v 319.755n 0.0v 324.745n 0.0v 324.755n 0.0v 329.745n 0.0v 329.755n 0.0v 334.745n 0.0v 334.755n 0.0v 339.745n 0.0v 339.755n 0.0v 344.745n 0.0v 344.755n 0.0v 349.745n 0.0v 349.755n 0.0v 354.745n 0.0v 354.755n 0.0v 359.745n 0.0v 359.755n 0.0v 364.745n 0.0v 364.755n 1.0v 369.745n 1.0v 369.755n 1.0v 374.745n 1.0v 374.755n 1.0v 379.745n 1.0v 379.755n 1.0v 384.745n 1.0v 384.755n 1.0v 389.745n 1.0v 389.755n 1.0v 394.745n 1.0v 394.755n 0.0v 399.745n 0.0v 399.755n 0.0v 404.745n 0.0v 404.755n 0.0v 409.745n 0.0v 409.755n 0.0v 414.745n 0.0v 414.755n 0.0v 419.745n 0.0v 419.755n 0.0v 424.745n 0.0v 424.755n 0.0v 429.745n 0.0v 429.755n 0.0v 434.745n 0.0v 434.755n 0.0v 439.745n 0.0v 439.755n 0.0v 444.745n 0.0v 444.755n 0.0v 449.745n 0.0v 449.755n 0.0v 454.745n 0.0v 454.755n 0.0v 459.745n 0.0v 459.755n 0.0v 464.745n 0.0v 464.755n 0.0v 469.745n 0.0v 469.755n 0.0v 474.745n 0.0v 474.755n 0.0v 479.745n 0.0v 479.755n 0.0v 484.745n 0.0v 484.755n 1.0v 489.745n 1.0v 489.755n 1.0v 494.745n 1.0v 494.755n 1.0v 499.745n 1.0v 499.755n 1.0v 504.745n 1.0v 504.755n 1.0v 509.745n 1.0v 509.755n 1.0v 514.745n 1.0v 514.755n 1.0v 519.745n 1.0v 519.755n 1.0v 524.745n 1.0v 524.755n 1.0v 529.745n 1.0v 529.755n 1.0v 534.745n 1.0v 534.755n 1.0v 539.745n 1.0v 539.755n 1.0v 544.745n 1.0v 544.755n 1.0v 549.745n 1.0v 549.755n 1.0v 554.745n 1.0v 554.755n 1.0v 559.745n 1.0v 559.755n 1.0v 564.745n 1.0v 564.755n 1.0v 569.745n 1.0v 569.755n 1.0v 574.745n 1.0v 574.755n 1.0v 579.745n 1.0v 579.755n 0.0v 584.745n 0.0v 584.755n 1.0v 589.745n 1.0v 589.755n 1.0v 594.745n 1.0v 594.755n 1.0v 599.745n 1.0v 599.755n 1.0v 604.745n 1.0v 604.755n 0.0v 609.745n 0.0v 609.755n 0.0v 614.745n 0.0v 614.755n 1.0v 619.745n 1.0v 619.755n 1.0v 624.745n 1.0v 624.755n 1.0v 629.745n 1.0v 629.755n 1.0v 634.745n 1.0v 634.755n 1.0v 639.745n 1.0v 639.755n 1.0v 644.745n 1.0v 644.755n 1.0v 649.745n 1.0v 649.755n 1.0v 654.745n 1.0v 654.755n 1.0v 659.745n 1.0v 659.755n 1.0v 664.745n 1.0v 664.755n 1.0v 669.745n 1.0v 669.755n 1.0v 674.745n 1.0v 674.755n 1.0v 679.745n 1.0v 679.755n 1.0v 684.745n 1.0v 684.755n 1.0v 689.745n 1.0v 689.755n 0.0v 694.745n 0.0v 694.755n 0.0v 699.745n 0.0v 699.755n 0.0v 704.745n 0.0v 704.755n 0.0v 709.745n 0.0v 709.755n 0.0v 714.745n 0.0v 714.755n 0.0v 719.745n 0.0v 719.755n 0.0v 724.745n 0.0v 724.755n 0.0v 729.745n 0.0v 729.755n 1.0v 734.745n 1.0v 734.755n 0.0v 739.745n 0.0v 739.755n 0.0v 744.745n 0.0v 744.755n 0.0v 749.745n 0.0v 749.755n 0.0v 754.745n 0.0v 754.755n 0.0v 759.745n 0.0v 759.755n 1.0v 764.745n 1.0v 764.755n 1.0v 769.745n 1.0v 769.755n 1.0v 774.745n 1.0v 774.755n 1.0v 779.745n 1.0v 779.755n 1.0v 784.745n 1.0v 784.755n 1.0v 789.745n 1.0v 789.755n 0.0v 794.745n 0.0v 794.755n 0.0v 799.745n 0.0v 799.755n 0.0v 804.745n 0.0v 804.755n 0.0v 809.745n 0.0v 809.755n 0.0v 814.745n 0.0v 814.755n 0.0v 819.745n 0.0v 819.755n 0.0v 824.745n 0.0v 824.755n 0.0v 829.745n 0.0v 829.755n 1.0v 834.745n 1.0v 834.755n 1.0v 839.745n 1.0v 839.755n 1.0v 844.745n 1.0v 844.755n 1.0v 849.745n 1.0v 849.755n 1.0v 854.745n 1.0v 854.755n 1.0v 859.745n 1.0v 859.755n 0.0v 864.745n 0.0v 864.755n 0.0v 869.745n 0.0v 869.755n 0.0v 874.745n 0.0v 874.755n 0.0v 879.745n 0.0v 879.755n 0.0v 884.745n 0.0v 884.755n 0.0v 889.745n 0.0v 889.755n 0.0v 894.745n 0.0v 894.755n 0.0v 899.745n 0.0v 899.755n 1.0v 904.745n 1.0v 904.755n 0.0v 909.745n 0.0v 909.755n 0.0v 914.745n 0.0v 914.755n 0.0v 919.745n 0.0v 919.755n 0.0v 924.745n 0.0v 924.755n 0.0v 929.745n 0.0v 929.755n 1.0v 934.745n 1.0v 934.755n 1.0v 939.745n 1.0v 939.755n 1.0v 944.745n 1.0v 944.755n 1.0v 949.745n 1.0v 949.755n 1.0v 954.745n 1.0v 954.755n 1.0v 959.745n 1.0v 959.755n 1.0v 964.745n 1.0v 964.755n 1.0v 969.745n 1.0v 969.755n 1.0v 974.745n 1.0v 974.755n 1.0v 979.745n 1.0v 979.755n 1.0v 984.745n 1.0v 984.755n 1.0v 989.745n 1.0v 989.755n 1.0v 994.745n 1.0v 994.755n 1.0v 999.745n 1.0v 999.755n 0.0v 1004.745n 0.0v 1004.755n 0.0v 1009.745n 0.0v 1009.755n 1.0v 1014.745n 1.0v 1014.755n 1.0v 1019.745n 1.0v 1019.755n 1.0v 1024.745n 1.0v 1024.755n 1.0v )
* (time, data): [(0, 0), (5, 1), (10, 0), (15, 1), (20, 1), (25, 1), (30, 1), (35, 1), (40, 1), (45, 1), (50, 1), (55, 1), (60, 1), (65, 1), (70, 1), (75, 1), (80, 0), (85, 0), (90, 1), (95, 1), (100, 1), (105, 1), (110, 1), (115, 1), (120, 1), (125, 1), (130, 0), (135, 0), (140, 0), (145, 0), (150, 0), (155, 0), (160, 0), (165, 0), (170, 0), (175, 1), (180, 0), (185, 0), (190, 0), (195, 0), (200, 0), (205, 0), (210, 0), (215, 0), (220, 0), (225, 0), (230, 0), (235, 0), (240, 0), (245, 1), (250, 1), (255, 1), (260, 1), (265, 1), (270, 1), (275, 1), (280, 1), (285, 1), (290, 1), (295, 1), (300, 1), (305, 1), (310, 1), (315, 1), (320, 1), (325, 1), (330, 1), (335, 1), (340, 1), (345, 1), (350, 1), (355, 1), (360, 1), (365, 0), (370, 0), (375, 0), (380, 0), (385, 0), (390, 1), (395, 1), (400, 1), (405, 1), (410, 1), (415, 1), (420, 1), (425, 1), (430, 1), (435, 1), (440, 1), (445, 1), (450, 1), (455, 1), (460, 1), (465, 0), (470, 0), (475, 0), (480, 0), (485, 1), (490, 1), (495, 1), (500, 1), (505, 0), (510, 0), (515, 0), (520, 0), (525, 0), (530, 0), (535, 0), (540, 0), (545, 0), (550, 0), (555, 0), (560, 0), (565, 0), (570, 0), (575, 0), (580, 0), (585, 0), (590, 0), (595, 0), (600, 0), (605, 1), (610, 1), (615, 0), (620, 0), (625, 0), (630, 0), (635, 0), (640, 0), (645, 0), (650, 0), (655, 0), (660, 0), (665, 0), (670, 0), (675, 0), (680, 0), (685, 0), (690, 1), (695, 1), (700, 1), (705, 1), (710, 1), (715, 1), (720, 1), (725, 1), (730, 1), (735, 0), (740, 0), (745, 0), (750, 0), (755, 0), (760, 0), (765, 0), (770, 0), (775, 0), (780, 0), (785, 0), (790, 1), (795, 1), (800, 1), (805, 1), (810, 1), (815, 1), (820, 1), (825, 1), (830, 0), (835, 0), (840, 0), (845, 0), (850, 0), (855, 0), (860, 1), (865, 1), (870, 1), (875, 1), (880, 0), (885, 0), (890, 0), (895, 0), (900, 0), (905, 0), (910, 0), (915, 0), (920, 0), (925, 0), (930, 1), (935, 1), (940, 1), (945, 1), (950, 1), (955, 1), (960, 1), (965, 1), (970, 1), (975, 1), (980, 1), (985, 1), (990, 1), (995, 1), (1000, 1), (1005, 1), (1010, 0), (1015, 0), (1020, 0), (1025, 0)]
Vdin1_26  din1_26  0 PWL (0n 0.0v 4.745n 0.0v 4.755n 1.0v 9.745n 1.0v 9.755n 0.0v 14.745n 0.0v 14.755n 1.0v 19.745n 1.0v 19.755n 1.0v 24.745n 1.0v 24.755n 1.0v 29.745n 1.0v 29.755n 1.0v 34.745n 1.0v 34.755n 1.0v 39.745n 1.0v 39.755n 1.0v 44.745n 1.0v 44.755n 1.0v 49.745n 1.0v 49.755n 1.0v 54.745n 1.0v 54.755n 1.0v 59.745n 1.0v 59.755n 1.0v 64.745n 1.0v 64.755n 1.0v 69.745n 1.0v 69.755n 1.0v 74.745n 1.0v 74.755n 1.0v 79.745n 1.0v 79.755n 0.0v 84.745n 0.0v 84.755n 0.0v 89.745n 0.0v 89.755n 1.0v 94.745n 1.0v 94.755n 1.0v 99.745n 1.0v 99.755n 1.0v 104.745n 1.0v 104.755n 1.0v 109.745n 1.0v 109.755n 1.0v 114.745n 1.0v 114.755n 1.0v 119.745n 1.0v 119.755n 1.0v 124.745n 1.0v 124.755n 1.0v 129.745n 1.0v 129.755n 0.0v 134.745n 0.0v 134.755n 0.0v 139.745n 0.0v 139.755n 0.0v 144.745n 0.0v 144.755n 0.0v 149.745n 0.0v 149.755n 0.0v 154.745n 0.0v 154.755n 0.0v 159.745n 0.0v 159.755n 0.0v 164.745n 0.0v 164.755n 0.0v 169.745n 0.0v 169.755n 0.0v 174.745n 0.0v 174.755n 1.0v 179.745n 1.0v 179.755n 0.0v 184.745n 0.0v 184.755n 0.0v 189.745n 0.0v 189.755n 0.0v 194.745n 0.0v 194.755n 0.0v 199.745n 0.0v 199.755n 0.0v 204.745n 0.0v 204.755n 0.0v 209.745n 0.0v 209.755n 0.0v 214.745n 0.0v 214.755n 0.0v 219.745n 0.0v 219.755n 0.0v 224.745n 0.0v 224.755n 0.0v 229.745n 0.0v 229.755n 0.0v 234.745n 0.0v 234.755n 0.0v 239.745n 0.0v 239.755n 0.0v 244.745n 0.0v 244.755n 1.0v 249.745n 1.0v 249.755n 1.0v 254.745n 1.0v 254.755n 1.0v 259.745n 1.0v 259.755n 1.0v 264.745n 1.0v 264.755n 1.0v 269.745n 1.0v 269.755n 1.0v 274.745n 1.0v 274.755n 1.0v 279.745n 1.0v 279.755n 1.0v 284.745n 1.0v 284.755n 1.0v 289.745n 1.0v 289.755n 1.0v 294.745n 1.0v 294.755n 1.0v 299.745n 1.0v 299.755n 1.0v 304.745n 1.0v 304.755n 1.0v 309.745n 1.0v 309.755n 1.0v 314.745n 1.0v 314.755n 1.0v 319.745n 1.0v 319.755n 1.0v 324.745n 1.0v 324.755n 1.0v 329.745n 1.0v 329.755n 1.0v 334.745n 1.0v 334.755n 1.0v 339.745n 1.0v 339.755n 1.0v 344.745n 1.0v 344.755n 1.0v 349.745n 1.0v 349.755n 1.0v 354.745n 1.0v 354.755n 1.0v 359.745n 1.0v 359.755n 1.0v 364.745n 1.0v 364.755n 0.0v 369.745n 0.0v 369.755n 0.0v 374.745n 0.0v 374.755n 0.0v 379.745n 0.0v 379.755n 0.0v 384.745n 0.0v 384.755n 0.0v 389.745n 0.0v 389.755n 1.0v 394.745n 1.0v 394.755n 1.0v 399.745n 1.0v 399.755n 1.0v 404.745n 1.0v 404.755n 1.0v 409.745n 1.0v 409.755n 1.0v 414.745n 1.0v 414.755n 1.0v 419.745n 1.0v 419.755n 1.0v 424.745n 1.0v 424.755n 1.0v 429.745n 1.0v 429.755n 1.0v 434.745n 1.0v 434.755n 1.0v 439.745n 1.0v 439.755n 1.0v 444.745n 1.0v 444.755n 1.0v 449.745n 1.0v 449.755n 1.0v 454.745n 1.0v 454.755n 1.0v 459.745n 1.0v 459.755n 1.0v 464.745n 1.0v 464.755n 0.0v 469.745n 0.0v 469.755n 0.0v 474.745n 0.0v 474.755n 0.0v 479.745n 0.0v 479.755n 0.0v 484.745n 0.0v 484.755n 1.0v 489.745n 1.0v 489.755n 1.0v 494.745n 1.0v 494.755n 1.0v 499.745n 1.0v 499.755n 1.0v 504.745n 1.0v 504.755n 0.0v 509.745n 0.0v 509.755n 0.0v 514.745n 0.0v 514.755n 0.0v 519.745n 0.0v 519.755n 0.0v 524.745n 0.0v 524.755n 0.0v 529.745n 0.0v 529.755n 0.0v 534.745n 0.0v 534.755n 0.0v 539.745n 0.0v 539.755n 0.0v 544.745n 0.0v 544.755n 0.0v 549.745n 0.0v 549.755n 0.0v 554.745n 0.0v 554.755n 0.0v 559.745n 0.0v 559.755n 0.0v 564.745n 0.0v 564.755n 0.0v 569.745n 0.0v 569.755n 0.0v 574.745n 0.0v 574.755n 0.0v 579.745n 0.0v 579.755n 0.0v 584.745n 0.0v 584.755n 0.0v 589.745n 0.0v 589.755n 0.0v 594.745n 0.0v 594.755n 0.0v 599.745n 0.0v 599.755n 0.0v 604.745n 0.0v 604.755n 1.0v 609.745n 1.0v 609.755n 1.0v 614.745n 1.0v 614.755n 0.0v 619.745n 0.0v 619.755n 0.0v 624.745n 0.0v 624.755n 0.0v 629.745n 0.0v 629.755n 0.0v 634.745n 0.0v 634.755n 0.0v 639.745n 0.0v 639.755n 0.0v 644.745n 0.0v 644.755n 0.0v 649.745n 0.0v 649.755n 0.0v 654.745n 0.0v 654.755n 0.0v 659.745n 0.0v 659.755n 0.0v 664.745n 0.0v 664.755n 0.0v 669.745n 0.0v 669.755n 0.0v 674.745n 0.0v 674.755n 0.0v 679.745n 0.0v 679.755n 0.0v 684.745n 0.0v 684.755n 0.0v 689.745n 0.0v 689.755n 1.0v 694.745n 1.0v 694.755n 1.0v 699.745n 1.0v 699.755n 1.0v 704.745n 1.0v 704.755n 1.0v 709.745n 1.0v 709.755n 1.0v 714.745n 1.0v 714.755n 1.0v 719.745n 1.0v 719.755n 1.0v 724.745n 1.0v 724.755n 1.0v 729.745n 1.0v 729.755n 1.0v 734.745n 1.0v 734.755n 0.0v 739.745n 0.0v 739.755n 0.0v 744.745n 0.0v 744.755n 0.0v 749.745n 0.0v 749.755n 0.0v 754.745n 0.0v 754.755n 0.0v 759.745n 0.0v 759.755n 0.0v 764.745n 0.0v 764.755n 0.0v 769.745n 0.0v 769.755n 0.0v 774.745n 0.0v 774.755n 0.0v 779.745n 0.0v 779.755n 0.0v 784.745n 0.0v 784.755n 0.0v 789.745n 0.0v 789.755n 1.0v 794.745n 1.0v 794.755n 1.0v 799.745n 1.0v 799.755n 1.0v 804.745n 1.0v 804.755n 1.0v 809.745n 1.0v 809.755n 1.0v 814.745n 1.0v 814.755n 1.0v 819.745n 1.0v 819.755n 1.0v 824.745n 1.0v 824.755n 1.0v 829.745n 1.0v 829.755n 0.0v 834.745n 0.0v 834.755n 0.0v 839.745n 0.0v 839.755n 0.0v 844.745n 0.0v 844.755n 0.0v 849.745n 0.0v 849.755n 0.0v 854.745n 0.0v 854.755n 0.0v 859.745n 0.0v 859.755n 1.0v 864.745n 1.0v 864.755n 1.0v 869.745n 1.0v 869.755n 1.0v 874.745n 1.0v 874.755n 1.0v 879.745n 1.0v 879.755n 0.0v 884.745n 0.0v 884.755n 0.0v 889.745n 0.0v 889.755n 0.0v 894.745n 0.0v 894.755n 0.0v 899.745n 0.0v 899.755n 0.0v 904.745n 0.0v 904.755n 0.0v 909.745n 0.0v 909.755n 0.0v 914.745n 0.0v 914.755n 0.0v 919.745n 0.0v 919.755n 0.0v 924.745n 0.0v 924.755n 0.0v 929.745n 0.0v 929.755n 1.0v 934.745n 1.0v 934.755n 1.0v 939.745n 1.0v 939.755n 1.0v 944.745n 1.0v 944.755n 1.0v 949.745n 1.0v 949.755n 1.0v 954.745n 1.0v 954.755n 1.0v 959.745n 1.0v 959.755n 1.0v 964.745n 1.0v 964.755n 1.0v 969.745n 1.0v 969.755n 1.0v 974.745n 1.0v 974.755n 1.0v 979.745n 1.0v 979.755n 1.0v 984.745n 1.0v 984.755n 1.0v 989.745n 1.0v 989.755n 1.0v 994.745n 1.0v 994.755n 1.0v 999.745n 1.0v 999.755n 1.0v 1004.745n 1.0v 1004.755n 1.0v 1009.745n 1.0v 1009.755n 0.0v 1014.745n 0.0v 1014.755n 0.0v 1019.745n 0.0v 1019.755n 0.0v 1024.745n 0.0v 1024.755n 0.0v )
* (time, data): [(0, 0), (5, 0), (10, 1), (15, 0), (20, 0), (25, 0), (30, 0), (35, 0), (40, 0), (45, 0), (50, 0), (55, 0), (60, 0), (65, 0), (70, 0), (75, 0), (80, 1), (85, 1), (90, 0), (95, 0), (100, 0), (105, 0), (110, 0), (115, 0), (120, 0), (125, 0), (130, 1), (135, 1), (140, 1), (145, 0), (150, 0), (155, 0), (160, 0), (165, 0), (170, 0), (175, 1), (180, 1), (185, 1), (190, 1), (195, 1), (200, 1), (205, 1), (210, 1), (215, 1), (220, 1), (225, 1), (230, 1), (235, 1), (240, 1), (245, 1), (250, 0), (255, 0), (260, 0), (265, 0), (270, 0), (275, 0), (280, 0), (285, 0), (290, 0), (295, 0), (300, 0), (305, 0), (310, 0), (315, 0), (320, 0), (325, 0), (330, 0), (335, 0), (340, 0), (345, 0), (350, 0), (355, 0), (360, 0), (365, 1), (370, 1), (375, 1), (380, 1), (385, 1), (390, 0), (395, 0), (400, 0), (405, 0), (410, 0), (415, 0), (420, 1), (425, 1), (430, 1), (435, 1), (440, 1), (445, 1), (450, 1), (455, 1), (460, 1), (465, 0), (470, 0), (475, 0), (480, 0), (485, 1), (490, 1), (495, 1), (500, 1), (505, 0), (510, 0), (515, 0), (520, 0), (525, 0), (530, 0), (535, 0), (540, 0), (545, 0), (550, 0), (555, 0), (560, 0), (565, 0), (570, 0), (575, 0), (580, 1), (585, 0), (590, 0), (595, 0), (600, 0), (605, 1), (610, 1), (615, 1), (620, 1), (625, 1), (630, 1), (635, 1), (640, 1), (645, 1), (650, 1), (655, 1), (660, 1), (665, 1), (670, 1), (675, 1), (680, 1), (685, 1), (690, 0), (695, 0), (700, 0), (705, 0), (710, 0), (715, 0), (720, 0), (725, 0), (730, 1), (735, 0), (740, 0), (745, 0), (750, 0), (755, 0), (760, 0), (765, 0), (770, 0), (775, 0), (780, 0), (785, 0), (790, 1), (795, 1), (800, 1), (805, 1), (810, 1), (815, 1), (820, 1), (825, 1), (830, 0), (835, 0), (840, 0), (845, 0), (850, 0), (855, 0), (860, 1), (865, 1), (870, 1), (875, 1), (880, 0), (885, 0), (890, 0), (895, 0), (900, 1), (905, 1), (910, 1), (915, 1), (920, 1), (925, 1), (930, 0), (935, 0), (940, 0), (945, 0), (950, 0), (955, 0), (960, 0), (965, 0), (970, 0), (975, 0), (980, 0), (985, 0), (990, 0), (995, 0), (1000, 1), (1005, 1), (1010, 0), (1015, 0), (1020, 0), (1025, 0)]
Vdin1_27  din1_27  0 PWL (0n 0.0v 4.745n 0.0v 4.755n 0.0v 9.745n 0.0v 9.755n 1.0v 14.745n 1.0v 14.755n 0.0v 19.745n 0.0v 19.755n 0.0v 24.745n 0.0v 24.755n 0.0v 29.745n 0.0v 29.755n 0.0v 34.745n 0.0v 34.755n 0.0v 39.745n 0.0v 39.755n 0.0v 44.745n 0.0v 44.755n 0.0v 49.745n 0.0v 49.755n 0.0v 54.745n 0.0v 54.755n 0.0v 59.745n 0.0v 59.755n 0.0v 64.745n 0.0v 64.755n 0.0v 69.745n 0.0v 69.755n 0.0v 74.745n 0.0v 74.755n 0.0v 79.745n 0.0v 79.755n 1.0v 84.745n 1.0v 84.755n 1.0v 89.745n 1.0v 89.755n 0.0v 94.745n 0.0v 94.755n 0.0v 99.745n 0.0v 99.755n 0.0v 104.745n 0.0v 104.755n 0.0v 109.745n 0.0v 109.755n 0.0v 114.745n 0.0v 114.755n 0.0v 119.745n 0.0v 119.755n 0.0v 124.745n 0.0v 124.755n 0.0v 129.745n 0.0v 129.755n 1.0v 134.745n 1.0v 134.755n 1.0v 139.745n 1.0v 139.755n 1.0v 144.745n 1.0v 144.755n 0.0v 149.745n 0.0v 149.755n 0.0v 154.745n 0.0v 154.755n 0.0v 159.745n 0.0v 159.755n 0.0v 164.745n 0.0v 164.755n 0.0v 169.745n 0.0v 169.755n 0.0v 174.745n 0.0v 174.755n 1.0v 179.745n 1.0v 179.755n 1.0v 184.745n 1.0v 184.755n 1.0v 189.745n 1.0v 189.755n 1.0v 194.745n 1.0v 194.755n 1.0v 199.745n 1.0v 199.755n 1.0v 204.745n 1.0v 204.755n 1.0v 209.745n 1.0v 209.755n 1.0v 214.745n 1.0v 214.755n 1.0v 219.745n 1.0v 219.755n 1.0v 224.745n 1.0v 224.755n 1.0v 229.745n 1.0v 229.755n 1.0v 234.745n 1.0v 234.755n 1.0v 239.745n 1.0v 239.755n 1.0v 244.745n 1.0v 244.755n 1.0v 249.745n 1.0v 249.755n 0.0v 254.745n 0.0v 254.755n 0.0v 259.745n 0.0v 259.755n 0.0v 264.745n 0.0v 264.755n 0.0v 269.745n 0.0v 269.755n 0.0v 274.745n 0.0v 274.755n 0.0v 279.745n 0.0v 279.755n 0.0v 284.745n 0.0v 284.755n 0.0v 289.745n 0.0v 289.755n 0.0v 294.745n 0.0v 294.755n 0.0v 299.745n 0.0v 299.755n 0.0v 304.745n 0.0v 304.755n 0.0v 309.745n 0.0v 309.755n 0.0v 314.745n 0.0v 314.755n 0.0v 319.745n 0.0v 319.755n 0.0v 324.745n 0.0v 324.755n 0.0v 329.745n 0.0v 329.755n 0.0v 334.745n 0.0v 334.755n 0.0v 339.745n 0.0v 339.755n 0.0v 344.745n 0.0v 344.755n 0.0v 349.745n 0.0v 349.755n 0.0v 354.745n 0.0v 354.755n 0.0v 359.745n 0.0v 359.755n 0.0v 364.745n 0.0v 364.755n 1.0v 369.745n 1.0v 369.755n 1.0v 374.745n 1.0v 374.755n 1.0v 379.745n 1.0v 379.755n 1.0v 384.745n 1.0v 384.755n 1.0v 389.745n 1.0v 389.755n 0.0v 394.745n 0.0v 394.755n 0.0v 399.745n 0.0v 399.755n 0.0v 404.745n 0.0v 404.755n 0.0v 409.745n 0.0v 409.755n 0.0v 414.745n 0.0v 414.755n 0.0v 419.745n 0.0v 419.755n 1.0v 424.745n 1.0v 424.755n 1.0v 429.745n 1.0v 429.755n 1.0v 434.745n 1.0v 434.755n 1.0v 439.745n 1.0v 439.755n 1.0v 444.745n 1.0v 444.755n 1.0v 449.745n 1.0v 449.755n 1.0v 454.745n 1.0v 454.755n 1.0v 459.745n 1.0v 459.755n 1.0v 464.745n 1.0v 464.755n 0.0v 469.745n 0.0v 469.755n 0.0v 474.745n 0.0v 474.755n 0.0v 479.745n 0.0v 479.755n 0.0v 484.745n 0.0v 484.755n 1.0v 489.745n 1.0v 489.755n 1.0v 494.745n 1.0v 494.755n 1.0v 499.745n 1.0v 499.755n 1.0v 504.745n 1.0v 504.755n 0.0v 509.745n 0.0v 509.755n 0.0v 514.745n 0.0v 514.755n 0.0v 519.745n 0.0v 519.755n 0.0v 524.745n 0.0v 524.755n 0.0v 529.745n 0.0v 529.755n 0.0v 534.745n 0.0v 534.755n 0.0v 539.745n 0.0v 539.755n 0.0v 544.745n 0.0v 544.755n 0.0v 549.745n 0.0v 549.755n 0.0v 554.745n 0.0v 554.755n 0.0v 559.745n 0.0v 559.755n 0.0v 564.745n 0.0v 564.755n 0.0v 569.745n 0.0v 569.755n 0.0v 574.745n 0.0v 574.755n 0.0v 579.745n 0.0v 579.755n 1.0v 584.745n 1.0v 584.755n 0.0v 589.745n 0.0v 589.755n 0.0v 594.745n 0.0v 594.755n 0.0v 599.745n 0.0v 599.755n 0.0v 604.745n 0.0v 604.755n 1.0v 609.745n 1.0v 609.755n 1.0v 614.745n 1.0v 614.755n 1.0v 619.745n 1.0v 619.755n 1.0v 624.745n 1.0v 624.755n 1.0v 629.745n 1.0v 629.755n 1.0v 634.745n 1.0v 634.755n 1.0v 639.745n 1.0v 639.755n 1.0v 644.745n 1.0v 644.755n 1.0v 649.745n 1.0v 649.755n 1.0v 654.745n 1.0v 654.755n 1.0v 659.745n 1.0v 659.755n 1.0v 664.745n 1.0v 664.755n 1.0v 669.745n 1.0v 669.755n 1.0v 674.745n 1.0v 674.755n 1.0v 679.745n 1.0v 679.755n 1.0v 684.745n 1.0v 684.755n 1.0v 689.745n 1.0v 689.755n 0.0v 694.745n 0.0v 694.755n 0.0v 699.745n 0.0v 699.755n 0.0v 704.745n 0.0v 704.755n 0.0v 709.745n 0.0v 709.755n 0.0v 714.745n 0.0v 714.755n 0.0v 719.745n 0.0v 719.755n 0.0v 724.745n 0.0v 724.755n 0.0v 729.745n 0.0v 729.755n 1.0v 734.745n 1.0v 734.755n 0.0v 739.745n 0.0v 739.755n 0.0v 744.745n 0.0v 744.755n 0.0v 749.745n 0.0v 749.755n 0.0v 754.745n 0.0v 754.755n 0.0v 759.745n 0.0v 759.755n 0.0v 764.745n 0.0v 764.755n 0.0v 769.745n 0.0v 769.755n 0.0v 774.745n 0.0v 774.755n 0.0v 779.745n 0.0v 779.755n 0.0v 784.745n 0.0v 784.755n 0.0v 789.745n 0.0v 789.755n 1.0v 794.745n 1.0v 794.755n 1.0v 799.745n 1.0v 799.755n 1.0v 804.745n 1.0v 804.755n 1.0v 809.745n 1.0v 809.755n 1.0v 814.745n 1.0v 814.755n 1.0v 819.745n 1.0v 819.755n 1.0v 824.745n 1.0v 824.755n 1.0v 829.745n 1.0v 829.755n 0.0v 834.745n 0.0v 834.755n 0.0v 839.745n 0.0v 839.755n 0.0v 844.745n 0.0v 844.755n 0.0v 849.745n 0.0v 849.755n 0.0v 854.745n 0.0v 854.755n 0.0v 859.745n 0.0v 859.755n 1.0v 864.745n 1.0v 864.755n 1.0v 869.745n 1.0v 869.755n 1.0v 874.745n 1.0v 874.755n 1.0v 879.745n 1.0v 879.755n 0.0v 884.745n 0.0v 884.755n 0.0v 889.745n 0.0v 889.755n 0.0v 894.745n 0.0v 894.755n 0.0v 899.745n 0.0v 899.755n 1.0v 904.745n 1.0v 904.755n 1.0v 909.745n 1.0v 909.755n 1.0v 914.745n 1.0v 914.755n 1.0v 919.745n 1.0v 919.755n 1.0v 924.745n 1.0v 924.755n 1.0v 929.745n 1.0v 929.755n 0.0v 934.745n 0.0v 934.755n 0.0v 939.745n 0.0v 939.755n 0.0v 944.745n 0.0v 944.755n 0.0v 949.745n 0.0v 949.755n 0.0v 954.745n 0.0v 954.755n 0.0v 959.745n 0.0v 959.755n 0.0v 964.745n 0.0v 964.755n 0.0v 969.745n 0.0v 969.755n 0.0v 974.745n 0.0v 974.755n 0.0v 979.745n 0.0v 979.755n 0.0v 984.745n 0.0v 984.755n 0.0v 989.745n 0.0v 989.755n 0.0v 994.745n 0.0v 994.755n 0.0v 999.745n 0.0v 999.755n 1.0v 1004.745n 1.0v 1004.755n 1.0v 1009.745n 1.0v 1009.755n 0.0v 1014.745n 0.0v 1014.755n 0.0v 1019.745n 0.0v 1019.755n 0.0v 1024.745n 0.0v 1024.755n 0.0v )
* (time, data): [(0, 0), (5, 0), (10, 1), (15, 1), (20, 1), (25, 1), (30, 1), (35, 1), (40, 1), (45, 1), (50, 1), (55, 1), (60, 1), (65, 1), (70, 1), (75, 1), (80, 0), (85, 0), (90, 1), (95, 1), (100, 1), (105, 1), (110, 1), (115, 1), (120, 1), (125, 1), (130, 0), (135, 0), (140, 0), (145, 0), (150, 0), (155, 0), (160, 0), (165, 0), (170, 0), (175, 0), (180, 0), (185, 0), (190, 0), (195, 0), (200, 0), (205, 0), (210, 0), (215, 0), (220, 0), (225, 0), (230, 0), (235, 0), (240, 0), (245, 0), (250, 0), (255, 0), (260, 0), (265, 0), (270, 0), (275, 0), (280, 0), (285, 1), (290, 1), (295, 1), (300, 1), (305, 1), (310, 1), (315, 1), (320, 1), (325, 1), (330, 1), (335, 1), (340, 1), (345, 1), (350, 1), (355, 1), (360, 1), (365, 0), (370, 0), (375, 0), (380, 0), (385, 0), (390, 1), (395, 0), (400, 0), (405, 0), (410, 0), (415, 0), (420, 1), (425, 1), (430, 1), (435, 1), (440, 1), (445, 1), (450, 1), (455, 1), (460, 1), (465, 1), (470, 1), (475, 1), (480, 1), (485, 0), (490, 0), (495, 0), (500, 0), (505, 0), (510, 0), (515, 0), (520, 0), (525, 0), (530, 0), (535, 0), (540, 0), (545, 0), (550, 0), (555, 0), (560, 0), (565, 0), (570, 0), (575, 0), (580, 0), (585, 1), (590, 1), (595, 1), (600, 1), (605, 0), (610, 0), (615, 1), (620, 1), (625, 1), (630, 1), (635, 1), (640, 1), (645, 1), (650, 1), (655, 1), (660, 1), (665, 1), (670, 1), (675, 1), (680, 1), (685, 1), (690, 1), (695, 1), (700, 1), (705, 1), (710, 1), (715, 1), (720, 1), (725, 1), (730, 0), (735, 1), (740, 1), (745, 1), (750, 1), (755, 1), (760, 0), (765, 1), (770, 1), (775, 1), (780, 1), (785, 1), (790, 0), (795, 0), (800, 0), (805, 0), (810, 1), (815, 1), (820, 1), (825, 1), (830, 0), (835, 0), (840, 0), (845, 0), (850, 0), (855, 0), (860, 1), (865, 1), (870, 1), (875, 1), (880, 0), (885, 0), (890, 0), (895, 0), (900, 0), (905, 0), (910, 0), (915, 0), (920, 0), (925, 0), (930, 1), (935, 1), (940, 1), (945, 1), (950, 1), (955, 1), (960, 1), (965, 1), (970, 1), (975, 1), (980, 1), (985, 1), (990, 1), (995, 1), (1000, 1), (1005, 1), (1010, 1), (1015, 1), (1020, 1), (1025, 1)]
Vdin1_28  din1_28  0 PWL (0n 0.0v 4.745n 0.0v 4.755n 0.0v 9.745n 0.0v 9.755n 1.0v 14.745n 1.0v 14.755n 1.0v 19.745n 1.0v 19.755n 1.0v 24.745n 1.0v 24.755n 1.0v 29.745n 1.0v 29.755n 1.0v 34.745n 1.0v 34.755n 1.0v 39.745n 1.0v 39.755n 1.0v 44.745n 1.0v 44.755n 1.0v 49.745n 1.0v 49.755n 1.0v 54.745n 1.0v 54.755n 1.0v 59.745n 1.0v 59.755n 1.0v 64.745n 1.0v 64.755n 1.0v 69.745n 1.0v 69.755n 1.0v 74.745n 1.0v 74.755n 1.0v 79.745n 1.0v 79.755n 0.0v 84.745n 0.0v 84.755n 0.0v 89.745n 0.0v 89.755n 1.0v 94.745n 1.0v 94.755n 1.0v 99.745n 1.0v 99.755n 1.0v 104.745n 1.0v 104.755n 1.0v 109.745n 1.0v 109.755n 1.0v 114.745n 1.0v 114.755n 1.0v 119.745n 1.0v 119.755n 1.0v 124.745n 1.0v 124.755n 1.0v 129.745n 1.0v 129.755n 0.0v 134.745n 0.0v 134.755n 0.0v 139.745n 0.0v 139.755n 0.0v 144.745n 0.0v 144.755n 0.0v 149.745n 0.0v 149.755n 0.0v 154.745n 0.0v 154.755n 0.0v 159.745n 0.0v 159.755n 0.0v 164.745n 0.0v 164.755n 0.0v 169.745n 0.0v 169.755n 0.0v 174.745n 0.0v 174.755n 0.0v 179.745n 0.0v 179.755n 0.0v 184.745n 0.0v 184.755n 0.0v 189.745n 0.0v 189.755n 0.0v 194.745n 0.0v 194.755n 0.0v 199.745n 0.0v 199.755n 0.0v 204.745n 0.0v 204.755n 0.0v 209.745n 0.0v 209.755n 0.0v 214.745n 0.0v 214.755n 0.0v 219.745n 0.0v 219.755n 0.0v 224.745n 0.0v 224.755n 0.0v 229.745n 0.0v 229.755n 0.0v 234.745n 0.0v 234.755n 0.0v 239.745n 0.0v 239.755n 0.0v 244.745n 0.0v 244.755n 0.0v 249.745n 0.0v 249.755n 0.0v 254.745n 0.0v 254.755n 0.0v 259.745n 0.0v 259.755n 0.0v 264.745n 0.0v 264.755n 0.0v 269.745n 0.0v 269.755n 0.0v 274.745n 0.0v 274.755n 0.0v 279.745n 0.0v 279.755n 0.0v 284.745n 0.0v 284.755n 1.0v 289.745n 1.0v 289.755n 1.0v 294.745n 1.0v 294.755n 1.0v 299.745n 1.0v 299.755n 1.0v 304.745n 1.0v 304.755n 1.0v 309.745n 1.0v 309.755n 1.0v 314.745n 1.0v 314.755n 1.0v 319.745n 1.0v 319.755n 1.0v 324.745n 1.0v 324.755n 1.0v 329.745n 1.0v 329.755n 1.0v 334.745n 1.0v 334.755n 1.0v 339.745n 1.0v 339.755n 1.0v 344.745n 1.0v 344.755n 1.0v 349.745n 1.0v 349.755n 1.0v 354.745n 1.0v 354.755n 1.0v 359.745n 1.0v 359.755n 1.0v 364.745n 1.0v 364.755n 0.0v 369.745n 0.0v 369.755n 0.0v 374.745n 0.0v 374.755n 0.0v 379.745n 0.0v 379.755n 0.0v 384.745n 0.0v 384.755n 0.0v 389.745n 0.0v 389.755n 1.0v 394.745n 1.0v 394.755n 0.0v 399.745n 0.0v 399.755n 0.0v 404.745n 0.0v 404.755n 0.0v 409.745n 0.0v 409.755n 0.0v 414.745n 0.0v 414.755n 0.0v 419.745n 0.0v 419.755n 1.0v 424.745n 1.0v 424.755n 1.0v 429.745n 1.0v 429.755n 1.0v 434.745n 1.0v 434.755n 1.0v 439.745n 1.0v 439.755n 1.0v 444.745n 1.0v 444.755n 1.0v 449.745n 1.0v 449.755n 1.0v 454.745n 1.0v 454.755n 1.0v 459.745n 1.0v 459.755n 1.0v 464.745n 1.0v 464.755n 1.0v 469.745n 1.0v 469.755n 1.0v 474.745n 1.0v 474.755n 1.0v 479.745n 1.0v 479.755n 1.0v 484.745n 1.0v 484.755n 0.0v 489.745n 0.0v 489.755n 0.0v 494.745n 0.0v 494.755n 0.0v 499.745n 0.0v 499.755n 0.0v 504.745n 0.0v 504.755n 0.0v 509.745n 0.0v 509.755n 0.0v 514.745n 0.0v 514.755n 0.0v 519.745n 0.0v 519.755n 0.0v 524.745n 0.0v 524.755n 0.0v 529.745n 0.0v 529.755n 0.0v 534.745n 0.0v 534.755n 0.0v 539.745n 0.0v 539.755n 0.0v 544.745n 0.0v 544.755n 0.0v 549.745n 0.0v 549.755n 0.0v 554.745n 0.0v 554.755n 0.0v 559.745n 0.0v 559.755n 0.0v 564.745n 0.0v 564.755n 0.0v 569.745n 0.0v 569.755n 0.0v 574.745n 0.0v 574.755n 0.0v 579.745n 0.0v 579.755n 0.0v 584.745n 0.0v 584.755n 1.0v 589.745n 1.0v 589.755n 1.0v 594.745n 1.0v 594.755n 1.0v 599.745n 1.0v 599.755n 1.0v 604.745n 1.0v 604.755n 0.0v 609.745n 0.0v 609.755n 0.0v 614.745n 0.0v 614.755n 1.0v 619.745n 1.0v 619.755n 1.0v 624.745n 1.0v 624.755n 1.0v 629.745n 1.0v 629.755n 1.0v 634.745n 1.0v 634.755n 1.0v 639.745n 1.0v 639.755n 1.0v 644.745n 1.0v 644.755n 1.0v 649.745n 1.0v 649.755n 1.0v 654.745n 1.0v 654.755n 1.0v 659.745n 1.0v 659.755n 1.0v 664.745n 1.0v 664.755n 1.0v 669.745n 1.0v 669.755n 1.0v 674.745n 1.0v 674.755n 1.0v 679.745n 1.0v 679.755n 1.0v 684.745n 1.0v 684.755n 1.0v 689.745n 1.0v 689.755n 1.0v 694.745n 1.0v 694.755n 1.0v 699.745n 1.0v 699.755n 1.0v 704.745n 1.0v 704.755n 1.0v 709.745n 1.0v 709.755n 1.0v 714.745n 1.0v 714.755n 1.0v 719.745n 1.0v 719.755n 1.0v 724.745n 1.0v 724.755n 1.0v 729.745n 1.0v 729.755n 0.0v 734.745n 0.0v 734.755n 1.0v 739.745n 1.0v 739.755n 1.0v 744.745n 1.0v 744.755n 1.0v 749.745n 1.0v 749.755n 1.0v 754.745n 1.0v 754.755n 1.0v 759.745n 1.0v 759.755n 0.0v 764.745n 0.0v 764.755n 1.0v 769.745n 1.0v 769.755n 1.0v 774.745n 1.0v 774.755n 1.0v 779.745n 1.0v 779.755n 1.0v 784.745n 1.0v 784.755n 1.0v 789.745n 1.0v 789.755n 0.0v 794.745n 0.0v 794.755n 0.0v 799.745n 0.0v 799.755n 0.0v 804.745n 0.0v 804.755n 0.0v 809.745n 0.0v 809.755n 1.0v 814.745n 1.0v 814.755n 1.0v 819.745n 1.0v 819.755n 1.0v 824.745n 1.0v 824.755n 1.0v 829.745n 1.0v 829.755n 0.0v 834.745n 0.0v 834.755n 0.0v 839.745n 0.0v 839.755n 0.0v 844.745n 0.0v 844.755n 0.0v 849.745n 0.0v 849.755n 0.0v 854.745n 0.0v 854.755n 0.0v 859.745n 0.0v 859.755n 1.0v 864.745n 1.0v 864.755n 1.0v 869.745n 1.0v 869.755n 1.0v 874.745n 1.0v 874.755n 1.0v 879.745n 1.0v 879.755n 0.0v 884.745n 0.0v 884.755n 0.0v 889.745n 0.0v 889.755n 0.0v 894.745n 0.0v 894.755n 0.0v 899.745n 0.0v 899.755n 0.0v 904.745n 0.0v 904.755n 0.0v 909.745n 0.0v 909.755n 0.0v 914.745n 0.0v 914.755n 0.0v 919.745n 0.0v 919.755n 0.0v 924.745n 0.0v 924.755n 0.0v 929.745n 0.0v 929.755n 1.0v 934.745n 1.0v 934.755n 1.0v 939.745n 1.0v 939.755n 1.0v 944.745n 1.0v 944.755n 1.0v 949.745n 1.0v 949.755n 1.0v 954.745n 1.0v 954.755n 1.0v 959.745n 1.0v 959.755n 1.0v 964.745n 1.0v 964.755n 1.0v 969.745n 1.0v 969.755n 1.0v 974.745n 1.0v 974.755n 1.0v 979.745n 1.0v 979.755n 1.0v 984.745n 1.0v 984.755n 1.0v 989.745n 1.0v 989.755n 1.0v 994.745n 1.0v 994.755n 1.0v 999.745n 1.0v 999.755n 1.0v 1004.745n 1.0v 1004.755n 1.0v 1009.745n 1.0v 1009.755n 1.0v 1014.745n 1.0v 1014.755n 1.0v 1019.745n 1.0v 1019.755n 1.0v 1024.745n 1.0v 1024.755n 1.0v )
* (time, data): [(0, 0), (5, 1), (10, 1), (15, 1), (20, 1), (25, 1), (30, 1), (35, 1), (40, 1), (45, 1), (50, 1), (55, 1), (60, 0), (65, 0), (70, 0), (75, 0), (80, 1), (85, 1), (90, 1), (95, 1), (100, 1), (105, 1), (110, 1), (115, 1), (120, 1), (125, 1), (130, 1), (135, 1), (140, 1), (145, 1), (150, 1), (155, 1), (160, 1), (165, 1), (170, 1), (175, 1), (180, 0), (185, 0), (190, 0), (195, 0), (200, 0), (205, 0), (210, 0), (215, 0), (220, 0), (225, 0), (230, 0), (235, 0), (240, 0), (245, 0), (250, 0), (255, 0), (260, 0), (265, 0), (270, 0), (275, 0), (280, 0), (285, 1), (290, 1), (295, 1), (300, 0), (305, 0), (310, 0), (315, 0), (320, 0), (325, 0), (330, 0), (335, 0), (340, 0), (345, 0), (350, 0), (355, 0), (360, 0), (365, 1), (370, 1), (375, 1), (380, 0), (385, 0), (390, 1), (395, 1), (400, 0), (405, 0), (410, 0), (415, 0), (420, 0), (425, 0), (430, 0), (435, 0), (440, 0), (445, 0), (450, 0), (455, 0), (460, 0), (465, 0), (470, 0), (475, 0), (480, 0), (485, 1), (490, 1), (495, 1), (500, 1), (505, 1), (510, 1), (515, 1), (520, 1), (525, 1), (530, 1), (535, 1), (540, 1), (545, 1), (550, 1), (555, 1), (560, 1), (565, 1), (570, 1), (575, 1), (580, 0), (585, 0), (590, 0), (595, 0), (600, 0), (605, 1), (610, 1), (615, 1), (620, 1), (625, 1), (630, 1), (635, 1), (640, 1), (645, 1), (650, 1), (655, 1), (660, 1), (665, 1), (670, 1), (675, 1), (680, 1), (685, 1), (690, 1), (695, 1), (700, 1), (705, 1), (710, 1), (715, 1), (720, 1), (725, 1), (730, 0), (735, 0), (740, 0), (745, 0), (750, 0), (755, 0), (760, 0), (765, 1), (770, 1), (775, 1), (780, 1), (785, 1), (790, 0), (795, 0), (800, 0), (805, 0), (810, 1), (815, 1), (820, 1), (825, 1), (830, 0), (835, 0), (840, 0), (845, 0), (850, 0), (855, 0), (860, 0), (865, 0), (870, 0), (875, 0), (880, 1), (885, 1), (890, 1), (895, 1), (900, 0), (905, 1), (910, 1), (915, 1), (920, 1), (925, 1), (930, 1), (935, 1), (940, 1), (945, 1), (950, 1), (955, 1), (960, 1), (965, 1), (970, 1), (975, 1), (980, 1), (985, 1), (990, 1), (995, 1), (1000, 0), (1005, 0), (1010, 0), (1015, 0), (1020, 0), (1025, 0)]
Vdin1_29  din1_29  0 PWL (0n 0.0v 4.745n 0.0v 4.755n 1.0v 9.745n 1.0v 9.755n 1.0v 14.745n 1.0v 14.755n 1.0v 19.745n 1.0v 19.755n 1.0v 24.745n 1.0v 24.755n 1.0v 29.745n 1.0v 29.755n 1.0v 34.745n 1.0v 34.755n 1.0v 39.745n 1.0v 39.755n 1.0v 44.745n 1.0v 44.755n 1.0v 49.745n 1.0v 49.755n 1.0v 54.745n 1.0v 54.755n 1.0v 59.745n 1.0v 59.755n 0.0v 64.745n 0.0v 64.755n 0.0v 69.745n 0.0v 69.755n 0.0v 74.745n 0.0v 74.755n 0.0v 79.745n 0.0v 79.755n 1.0v 84.745n 1.0v 84.755n 1.0v 89.745n 1.0v 89.755n 1.0v 94.745n 1.0v 94.755n 1.0v 99.745n 1.0v 99.755n 1.0v 104.745n 1.0v 104.755n 1.0v 109.745n 1.0v 109.755n 1.0v 114.745n 1.0v 114.755n 1.0v 119.745n 1.0v 119.755n 1.0v 124.745n 1.0v 124.755n 1.0v 129.745n 1.0v 129.755n 1.0v 134.745n 1.0v 134.755n 1.0v 139.745n 1.0v 139.755n 1.0v 144.745n 1.0v 144.755n 1.0v 149.745n 1.0v 149.755n 1.0v 154.745n 1.0v 154.755n 1.0v 159.745n 1.0v 159.755n 1.0v 164.745n 1.0v 164.755n 1.0v 169.745n 1.0v 169.755n 1.0v 174.745n 1.0v 174.755n 1.0v 179.745n 1.0v 179.755n 0.0v 184.745n 0.0v 184.755n 0.0v 189.745n 0.0v 189.755n 0.0v 194.745n 0.0v 194.755n 0.0v 199.745n 0.0v 199.755n 0.0v 204.745n 0.0v 204.755n 0.0v 209.745n 0.0v 209.755n 0.0v 214.745n 0.0v 214.755n 0.0v 219.745n 0.0v 219.755n 0.0v 224.745n 0.0v 224.755n 0.0v 229.745n 0.0v 229.755n 0.0v 234.745n 0.0v 234.755n 0.0v 239.745n 0.0v 239.755n 0.0v 244.745n 0.0v 244.755n 0.0v 249.745n 0.0v 249.755n 0.0v 254.745n 0.0v 254.755n 0.0v 259.745n 0.0v 259.755n 0.0v 264.745n 0.0v 264.755n 0.0v 269.745n 0.0v 269.755n 0.0v 274.745n 0.0v 274.755n 0.0v 279.745n 0.0v 279.755n 0.0v 284.745n 0.0v 284.755n 1.0v 289.745n 1.0v 289.755n 1.0v 294.745n 1.0v 294.755n 1.0v 299.745n 1.0v 299.755n 0.0v 304.745n 0.0v 304.755n 0.0v 309.745n 0.0v 309.755n 0.0v 314.745n 0.0v 314.755n 0.0v 319.745n 0.0v 319.755n 0.0v 324.745n 0.0v 324.755n 0.0v 329.745n 0.0v 329.755n 0.0v 334.745n 0.0v 334.755n 0.0v 339.745n 0.0v 339.755n 0.0v 344.745n 0.0v 344.755n 0.0v 349.745n 0.0v 349.755n 0.0v 354.745n 0.0v 354.755n 0.0v 359.745n 0.0v 359.755n 0.0v 364.745n 0.0v 364.755n 1.0v 369.745n 1.0v 369.755n 1.0v 374.745n 1.0v 374.755n 1.0v 379.745n 1.0v 379.755n 0.0v 384.745n 0.0v 384.755n 0.0v 389.745n 0.0v 389.755n 1.0v 394.745n 1.0v 394.755n 1.0v 399.745n 1.0v 399.755n 0.0v 404.745n 0.0v 404.755n 0.0v 409.745n 0.0v 409.755n 0.0v 414.745n 0.0v 414.755n 0.0v 419.745n 0.0v 419.755n 0.0v 424.745n 0.0v 424.755n 0.0v 429.745n 0.0v 429.755n 0.0v 434.745n 0.0v 434.755n 0.0v 439.745n 0.0v 439.755n 0.0v 444.745n 0.0v 444.755n 0.0v 449.745n 0.0v 449.755n 0.0v 454.745n 0.0v 454.755n 0.0v 459.745n 0.0v 459.755n 0.0v 464.745n 0.0v 464.755n 0.0v 469.745n 0.0v 469.755n 0.0v 474.745n 0.0v 474.755n 0.0v 479.745n 0.0v 479.755n 0.0v 484.745n 0.0v 484.755n 1.0v 489.745n 1.0v 489.755n 1.0v 494.745n 1.0v 494.755n 1.0v 499.745n 1.0v 499.755n 1.0v 504.745n 1.0v 504.755n 1.0v 509.745n 1.0v 509.755n 1.0v 514.745n 1.0v 514.755n 1.0v 519.745n 1.0v 519.755n 1.0v 524.745n 1.0v 524.755n 1.0v 529.745n 1.0v 529.755n 1.0v 534.745n 1.0v 534.755n 1.0v 539.745n 1.0v 539.755n 1.0v 544.745n 1.0v 544.755n 1.0v 549.745n 1.0v 549.755n 1.0v 554.745n 1.0v 554.755n 1.0v 559.745n 1.0v 559.755n 1.0v 564.745n 1.0v 564.755n 1.0v 569.745n 1.0v 569.755n 1.0v 574.745n 1.0v 574.755n 1.0v 579.745n 1.0v 579.755n 0.0v 584.745n 0.0v 584.755n 0.0v 589.745n 0.0v 589.755n 0.0v 594.745n 0.0v 594.755n 0.0v 599.745n 0.0v 599.755n 0.0v 604.745n 0.0v 604.755n 1.0v 609.745n 1.0v 609.755n 1.0v 614.745n 1.0v 614.755n 1.0v 619.745n 1.0v 619.755n 1.0v 624.745n 1.0v 624.755n 1.0v 629.745n 1.0v 629.755n 1.0v 634.745n 1.0v 634.755n 1.0v 639.745n 1.0v 639.755n 1.0v 644.745n 1.0v 644.755n 1.0v 649.745n 1.0v 649.755n 1.0v 654.745n 1.0v 654.755n 1.0v 659.745n 1.0v 659.755n 1.0v 664.745n 1.0v 664.755n 1.0v 669.745n 1.0v 669.755n 1.0v 674.745n 1.0v 674.755n 1.0v 679.745n 1.0v 679.755n 1.0v 684.745n 1.0v 684.755n 1.0v 689.745n 1.0v 689.755n 1.0v 694.745n 1.0v 694.755n 1.0v 699.745n 1.0v 699.755n 1.0v 704.745n 1.0v 704.755n 1.0v 709.745n 1.0v 709.755n 1.0v 714.745n 1.0v 714.755n 1.0v 719.745n 1.0v 719.755n 1.0v 724.745n 1.0v 724.755n 1.0v 729.745n 1.0v 729.755n 0.0v 734.745n 0.0v 734.755n 0.0v 739.745n 0.0v 739.755n 0.0v 744.745n 0.0v 744.755n 0.0v 749.745n 0.0v 749.755n 0.0v 754.745n 0.0v 754.755n 0.0v 759.745n 0.0v 759.755n 0.0v 764.745n 0.0v 764.755n 1.0v 769.745n 1.0v 769.755n 1.0v 774.745n 1.0v 774.755n 1.0v 779.745n 1.0v 779.755n 1.0v 784.745n 1.0v 784.755n 1.0v 789.745n 1.0v 789.755n 0.0v 794.745n 0.0v 794.755n 0.0v 799.745n 0.0v 799.755n 0.0v 804.745n 0.0v 804.755n 0.0v 809.745n 0.0v 809.755n 1.0v 814.745n 1.0v 814.755n 1.0v 819.745n 1.0v 819.755n 1.0v 824.745n 1.0v 824.755n 1.0v 829.745n 1.0v 829.755n 0.0v 834.745n 0.0v 834.755n 0.0v 839.745n 0.0v 839.755n 0.0v 844.745n 0.0v 844.755n 0.0v 849.745n 0.0v 849.755n 0.0v 854.745n 0.0v 854.755n 0.0v 859.745n 0.0v 859.755n 0.0v 864.745n 0.0v 864.755n 0.0v 869.745n 0.0v 869.755n 0.0v 874.745n 0.0v 874.755n 0.0v 879.745n 0.0v 879.755n 1.0v 884.745n 1.0v 884.755n 1.0v 889.745n 1.0v 889.755n 1.0v 894.745n 1.0v 894.755n 1.0v 899.745n 1.0v 899.755n 0.0v 904.745n 0.0v 904.755n 1.0v 909.745n 1.0v 909.755n 1.0v 914.745n 1.0v 914.755n 1.0v 919.745n 1.0v 919.755n 1.0v 924.745n 1.0v 924.755n 1.0v 929.745n 1.0v 929.755n 1.0v 934.745n 1.0v 934.755n 1.0v 939.745n 1.0v 939.755n 1.0v 944.745n 1.0v 944.755n 1.0v 949.745n 1.0v 949.755n 1.0v 954.745n 1.0v 954.755n 1.0v 959.745n 1.0v 959.755n 1.0v 964.745n 1.0v 964.755n 1.0v 969.745n 1.0v 969.755n 1.0v 974.745n 1.0v 974.755n 1.0v 979.745n 1.0v 979.755n 1.0v 984.745n 1.0v 984.755n 1.0v 989.745n 1.0v 989.755n 1.0v 994.745n 1.0v 994.755n 1.0v 999.745n 1.0v 999.755n 0.0v 1004.745n 0.0v 1004.755n 0.0v 1009.745n 0.0v 1009.755n 0.0v 1014.745n 0.0v 1014.755n 0.0v 1019.745n 0.0v 1019.755n 0.0v 1024.745n 0.0v 1024.755n 0.0v )
* (time, data): [(0, 0), (5, 0), (10, 1), (15, 1), (20, 1), (25, 1), (30, 1), (35, 1), (40, 1), (45, 1), (50, 1), (55, 1), (60, 0), (65, 0), (70, 0), (75, 0), (80, 1), (85, 1), (90, 1), (95, 1), (100, 1), (105, 1), (110, 1), (115, 1), (120, 1), (125, 1), (130, 0), (135, 0), (140, 0), (145, 0), (150, 0), (155, 0), (160, 0), (165, 0), (170, 0), (175, 1), (180, 1), (185, 1), (190, 1), (195, 1), (200, 1), (205, 1), (210, 1), (215, 1), (220, 1), (225, 1), (230, 1), (235, 1), (240, 1), (245, 1), (250, 1), (255, 1), (260, 1), (265, 1), (270, 1), (275, 1), (280, 1), (285, 1), (290, 1), (295, 1), (300, 0), (305, 0), (310, 0), (315, 0), (320, 0), (325, 0), (330, 0), (335, 0), (340, 0), (345, 0), (350, 0), (355, 0), (360, 0), (365, 0), (370, 0), (375, 0), (380, 0), (385, 0), (390, 0), (395, 1), (400, 0), (405, 0), (410, 0), (415, 0), (420, 0), (425, 0), (430, 0), (435, 0), (440, 0), (445, 0), (450, 0), (455, 0), (460, 0), (465, 1), (470, 1), (475, 1), (480, 1), (485, 1), (490, 1), (495, 1), (500, 1), (505, 1), (510, 1), (515, 1), (520, 0), (525, 0), (530, 0), (535, 0), (540, 0), (545, 0), (550, 0), (555, 0), (560, 0), (565, 0), (570, 0), (575, 0), (580, 0), (585, 1), (590, 1), (595, 1), (600, 1), (605, 1), (610, 1), (615, 1), (620, 1), (625, 1), (630, 1), (635, 1), (640, 1), (645, 1), (650, 1), (655, 1), (660, 1), (665, 1), (670, 1), (675, 1), (680, 1), (685, 1), (690, 1), (695, 1), (700, 1), (705, 1), (710, 1), (715, 1), (720, 1), (725, 1), (730, 0), (735, 1), (740, 1), (745, 1), (750, 1), (755, 1), (760, 0), (765, 1), (770, 0), (775, 0), (780, 0), (785, 0), (790, 0), (795, 0), (800, 0), (805, 0), (810, 0), (815, 0), (820, 0), (825, 0), (830, 0), (835, 0), (840, 0), (845, 0), (850, 0), (855, 0), (860, 1), (865, 1), (870, 1), (875, 1), (880, 0), (885, 0), (890, 0), (895, 0), (900, 0), (905, 1), (910, 1), (915, 1), (920, 1), (925, 0), (930, 0), (935, 0), (940, 0), (945, 0), (950, 0), (955, 0), (960, 0), (965, 0), (970, 0), (975, 0), (980, 0), (985, 0), (990, 0), (995, 0), (1000, 0), (1005, 0), (1010, 1), (1015, 1), (1020, 0), (1025, 0)]
Vdin1_30  din1_30  0 PWL (0n 0.0v 4.745n 0.0v 4.755n 0.0v 9.745n 0.0v 9.755n 1.0v 14.745n 1.0v 14.755n 1.0v 19.745n 1.0v 19.755n 1.0v 24.745n 1.0v 24.755n 1.0v 29.745n 1.0v 29.755n 1.0v 34.745n 1.0v 34.755n 1.0v 39.745n 1.0v 39.755n 1.0v 44.745n 1.0v 44.755n 1.0v 49.745n 1.0v 49.755n 1.0v 54.745n 1.0v 54.755n 1.0v 59.745n 1.0v 59.755n 0.0v 64.745n 0.0v 64.755n 0.0v 69.745n 0.0v 69.755n 0.0v 74.745n 0.0v 74.755n 0.0v 79.745n 0.0v 79.755n 1.0v 84.745n 1.0v 84.755n 1.0v 89.745n 1.0v 89.755n 1.0v 94.745n 1.0v 94.755n 1.0v 99.745n 1.0v 99.755n 1.0v 104.745n 1.0v 104.755n 1.0v 109.745n 1.0v 109.755n 1.0v 114.745n 1.0v 114.755n 1.0v 119.745n 1.0v 119.755n 1.0v 124.745n 1.0v 124.755n 1.0v 129.745n 1.0v 129.755n 0.0v 134.745n 0.0v 134.755n 0.0v 139.745n 0.0v 139.755n 0.0v 144.745n 0.0v 144.755n 0.0v 149.745n 0.0v 149.755n 0.0v 154.745n 0.0v 154.755n 0.0v 159.745n 0.0v 159.755n 0.0v 164.745n 0.0v 164.755n 0.0v 169.745n 0.0v 169.755n 0.0v 174.745n 0.0v 174.755n 1.0v 179.745n 1.0v 179.755n 1.0v 184.745n 1.0v 184.755n 1.0v 189.745n 1.0v 189.755n 1.0v 194.745n 1.0v 194.755n 1.0v 199.745n 1.0v 199.755n 1.0v 204.745n 1.0v 204.755n 1.0v 209.745n 1.0v 209.755n 1.0v 214.745n 1.0v 214.755n 1.0v 219.745n 1.0v 219.755n 1.0v 224.745n 1.0v 224.755n 1.0v 229.745n 1.0v 229.755n 1.0v 234.745n 1.0v 234.755n 1.0v 239.745n 1.0v 239.755n 1.0v 244.745n 1.0v 244.755n 1.0v 249.745n 1.0v 249.755n 1.0v 254.745n 1.0v 254.755n 1.0v 259.745n 1.0v 259.755n 1.0v 264.745n 1.0v 264.755n 1.0v 269.745n 1.0v 269.755n 1.0v 274.745n 1.0v 274.755n 1.0v 279.745n 1.0v 279.755n 1.0v 284.745n 1.0v 284.755n 1.0v 289.745n 1.0v 289.755n 1.0v 294.745n 1.0v 294.755n 1.0v 299.745n 1.0v 299.755n 0.0v 304.745n 0.0v 304.755n 0.0v 309.745n 0.0v 309.755n 0.0v 314.745n 0.0v 314.755n 0.0v 319.745n 0.0v 319.755n 0.0v 324.745n 0.0v 324.755n 0.0v 329.745n 0.0v 329.755n 0.0v 334.745n 0.0v 334.755n 0.0v 339.745n 0.0v 339.755n 0.0v 344.745n 0.0v 344.755n 0.0v 349.745n 0.0v 349.755n 0.0v 354.745n 0.0v 354.755n 0.0v 359.745n 0.0v 359.755n 0.0v 364.745n 0.0v 364.755n 0.0v 369.745n 0.0v 369.755n 0.0v 374.745n 0.0v 374.755n 0.0v 379.745n 0.0v 379.755n 0.0v 384.745n 0.0v 384.755n 0.0v 389.745n 0.0v 389.755n 0.0v 394.745n 0.0v 394.755n 1.0v 399.745n 1.0v 399.755n 0.0v 404.745n 0.0v 404.755n 0.0v 409.745n 0.0v 409.755n 0.0v 414.745n 0.0v 414.755n 0.0v 419.745n 0.0v 419.755n 0.0v 424.745n 0.0v 424.755n 0.0v 429.745n 0.0v 429.755n 0.0v 434.745n 0.0v 434.755n 0.0v 439.745n 0.0v 439.755n 0.0v 444.745n 0.0v 444.755n 0.0v 449.745n 0.0v 449.755n 0.0v 454.745n 0.0v 454.755n 0.0v 459.745n 0.0v 459.755n 0.0v 464.745n 0.0v 464.755n 1.0v 469.745n 1.0v 469.755n 1.0v 474.745n 1.0v 474.755n 1.0v 479.745n 1.0v 479.755n 1.0v 484.745n 1.0v 484.755n 1.0v 489.745n 1.0v 489.755n 1.0v 494.745n 1.0v 494.755n 1.0v 499.745n 1.0v 499.755n 1.0v 504.745n 1.0v 504.755n 1.0v 509.745n 1.0v 509.755n 1.0v 514.745n 1.0v 514.755n 1.0v 519.745n 1.0v 519.755n 0.0v 524.745n 0.0v 524.755n 0.0v 529.745n 0.0v 529.755n 0.0v 534.745n 0.0v 534.755n 0.0v 539.745n 0.0v 539.755n 0.0v 544.745n 0.0v 544.755n 0.0v 549.745n 0.0v 549.755n 0.0v 554.745n 0.0v 554.755n 0.0v 559.745n 0.0v 559.755n 0.0v 564.745n 0.0v 564.755n 0.0v 569.745n 0.0v 569.755n 0.0v 574.745n 0.0v 574.755n 0.0v 579.745n 0.0v 579.755n 0.0v 584.745n 0.0v 584.755n 1.0v 589.745n 1.0v 589.755n 1.0v 594.745n 1.0v 594.755n 1.0v 599.745n 1.0v 599.755n 1.0v 604.745n 1.0v 604.755n 1.0v 609.745n 1.0v 609.755n 1.0v 614.745n 1.0v 614.755n 1.0v 619.745n 1.0v 619.755n 1.0v 624.745n 1.0v 624.755n 1.0v 629.745n 1.0v 629.755n 1.0v 634.745n 1.0v 634.755n 1.0v 639.745n 1.0v 639.755n 1.0v 644.745n 1.0v 644.755n 1.0v 649.745n 1.0v 649.755n 1.0v 654.745n 1.0v 654.755n 1.0v 659.745n 1.0v 659.755n 1.0v 664.745n 1.0v 664.755n 1.0v 669.745n 1.0v 669.755n 1.0v 674.745n 1.0v 674.755n 1.0v 679.745n 1.0v 679.755n 1.0v 684.745n 1.0v 684.755n 1.0v 689.745n 1.0v 689.755n 1.0v 694.745n 1.0v 694.755n 1.0v 699.745n 1.0v 699.755n 1.0v 704.745n 1.0v 704.755n 1.0v 709.745n 1.0v 709.755n 1.0v 714.745n 1.0v 714.755n 1.0v 719.745n 1.0v 719.755n 1.0v 724.745n 1.0v 724.755n 1.0v 729.745n 1.0v 729.755n 0.0v 734.745n 0.0v 734.755n 1.0v 739.745n 1.0v 739.755n 1.0v 744.745n 1.0v 744.755n 1.0v 749.745n 1.0v 749.755n 1.0v 754.745n 1.0v 754.755n 1.0v 759.745n 1.0v 759.755n 0.0v 764.745n 0.0v 764.755n 1.0v 769.745n 1.0v 769.755n 0.0v 774.745n 0.0v 774.755n 0.0v 779.745n 0.0v 779.755n 0.0v 784.745n 0.0v 784.755n 0.0v 789.745n 0.0v 789.755n 0.0v 794.745n 0.0v 794.755n 0.0v 799.745n 0.0v 799.755n 0.0v 804.745n 0.0v 804.755n 0.0v 809.745n 0.0v 809.755n 0.0v 814.745n 0.0v 814.755n 0.0v 819.745n 0.0v 819.755n 0.0v 824.745n 0.0v 824.755n 0.0v 829.745n 0.0v 829.755n 0.0v 834.745n 0.0v 834.755n 0.0v 839.745n 0.0v 839.755n 0.0v 844.745n 0.0v 844.755n 0.0v 849.745n 0.0v 849.755n 0.0v 854.745n 0.0v 854.755n 0.0v 859.745n 0.0v 859.755n 1.0v 864.745n 1.0v 864.755n 1.0v 869.745n 1.0v 869.755n 1.0v 874.745n 1.0v 874.755n 1.0v 879.745n 1.0v 879.755n 0.0v 884.745n 0.0v 884.755n 0.0v 889.745n 0.0v 889.755n 0.0v 894.745n 0.0v 894.755n 0.0v 899.745n 0.0v 899.755n 0.0v 904.745n 0.0v 904.755n 1.0v 909.745n 1.0v 909.755n 1.0v 914.745n 1.0v 914.755n 1.0v 919.745n 1.0v 919.755n 1.0v 924.745n 1.0v 924.755n 0.0v 929.745n 0.0v 929.755n 0.0v 934.745n 0.0v 934.755n 0.0v 939.745n 0.0v 939.755n 0.0v 944.745n 0.0v 944.755n 0.0v 949.745n 0.0v 949.755n 0.0v 954.745n 0.0v 954.755n 0.0v 959.745n 0.0v 959.755n 0.0v 964.745n 0.0v 964.755n 0.0v 969.745n 0.0v 969.755n 0.0v 974.745n 0.0v 974.755n 0.0v 979.745n 0.0v 979.755n 0.0v 984.745n 0.0v 984.755n 0.0v 989.745n 0.0v 989.755n 0.0v 994.745n 0.0v 994.755n 0.0v 999.745n 0.0v 999.755n 0.0v 1004.745n 0.0v 1004.755n 0.0v 1009.745n 0.0v 1009.755n 1.0v 1014.745n 1.0v 1014.755n 1.0v 1019.745n 1.0v 1019.755n 0.0v 1024.745n 0.0v 1024.755n 0.0v )
* (time, data): [(0, 0), (5, 1), (10, 1), (15, 1), (20, 1), (25, 1), (30, 1), (35, 1), (40, 1), (45, 1), (50, 1), (55, 1), (60, 1), (65, 1), (70, 1), (75, 1), (80, 0), (85, 0), (90, 1), (95, 1), (100, 1), (105, 1), (110, 1), (115, 1), (120, 1), (125, 1), (130, 1), (135, 1), (140, 1), (145, 1), (150, 1), (155, 1), (160, 1), (165, 1), (170, 1), (175, 0), (180, 0), (185, 0), (190, 0), (195, 0), (200, 0), (205, 0), (210, 0), (215, 0), (220, 0), (225, 0), (230, 0), (235, 0), (240, 0), (245, 0), (250, 0), (255, 0), (260, 0), (265, 0), (270, 0), (275, 0), (280, 0), (285, 1), (290, 1), (295, 1), (300, 1), (305, 1), (310, 1), (315, 1), (320, 1), (325, 1), (330, 1), (335, 1), (340, 1), (345, 1), (350, 1), (355, 1), (360, 1), (365, 1), (370, 1), (375, 1), (380, 0), (385, 0), (390, 1), (395, 0), (400, 0), (405, 0), (410, 0), (415, 0), (420, 1), (425, 1), (430, 1), (435, 1), (440, 1), (445, 1), (450, 1), (455, 1), (460, 1), (465, 0), (470, 0), (475, 0), (480, 0), (485, 0), (490, 0), (495, 0), (500, 0), (505, 0), (510, 0), (515, 0), (520, 0), (525, 0), (530, 0), (535, 0), (540, 0), (545, 0), (550, 0), (555, 0), (560, 0), (565, 0), (570, 0), (575, 0), (580, 1), (585, 0), (590, 0), (595, 0), (600, 0), (605, 0), (610, 0), (615, 1), (620, 1), (625, 1), (630, 1), (635, 1), (640, 1), (645, 1), (650, 1), (655, 1), (660, 1), (665, 1), (670, 1), (675, 1), (680, 1), (685, 1), (690, 0), (695, 0), (700, 0), (705, 0), (710, 0), (715, 0), (720, 0), (725, 0), (730, 0), (735, 0), (740, 0), (745, 0), (750, 0), (755, 0), (760, 0), (765, 1), (770, 0), (775, 0), (780, 0), (785, 0), (790, 0), (795, 0), (800, 0), (805, 0), (810, 0), (815, 0), (820, 0), (825, 0), (830, 0), (835, 0), (840, 0), (845, 0), (850, 0), (855, 0), (860, 0), (865, 0), (870, 0), (875, 0), (880, 0), (885, 0), (890, 0), (895, 0), (900, 1), (905, 1), (910, 1), (915, 1), (920, 1), (925, 0), (930, 0), (935, 0), (940, 0), (945, 0), (950, 0), (955, 0), (960, 0), (965, 0), (970, 0), (975, 0), (980, 0), (985, 0), (990, 0), (995, 0), (1000, 1), (1005, 1), (1010, 0), (1015, 0), (1020, 0), (1025, 0)]
Vdin1_31  din1_31  0 PWL (0n 0.0v 4.745n 0.0v 4.755n 1.0v 9.745n 1.0v 9.755n 1.0v 14.745n 1.0v 14.755n 1.0v 19.745n 1.0v 19.755n 1.0v 24.745n 1.0v 24.755n 1.0v 29.745n 1.0v 29.755n 1.0v 34.745n 1.0v 34.755n 1.0v 39.745n 1.0v 39.755n 1.0v 44.745n 1.0v 44.755n 1.0v 49.745n 1.0v 49.755n 1.0v 54.745n 1.0v 54.755n 1.0v 59.745n 1.0v 59.755n 1.0v 64.745n 1.0v 64.755n 1.0v 69.745n 1.0v 69.755n 1.0v 74.745n 1.0v 74.755n 1.0v 79.745n 1.0v 79.755n 0.0v 84.745n 0.0v 84.755n 0.0v 89.745n 0.0v 89.755n 1.0v 94.745n 1.0v 94.755n 1.0v 99.745n 1.0v 99.755n 1.0v 104.745n 1.0v 104.755n 1.0v 109.745n 1.0v 109.755n 1.0v 114.745n 1.0v 114.755n 1.0v 119.745n 1.0v 119.755n 1.0v 124.745n 1.0v 124.755n 1.0v 129.745n 1.0v 129.755n 1.0v 134.745n 1.0v 134.755n 1.0v 139.745n 1.0v 139.755n 1.0v 144.745n 1.0v 144.755n 1.0v 149.745n 1.0v 149.755n 1.0v 154.745n 1.0v 154.755n 1.0v 159.745n 1.0v 159.755n 1.0v 164.745n 1.0v 164.755n 1.0v 169.745n 1.0v 169.755n 1.0v 174.745n 1.0v 174.755n 0.0v 179.745n 0.0v 179.755n 0.0v 184.745n 0.0v 184.755n 0.0v 189.745n 0.0v 189.755n 0.0v 194.745n 0.0v 194.755n 0.0v 199.745n 0.0v 199.755n 0.0v 204.745n 0.0v 204.755n 0.0v 209.745n 0.0v 209.755n 0.0v 214.745n 0.0v 214.755n 0.0v 219.745n 0.0v 219.755n 0.0v 224.745n 0.0v 224.755n 0.0v 229.745n 0.0v 229.755n 0.0v 234.745n 0.0v 234.755n 0.0v 239.745n 0.0v 239.755n 0.0v 244.745n 0.0v 244.755n 0.0v 249.745n 0.0v 249.755n 0.0v 254.745n 0.0v 254.755n 0.0v 259.745n 0.0v 259.755n 0.0v 264.745n 0.0v 264.755n 0.0v 269.745n 0.0v 269.755n 0.0v 274.745n 0.0v 274.755n 0.0v 279.745n 0.0v 279.755n 0.0v 284.745n 0.0v 284.755n 1.0v 289.745n 1.0v 289.755n 1.0v 294.745n 1.0v 294.755n 1.0v 299.745n 1.0v 299.755n 1.0v 304.745n 1.0v 304.755n 1.0v 309.745n 1.0v 309.755n 1.0v 314.745n 1.0v 314.755n 1.0v 319.745n 1.0v 319.755n 1.0v 324.745n 1.0v 324.755n 1.0v 329.745n 1.0v 329.755n 1.0v 334.745n 1.0v 334.755n 1.0v 339.745n 1.0v 339.755n 1.0v 344.745n 1.0v 344.755n 1.0v 349.745n 1.0v 349.755n 1.0v 354.745n 1.0v 354.755n 1.0v 359.745n 1.0v 359.755n 1.0v 364.745n 1.0v 364.755n 1.0v 369.745n 1.0v 369.755n 1.0v 374.745n 1.0v 374.755n 1.0v 379.745n 1.0v 379.755n 0.0v 384.745n 0.0v 384.755n 0.0v 389.745n 0.0v 389.755n 1.0v 394.745n 1.0v 394.755n 0.0v 399.745n 0.0v 399.755n 0.0v 404.745n 0.0v 404.755n 0.0v 409.745n 0.0v 409.755n 0.0v 414.745n 0.0v 414.755n 0.0v 419.745n 0.0v 419.755n 1.0v 424.745n 1.0v 424.755n 1.0v 429.745n 1.0v 429.755n 1.0v 434.745n 1.0v 434.755n 1.0v 439.745n 1.0v 439.755n 1.0v 444.745n 1.0v 444.755n 1.0v 449.745n 1.0v 449.755n 1.0v 454.745n 1.0v 454.755n 1.0v 459.745n 1.0v 459.755n 1.0v 464.745n 1.0v 464.755n 0.0v 469.745n 0.0v 469.755n 0.0v 474.745n 0.0v 474.755n 0.0v 479.745n 0.0v 479.755n 0.0v 484.745n 0.0v 484.755n 0.0v 489.745n 0.0v 489.755n 0.0v 494.745n 0.0v 494.755n 0.0v 499.745n 0.0v 499.755n 0.0v 504.745n 0.0v 504.755n 0.0v 509.745n 0.0v 509.755n 0.0v 514.745n 0.0v 514.755n 0.0v 519.745n 0.0v 519.755n 0.0v 524.745n 0.0v 524.755n 0.0v 529.745n 0.0v 529.755n 0.0v 534.745n 0.0v 534.755n 0.0v 539.745n 0.0v 539.755n 0.0v 544.745n 0.0v 544.755n 0.0v 549.745n 0.0v 549.755n 0.0v 554.745n 0.0v 554.755n 0.0v 559.745n 0.0v 559.755n 0.0v 564.745n 0.0v 564.755n 0.0v 569.745n 0.0v 569.755n 0.0v 574.745n 0.0v 574.755n 0.0v 579.745n 0.0v 579.755n 1.0v 584.745n 1.0v 584.755n 0.0v 589.745n 0.0v 589.755n 0.0v 594.745n 0.0v 594.755n 0.0v 599.745n 0.0v 599.755n 0.0v 604.745n 0.0v 604.755n 0.0v 609.745n 0.0v 609.755n 0.0v 614.745n 0.0v 614.755n 1.0v 619.745n 1.0v 619.755n 1.0v 624.745n 1.0v 624.755n 1.0v 629.745n 1.0v 629.755n 1.0v 634.745n 1.0v 634.755n 1.0v 639.745n 1.0v 639.755n 1.0v 644.745n 1.0v 644.755n 1.0v 649.745n 1.0v 649.755n 1.0v 654.745n 1.0v 654.755n 1.0v 659.745n 1.0v 659.755n 1.0v 664.745n 1.0v 664.755n 1.0v 669.745n 1.0v 669.755n 1.0v 674.745n 1.0v 674.755n 1.0v 679.745n 1.0v 679.755n 1.0v 684.745n 1.0v 684.755n 1.0v 689.745n 1.0v 689.755n 0.0v 694.745n 0.0v 694.755n 0.0v 699.745n 0.0v 699.755n 0.0v 704.745n 0.0v 704.755n 0.0v 709.745n 0.0v 709.755n 0.0v 714.745n 0.0v 714.755n 0.0v 719.745n 0.0v 719.755n 0.0v 724.745n 0.0v 724.755n 0.0v 729.745n 0.0v 729.755n 0.0v 734.745n 0.0v 734.755n 0.0v 739.745n 0.0v 739.755n 0.0v 744.745n 0.0v 744.755n 0.0v 749.745n 0.0v 749.755n 0.0v 754.745n 0.0v 754.755n 0.0v 759.745n 0.0v 759.755n 0.0v 764.745n 0.0v 764.755n 1.0v 769.745n 1.0v 769.755n 0.0v 774.745n 0.0v 774.755n 0.0v 779.745n 0.0v 779.755n 0.0v 784.745n 0.0v 784.755n 0.0v 789.745n 0.0v 789.755n 0.0v 794.745n 0.0v 794.755n 0.0v 799.745n 0.0v 799.755n 0.0v 804.745n 0.0v 804.755n 0.0v 809.745n 0.0v 809.755n 0.0v 814.745n 0.0v 814.755n 0.0v 819.745n 0.0v 819.755n 0.0v 824.745n 0.0v 824.755n 0.0v 829.745n 0.0v 829.755n 0.0v 834.745n 0.0v 834.755n 0.0v 839.745n 0.0v 839.755n 0.0v 844.745n 0.0v 844.755n 0.0v 849.745n 0.0v 849.755n 0.0v 854.745n 0.0v 854.755n 0.0v 859.745n 0.0v 859.755n 0.0v 864.745n 0.0v 864.755n 0.0v 869.745n 0.0v 869.755n 0.0v 874.745n 0.0v 874.755n 0.0v 879.745n 0.0v 879.755n 0.0v 884.745n 0.0v 884.755n 0.0v 889.745n 0.0v 889.755n 0.0v 894.745n 0.0v 894.755n 0.0v 899.745n 0.0v 899.755n 1.0v 904.745n 1.0v 904.755n 1.0v 909.745n 1.0v 909.755n 1.0v 914.745n 1.0v 914.755n 1.0v 919.745n 1.0v 919.755n 1.0v 924.745n 1.0v 924.755n 0.0v 929.745n 0.0v 929.755n 0.0v 934.745n 0.0v 934.755n 0.0v 939.745n 0.0v 939.755n 0.0v 944.745n 0.0v 944.755n 0.0v 949.745n 0.0v 949.755n 0.0v 954.745n 0.0v 954.755n 0.0v 959.745n 0.0v 959.755n 0.0v 964.745n 0.0v 964.755n 0.0v 969.745n 0.0v 969.755n 0.0v 974.745n 0.0v 974.755n 0.0v 979.745n 0.0v 979.755n 0.0v 984.745n 0.0v 984.755n 0.0v 989.745n 0.0v 989.755n 0.0v 994.745n 0.0v 994.755n 0.0v 999.745n 0.0v 999.755n 1.0v 1004.745n 1.0v 1004.755n 1.0v 1009.745n 1.0v 1009.755n 0.0v 1014.745n 0.0v 1014.755n 0.0v 1019.745n 0.0v 1019.755n 0.0v 1024.745n 0.0v 1024.755n 0.0v )
* (time, data): [(0, 0), (5, 1), (10, 0), (15, 1), (20, 1), (25, 1), (30, 1), (35, 1), (40, 1), (45, 1), (50, 1), (55, 1), (60, 1), (65, 1), (70, 1), (75, 1), (80, 1), (85, 1), (90, 0), (95, 0), (100, 0), (105, 0), (110, 0), (115, 0), (120, 0), (125, 0), (130, 0), (135, 0), (140, 0), (145, 1), (150, 1), (155, 1), (160, 1), (165, 1), (170, 1), (175, 0), (180, 1), (185, 1), (190, 1), (195, 1), (200, 1), (205, 1), (210, 1), (215, 1), (220, 1), (225, 1), (230, 1), (235, 1), (240, 1), (245, 0), (250, 0), (255, 0), (260, 0), (265, 0), (270, 0), (275, 0), (280, 0), (285, 1), (290, 1), (295, 1), (300, 1), (305, 1), (310, 1), (315, 1), (320, 1), (325, 1), (330, 1), (335, 1), (340, 1), (345, 1), (350, 1), (355, 1), (360, 1), (365, 1), (370, 1), (375, 1), (380, 1), (385, 1), (390, 1), (395, 0), (400, 1), (405, 1), (410, 1), (415, 1), (420, 0), (425, 0), (430, 0), (435, 0), (440, 0), (445, 0), (450, 0), (455, 0), (460, 0), (465, 1), (470, 1), (475, 1), (480, 1), (485, 0), (490, 0), (495, 0), (500, 0), (505, 0), (510, 0), (515, 0), (520, 0), (525, 0), (530, 0), (535, 0), (540, 0), (545, 0), (550, 0), (555, 0), (560, 0), (565, 0), (570, 0), (575, 0), (580, 0), (585, 0), (590, 0), (595, 0), (600, 0), (605, 0), (610, 0), (615, 1), (620, 1), (625, 1), (630, 1), (635, 1), (640, 1), (645, 1), (650, 1), (655, 1), (660, 1), (665, 1), (670, 1), (675, 1), (680, 1), (685, 1), (690, 0), (695, 0), (700, 0), (705, 0), (710, 0), (715, 0), (720, 0), (725, 0), (730, 1), (735, 1), (740, 1), (745, 1), (750, 1), (755, 1), (760, 1), (765, 1), (770, 0), (775, 0), (780, 0), (785, 0), (790, 1), (795, 1), (800, 1), (805, 1), (810, 1), (815, 1), (820, 1), (825, 1), (830, 1), (835, 1), (840, 1), (845, 1), (850, 1), (855, 1), (860, 1), (865, 1), (870, 1), (875, 1), (880, 0), (885, 0), (890, 0), (895, 0), (900, 0), (905, 0), (910, 0), (915, 0), (920, 0), (925, 1), (930, 1), (935, 1), (940, 1), (945, 0), (950, 0), (955, 0), (960, 0), (965, 0), (970, 0), (975, 0), (980, 0), (985, 0), (990, 0), (995, 0), (1000, 1), (1005, 1), (1010, 1), (1015, 1), (1020, 1), (1025, 1)]
Vdin1_32  din1_32  0 PWL (0n 0.0v 4.745n 0.0v 4.755n 1.0v 9.745n 1.0v 9.755n 0.0v 14.745n 0.0v 14.755n 1.0v 19.745n 1.0v 19.755n 1.0v 24.745n 1.0v 24.755n 1.0v 29.745n 1.0v 29.755n 1.0v 34.745n 1.0v 34.755n 1.0v 39.745n 1.0v 39.755n 1.0v 44.745n 1.0v 44.755n 1.0v 49.745n 1.0v 49.755n 1.0v 54.745n 1.0v 54.755n 1.0v 59.745n 1.0v 59.755n 1.0v 64.745n 1.0v 64.755n 1.0v 69.745n 1.0v 69.755n 1.0v 74.745n 1.0v 74.755n 1.0v 79.745n 1.0v 79.755n 1.0v 84.745n 1.0v 84.755n 1.0v 89.745n 1.0v 89.755n 0.0v 94.745n 0.0v 94.755n 0.0v 99.745n 0.0v 99.755n 0.0v 104.745n 0.0v 104.755n 0.0v 109.745n 0.0v 109.755n 0.0v 114.745n 0.0v 114.755n 0.0v 119.745n 0.0v 119.755n 0.0v 124.745n 0.0v 124.755n 0.0v 129.745n 0.0v 129.755n 0.0v 134.745n 0.0v 134.755n 0.0v 139.745n 0.0v 139.755n 0.0v 144.745n 0.0v 144.755n 1.0v 149.745n 1.0v 149.755n 1.0v 154.745n 1.0v 154.755n 1.0v 159.745n 1.0v 159.755n 1.0v 164.745n 1.0v 164.755n 1.0v 169.745n 1.0v 169.755n 1.0v 174.745n 1.0v 174.755n 0.0v 179.745n 0.0v 179.755n 1.0v 184.745n 1.0v 184.755n 1.0v 189.745n 1.0v 189.755n 1.0v 194.745n 1.0v 194.755n 1.0v 199.745n 1.0v 199.755n 1.0v 204.745n 1.0v 204.755n 1.0v 209.745n 1.0v 209.755n 1.0v 214.745n 1.0v 214.755n 1.0v 219.745n 1.0v 219.755n 1.0v 224.745n 1.0v 224.755n 1.0v 229.745n 1.0v 229.755n 1.0v 234.745n 1.0v 234.755n 1.0v 239.745n 1.0v 239.755n 1.0v 244.745n 1.0v 244.755n 0.0v 249.745n 0.0v 249.755n 0.0v 254.745n 0.0v 254.755n 0.0v 259.745n 0.0v 259.755n 0.0v 264.745n 0.0v 264.755n 0.0v 269.745n 0.0v 269.755n 0.0v 274.745n 0.0v 274.755n 0.0v 279.745n 0.0v 279.755n 0.0v 284.745n 0.0v 284.755n 1.0v 289.745n 1.0v 289.755n 1.0v 294.745n 1.0v 294.755n 1.0v 299.745n 1.0v 299.755n 1.0v 304.745n 1.0v 304.755n 1.0v 309.745n 1.0v 309.755n 1.0v 314.745n 1.0v 314.755n 1.0v 319.745n 1.0v 319.755n 1.0v 324.745n 1.0v 324.755n 1.0v 329.745n 1.0v 329.755n 1.0v 334.745n 1.0v 334.755n 1.0v 339.745n 1.0v 339.755n 1.0v 344.745n 1.0v 344.755n 1.0v 349.745n 1.0v 349.755n 1.0v 354.745n 1.0v 354.755n 1.0v 359.745n 1.0v 359.755n 1.0v 364.745n 1.0v 364.755n 1.0v 369.745n 1.0v 369.755n 1.0v 374.745n 1.0v 374.755n 1.0v 379.745n 1.0v 379.755n 1.0v 384.745n 1.0v 384.755n 1.0v 389.745n 1.0v 389.755n 1.0v 394.745n 1.0v 394.755n 0.0v 399.745n 0.0v 399.755n 1.0v 404.745n 1.0v 404.755n 1.0v 409.745n 1.0v 409.755n 1.0v 414.745n 1.0v 414.755n 1.0v 419.745n 1.0v 419.755n 0.0v 424.745n 0.0v 424.755n 0.0v 429.745n 0.0v 429.755n 0.0v 434.745n 0.0v 434.755n 0.0v 439.745n 0.0v 439.755n 0.0v 444.745n 0.0v 444.755n 0.0v 449.745n 0.0v 449.755n 0.0v 454.745n 0.0v 454.755n 0.0v 459.745n 0.0v 459.755n 0.0v 464.745n 0.0v 464.755n 1.0v 469.745n 1.0v 469.755n 1.0v 474.745n 1.0v 474.755n 1.0v 479.745n 1.0v 479.755n 1.0v 484.745n 1.0v 484.755n 0.0v 489.745n 0.0v 489.755n 0.0v 494.745n 0.0v 494.755n 0.0v 499.745n 0.0v 499.755n 0.0v 504.745n 0.0v 504.755n 0.0v 509.745n 0.0v 509.755n 0.0v 514.745n 0.0v 514.755n 0.0v 519.745n 0.0v 519.755n 0.0v 524.745n 0.0v 524.755n 0.0v 529.745n 0.0v 529.755n 0.0v 534.745n 0.0v 534.755n 0.0v 539.745n 0.0v 539.755n 0.0v 544.745n 0.0v 544.755n 0.0v 549.745n 0.0v 549.755n 0.0v 554.745n 0.0v 554.755n 0.0v 559.745n 0.0v 559.755n 0.0v 564.745n 0.0v 564.755n 0.0v 569.745n 0.0v 569.755n 0.0v 574.745n 0.0v 574.755n 0.0v 579.745n 0.0v 579.755n 0.0v 584.745n 0.0v 584.755n 0.0v 589.745n 0.0v 589.755n 0.0v 594.745n 0.0v 594.755n 0.0v 599.745n 0.0v 599.755n 0.0v 604.745n 0.0v 604.755n 0.0v 609.745n 0.0v 609.755n 0.0v 614.745n 0.0v 614.755n 1.0v 619.745n 1.0v 619.755n 1.0v 624.745n 1.0v 624.755n 1.0v 629.745n 1.0v 629.755n 1.0v 634.745n 1.0v 634.755n 1.0v 639.745n 1.0v 639.755n 1.0v 644.745n 1.0v 644.755n 1.0v 649.745n 1.0v 649.755n 1.0v 654.745n 1.0v 654.755n 1.0v 659.745n 1.0v 659.755n 1.0v 664.745n 1.0v 664.755n 1.0v 669.745n 1.0v 669.755n 1.0v 674.745n 1.0v 674.755n 1.0v 679.745n 1.0v 679.755n 1.0v 684.745n 1.0v 684.755n 1.0v 689.745n 1.0v 689.755n 0.0v 694.745n 0.0v 694.755n 0.0v 699.745n 0.0v 699.755n 0.0v 704.745n 0.0v 704.755n 0.0v 709.745n 0.0v 709.755n 0.0v 714.745n 0.0v 714.755n 0.0v 719.745n 0.0v 719.755n 0.0v 724.745n 0.0v 724.755n 0.0v 729.745n 0.0v 729.755n 1.0v 734.745n 1.0v 734.755n 1.0v 739.745n 1.0v 739.755n 1.0v 744.745n 1.0v 744.755n 1.0v 749.745n 1.0v 749.755n 1.0v 754.745n 1.0v 754.755n 1.0v 759.745n 1.0v 759.755n 1.0v 764.745n 1.0v 764.755n 1.0v 769.745n 1.0v 769.755n 0.0v 774.745n 0.0v 774.755n 0.0v 779.745n 0.0v 779.755n 0.0v 784.745n 0.0v 784.755n 0.0v 789.745n 0.0v 789.755n 1.0v 794.745n 1.0v 794.755n 1.0v 799.745n 1.0v 799.755n 1.0v 804.745n 1.0v 804.755n 1.0v 809.745n 1.0v 809.755n 1.0v 814.745n 1.0v 814.755n 1.0v 819.745n 1.0v 819.755n 1.0v 824.745n 1.0v 824.755n 1.0v 829.745n 1.0v 829.755n 1.0v 834.745n 1.0v 834.755n 1.0v 839.745n 1.0v 839.755n 1.0v 844.745n 1.0v 844.755n 1.0v 849.745n 1.0v 849.755n 1.0v 854.745n 1.0v 854.755n 1.0v 859.745n 1.0v 859.755n 1.0v 864.745n 1.0v 864.755n 1.0v 869.745n 1.0v 869.755n 1.0v 874.745n 1.0v 874.755n 1.0v 879.745n 1.0v 879.755n 0.0v 884.745n 0.0v 884.755n 0.0v 889.745n 0.0v 889.755n 0.0v 894.745n 0.0v 894.755n 0.0v 899.745n 0.0v 899.755n 0.0v 904.745n 0.0v 904.755n 0.0v 909.745n 0.0v 909.755n 0.0v 914.745n 0.0v 914.755n 0.0v 919.745n 0.0v 919.755n 0.0v 924.745n 0.0v 924.755n 1.0v 929.745n 1.0v 929.755n 1.0v 934.745n 1.0v 934.755n 1.0v 939.745n 1.0v 939.755n 1.0v 944.745n 1.0v 944.755n 0.0v 949.745n 0.0v 949.755n 0.0v 954.745n 0.0v 954.755n 0.0v 959.745n 0.0v 959.755n 0.0v 964.745n 0.0v 964.755n 0.0v 969.745n 0.0v 969.755n 0.0v 974.745n 0.0v 974.755n 0.0v 979.745n 0.0v 979.755n 0.0v 984.745n 0.0v 984.755n 0.0v 989.745n 0.0v 989.755n 0.0v 994.745n 0.0v 994.755n 0.0v 999.745n 0.0v 999.755n 1.0v 1004.745n 1.0v 1004.755n 1.0v 1009.745n 1.0v 1009.755n 1.0v 1014.745n 1.0v 1014.755n 1.0v 1019.745n 1.0v 1019.755n 1.0v 1024.745n 1.0v 1024.755n 1.0v )
* (time, data): [(0, 0), (5, 0), (10, 0), (15, 1), (20, 1), (25, 1), (30, 1), (35, 1), (40, 1), (45, 1), (50, 1), (55, 1), (60, 1), (65, 1), (70, 1), (75, 1), (80, 1), (85, 1), (90, 1), (95, 1), (100, 1), (105, 1), (110, 1), (115, 1), (120, 1), (125, 1), (130, 1), (135, 1), (140, 1), (145, 1), (150, 1), (155, 1), (160, 1), (165, 1), (170, 1), (175, 1), (180, 1), (185, 1), (190, 1), (195, 1), (200, 1), (205, 1), (210, 1), (215, 1), (220, 1), (225, 1), (230, 1), (235, 1), (240, 1), (245, 0), (250, 0), (255, 0), (260, 0), (265, 0), (270, 0), (275, 0), (280, 0), (285, 1), (290, 1), (295, 1), (300, 0), (305, 0), (310, 0), (315, 0), (320, 0), (325, 0), (330, 0), (335, 0), (340, 0), (345, 0), (350, 0), (355, 0), (360, 0), (365, 0), (370, 0), (375, 0), (380, 0), (385, 0), (390, 1), (395, 1), (400, 1), (405, 1), (410, 1), (415, 1), (420, 0), (425, 0), (430, 0), (435, 0), (440, 0), (445, 0), (450, 0), (455, 0), (460, 0), (465, 1), (470, 1), (475, 1), (480, 1), (485, 0), (490, 0), (495, 0), (500, 0), (505, 1), (510, 1), (515, 1), (520, 0), (525, 0), (530, 0), (535, 0), (540, 0), (545, 0), (550, 0), (555, 0), (560, 0), (565, 0), (570, 0), (575, 0), (580, 1), (585, 1), (590, 1), (595, 1), (600, 1), (605, 0), (610, 0), (615, 0), (620, 0), (625, 0), (630, 0), (635, 0), (640, 0), (645, 0), (650, 0), (655, 0), (660, 0), (665, 0), (670, 0), (675, 0), (680, 0), (685, 0), (690, 1), (695, 1), (700, 1), (705, 1), (710, 1), (715, 1), (720, 1), (725, 1), (730, 1), (735, 1), (740, 1), (745, 1), (750, 1), (755, 1), (760, 1), (765, 1), (770, 1), (775, 1), (780, 1), (785, 1), (790, 0), (795, 0), (800, 0), (805, 0), (810, 0), (815, 0), (820, 0), (825, 0), (830, 1), (835, 1), (840, 1), (845, 1), (850, 1), (855, 1), (860, 0), (865, 0), (870, 0), (875, 0), (880, 0), (885, 0), (890, 0), (895, 0), (900, 1), (905, 0), (910, 0), (915, 0), (920, 0), (925, 1), (930, 1), (935, 1), (940, 1), (945, 1), (950, 1), (955, 1), (960, 1), (965, 1), (970, 1), (975, 1), (980, 1), (985, 1), (990, 1), (995, 1), (1000, 0), (1005, 0), (1010, 0), (1015, 0), (1020, 0), (1025, 0)]
Vdin1_33  din1_33  0 PWL (0n 0.0v 4.745n 0.0v 4.755n 0.0v 9.745n 0.0v 9.755n 0.0v 14.745n 0.0v 14.755n 1.0v 19.745n 1.0v 19.755n 1.0v 24.745n 1.0v 24.755n 1.0v 29.745n 1.0v 29.755n 1.0v 34.745n 1.0v 34.755n 1.0v 39.745n 1.0v 39.755n 1.0v 44.745n 1.0v 44.755n 1.0v 49.745n 1.0v 49.755n 1.0v 54.745n 1.0v 54.755n 1.0v 59.745n 1.0v 59.755n 1.0v 64.745n 1.0v 64.755n 1.0v 69.745n 1.0v 69.755n 1.0v 74.745n 1.0v 74.755n 1.0v 79.745n 1.0v 79.755n 1.0v 84.745n 1.0v 84.755n 1.0v 89.745n 1.0v 89.755n 1.0v 94.745n 1.0v 94.755n 1.0v 99.745n 1.0v 99.755n 1.0v 104.745n 1.0v 104.755n 1.0v 109.745n 1.0v 109.755n 1.0v 114.745n 1.0v 114.755n 1.0v 119.745n 1.0v 119.755n 1.0v 124.745n 1.0v 124.755n 1.0v 129.745n 1.0v 129.755n 1.0v 134.745n 1.0v 134.755n 1.0v 139.745n 1.0v 139.755n 1.0v 144.745n 1.0v 144.755n 1.0v 149.745n 1.0v 149.755n 1.0v 154.745n 1.0v 154.755n 1.0v 159.745n 1.0v 159.755n 1.0v 164.745n 1.0v 164.755n 1.0v 169.745n 1.0v 169.755n 1.0v 174.745n 1.0v 174.755n 1.0v 179.745n 1.0v 179.755n 1.0v 184.745n 1.0v 184.755n 1.0v 189.745n 1.0v 189.755n 1.0v 194.745n 1.0v 194.755n 1.0v 199.745n 1.0v 199.755n 1.0v 204.745n 1.0v 204.755n 1.0v 209.745n 1.0v 209.755n 1.0v 214.745n 1.0v 214.755n 1.0v 219.745n 1.0v 219.755n 1.0v 224.745n 1.0v 224.755n 1.0v 229.745n 1.0v 229.755n 1.0v 234.745n 1.0v 234.755n 1.0v 239.745n 1.0v 239.755n 1.0v 244.745n 1.0v 244.755n 0.0v 249.745n 0.0v 249.755n 0.0v 254.745n 0.0v 254.755n 0.0v 259.745n 0.0v 259.755n 0.0v 264.745n 0.0v 264.755n 0.0v 269.745n 0.0v 269.755n 0.0v 274.745n 0.0v 274.755n 0.0v 279.745n 0.0v 279.755n 0.0v 284.745n 0.0v 284.755n 1.0v 289.745n 1.0v 289.755n 1.0v 294.745n 1.0v 294.755n 1.0v 299.745n 1.0v 299.755n 0.0v 304.745n 0.0v 304.755n 0.0v 309.745n 0.0v 309.755n 0.0v 314.745n 0.0v 314.755n 0.0v 319.745n 0.0v 319.755n 0.0v 324.745n 0.0v 324.755n 0.0v 329.745n 0.0v 329.755n 0.0v 334.745n 0.0v 334.755n 0.0v 339.745n 0.0v 339.755n 0.0v 344.745n 0.0v 344.755n 0.0v 349.745n 0.0v 349.755n 0.0v 354.745n 0.0v 354.755n 0.0v 359.745n 0.0v 359.755n 0.0v 364.745n 0.0v 364.755n 0.0v 369.745n 0.0v 369.755n 0.0v 374.745n 0.0v 374.755n 0.0v 379.745n 0.0v 379.755n 0.0v 384.745n 0.0v 384.755n 0.0v 389.745n 0.0v 389.755n 1.0v 394.745n 1.0v 394.755n 1.0v 399.745n 1.0v 399.755n 1.0v 404.745n 1.0v 404.755n 1.0v 409.745n 1.0v 409.755n 1.0v 414.745n 1.0v 414.755n 1.0v 419.745n 1.0v 419.755n 0.0v 424.745n 0.0v 424.755n 0.0v 429.745n 0.0v 429.755n 0.0v 434.745n 0.0v 434.755n 0.0v 439.745n 0.0v 439.755n 0.0v 444.745n 0.0v 444.755n 0.0v 449.745n 0.0v 449.755n 0.0v 454.745n 0.0v 454.755n 0.0v 459.745n 0.0v 459.755n 0.0v 464.745n 0.0v 464.755n 1.0v 469.745n 1.0v 469.755n 1.0v 474.745n 1.0v 474.755n 1.0v 479.745n 1.0v 479.755n 1.0v 484.745n 1.0v 484.755n 0.0v 489.745n 0.0v 489.755n 0.0v 494.745n 0.0v 494.755n 0.0v 499.745n 0.0v 499.755n 0.0v 504.745n 0.0v 504.755n 1.0v 509.745n 1.0v 509.755n 1.0v 514.745n 1.0v 514.755n 1.0v 519.745n 1.0v 519.755n 0.0v 524.745n 0.0v 524.755n 0.0v 529.745n 0.0v 529.755n 0.0v 534.745n 0.0v 534.755n 0.0v 539.745n 0.0v 539.755n 0.0v 544.745n 0.0v 544.755n 0.0v 549.745n 0.0v 549.755n 0.0v 554.745n 0.0v 554.755n 0.0v 559.745n 0.0v 559.755n 0.0v 564.745n 0.0v 564.755n 0.0v 569.745n 0.0v 569.755n 0.0v 574.745n 0.0v 574.755n 0.0v 579.745n 0.0v 579.755n 1.0v 584.745n 1.0v 584.755n 1.0v 589.745n 1.0v 589.755n 1.0v 594.745n 1.0v 594.755n 1.0v 599.745n 1.0v 599.755n 1.0v 604.745n 1.0v 604.755n 0.0v 609.745n 0.0v 609.755n 0.0v 614.745n 0.0v 614.755n 0.0v 619.745n 0.0v 619.755n 0.0v 624.745n 0.0v 624.755n 0.0v 629.745n 0.0v 629.755n 0.0v 634.745n 0.0v 634.755n 0.0v 639.745n 0.0v 639.755n 0.0v 644.745n 0.0v 644.755n 0.0v 649.745n 0.0v 649.755n 0.0v 654.745n 0.0v 654.755n 0.0v 659.745n 0.0v 659.755n 0.0v 664.745n 0.0v 664.755n 0.0v 669.745n 0.0v 669.755n 0.0v 674.745n 0.0v 674.755n 0.0v 679.745n 0.0v 679.755n 0.0v 684.745n 0.0v 684.755n 0.0v 689.745n 0.0v 689.755n 1.0v 694.745n 1.0v 694.755n 1.0v 699.745n 1.0v 699.755n 1.0v 704.745n 1.0v 704.755n 1.0v 709.745n 1.0v 709.755n 1.0v 714.745n 1.0v 714.755n 1.0v 719.745n 1.0v 719.755n 1.0v 724.745n 1.0v 724.755n 1.0v 729.745n 1.0v 729.755n 1.0v 734.745n 1.0v 734.755n 1.0v 739.745n 1.0v 739.755n 1.0v 744.745n 1.0v 744.755n 1.0v 749.745n 1.0v 749.755n 1.0v 754.745n 1.0v 754.755n 1.0v 759.745n 1.0v 759.755n 1.0v 764.745n 1.0v 764.755n 1.0v 769.745n 1.0v 769.755n 1.0v 774.745n 1.0v 774.755n 1.0v 779.745n 1.0v 779.755n 1.0v 784.745n 1.0v 784.755n 1.0v 789.745n 1.0v 789.755n 0.0v 794.745n 0.0v 794.755n 0.0v 799.745n 0.0v 799.755n 0.0v 804.745n 0.0v 804.755n 0.0v 809.745n 0.0v 809.755n 0.0v 814.745n 0.0v 814.755n 0.0v 819.745n 0.0v 819.755n 0.0v 824.745n 0.0v 824.755n 0.0v 829.745n 0.0v 829.755n 1.0v 834.745n 1.0v 834.755n 1.0v 839.745n 1.0v 839.755n 1.0v 844.745n 1.0v 844.755n 1.0v 849.745n 1.0v 849.755n 1.0v 854.745n 1.0v 854.755n 1.0v 859.745n 1.0v 859.755n 0.0v 864.745n 0.0v 864.755n 0.0v 869.745n 0.0v 869.755n 0.0v 874.745n 0.0v 874.755n 0.0v 879.745n 0.0v 879.755n 0.0v 884.745n 0.0v 884.755n 0.0v 889.745n 0.0v 889.755n 0.0v 894.745n 0.0v 894.755n 0.0v 899.745n 0.0v 899.755n 1.0v 904.745n 1.0v 904.755n 0.0v 909.745n 0.0v 909.755n 0.0v 914.745n 0.0v 914.755n 0.0v 919.745n 0.0v 919.755n 0.0v 924.745n 0.0v 924.755n 1.0v 929.745n 1.0v 929.755n 1.0v 934.745n 1.0v 934.755n 1.0v 939.745n 1.0v 939.755n 1.0v 944.745n 1.0v 944.755n 1.0v 949.745n 1.0v 949.755n 1.0v 954.745n 1.0v 954.755n 1.0v 959.745n 1.0v 959.755n 1.0v 964.745n 1.0v 964.755n 1.0v 969.745n 1.0v 969.755n 1.0v 974.745n 1.0v 974.755n 1.0v 979.745n 1.0v 979.755n 1.0v 984.745n 1.0v 984.755n 1.0v 989.745n 1.0v 989.755n 1.0v 994.745n 1.0v 994.755n 1.0v 999.745n 1.0v 999.755n 0.0v 1004.745n 0.0v 1004.755n 0.0v 1009.745n 0.0v 1009.755n 0.0v 1014.745n 0.0v 1014.755n 0.0v 1019.745n 0.0v 1019.755n 0.0v 1024.745n 0.0v 1024.755n 0.0v )
* (time, data): [(0, 0), (5, 1), (10, 1), (15, 0), (20, 0), (25, 0), (30, 0), (35, 0), (40, 0), (45, 0), (50, 0), (55, 0), (60, 1), (65, 1), (70, 1), (75, 1), (80, 1), (85, 1), (90, 1), (95, 1), (100, 1), (105, 1), (110, 1), (115, 1), (120, 1), (125, 1), (130, 1), (135, 1), (140, 1), (145, 0), (150, 0), (155, 0), (160, 0), (165, 0), (170, 0), (175, 0), (180, 1), (185, 1), (190, 1), (195, 1), (200, 1), (205, 1), (210, 1), (215, 1), (220, 1), (225, 1), (230, 1), (235, 1), (240, 1), (245, 0), (250, 1), (255, 1), (260, 1), (265, 1), (270, 1), (275, 1), (280, 1), (285, 1), (290, 1), (295, 1), (300, 0), (305, 0), (310, 0), (315, 0), (320, 0), (325, 0), (330, 0), (335, 0), (340, 0), (345, 0), (350, 0), (355, 0), (360, 0), (365, 0), (370, 0), (375, 0), (380, 1), (385, 1), (390, 0), (395, 0), (400, 0), (405, 0), (410, 0), (415, 0), (420, 0), (425, 0), (430, 0), (435, 0), (440, 0), (445, 0), (450, 0), (455, 0), (460, 0), (465, 0), (470, 0), (475, 0), (480, 0), (485, 0), (490, 0), (495, 0), (500, 0), (505, 1), (510, 1), (515, 1), (520, 1), (525, 1), (530, 1), (535, 1), (540, 1), (545, 1), (550, 1), (555, 1), (560, 1), (565, 1), (570, 1), (575, 1), (580, 1), (585, 1), (590, 1), (595, 1), (600, 1), (605, 0), (610, 0), (615, 0), (620, 0), (625, 0), (630, 0), (635, 0), (640, 0), (645, 0), (650, 0), (655, 0), (660, 0), (665, 0), (670, 0), (675, 0), (680, 0), (685, 0), (690, 1), (695, 1), (700, 1), (705, 1), (710, 1), (715, 1), (720, 1), (725, 1), (730, 1), (735, 0), (740, 0), (745, 0), (750, 0), (755, 0), (760, 1), (765, 0), (770, 0), (775, 0), (780, 0), (785, 0), (790, 0), (795, 0), (800, 0), (805, 0), (810, 0), (815, 0), (820, 0), (825, 0), (830, 0), (835, 0), (840, 0), (845, 0), (850, 0), (855, 0), (860, 1), (865, 1), (870, 1), (875, 1), (880, 1), (885, 1), (890, 1), (895, 1), (900, 1), (905, 1), (910, 1), (915, 1), (920, 1), (925, 1), (930, 1), (935, 1), (940, 1), (945, 1), (950, 1), (955, 1), (960, 1), (965, 1), (970, 1), (975, 1), (980, 1), (985, 1), (990, 1), (995, 1), (1000, 0), (1005, 0), (1010, 0), (1015, 0), (1020, 0), (1025, 0)]
Vdin1_34  din1_34  0 PWL (0n 0.0v 4.745n 0.0v 4.755n 1.0v 9.745n 1.0v 9.755n 1.0v 14.745n 1.0v 14.755n 0.0v 19.745n 0.0v 19.755n 0.0v 24.745n 0.0v 24.755n 0.0v 29.745n 0.0v 29.755n 0.0v 34.745n 0.0v 34.755n 0.0v 39.745n 0.0v 39.755n 0.0v 44.745n 0.0v 44.755n 0.0v 49.745n 0.0v 49.755n 0.0v 54.745n 0.0v 54.755n 0.0v 59.745n 0.0v 59.755n 1.0v 64.745n 1.0v 64.755n 1.0v 69.745n 1.0v 69.755n 1.0v 74.745n 1.0v 74.755n 1.0v 79.745n 1.0v 79.755n 1.0v 84.745n 1.0v 84.755n 1.0v 89.745n 1.0v 89.755n 1.0v 94.745n 1.0v 94.755n 1.0v 99.745n 1.0v 99.755n 1.0v 104.745n 1.0v 104.755n 1.0v 109.745n 1.0v 109.755n 1.0v 114.745n 1.0v 114.755n 1.0v 119.745n 1.0v 119.755n 1.0v 124.745n 1.0v 124.755n 1.0v 129.745n 1.0v 129.755n 1.0v 134.745n 1.0v 134.755n 1.0v 139.745n 1.0v 139.755n 1.0v 144.745n 1.0v 144.755n 0.0v 149.745n 0.0v 149.755n 0.0v 154.745n 0.0v 154.755n 0.0v 159.745n 0.0v 159.755n 0.0v 164.745n 0.0v 164.755n 0.0v 169.745n 0.0v 169.755n 0.0v 174.745n 0.0v 174.755n 0.0v 179.745n 0.0v 179.755n 1.0v 184.745n 1.0v 184.755n 1.0v 189.745n 1.0v 189.755n 1.0v 194.745n 1.0v 194.755n 1.0v 199.745n 1.0v 199.755n 1.0v 204.745n 1.0v 204.755n 1.0v 209.745n 1.0v 209.755n 1.0v 214.745n 1.0v 214.755n 1.0v 219.745n 1.0v 219.755n 1.0v 224.745n 1.0v 224.755n 1.0v 229.745n 1.0v 229.755n 1.0v 234.745n 1.0v 234.755n 1.0v 239.745n 1.0v 239.755n 1.0v 244.745n 1.0v 244.755n 0.0v 249.745n 0.0v 249.755n 1.0v 254.745n 1.0v 254.755n 1.0v 259.745n 1.0v 259.755n 1.0v 264.745n 1.0v 264.755n 1.0v 269.745n 1.0v 269.755n 1.0v 274.745n 1.0v 274.755n 1.0v 279.745n 1.0v 279.755n 1.0v 284.745n 1.0v 284.755n 1.0v 289.745n 1.0v 289.755n 1.0v 294.745n 1.0v 294.755n 1.0v 299.745n 1.0v 299.755n 0.0v 304.745n 0.0v 304.755n 0.0v 309.745n 0.0v 309.755n 0.0v 314.745n 0.0v 314.755n 0.0v 319.745n 0.0v 319.755n 0.0v 324.745n 0.0v 324.755n 0.0v 329.745n 0.0v 329.755n 0.0v 334.745n 0.0v 334.755n 0.0v 339.745n 0.0v 339.755n 0.0v 344.745n 0.0v 344.755n 0.0v 349.745n 0.0v 349.755n 0.0v 354.745n 0.0v 354.755n 0.0v 359.745n 0.0v 359.755n 0.0v 364.745n 0.0v 364.755n 0.0v 369.745n 0.0v 369.755n 0.0v 374.745n 0.0v 374.755n 0.0v 379.745n 0.0v 379.755n 1.0v 384.745n 1.0v 384.755n 1.0v 389.745n 1.0v 389.755n 0.0v 394.745n 0.0v 394.755n 0.0v 399.745n 0.0v 399.755n 0.0v 404.745n 0.0v 404.755n 0.0v 409.745n 0.0v 409.755n 0.0v 414.745n 0.0v 414.755n 0.0v 419.745n 0.0v 419.755n 0.0v 424.745n 0.0v 424.755n 0.0v 429.745n 0.0v 429.755n 0.0v 434.745n 0.0v 434.755n 0.0v 439.745n 0.0v 439.755n 0.0v 444.745n 0.0v 444.755n 0.0v 449.745n 0.0v 449.755n 0.0v 454.745n 0.0v 454.755n 0.0v 459.745n 0.0v 459.755n 0.0v 464.745n 0.0v 464.755n 0.0v 469.745n 0.0v 469.755n 0.0v 474.745n 0.0v 474.755n 0.0v 479.745n 0.0v 479.755n 0.0v 484.745n 0.0v 484.755n 0.0v 489.745n 0.0v 489.755n 0.0v 494.745n 0.0v 494.755n 0.0v 499.745n 0.0v 499.755n 0.0v 504.745n 0.0v 504.755n 1.0v 509.745n 1.0v 509.755n 1.0v 514.745n 1.0v 514.755n 1.0v 519.745n 1.0v 519.755n 1.0v 524.745n 1.0v 524.755n 1.0v 529.745n 1.0v 529.755n 1.0v 534.745n 1.0v 534.755n 1.0v 539.745n 1.0v 539.755n 1.0v 544.745n 1.0v 544.755n 1.0v 549.745n 1.0v 549.755n 1.0v 554.745n 1.0v 554.755n 1.0v 559.745n 1.0v 559.755n 1.0v 564.745n 1.0v 564.755n 1.0v 569.745n 1.0v 569.755n 1.0v 574.745n 1.0v 574.755n 1.0v 579.745n 1.0v 579.755n 1.0v 584.745n 1.0v 584.755n 1.0v 589.745n 1.0v 589.755n 1.0v 594.745n 1.0v 594.755n 1.0v 599.745n 1.0v 599.755n 1.0v 604.745n 1.0v 604.755n 0.0v 609.745n 0.0v 609.755n 0.0v 614.745n 0.0v 614.755n 0.0v 619.745n 0.0v 619.755n 0.0v 624.745n 0.0v 624.755n 0.0v 629.745n 0.0v 629.755n 0.0v 634.745n 0.0v 634.755n 0.0v 639.745n 0.0v 639.755n 0.0v 644.745n 0.0v 644.755n 0.0v 649.745n 0.0v 649.755n 0.0v 654.745n 0.0v 654.755n 0.0v 659.745n 0.0v 659.755n 0.0v 664.745n 0.0v 664.755n 0.0v 669.745n 0.0v 669.755n 0.0v 674.745n 0.0v 674.755n 0.0v 679.745n 0.0v 679.755n 0.0v 684.745n 0.0v 684.755n 0.0v 689.745n 0.0v 689.755n 1.0v 694.745n 1.0v 694.755n 1.0v 699.745n 1.0v 699.755n 1.0v 704.745n 1.0v 704.755n 1.0v 709.745n 1.0v 709.755n 1.0v 714.745n 1.0v 714.755n 1.0v 719.745n 1.0v 719.755n 1.0v 724.745n 1.0v 724.755n 1.0v 729.745n 1.0v 729.755n 1.0v 734.745n 1.0v 734.755n 0.0v 739.745n 0.0v 739.755n 0.0v 744.745n 0.0v 744.755n 0.0v 749.745n 0.0v 749.755n 0.0v 754.745n 0.0v 754.755n 0.0v 759.745n 0.0v 759.755n 1.0v 764.745n 1.0v 764.755n 0.0v 769.745n 0.0v 769.755n 0.0v 774.745n 0.0v 774.755n 0.0v 779.745n 0.0v 779.755n 0.0v 784.745n 0.0v 784.755n 0.0v 789.745n 0.0v 789.755n 0.0v 794.745n 0.0v 794.755n 0.0v 799.745n 0.0v 799.755n 0.0v 804.745n 0.0v 804.755n 0.0v 809.745n 0.0v 809.755n 0.0v 814.745n 0.0v 814.755n 0.0v 819.745n 0.0v 819.755n 0.0v 824.745n 0.0v 824.755n 0.0v 829.745n 0.0v 829.755n 0.0v 834.745n 0.0v 834.755n 0.0v 839.745n 0.0v 839.755n 0.0v 844.745n 0.0v 844.755n 0.0v 849.745n 0.0v 849.755n 0.0v 854.745n 0.0v 854.755n 0.0v 859.745n 0.0v 859.755n 1.0v 864.745n 1.0v 864.755n 1.0v 869.745n 1.0v 869.755n 1.0v 874.745n 1.0v 874.755n 1.0v 879.745n 1.0v 879.755n 1.0v 884.745n 1.0v 884.755n 1.0v 889.745n 1.0v 889.755n 1.0v 894.745n 1.0v 894.755n 1.0v 899.745n 1.0v 899.755n 1.0v 904.745n 1.0v 904.755n 1.0v 909.745n 1.0v 909.755n 1.0v 914.745n 1.0v 914.755n 1.0v 919.745n 1.0v 919.755n 1.0v 924.745n 1.0v 924.755n 1.0v 929.745n 1.0v 929.755n 1.0v 934.745n 1.0v 934.755n 1.0v 939.745n 1.0v 939.755n 1.0v 944.745n 1.0v 944.755n 1.0v 949.745n 1.0v 949.755n 1.0v 954.745n 1.0v 954.755n 1.0v 959.745n 1.0v 959.755n 1.0v 964.745n 1.0v 964.755n 1.0v 969.745n 1.0v 969.755n 1.0v 974.745n 1.0v 974.755n 1.0v 979.745n 1.0v 979.755n 1.0v 984.745n 1.0v 984.755n 1.0v 989.745n 1.0v 989.755n 1.0v 994.745n 1.0v 994.755n 1.0v 999.745n 1.0v 999.755n 0.0v 1004.745n 0.0v 1004.755n 0.0v 1009.745n 0.0v 1009.755n 0.0v 1014.745n 0.0v 1014.755n 0.0v 1019.745n 0.0v 1019.755n 0.0v 1024.745n 0.0v 1024.755n 0.0v )
* (time, data): [(0, 0), (5, 0), (10, 0), (15, 1), (20, 1), (25, 1), (30, 1), (35, 1), (40, 1), (45, 1), (50, 1), (55, 1), (60, 0), (65, 0), (70, 0), (75, 0), (80, 0), (85, 0), (90, 1), (95, 1), (100, 1), (105, 1), (110, 1), (115, 1), (120, 1), (125, 1), (130, 1), (135, 1), (140, 1), (145, 1), (150, 1), (155, 1), (160, 1), (165, 1), (170, 1), (175, 0), (180, 1), (185, 1), (190, 1), (195, 1), (200, 1), (205, 1), (210, 1), (215, 1), (220, 1), (225, 1), (230, 1), (235, 1), (240, 1), (245, 1), (250, 0), (255, 0), (260, 0), (265, 0), (270, 0), (275, 0), (280, 0), (285, 1), (290, 1), (295, 1), (300, 1), (305, 1), (310, 1), (315, 1), (320, 1), (325, 1), (330, 1), (335, 1), (340, 1), (345, 1), (350, 1), (355, 1), (360, 1), (365, 0), (370, 0), (375, 0), (380, 0), (385, 0), (390, 1), (395, 0), (400, 0), (405, 0), (410, 0), (415, 0), (420, 0), (425, 0), (430, 0), (435, 0), (440, 0), (445, 0), (450, 0), (455, 0), (460, 0), (465, 1), (470, 1), (475, 1), (480, 1), (485, 1), (490, 1), (495, 1), (500, 1), (505, 1), (510, 1), (515, 1), (520, 1), (525, 1), (530, 1), (535, 1), (540, 1), (545, 1), (550, 1), (555, 1), (560, 1), (565, 1), (570, 1), (575, 1), (580, 1), (585, 1), (590, 1), (595, 1), (600, 1), (605, 1), (610, 1), (615, 0), (620, 0), (625, 0), (630, 0), (635, 0), (640, 0), (645, 0), (650, 0), (655, 0), (660, 0), (665, 0), (670, 0), (675, 0), (680, 0), (685, 0), (690, 0), (695, 0), (700, 0), (705, 0), (710, 0), (715, 0), (720, 0), (725, 0), (730, 1), (735, 0), (740, 0), (745, 0), (750, 0), (755, 0), (760, 1), (765, 0), (770, 1), (775, 1), (780, 1), (785, 1), (790, 1), (795, 1), (800, 1), (805, 1), (810, 1), (815, 1), (820, 1), (825, 1), (830, 0), (835, 0), (840, 0), (845, 0), (850, 0), (855, 0), (860, 1), (865, 1), (870, 1), (875, 1), (880, 1), (885, 1), (890, 1), (895, 1), (900, 0), (905, 0), (910, 0), (915, 0), (920, 0), (925, 0), (930, 0), (935, 0), (940, 0), (945, 1), (950, 1), (955, 1), (960, 1), (965, 1), (970, 1), (975, 1), (980, 1), (985, 1), (990, 1), (995, 1), (1000, 0), (1005, 0), (1010, 1), (1015, 1), (1020, 0), (1025, 0)]
Vdin1_35  din1_35  0 PWL (0n 0.0v 4.745n 0.0v 4.755n 0.0v 9.745n 0.0v 9.755n 0.0v 14.745n 0.0v 14.755n 1.0v 19.745n 1.0v 19.755n 1.0v 24.745n 1.0v 24.755n 1.0v 29.745n 1.0v 29.755n 1.0v 34.745n 1.0v 34.755n 1.0v 39.745n 1.0v 39.755n 1.0v 44.745n 1.0v 44.755n 1.0v 49.745n 1.0v 49.755n 1.0v 54.745n 1.0v 54.755n 1.0v 59.745n 1.0v 59.755n 0.0v 64.745n 0.0v 64.755n 0.0v 69.745n 0.0v 69.755n 0.0v 74.745n 0.0v 74.755n 0.0v 79.745n 0.0v 79.755n 0.0v 84.745n 0.0v 84.755n 0.0v 89.745n 0.0v 89.755n 1.0v 94.745n 1.0v 94.755n 1.0v 99.745n 1.0v 99.755n 1.0v 104.745n 1.0v 104.755n 1.0v 109.745n 1.0v 109.755n 1.0v 114.745n 1.0v 114.755n 1.0v 119.745n 1.0v 119.755n 1.0v 124.745n 1.0v 124.755n 1.0v 129.745n 1.0v 129.755n 1.0v 134.745n 1.0v 134.755n 1.0v 139.745n 1.0v 139.755n 1.0v 144.745n 1.0v 144.755n 1.0v 149.745n 1.0v 149.755n 1.0v 154.745n 1.0v 154.755n 1.0v 159.745n 1.0v 159.755n 1.0v 164.745n 1.0v 164.755n 1.0v 169.745n 1.0v 169.755n 1.0v 174.745n 1.0v 174.755n 0.0v 179.745n 0.0v 179.755n 1.0v 184.745n 1.0v 184.755n 1.0v 189.745n 1.0v 189.755n 1.0v 194.745n 1.0v 194.755n 1.0v 199.745n 1.0v 199.755n 1.0v 204.745n 1.0v 204.755n 1.0v 209.745n 1.0v 209.755n 1.0v 214.745n 1.0v 214.755n 1.0v 219.745n 1.0v 219.755n 1.0v 224.745n 1.0v 224.755n 1.0v 229.745n 1.0v 229.755n 1.0v 234.745n 1.0v 234.755n 1.0v 239.745n 1.0v 239.755n 1.0v 244.745n 1.0v 244.755n 1.0v 249.745n 1.0v 249.755n 0.0v 254.745n 0.0v 254.755n 0.0v 259.745n 0.0v 259.755n 0.0v 264.745n 0.0v 264.755n 0.0v 269.745n 0.0v 269.755n 0.0v 274.745n 0.0v 274.755n 0.0v 279.745n 0.0v 279.755n 0.0v 284.745n 0.0v 284.755n 1.0v 289.745n 1.0v 289.755n 1.0v 294.745n 1.0v 294.755n 1.0v 299.745n 1.0v 299.755n 1.0v 304.745n 1.0v 304.755n 1.0v 309.745n 1.0v 309.755n 1.0v 314.745n 1.0v 314.755n 1.0v 319.745n 1.0v 319.755n 1.0v 324.745n 1.0v 324.755n 1.0v 329.745n 1.0v 329.755n 1.0v 334.745n 1.0v 334.755n 1.0v 339.745n 1.0v 339.755n 1.0v 344.745n 1.0v 344.755n 1.0v 349.745n 1.0v 349.755n 1.0v 354.745n 1.0v 354.755n 1.0v 359.745n 1.0v 359.755n 1.0v 364.745n 1.0v 364.755n 0.0v 369.745n 0.0v 369.755n 0.0v 374.745n 0.0v 374.755n 0.0v 379.745n 0.0v 379.755n 0.0v 384.745n 0.0v 384.755n 0.0v 389.745n 0.0v 389.755n 1.0v 394.745n 1.0v 394.755n 0.0v 399.745n 0.0v 399.755n 0.0v 404.745n 0.0v 404.755n 0.0v 409.745n 0.0v 409.755n 0.0v 414.745n 0.0v 414.755n 0.0v 419.745n 0.0v 419.755n 0.0v 424.745n 0.0v 424.755n 0.0v 429.745n 0.0v 429.755n 0.0v 434.745n 0.0v 434.755n 0.0v 439.745n 0.0v 439.755n 0.0v 444.745n 0.0v 444.755n 0.0v 449.745n 0.0v 449.755n 0.0v 454.745n 0.0v 454.755n 0.0v 459.745n 0.0v 459.755n 0.0v 464.745n 0.0v 464.755n 1.0v 469.745n 1.0v 469.755n 1.0v 474.745n 1.0v 474.755n 1.0v 479.745n 1.0v 479.755n 1.0v 484.745n 1.0v 484.755n 1.0v 489.745n 1.0v 489.755n 1.0v 494.745n 1.0v 494.755n 1.0v 499.745n 1.0v 499.755n 1.0v 504.745n 1.0v 504.755n 1.0v 509.745n 1.0v 509.755n 1.0v 514.745n 1.0v 514.755n 1.0v 519.745n 1.0v 519.755n 1.0v 524.745n 1.0v 524.755n 1.0v 529.745n 1.0v 529.755n 1.0v 534.745n 1.0v 534.755n 1.0v 539.745n 1.0v 539.755n 1.0v 544.745n 1.0v 544.755n 1.0v 549.745n 1.0v 549.755n 1.0v 554.745n 1.0v 554.755n 1.0v 559.745n 1.0v 559.755n 1.0v 564.745n 1.0v 564.755n 1.0v 569.745n 1.0v 569.755n 1.0v 574.745n 1.0v 574.755n 1.0v 579.745n 1.0v 579.755n 1.0v 584.745n 1.0v 584.755n 1.0v 589.745n 1.0v 589.755n 1.0v 594.745n 1.0v 594.755n 1.0v 599.745n 1.0v 599.755n 1.0v 604.745n 1.0v 604.755n 1.0v 609.745n 1.0v 609.755n 1.0v 614.745n 1.0v 614.755n 0.0v 619.745n 0.0v 619.755n 0.0v 624.745n 0.0v 624.755n 0.0v 629.745n 0.0v 629.755n 0.0v 634.745n 0.0v 634.755n 0.0v 639.745n 0.0v 639.755n 0.0v 644.745n 0.0v 644.755n 0.0v 649.745n 0.0v 649.755n 0.0v 654.745n 0.0v 654.755n 0.0v 659.745n 0.0v 659.755n 0.0v 664.745n 0.0v 664.755n 0.0v 669.745n 0.0v 669.755n 0.0v 674.745n 0.0v 674.755n 0.0v 679.745n 0.0v 679.755n 0.0v 684.745n 0.0v 684.755n 0.0v 689.745n 0.0v 689.755n 0.0v 694.745n 0.0v 694.755n 0.0v 699.745n 0.0v 699.755n 0.0v 704.745n 0.0v 704.755n 0.0v 709.745n 0.0v 709.755n 0.0v 714.745n 0.0v 714.755n 0.0v 719.745n 0.0v 719.755n 0.0v 724.745n 0.0v 724.755n 0.0v 729.745n 0.0v 729.755n 1.0v 734.745n 1.0v 734.755n 0.0v 739.745n 0.0v 739.755n 0.0v 744.745n 0.0v 744.755n 0.0v 749.745n 0.0v 749.755n 0.0v 754.745n 0.0v 754.755n 0.0v 759.745n 0.0v 759.755n 1.0v 764.745n 1.0v 764.755n 0.0v 769.745n 0.0v 769.755n 1.0v 774.745n 1.0v 774.755n 1.0v 779.745n 1.0v 779.755n 1.0v 784.745n 1.0v 784.755n 1.0v 789.745n 1.0v 789.755n 1.0v 794.745n 1.0v 794.755n 1.0v 799.745n 1.0v 799.755n 1.0v 804.745n 1.0v 804.755n 1.0v 809.745n 1.0v 809.755n 1.0v 814.745n 1.0v 814.755n 1.0v 819.745n 1.0v 819.755n 1.0v 824.745n 1.0v 824.755n 1.0v 829.745n 1.0v 829.755n 0.0v 834.745n 0.0v 834.755n 0.0v 839.745n 0.0v 839.755n 0.0v 844.745n 0.0v 844.755n 0.0v 849.745n 0.0v 849.755n 0.0v 854.745n 0.0v 854.755n 0.0v 859.745n 0.0v 859.755n 1.0v 864.745n 1.0v 864.755n 1.0v 869.745n 1.0v 869.755n 1.0v 874.745n 1.0v 874.755n 1.0v 879.745n 1.0v 879.755n 1.0v 884.745n 1.0v 884.755n 1.0v 889.745n 1.0v 889.755n 1.0v 894.745n 1.0v 894.755n 1.0v 899.745n 1.0v 899.755n 0.0v 904.745n 0.0v 904.755n 0.0v 909.745n 0.0v 909.755n 0.0v 914.745n 0.0v 914.755n 0.0v 919.745n 0.0v 919.755n 0.0v 924.745n 0.0v 924.755n 0.0v 929.745n 0.0v 929.755n 0.0v 934.745n 0.0v 934.755n 0.0v 939.745n 0.0v 939.755n 0.0v 944.745n 0.0v 944.755n 1.0v 949.745n 1.0v 949.755n 1.0v 954.745n 1.0v 954.755n 1.0v 959.745n 1.0v 959.755n 1.0v 964.745n 1.0v 964.755n 1.0v 969.745n 1.0v 969.755n 1.0v 974.745n 1.0v 974.755n 1.0v 979.745n 1.0v 979.755n 1.0v 984.745n 1.0v 984.755n 1.0v 989.745n 1.0v 989.755n 1.0v 994.745n 1.0v 994.755n 1.0v 999.745n 1.0v 999.755n 0.0v 1004.745n 0.0v 1004.755n 0.0v 1009.745n 0.0v 1009.755n 1.0v 1014.745n 1.0v 1014.755n 1.0v 1019.745n 1.0v 1019.755n 0.0v 1024.745n 0.0v 1024.755n 0.0v )
* (time, data): [(0, 0), (5, 1), (10, 1), (15, 1), (20, 1), (25, 1), (30, 1), (35, 1), (40, 1), (45, 1), (50, 1), (55, 1), (60, 1), (65, 1), (70, 1), (75, 1), (80, 0), (85, 0), (90, 1), (95, 1), (100, 1), (105, 1), (110, 1), (115, 1), (120, 1), (125, 1), (130, 1), (135, 1), (140, 1), (145, 1), (150, 1), (155, 1), (160, 1), (165, 1), (170, 1), (175, 0), (180, 1), (185, 1), (190, 1), (195, 1), (200, 1), (205, 1), (210, 1), (215, 1), (220, 1), (225, 1), (230, 1), (235, 1), (240, 1), (245, 0), (250, 1), (255, 1), (260, 1), (265, 1), (270, 1), (275, 1), (280, 1), (285, 0), (290, 0), (295, 0), (300, 0), (305, 0), (310, 0), (315, 0), (320, 0), (325, 0), (330, 0), (335, 0), (340, 0), (345, 0), (350, 0), (355, 0), (360, 0), (365, 1), (370, 1), (375, 1), (380, 0), (385, 0), (390, 1), (395, 0), (400, 1), (405, 1), (410, 1), (415, 1), (420, 0), (425, 0), (430, 0), (435, 0), (440, 0), (445, 0), (450, 0), (455, 0), (460, 0), (465, 1), (470, 1), (475, 1), (480, 1), (485, 0), (490, 0), (495, 0), (500, 0), (505, 1), (510, 1), (515, 1), (520, 0), (525, 0), (530, 0), (535, 0), (540, 0), (545, 0), (550, 0), (555, 0), (560, 0), (565, 0), (570, 0), (575, 0), (580, 1), (585, 1), (590, 1), (595, 1), (600, 1), (605, 0), (610, 0), (615, 1), (620, 1), (625, 1), (630, 1), (635, 1), (640, 1), (645, 1), (650, 1), (655, 1), (660, 1), (665, 1), (670, 1), (675, 1), (680, 1), (685, 1), (690, 0), (695, 0), (700, 0), (705, 0), (710, 0), (715, 0), (720, 0), (725, 0), (730, 0), (735, 1), (740, 1), (745, 1), (750, 1), (755, 1), (760, 0), (765, 1), (770, 1), (775, 1), (780, 1), (785, 1), (790, 1), (795, 1), (800, 1), (805, 1), (810, 0), (815, 0), (820, 0), (825, 0), (830, 1), (835, 1), (840, 1), (845, 1), (850, 1), (855, 1), (860, 1), (865, 1), (870, 1), (875, 1), (880, 1), (885, 1), (890, 1), (895, 1), (900, 1), (905, 0), (910, 0), (915, 0), (920, 0), (925, 1), (930, 1), (935, 1), (940, 1), (945, 0), (950, 0), (955, 0), (960, 0), (965, 0), (970, 0), (975, 0), (980, 0), (985, 0), (990, 0), (995, 0), (1000, 1), (1005, 1), (1010, 0), (1015, 0), (1020, 1), (1025, 1)]
Vdin1_36  din1_36  0 PWL (0n 0.0v 4.745n 0.0v 4.755n 1.0v 9.745n 1.0v 9.755n 1.0v 14.745n 1.0v 14.755n 1.0v 19.745n 1.0v 19.755n 1.0v 24.745n 1.0v 24.755n 1.0v 29.745n 1.0v 29.755n 1.0v 34.745n 1.0v 34.755n 1.0v 39.745n 1.0v 39.755n 1.0v 44.745n 1.0v 44.755n 1.0v 49.745n 1.0v 49.755n 1.0v 54.745n 1.0v 54.755n 1.0v 59.745n 1.0v 59.755n 1.0v 64.745n 1.0v 64.755n 1.0v 69.745n 1.0v 69.755n 1.0v 74.745n 1.0v 74.755n 1.0v 79.745n 1.0v 79.755n 0.0v 84.745n 0.0v 84.755n 0.0v 89.745n 0.0v 89.755n 1.0v 94.745n 1.0v 94.755n 1.0v 99.745n 1.0v 99.755n 1.0v 104.745n 1.0v 104.755n 1.0v 109.745n 1.0v 109.755n 1.0v 114.745n 1.0v 114.755n 1.0v 119.745n 1.0v 119.755n 1.0v 124.745n 1.0v 124.755n 1.0v 129.745n 1.0v 129.755n 1.0v 134.745n 1.0v 134.755n 1.0v 139.745n 1.0v 139.755n 1.0v 144.745n 1.0v 144.755n 1.0v 149.745n 1.0v 149.755n 1.0v 154.745n 1.0v 154.755n 1.0v 159.745n 1.0v 159.755n 1.0v 164.745n 1.0v 164.755n 1.0v 169.745n 1.0v 169.755n 1.0v 174.745n 1.0v 174.755n 0.0v 179.745n 0.0v 179.755n 1.0v 184.745n 1.0v 184.755n 1.0v 189.745n 1.0v 189.755n 1.0v 194.745n 1.0v 194.755n 1.0v 199.745n 1.0v 199.755n 1.0v 204.745n 1.0v 204.755n 1.0v 209.745n 1.0v 209.755n 1.0v 214.745n 1.0v 214.755n 1.0v 219.745n 1.0v 219.755n 1.0v 224.745n 1.0v 224.755n 1.0v 229.745n 1.0v 229.755n 1.0v 234.745n 1.0v 234.755n 1.0v 239.745n 1.0v 239.755n 1.0v 244.745n 1.0v 244.755n 0.0v 249.745n 0.0v 249.755n 1.0v 254.745n 1.0v 254.755n 1.0v 259.745n 1.0v 259.755n 1.0v 264.745n 1.0v 264.755n 1.0v 269.745n 1.0v 269.755n 1.0v 274.745n 1.0v 274.755n 1.0v 279.745n 1.0v 279.755n 1.0v 284.745n 1.0v 284.755n 0.0v 289.745n 0.0v 289.755n 0.0v 294.745n 0.0v 294.755n 0.0v 299.745n 0.0v 299.755n 0.0v 304.745n 0.0v 304.755n 0.0v 309.745n 0.0v 309.755n 0.0v 314.745n 0.0v 314.755n 0.0v 319.745n 0.0v 319.755n 0.0v 324.745n 0.0v 324.755n 0.0v 329.745n 0.0v 329.755n 0.0v 334.745n 0.0v 334.755n 0.0v 339.745n 0.0v 339.755n 0.0v 344.745n 0.0v 344.755n 0.0v 349.745n 0.0v 349.755n 0.0v 354.745n 0.0v 354.755n 0.0v 359.745n 0.0v 359.755n 0.0v 364.745n 0.0v 364.755n 1.0v 369.745n 1.0v 369.755n 1.0v 374.745n 1.0v 374.755n 1.0v 379.745n 1.0v 379.755n 0.0v 384.745n 0.0v 384.755n 0.0v 389.745n 0.0v 389.755n 1.0v 394.745n 1.0v 394.755n 0.0v 399.745n 0.0v 399.755n 1.0v 404.745n 1.0v 404.755n 1.0v 409.745n 1.0v 409.755n 1.0v 414.745n 1.0v 414.755n 1.0v 419.745n 1.0v 419.755n 0.0v 424.745n 0.0v 424.755n 0.0v 429.745n 0.0v 429.755n 0.0v 434.745n 0.0v 434.755n 0.0v 439.745n 0.0v 439.755n 0.0v 444.745n 0.0v 444.755n 0.0v 449.745n 0.0v 449.755n 0.0v 454.745n 0.0v 454.755n 0.0v 459.745n 0.0v 459.755n 0.0v 464.745n 0.0v 464.755n 1.0v 469.745n 1.0v 469.755n 1.0v 474.745n 1.0v 474.755n 1.0v 479.745n 1.0v 479.755n 1.0v 484.745n 1.0v 484.755n 0.0v 489.745n 0.0v 489.755n 0.0v 494.745n 0.0v 494.755n 0.0v 499.745n 0.0v 499.755n 0.0v 504.745n 0.0v 504.755n 1.0v 509.745n 1.0v 509.755n 1.0v 514.745n 1.0v 514.755n 1.0v 519.745n 1.0v 519.755n 0.0v 524.745n 0.0v 524.755n 0.0v 529.745n 0.0v 529.755n 0.0v 534.745n 0.0v 534.755n 0.0v 539.745n 0.0v 539.755n 0.0v 544.745n 0.0v 544.755n 0.0v 549.745n 0.0v 549.755n 0.0v 554.745n 0.0v 554.755n 0.0v 559.745n 0.0v 559.755n 0.0v 564.745n 0.0v 564.755n 0.0v 569.745n 0.0v 569.755n 0.0v 574.745n 0.0v 574.755n 0.0v 579.745n 0.0v 579.755n 1.0v 584.745n 1.0v 584.755n 1.0v 589.745n 1.0v 589.755n 1.0v 594.745n 1.0v 594.755n 1.0v 599.745n 1.0v 599.755n 1.0v 604.745n 1.0v 604.755n 0.0v 609.745n 0.0v 609.755n 0.0v 614.745n 0.0v 614.755n 1.0v 619.745n 1.0v 619.755n 1.0v 624.745n 1.0v 624.755n 1.0v 629.745n 1.0v 629.755n 1.0v 634.745n 1.0v 634.755n 1.0v 639.745n 1.0v 639.755n 1.0v 644.745n 1.0v 644.755n 1.0v 649.745n 1.0v 649.755n 1.0v 654.745n 1.0v 654.755n 1.0v 659.745n 1.0v 659.755n 1.0v 664.745n 1.0v 664.755n 1.0v 669.745n 1.0v 669.755n 1.0v 674.745n 1.0v 674.755n 1.0v 679.745n 1.0v 679.755n 1.0v 684.745n 1.0v 684.755n 1.0v 689.745n 1.0v 689.755n 0.0v 694.745n 0.0v 694.755n 0.0v 699.745n 0.0v 699.755n 0.0v 704.745n 0.0v 704.755n 0.0v 709.745n 0.0v 709.755n 0.0v 714.745n 0.0v 714.755n 0.0v 719.745n 0.0v 719.755n 0.0v 724.745n 0.0v 724.755n 0.0v 729.745n 0.0v 729.755n 0.0v 734.745n 0.0v 734.755n 1.0v 739.745n 1.0v 739.755n 1.0v 744.745n 1.0v 744.755n 1.0v 749.745n 1.0v 749.755n 1.0v 754.745n 1.0v 754.755n 1.0v 759.745n 1.0v 759.755n 0.0v 764.745n 0.0v 764.755n 1.0v 769.745n 1.0v 769.755n 1.0v 774.745n 1.0v 774.755n 1.0v 779.745n 1.0v 779.755n 1.0v 784.745n 1.0v 784.755n 1.0v 789.745n 1.0v 789.755n 1.0v 794.745n 1.0v 794.755n 1.0v 799.745n 1.0v 799.755n 1.0v 804.745n 1.0v 804.755n 1.0v 809.745n 1.0v 809.755n 0.0v 814.745n 0.0v 814.755n 0.0v 819.745n 0.0v 819.755n 0.0v 824.745n 0.0v 824.755n 0.0v 829.745n 0.0v 829.755n 1.0v 834.745n 1.0v 834.755n 1.0v 839.745n 1.0v 839.755n 1.0v 844.745n 1.0v 844.755n 1.0v 849.745n 1.0v 849.755n 1.0v 854.745n 1.0v 854.755n 1.0v 859.745n 1.0v 859.755n 1.0v 864.745n 1.0v 864.755n 1.0v 869.745n 1.0v 869.755n 1.0v 874.745n 1.0v 874.755n 1.0v 879.745n 1.0v 879.755n 1.0v 884.745n 1.0v 884.755n 1.0v 889.745n 1.0v 889.755n 1.0v 894.745n 1.0v 894.755n 1.0v 899.745n 1.0v 899.755n 1.0v 904.745n 1.0v 904.755n 0.0v 909.745n 0.0v 909.755n 0.0v 914.745n 0.0v 914.755n 0.0v 919.745n 0.0v 919.755n 0.0v 924.745n 0.0v 924.755n 1.0v 929.745n 1.0v 929.755n 1.0v 934.745n 1.0v 934.755n 1.0v 939.745n 1.0v 939.755n 1.0v 944.745n 1.0v 944.755n 0.0v 949.745n 0.0v 949.755n 0.0v 954.745n 0.0v 954.755n 0.0v 959.745n 0.0v 959.755n 0.0v 964.745n 0.0v 964.755n 0.0v 969.745n 0.0v 969.755n 0.0v 974.745n 0.0v 974.755n 0.0v 979.745n 0.0v 979.755n 0.0v 984.745n 0.0v 984.755n 0.0v 989.745n 0.0v 989.755n 0.0v 994.745n 0.0v 994.755n 0.0v 999.745n 0.0v 999.755n 1.0v 1004.745n 1.0v 1004.755n 1.0v 1009.745n 1.0v 1009.755n 0.0v 1014.745n 0.0v 1014.755n 0.0v 1019.745n 0.0v 1019.755n 1.0v 1024.745n 1.0v 1024.755n 1.0v )
* (time, data): [(0, 0), (5, 1), (10, 1), (15, 0), (20, 0), (25, 0), (30, 0), (35, 0), (40, 0), (45, 0), (50, 0), (55, 0), (60, 1), (65, 1), (70, 1), (75, 1), (80, 0), (85, 0), (90, 0), (95, 0), (100, 0), (105, 0), (110, 0), (115, 0), (120, 0), (125, 0), (130, 1), (135, 1), (140, 1), (145, 0), (150, 0), (155, 0), (160, 0), (165, 0), (170, 0), (175, 0), (180, 1), (185, 1), (190, 1), (195, 1), (200, 1), (205, 1), (210, 1), (215, 1), (220, 1), (225, 1), (230, 1), (235, 1), (240, 1), (245, 1), (250, 0), (255, 0), (260, 0), (265, 0), (270, 0), (275, 0), (280, 0), (285, 1), (290, 1), (295, 1), (300, 1), (305, 1), (310, 1), (315, 1), (320, 1), (325, 1), (330, 1), (335, 1), (340, 1), (345, 1), (350, 1), (355, 1), (360, 1), (365, 0), (370, 0), (375, 0), (380, 1), (385, 1), (390, 1), (395, 1), (400, 1), (405, 1), (410, 1), (415, 1), (420, 1), (425, 1), (430, 1), (435, 1), (440, 1), (445, 1), (450, 1), (455, 1), (460, 1), (465, 1), (470, 1), (475, 1), (480, 1), (485, 1), (490, 1), (495, 1), (500, 1), (505, 1), (510, 1), (515, 1), (520, 0), (525, 0), (530, 0), (535, 0), (540, 0), (545, 0), (550, 0), (555, 0), (560, 0), (565, 0), (570, 0), (575, 0), (580, 1), (585, 1), (590, 1), (595, 1), (600, 1), (605, 1), (610, 1), (615, 1), (620, 1), (625, 1), (630, 1), (635, 1), (640, 1), (645, 1), (650, 1), (655, 1), (660, 1), (665, 1), (670, 1), (675, 1), (680, 1), (685, 1), (690, 0), (695, 0), (700, 0), (705, 0), (710, 0), (715, 0), (720, 0), (725, 0), (730, 0), (735, 0), (740, 0), (745, 0), (750, 0), (755, 0), (760, 0), (765, 0), (770, 0), (775, 0), (780, 0), (785, 0), (790, 0), (795, 0), (800, 0), (805, 0), (810, 1), (815, 1), (820, 1), (825, 1), (830, 0), (835, 0), (840, 0), (845, 0), (850, 0), (855, 0), (860, 0), (865, 0), (870, 0), (875, 0), (880, 0), (885, 0), (890, 0), (895, 0), (900, 1), (905, 1), (910, 1), (915, 1), (920, 1), (925, 1), (930, 0), (935, 0), (940, 0), (945, 1), (950, 1), (955, 1), (960, 1), (965, 1), (970, 1), (975, 1), (980, 1), (985, 1), (990, 1), (995, 1), (1000, 1), (1005, 1), (1010, 1), (1015, 1), (1020, 1), (1025, 1)]
Vdin1_37  din1_37  0 PWL (0n 0.0v 4.745n 0.0v 4.755n 1.0v 9.745n 1.0v 9.755n 1.0v 14.745n 1.0v 14.755n 0.0v 19.745n 0.0v 19.755n 0.0v 24.745n 0.0v 24.755n 0.0v 29.745n 0.0v 29.755n 0.0v 34.745n 0.0v 34.755n 0.0v 39.745n 0.0v 39.755n 0.0v 44.745n 0.0v 44.755n 0.0v 49.745n 0.0v 49.755n 0.0v 54.745n 0.0v 54.755n 0.0v 59.745n 0.0v 59.755n 1.0v 64.745n 1.0v 64.755n 1.0v 69.745n 1.0v 69.755n 1.0v 74.745n 1.0v 74.755n 1.0v 79.745n 1.0v 79.755n 0.0v 84.745n 0.0v 84.755n 0.0v 89.745n 0.0v 89.755n 0.0v 94.745n 0.0v 94.755n 0.0v 99.745n 0.0v 99.755n 0.0v 104.745n 0.0v 104.755n 0.0v 109.745n 0.0v 109.755n 0.0v 114.745n 0.0v 114.755n 0.0v 119.745n 0.0v 119.755n 0.0v 124.745n 0.0v 124.755n 0.0v 129.745n 0.0v 129.755n 1.0v 134.745n 1.0v 134.755n 1.0v 139.745n 1.0v 139.755n 1.0v 144.745n 1.0v 144.755n 0.0v 149.745n 0.0v 149.755n 0.0v 154.745n 0.0v 154.755n 0.0v 159.745n 0.0v 159.755n 0.0v 164.745n 0.0v 164.755n 0.0v 169.745n 0.0v 169.755n 0.0v 174.745n 0.0v 174.755n 0.0v 179.745n 0.0v 179.755n 1.0v 184.745n 1.0v 184.755n 1.0v 189.745n 1.0v 189.755n 1.0v 194.745n 1.0v 194.755n 1.0v 199.745n 1.0v 199.755n 1.0v 204.745n 1.0v 204.755n 1.0v 209.745n 1.0v 209.755n 1.0v 214.745n 1.0v 214.755n 1.0v 219.745n 1.0v 219.755n 1.0v 224.745n 1.0v 224.755n 1.0v 229.745n 1.0v 229.755n 1.0v 234.745n 1.0v 234.755n 1.0v 239.745n 1.0v 239.755n 1.0v 244.745n 1.0v 244.755n 1.0v 249.745n 1.0v 249.755n 0.0v 254.745n 0.0v 254.755n 0.0v 259.745n 0.0v 259.755n 0.0v 264.745n 0.0v 264.755n 0.0v 269.745n 0.0v 269.755n 0.0v 274.745n 0.0v 274.755n 0.0v 279.745n 0.0v 279.755n 0.0v 284.745n 0.0v 284.755n 1.0v 289.745n 1.0v 289.755n 1.0v 294.745n 1.0v 294.755n 1.0v 299.745n 1.0v 299.755n 1.0v 304.745n 1.0v 304.755n 1.0v 309.745n 1.0v 309.755n 1.0v 314.745n 1.0v 314.755n 1.0v 319.745n 1.0v 319.755n 1.0v 324.745n 1.0v 324.755n 1.0v 329.745n 1.0v 329.755n 1.0v 334.745n 1.0v 334.755n 1.0v 339.745n 1.0v 339.755n 1.0v 344.745n 1.0v 344.755n 1.0v 349.745n 1.0v 349.755n 1.0v 354.745n 1.0v 354.755n 1.0v 359.745n 1.0v 359.755n 1.0v 364.745n 1.0v 364.755n 0.0v 369.745n 0.0v 369.755n 0.0v 374.745n 0.0v 374.755n 0.0v 379.745n 0.0v 379.755n 1.0v 384.745n 1.0v 384.755n 1.0v 389.745n 1.0v 389.755n 1.0v 394.745n 1.0v 394.755n 1.0v 399.745n 1.0v 399.755n 1.0v 404.745n 1.0v 404.755n 1.0v 409.745n 1.0v 409.755n 1.0v 414.745n 1.0v 414.755n 1.0v 419.745n 1.0v 419.755n 1.0v 424.745n 1.0v 424.755n 1.0v 429.745n 1.0v 429.755n 1.0v 434.745n 1.0v 434.755n 1.0v 439.745n 1.0v 439.755n 1.0v 444.745n 1.0v 444.755n 1.0v 449.745n 1.0v 449.755n 1.0v 454.745n 1.0v 454.755n 1.0v 459.745n 1.0v 459.755n 1.0v 464.745n 1.0v 464.755n 1.0v 469.745n 1.0v 469.755n 1.0v 474.745n 1.0v 474.755n 1.0v 479.745n 1.0v 479.755n 1.0v 484.745n 1.0v 484.755n 1.0v 489.745n 1.0v 489.755n 1.0v 494.745n 1.0v 494.755n 1.0v 499.745n 1.0v 499.755n 1.0v 504.745n 1.0v 504.755n 1.0v 509.745n 1.0v 509.755n 1.0v 514.745n 1.0v 514.755n 1.0v 519.745n 1.0v 519.755n 0.0v 524.745n 0.0v 524.755n 0.0v 529.745n 0.0v 529.755n 0.0v 534.745n 0.0v 534.755n 0.0v 539.745n 0.0v 539.755n 0.0v 544.745n 0.0v 544.755n 0.0v 549.745n 0.0v 549.755n 0.0v 554.745n 0.0v 554.755n 0.0v 559.745n 0.0v 559.755n 0.0v 564.745n 0.0v 564.755n 0.0v 569.745n 0.0v 569.755n 0.0v 574.745n 0.0v 574.755n 0.0v 579.745n 0.0v 579.755n 1.0v 584.745n 1.0v 584.755n 1.0v 589.745n 1.0v 589.755n 1.0v 594.745n 1.0v 594.755n 1.0v 599.745n 1.0v 599.755n 1.0v 604.745n 1.0v 604.755n 1.0v 609.745n 1.0v 609.755n 1.0v 614.745n 1.0v 614.755n 1.0v 619.745n 1.0v 619.755n 1.0v 624.745n 1.0v 624.755n 1.0v 629.745n 1.0v 629.755n 1.0v 634.745n 1.0v 634.755n 1.0v 639.745n 1.0v 639.755n 1.0v 644.745n 1.0v 644.755n 1.0v 649.745n 1.0v 649.755n 1.0v 654.745n 1.0v 654.755n 1.0v 659.745n 1.0v 659.755n 1.0v 664.745n 1.0v 664.755n 1.0v 669.745n 1.0v 669.755n 1.0v 674.745n 1.0v 674.755n 1.0v 679.745n 1.0v 679.755n 1.0v 684.745n 1.0v 684.755n 1.0v 689.745n 1.0v 689.755n 0.0v 694.745n 0.0v 694.755n 0.0v 699.745n 0.0v 699.755n 0.0v 704.745n 0.0v 704.755n 0.0v 709.745n 0.0v 709.755n 0.0v 714.745n 0.0v 714.755n 0.0v 719.745n 0.0v 719.755n 0.0v 724.745n 0.0v 724.755n 0.0v 729.745n 0.0v 729.755n 0.0v 734.745n 0.0v 734.755n 0.0v 739.745n 0.0v 739.755n 0.0v 744.745n 0.0v 744.755n 0.0v 749.745n 0.0v 749.755n 0.0v 754.745n 0.0v 754.755n 0.0v 759.745n 0.0v 759.755n 0.0v 764.745n 0.0v 764.755n 0.0v 769.745n 0.0v 769.755n 0.0v 774.745n 0.0v 774.755n 0.0v 779.745n 0.0v 779.755n 0.0v 784.745n 0.0v 784.755n 0.0v 789.745n 0.0v 789.755n 0.0v 794.745n 0.0v 794.755n 0.0v 799.745n 0.0v 799.755n 0.0v 804.745n 0.0v 804.755n 0.0v 809.745n 0.0v 809.755n 1.0v 814.745n 1.0v 814.755n 1.0v 819.745n 1.0v 819.755n 1.0v 824.745n 1.0v 824.755n 1.0v 829.745n 1.0v 829.755n 0.0v 834.745n 0.0v 834.755n 0.0v 839.745n 0.0v 839.755n 0.0v 844.745n 0.0v 844.755n 0.0v 849.745n 0.0v 849.755n 0.0v 854.745n 0.0v 854.755n 0.0v 859.745n 0.0v 859.755n 0.0v 864.745n 0.0v 864.755n 0.0v 869.745n 0.0v 869.755n 0.0v 874.745n 0.0v 874.755n 0.0v 879.745n 0.0v 879.755n 0.0v 884.745n 0.0v 884.755n 0.0v 889.745n 0.0v 889.755n 0.0v 894.745n 0.0v 894.755n 0.0v 899.745n 0.0v 899.755n 1.0v 904.745n 1.0v 904.755n 1.0v 909.745n 1.0v 909.755n 1.0v 914.745n 1.0v 914.755n 1.0v 919.745n 1.0v 919.755n 1.0v 924.745n 1.0v 924.755n 1.0v 929.745n 1.0v 929.755n 0.0v 934.745n 0.0v 934.755n 0.0v 939.745n 0.0v 939.755n 0.0v 944.745n 0.0v 944.755n 1.0v 949.745n 1.0v 949.755n 1.0v 954.745n 1.0v 954.755n 1.0v 959.745n 1.0v 959.755n 1.0v 964.745n 1.0v 964.755n 1.0v 969.745n 1.0v 969.755n 1.0v 974.745n 1.0v 974.755n 1.0v 979.745n 1.0v 979.755n 1.0v 984.745n 1.0v 984.755n 1.0v 989.745n 1.0v 989.755n 1.0v 994.745n 1.0v 994.755n 1.0v 999.745n 1.0v 999.755n 1.0v 1004.745n 1.0v 1004.755n 1.0v 1009.745n 1.0v 1009.755n 1.0v 1014.745n 1.0v 1014.755n 1.0v 1019.745n 1.0v 1019.755n 1.0v 1024.745n 1.0v 1024.755n 1.0v )
* (time, data): [(0, 0), (5, 1), (10, 1), (15, 1), (20, 1), (25, 1), (30, 1), (35, 1), (40, 1), (45, 1), (50, 1), (55, 1), (60, 0), (65, 0), (70, 0), (75, 0), (80, 0), (85, 0), (90, 0), (95, 0), (100, 0), (105, 0), (110, 0), (115, 0), (120, 0), (125, 0), (130, 0), (135, 0), (140, 0), (145, 0), (150, 0), (155, 0), (160, 0), (165, 0), (170, 0), (175, 0), (180, 0), (185, 0), (190, 0), (195, 0), (200, 0), (205, 0), (210, 0), (215, 0), (220, 0), (225, 0), (230, 0), (235, 0), (240, 0), (245, 0), (250, 0), (255, 0), (260, 0), (265, 0), (270, 0), (275, 0), (280, 0), (285, 0), (290, 0), (295, 0), (300, 0), (305, 0), (310, 0), (315, 0), (320, 0), (325, 0), (330, 0), (335, 0), (340, 0), (345, 0), (350, 0), (355, 0), (360, 0), (365, 0), (370, 0), (375, 0), (380, 0), (385, 0), (390, 1), (395, 1), (400, 1), (405, 1), (410, 1), (415, 1), (420, 1), (425, 1), (430, 1), (435, 1), (440, 1), (445, 1), (450, 1), (455, 1), (460, 1), (465, 1), (470, 1), (475, 1), (480, 1), (485, 1), (490, 1), (495, 1), (500, 1), (505, 0), (510, 0), (515, 0), (520, 1), (525, 1), (530, 1), (535, 1), (540, 1), (545, 1), (550, 1), (555, 1), (560, 1), (565, 1), (570, 1), (575, 1), (580, 0), (585, 0), (590, 0), (595, 0), (600, 0), (605, 0), (610, 0), (615, 1), (620, 1), (625, 1), (630, 1), (635, 1), (640, 1), (645, 1), (650, 1), (655, 1), (660, 1), (665, 1), (670, 1), (675, 1), (680, 1), (685, 1), (690, 1), (695, 1), (700, 1), (705, 1), (710, 1), (715, 1), (720, 1), (725, 1), (730, 0), (735, 0), (740, 0), (745, 0), (750, 0), (755, 0), (760, 0), (765, 1), (770, 0), (775, 0), (780, 0), (785, 0), (790, 0), (795, 0), (800, 0), (805, 0), (810, 0), (815, 0), (820, 0), (825, 0), (830, 1), (835, 1), (840, 1), (845, 1), (850, 1), (855, 1), (860, 1), (865, 1), (870, 1), (875, 1), (880, 0), (885, 0), (890, 0), (895, 0), (900, 0), (905, 1), (910, 1), (915, 1), (920, 1), (925, 1), (930, 0), (935, 0), (940, 0), (945, 1), (950, 1), (955, 1), (960, 1), (965, 1), (970, 1), (975, 1), (980, 1), (985, 1), (990, 1), (995, 1), (1000, 1), (1005, 1), (1010, 0), (1015, 0), (1020, 0), (1025, 0)]
Vdin1_38  din1_38  0 PWL (0n 0.0v 4.745n 0.0v 4.755n 1.0v 9.745n 1.0v 9.755n 1.0v 14.745n 1.0v 14.755n 1.0v 19.745n 1.0v 19.755n 1.0v 24.745n 1.0v 24.755n 1.0v 29.745n 1.0v 29.755n 1.0v 34.745n 1.0v 34.755n 1.0v 39.745n 1.0v 39.755n 1.0v 44.745n 1.0v 44.755n 1.0v 49.745n 1.0v 49.755n 1.0v 54.745n 1.0v 54.755n 1.0v 59.745n 1.0v 59.755n 0.0v 64.745n 0.0v 64.755n 0.0v 69.745n 0.0v 69.755n 0.0v 74.745n 0.0v 74.755n 0.0v 79.745n 0.0v 79.755n 0.0v 84.745n 0.0v 84.755n 0.0v 89.745n 0.0v 89.755n 0.0v 94.745n 0.0v 94.755n 0.0v 99.745n 0.0v 99.755n 0.0v 104.745n 0.0v 104.755n 0.0v 109.745n 0.0v 109.755n 0.0v 114.745n 0.0v 114.755n 0.0v 119.745n 0.0v 119.755n 0.0v 124.745n 0.0v 124.755n 0.0v 129.745n 0.0v 129.755n 0.0v 134.745n 0.0v 134.755n 0.0v 139.745n 0.0v 139.755n 0.0v 144.745n 0.0v 144.755n 0.0v 149.745n 0.0v 149.755n 0.0v 154.745n 0.0v 154.755n 0.0v 159.745n 0.0v 159.755n 0.0v 164.745n 0.0v 164.755n 0.0v 169.745n 0.0v 169.755n 0.0v 174.745n 0.0v 174.755n 0.0v 179.745n 0.0v 179.755n 0.0v 184.745n 0.0v 184.755n 0.0v 189.745n 0.0v 189.755n 0.0v 194.745n 0.0v 194.755n 0.0v 199.745n 0.0v 199.755n 0.0v 204.745n 0.0v 204.755n 0.0v 209.745n 0.0v 209.755n 0.0v 214.745n 0.0v 214.755n 0.0v 219.745n 0.0v 219.755n 0.0v 224.745n 0.0v 224.755n 0.0v 229.745n 0.0v 229.755n 0.0v 234.745n 0.0v 234.755n 0.0v 239.745n 0.0v 239.755n 0.0v 244.745n 0.0v 244.755n 0.0v 249.745n 0.0v 249.755n 0.0v 254.745n 0.0v 254.755n 0.0v 259.745n 0.0v 259.755n 0.0v 264.745n 0.0v 264.755n 0.0v 269.745n 0.0v 269.755n 0.0v 274.745n 0.0v 274.755n 0.0v 279.745n 0.0v 279.755n 0.0v 284.745n 0.0v 284.755n 0.0v 289.745n 0.0v 289.755n 0.0v 294.745n 0.0v 294.755n 0.0v 299.745n 0.0v 299.755n 0.0v 304.745n 0.0v 304.755n 0.0v 309.745n 0.0v 309.755n 0.0v 314.745n 0.0v 314.755n 0.0v 319.745n 0.0v 319.755n 0.0v 324.745n 0.0v 324.755n 0.0v 329.745n 0.0v 329.755n 0.0v 334.745n 0.0v 334.755n 0.0v 339.745n 0.0v 339.755n 0.0v 344.745n 0.0v 344.755n 0.0v 349.745n 0.0v 349.755n 0.0v 354.745n 0.0v 354.755n 0.0v 359.745n 0.0v 359.755n 0.0v 364.745n 0.0v 364.755n 0.0v 369.745n 0.0v 369.755n 0.0v 374.745n 0.0v 374.755n 0.0v 379.745n 0.0v 379.755n 0.0v 384.745n 0.0v 384.755n 0.0v 389.745n 0.0v 389.755n 1.0v 394.745n 1.0v 394.755n 1.0v 399.745n 1.0v 399.755n 1.0v 404.745n 1.0v 404.755n 1.0v 409.745n 1.0v 409.755n 1.0v 414.745n 1.0v 414.755n 1.0v 419.745n 1.0v 419.755n 1.0v 424.745n 1.0v 424.755n 1.0v 429.745n 1.0v 429.755n 1.0v 434.745n 1.0v 434.755n 1.0v 439.745n 1.0v 439.755n 1.0v 444.745n 1.0v 444.755n 1.0v 449.745n 1.0v 449.755n 1.0v 454.745n 1.0v 454.755n 1.0v 459.745n 1.0v 459.755n 1.0v 464.745n 1.0v 464.755n 1.0v 469.745n 1.0v 469.755n 1.0v 474.745n 1.0v 474.755n 1.0v 479.745n 1.0v 479.755n 1.0v 484.745n 1.0v 484.755n 1.0v 489.745n 1.0v 489.755n 1.0v 494.745n 1.0v 494.755n 1.0v 499.745n 1.0v 499.755n 1.0v 504.745n 1.0v 504.755n 0.0v 509.745n 0.0v 509.755n 0.0v 514.745n 0.0v 514.755n 0.0v 519.745n 0.0v 519.755n 1.0v 524.745n 1.0v 524.755n 1.0v 529.745n 1.0v 529.755n 1.0v 534.745n 1.0v 534.755n 1.0v 539.745n 1.0v 539.755n 1.0v 544.745n 1.0v 544.755n 1.0v 549.745n 1.0v 549.755n 1.0v 554.745n 1.0v 554.755n 1.0v 559.745n 1.0v 559.755n 1.0v 564.745n 1.0v 564.755n 1.0v 569.745n 1.0v 569.755n 1.0v 574.745n 1.0v 574.755n 1.0v 579.745n 1.0v 579.755n 0.0v 584.745n 0.0v 584.755n 0.0v 589.745n 0.0v 589.755n 0.0v 594.745n 0.0v 594.755n 0.0v 599.745n 0.0v 599.755n 0.0v 604.745n 0.0v 604.755n 0.0v 609.745n 0.0v 609.755n 0.0v 614.745n 0.0v 614.755n 1.0v 619.745n 1.0v 619.755n 1.0v 624.745n 1.0v 624.755n 1.0v 629.745n 1.0v 629.755n 1.0v 634.745n 1.0v 634.755n 1.0v 639.745n 1.0v 639.755n 1.0v 644.745n 1.0v 644.755n 1.0v 649.745n 1.0v 649.755n 1.0v 654.745n 1.0v 654.755n 1.0v 659.745n 1.0v 659.755n 1.0v 664.745n 1.0v 664.755n 1.0v 669.745n 1.0v 669.755n 1.0v 674.745n 1.0v 674.755n 1.0v 679.745n 1.0v 679.755n 1.0v 684.745n 1.0v 684.755n 1.0v 689.745n 1.0v 689.755n 1.0v 694.745n 1.0v 694.755n 1.0v 699.745n 1.0v 699.755n 1.0v 704.745n 1.0v 704.755n 1.0v 709.745n 1.0v 709.755n 1.0v 714.745n 1.0v 714.755n 1.0v 719.745n 1.0v 719.755n 1.0v 724.745n 1.0v 724.755n 1.0v 729.745n 1.0v 729.755n 0.0v 734.745n 0.0v 734.755n 0.0v 739.745n 0.0v 739.755n 0.0v 744.745n 0.0v 744.755n 0.0v 749.745n 0.0v 749.755n 0.0v 754.745n 0.0v 754.755n 0.0v 759.745n 0.0v 759.755n 0.0v 764.745n 0.0v 764.755n 1.0v 769.745n 1.0v 769.755n 0.0v 774.745n 0.0v 774.755n 0.0v 779.745n 0.0v 779.755n 0.0v 784.745n 0.0v 784.755n 0.0v 789.745n 0.0v 789.755n 0.0v 794.745n 0.0v 794.755n 0.0v 799.745n 0.0v 799.755n 0.0v 804.745n 0.0v 804.755n 0.0v 809.745n 0.0v 809.755n 0.0v 814.745n 0.0v 814.755n 0.0v 819.745n 0.0v 819.755n 0.0v 824.745n 0.0v 824.755n 0.0v 829.745n 0.0v 829.755n 1.0v 834.745n 1.0v 834.755n 1.0v 839.745n 1.0v 839.755n 1.0v 844.745n 1.0v 844.755n 1.0v 849.745n 1.0v 849.755n 1.0v 854.745n 1.0v 854.755n 1.0v 859.745n 1.0v 859.755n 1.0v 864.745n 1.0v 864.755n 1.0v 869.745n 1.0v 869.755n 1.0v 874.745n 1.0v 874.755n 1.0v 879.745n 1.0v 879.755n 0.0v 884.745n 0.0v 884.755n 0.0v 889.745n 0.0v 889.755n 0.0v 894.745n 0.0v 894.755n 0.0v 899.745n 0.0v 899.755n 0.0v 904.745n 0.0v 904.755n 1.0v 909.745n 1.0v 909.755n 1.0v 914.745n 1.0v 914.755n 1.0v 919.745n 1.0v 919.755n 1.0v 924.745n 1.0v 924.755n 1.0v 929.745n 1.0v 929.755n 0.0v 934.745n 0.0v 934.755n 0.0v 939.745n 0.0v 939.755n 0.0v 944.745n 0.0v 944.755n 1.0v 949.745n 1.0v 949.755n 1.0v 954.745n 1.0v 954.755n 1.0v 959.745n 1.0v 959.755n 1.0v 964.745n 1.0v 964.755n 1.0v 969.745n 1.0v 969.755n 1.0v 974.745n 1.0v 974.755n 1.0v 979.745n 1.0v 979.755n 1.0v 984.745n 1.0v 984.755n 1.0v 989.745n 1.0v 989.755n 1.0v 994.745n 1.0v 994.755n 1.0v 999.745n 1.0v 999.755n 1.0v 1004.745n 1.0v 1004.755n 1.0v 1009.745n 1.0v 1009.755n 0.0v 1014.745n 0.0v 1014.755n 0.0v 1019.745n 0.0v 1019.755n 0.0v 1024.745n 0.0v 1024.755n 0.0v )
* (time, data): [(0, 0), (5, 1), (10, 1), (15, 0), (20, 0), (25, 0), (30, 0), (35, 0), (40, 0), (45, 0), (50, 0), (55, 0), (60, 0), (65, 0), (70, 0), (75, 0), (80, 1), (85, 1), (90, 1), (95, 1), (100, 1), (105, 1), (110, 1), (115, 1), (120, 1), (125, 1), (130, 0), (135, 0), (140, 0), (145, 1), (150, 1), (155, 1), (160, 1), (165, 1), (170, 1), (175, 0), (180, 1), (185, 1), (190, 1), (195, 1), (200, 1), (205, 1), (210, 1), (215, 1), (220, 1), (225, 1), (230, 1), (235, 1), (240, 1), (245, 1), (250, 1), (255, 1), (260, 1), (265, 1), (270, 1), (275, 1), (280, 1), (285, 0), (290, 0), (295, 0), (300, 1), (305, 1), (310, 1), (315, 1), (320, 1), (325, 1), (330, 1), (335, 1), (340, 1), (345, 1), (350, 1), (355, 1), (360, 1), (365, 1), (370, 1), (375, 1), (380, 0), (385, 0), (390, 0), (395, 1), (400, 0), (405, 0), (410, 0), (415, 0), (420, 0), (425, 0), (430, 0), (435, 0), (440, 0), (445, 0), (450, 0), (455, 0), (460, 0), (465, 1), (470, 1), (475, 1), (480, 1), (485, 1), (490, 1), (495, 1), (500, 1), (505, 1), (510, 1), (515, 1), (520, 1), (525, 1), (530, 1), (535, 1), (540, 1), (545, 1), (550, 1), (555, 1), (560, 1), (565, 1), (570, 1), (575, 1), (580, 1), (585, 0), (590, 0), (595, 0), (600, 0), (605, 1), (610, 1), (615, 1), (620, 1), (625, 1), (630, 1), (635, 1), (640, 1), (645, 1), (650, 1), (655, 1), (660, 1), (665, 1), (670, 1), (675, 1), (680, 1), (685, 1), (690, 1), (695, 1), (700, 1), (705, 1), (710, 1), (715, 1), (720, 1), (725, 1), (730, 0), (735, 1), (740, 1), (745, 1), (750, 1), (755, 1), (760, 0), (765, 1), (770, 1), (775, 1), (780, 1), (785, 1), (790, 0), (795, 0), (800, 0), (805, 0), (810, 0), (815, 0), (820, 0), (825, 0), (830, 0), (835, 0), (840, 0), (845, 0), (850, 0), (855, 0), (860, 0), (865, 0), (870, 0), (875, 0), (880, 0), (885, 0), (890, 0), (895, 0), (900, 0), (905, 0), (910, 0), (915, 0), (920, 0), (925, 1), (930, 1), (935, 1), (940, 1), (945, 0), (950, 0), (955, 0), (960, 0), (965, 0), (970, 0), (975, 0), (980, 0), (985, 0), (990, 0), (995, 0), (1000, 1), (1005, 1), (1010, 0), (1015, 0), (1020, 0), (1025, 0)]
Vdin1_39  din1_39  0 PWL (0n 0.0v 4.745n 0.0v 4.755n 1.0v 9.745n 1.0v 9.755n 1.0v 14.745n 1.0v 14.755n 0.0v 19.745n 0.0v 19.755n 0.0v 24.745n 0.0v 24.755n 0.0v 29.745n 0.0v 29.755n 0.0v 34.745n 0.0v 34.755n 0.0v 39.745n 0.0v 39.755n 0.0v 44.745n 0.0v 44.755n 0.0v 49.745n 0.0v 49.755n 0.0v 54.745n 0.0v 54.755n 0.0v 59.745n 0.0v 59.755n 0.0v 64.745n 0.0v 64.755n 0.0v 69.745n 0.0v 69.755n 0.0v 74.745n 0.0v 74.755n 0.0v 79.745n 0.0v 79.755n 1.0v 84.745n 1.0v 84.755n 1.0v 89.745n 1.0v 89.755n 1.0v 94.745n 1.0v 94.755n 1.0v 99.745n 1.0v 99.755n 1.0v 104.745n 1.0v 104.755n 1.0v 109.745n 1.0v 109.755n 1.0v 114.745n 1.0v 114.755n 1.0v 119.745n 1.0v 119.755n 1.0v 124.745n 1.0v 124.755n 1.0v 129.745n 1.0v 129.755n 0.0v 134.745n 0.0v 134.755n 0.0v 139.745n 0.0v 139.755n 0.0v 144.745n 0.0v 144.755n 1.0v 149.745n 1.0v 149.755n 1.0v 154.745n 1.0v 154.755n 1.0v 159.745n 1.0v 159.755n 1.0v 164.745n 1.0v 164.755n 1.0v 169.745n 1.0v 169.755n 1.0v 174.745n 1.0v 174.755n 0.0v 179.745n 0.0v 179.755n 1.0v 184.745n 1.0v 184.755n 1.0v 189.745n 1.0v 189.755n 1.0v 194.745n 1.0v 194.755n 1.0v 199.745n 1.0v 199.755n 1.0v 204.745n 1.0v 204.755n 1.0v 209.745n 1.0v 209.755n 1.0v 214.745n 1.0v 214.755n 1.0v 219.745n 1.0v 219.755n 1.0v 224.745n 1.0v 224.755n 1.0v 229.745n 1.0v 229.755n 1.0v 234.745n 1.0v 234.755n 1.0v 239.745n 1.0v 239.755n 1.0v 244.745n 1.0v 244.755n 1.0v 249.745n 1.0v 249.755n 1.0v 254.745n 1.0v 254.755n 1.0v 259.745n 1.0v 259.755n 1.0v 264.745n 1.0v 264.755n 1.0v 269.745n 1.0v 269.755n 1.0v 274.745n 1.0v 274.755n 1.0v 279.745n 1.0v 279.755n 1.0v 284.745n 1.0v 284.755n 0.0v 289.745n 0.0v 289.755n 0.0v 294.745n 0.0v 294.755n 0.0v 299.745n 0.0v 299.755n 1.0v 304.745n 1.0v 304.755n 1.0v 309.745n 1.0v 309.755n 1.0v 314.745n 1.0v 314.755n 1.0v 319.745n 1.0v 319.755n 1.0v 324.745n 1.0v 324.755n 1.0v 329.745n 1.0v 329.755n 1.0v 334.745n 1.0v 334.755n 1.0v 339.745n 1.0v 339.755n 1.0v 344.745n 1.0v 344.755n 1.0v 349.745n 1.0v 349.755n 1.0v 354.745n 1.0v 354.755n 1.0v 359.745n 1.0v 359.755n 1.0v 364.745n 1.0v 364.755n 1.0v 369.745n 1.0v 369.755n 1.0v 374.745n 1.0v 374.755n 1.0v 379.745n 1.0v 379.755n 0.0v 384.745n 0.0v 384.755n 0.0v 389.745n 0.0v 389.755n 0.0v 394.745n 0.0v 394.755n 1.0v 399.745n 1.0v 399.755n 0.0v 404.745n 0.0v 404.755n 0.0v 409.745n 0.0v 409.755n 0.0v 414.745n 0.0v 414.755n 0.0v 419.745n 0.0v 419.755n 0.0v 424.745n 0.0v 424.755n 0.0v 429.745n 0.0v 429.755n 0.0v 434.745n 0.0v 434.755n 0.0v 439.745n 0.0v 439.755n 0.0v 444.745n 0.0v 444.755n 0.0v 449.745n 0.0v 449.755n 0.0v 454.745n 0.0v 454.755n 0.0v 459.745n 0.0v 459.755n 0.0v 464.745n 0.0v 464.755n 1.0v 469.745n 1.0v 469.755n 1.0v 474.745n 1.0v 474.755n 1.0v 479.745n 1.0v 479.755n 1.0v 484.745n 1.0v 484.755n 1.0v 489.745n 1.0v 489.755n 1.0v 494.745n 1.0v 494.755n 1.0v 499.745n 1.0v 499.755n 1.0v 504.745n 1.0v 504.755n 1.0v 509.745n 1.0v 509.755n 1.0v 514.745n 1.0v 514.755n 1.0v 519.745n 1.0v 519.755n 1.0v 524.745n 1.0v 524.755n 1.0v 529.745n 1.0v 529.755n 1.0v 534.745n 1.0v 534.755n 1.0v 539.745n 1.0v 539.755n 1.0v 544.745n 1.0v 544.755n 1.0v 549.745n 1.0v 549.755n 1.0v 554.745n 1.0v 554.755n 1.0v 559.745n 1.0v 559.755n 1.0v 564.745n 1.0v 564.755n 1.0v 569.745n 1.0v 569.755n 1.0v 574.745n 1.0v 574.755n 1.0v 579.745n 1.0v 579.755n 1.0v 584.745n 1.0v 584.755n 0.0v 589.745n 0.0v 589.755n 0.0v 594.745n 0.0v 594.755n 0.0v 599.745n 0.0v 599.755n 0.0v 604.745n 0.0v 604.755n 1.0v 609.745n 1.0v 609.755n 1.0v 614.745n 1.0v 614.755n 1.0v 619.745n 1.0v 619.755n 1.0v 624.745n 1.0v 624.755n 1.0v 629.745n 1.0v 629.755n 1.0v 634.745n 1.0v 634.755n 1.0v 639.745n 1.0v 639.755n 1.0v 644.745n 1.0v 644.755n 1.0v 649.745n 1.0v 649.755n 1.0v 654.745n 1.0v 654.755n 1.0v 659.745n 1.0v 659.755n 1.0v 664.745n 1.0v 664.755n 1.0v 669.745n 1.0v 669.755n 1.0v 674.745n 1.0v 674.755n 1.0v 679.745n 1.0v 679.755n 1.0v 684.745n 1.0v 684.755n 1.0v 689.745n 1.0v 689.755n 1.0v 694.745n 1.0v 694.755n 1.0v 699.745n 1.0v 699.755n 1.0v 704.745n 1.0v 704.755n 1.0v 709.745n 1.0v 709.755n 1.0v 714.745n 1.0v 714.755n 1.0v 719.745n 1.0v 719.755n 1.0v 724.745n 1.0v 724.755n 1.0v 729.745n 1.0v 729.755n 0.0v 734.745n 0.0v 734.755n 1.0v 739.745n 1.0v 739.755n 1.0v 744.745n 1.0v 744.755n 1.0v 749.745n 1.0v 749.755n 1.0v 754.745n 1.0v 754.755n 1.0v 759.745n 1.0v 759.755n 0.0v 764.745n 0.0v 764.755n 1.0v 769.745n 1.0v 769.755n 1.0v 774.745n 1.0v 774.755n 1.0v 779.745n 1.0v 779.755n 1.0v 784.745n 1.0v 784.755n 1.0v 789.745n 1.0v 789.755n 0.0v 794.745n 0.0v 794.755n 0.0v 799.745n 0.0v 799.755n 0.0v 804.745n 0.0v 804.755n 0.0v 809.745n 0.0v 809.755n 0.0v 814.745n 0.0v 814.755n 0.0v 819.745n 0.0v 819.755n 0.0v 824.745n 0.0v 824.755n 0.0v 829.745n 0.0v 829.755n 0.0v 834.745n 0.0v 834.755n 0.0v 839.745n 0.0v 839.755n 0.0v 844.745n 0.0v 844.755n 0.0v 849.745n 0.0v 849.755n 0.0v 854.745n 0.0v 854.755n 0.0v 859.745n 0.0v 859.755n 0.0v 864.745n 0.0v 864.755n 0.0v 869.745n 0.0v 869.755n 0.0v 874.745n 0.0v 874.755n 0.0v 879.745n 0.0v 879.755n 0.0v 884.745n 0.0v 884.755n 0.0v 889.745n 0.0v 889.755n 0.0v 894.745n 0.0v 894.755n 0.0v 899.745n 0.0v 899.755n 0.0v 904.745n 0.0v 904.755n 0.0v 909.745n 0.0v 909.755n 0.0v 914.745n 0.0v 914.755n 0.0v 919.745n 0.0v 919.755n 0.0v 924.745n 0.0v 924.755n 1.0v 929.745n 1.0v 929.755n 1.0v 934.745n 1.0v 934.755n 1.0v 939.745n 1.0v 939.755n 1.0v 944.745n 1.0v 944.755n 0.0v 949.745n 0.0v 949.755n 0.0v 954.745n 0.0v 954.755n 0.0v 959.745n 0.0v 959.755n 0.0v 964.745n 0.0v 964.755n 0.0v 969.745n 0.0v 969.755n 0.0v 974.745n 0.0v 974.755n 0.0v 979.745n 0.0v 979.755n 0.0v 984.745n 0.0v 984.755n 0.0v 989.745n 0.0v 989.755n 0.0v 994.745n 0.0v 994.755n 0.0v 999.745n 0.0v 999.755n 1.0v 1004.745n 1.0v 1004.755n 1.0v 1009.745n 1.0v 1009.755n 0.0v 1014.745n 0.0v 1014.755n 0.0v 1019.745n 0.0v 1019.755n 0.0v 1024.745n 0.0v 1024.755n 0.0v )
* (time, data): [(0, 0), (5, 1), (10, 1), (15, 0), (20, 0), (25, 0), (30, 0), (35, 0), (40, 0), (45, 0), (50, 0), (55, 0), (60, 0), (65, 0), (70, 0), (75, 0), (80, 1), (85, 1), (90, 1), (95, 1), (100, 1), (105, 1), (110, 1), (115, 1), (120, 1), (125, 1), (130, 1), (135, 1), (140, 1), (145, 0), (150, 0), (155, 0), (160, 0), (165, 0), (170, 0), (175, 1), (180, 0), (185, 0), (190, 0), (195, 0), (200, 0), (205, 0), (210, 0), (215, 0), (220, 0), (225, 0), (230, 0), (235, 0), (240, 0), (245, 0), (250, 0), (255, 0), (260, 0), (265, 0), (270, 0), (275, 0), (280, 0), (285, 1), (290, 1), (295, 1), (300, 1), (305, 1), (310, 1), (315, 1), (320, 1), (325, 1), (330, 1), (335, 1), (340, 1), (345, 1), (350, 1), (355, 1), (360, 1), (365, 1), (370, 1), (375, 1), (380, 0), (385, 0), (390, 1), (395, 1), (400, 1), (405, 1), (410, 1), (415, 1), (420, 0), (425, 0), (430, 0), (435, 0), (440, 0), (445, 0), (450, 0), (455, 0), (460, 0), (465, 1), (470, 1), (475, 1), (480, 1), (485, 1), (490, 1), (495, 1), (500, 1), (505, 1), (510, 1), (515, 1), (520, 0), (525, 0), (530, 0), (535, 0), (540, 0), (545, 0), (550, 0), (555, 0), (560, 0), (565, 0), (570, 0), (575, 0), (580, 0), (585, 1), (590, 1), (595, 1), (600, 1), (605, 1), (610, 1), (615, 0), (620, 0), (625, 0), (630, 0), (635, 0), (640, 0), (645, 0), (650, 0), (655, 0), (660, 0), (665, 0), (670, 0), (675, 0), (680, 0), (685, 0), (690, 0), (695, 0), (700, 0), (705, 0), (710, 0), (715, 0), (720, 0), (725, 0), (730, 0), (735, 0), (740, 0), (745, 0), (750, 0), (755, 0), (760, 1), (765, 1), (770, 0), (775, 0), (780, 0), (785, 0), (790, 1), (795, 1), (800, 1), (805, 1), (810, 0), (815, 0), (820, 0), (825, 0), (830, 1), (835, 1), (840, 1), (845, 1), (850, 1), (855, 1), (860, 1), (865, 1), (870, 1), (875, 1), (880, 1), (885, 1), (890, 1), (895, 1), (900, 1), (905, 1), (910, 1), (915, 1), (920, 1), (925, 1), (930, 0), (935, 0), (940, 0), (945, 1), (950, 1), (955, 1), (960, 1), (965, 1), (970, 1), (975, 1), (980, 1), (985, 1), (990, 1), (995, 1), (1000, 1), (1005, 1), (1010, 1), (1015, 1), (1020, 1), (1025, 1)]
Vdin1_40  din1_40  0 PWL (0n 0.0v 4.745n 0.0v 4.755n 1.0v 9.745n 1.0v 9.755n 1.0v 14.745n 1.0v 14.755n 0.0v 19.745n 0.0v 19.755n 0.0v 24.745n 0.0v 24.755n 0.0v 29.745n 0.0v 29.755n 0.0v 34.745n 0.0v 34.755n 0.0v 39.745n 0.0v 39.755n 0.0v 44.745n 0.0v 44.755n 0.0v 49.745n 0.0v 49.755n 0.0v 54.745n 0.0v 54.755n 0.0v 59.745n 0.0v 59.755n 0.0v 64.745n 0.0v 64.755n 0.0v 69.745n 0.0v 69.755n 0.0v 74.745n 0.0v 74.755n 0.0v 79.745n 0.0v 79.755n 1.0v 84.745n 1.0v 84.755n 1.0v 89.745n 1.0v 89.755n 1.0v 94.745n 1.0v 94.755n 1.0v 99.745n 1.0v 99.755n 1.0v 104.745n 1.0v 104.755n 1.0v 109.745n 1.0v 109.755n 1.0v 114.745n 1.0v 114.755n 1.0v 119.745n 1.0v 119.755n 1.0v 124.745n 1.0v 124.755n 1.0v 129.745n 1.0v 129.755n 1.0v 134.745n 1.0v 134.755n 1.0v 139.745n 1.0v 139.755n 1.0v 144.745n 1.0v 144.755n 0.0v 149.745n 0.0v 149.755n 0.0v 154.745n 0.0v 154.755n 0.0v 159.745n 0.0v 159.755n 0.0v 164.745n 0.0v 164.755n 0.0v 169.745n 0.0v 169.755n 0.0v 174.745n 0.0v 174.755n 1.0v 179.745n 1.0v 179.755n 0.0v 184.745n 0.0v 184.755n 0.0v 189.745n 0.0v 189.755n 0.0v 194.745n 0.0v 194.755n 0.0v 199.745n 0.0v 199.755n 0.0v 204.745n 0.0v 204.755n 0.0v 209.745n 0.0v 209.755n 0.0v 214.745n 0.0v 214.755n 0.0v 219.745n 0.0v 219.755n 0.0v 224.745n 0.0v 224.755n 0.0v 229.745n 0.0v 229.755n 0.0v 234.745n 0.0v 234.755n 0.0v 239.745n 0.0v 239.755n 0.0v 244.745n 0.0v 244.755n 0.0v 249.745n 0.0v 249.755n 0.0v 254.745n 0.0v 254.755n 0.0v 259.745n 0.0v 259.755n 0.0v 264.745n 0.0v 264.755n 0.0v 269.745n 0.0v 269.755n 0.0v 274.745n 0.0v 274.755n 0.0v 279.745n 0.0v 279.755n 0.0v 284.745n 0.0v 284.755n 1.0v 289.745n 1.0v 289.755n 1.0v 294.745n 1.0v 294.755n 1.0v 299.745n 1.0v 299.755n 1.0v 304.745n 1.0v 304.755n 1.0v 309.745n 1.0v 309.755n 1.0v 314.745n 1.0v 314.755n 1.0v 319.745n 1.0v 319.755n 1.0v 324.745n 1.0v 324.755n 1.0v 329.745n 1.0v 329.755n 1.0v 334.745n 1.0v 334.755n 1.0v 339.745n 1.0v 339.755n 1.0v 344.745n 1.0v 344.755n 1.0v 349.745n 1.0v 349.755n 1.0v 354.745n 1.0v 354.755n 1.0v 359.745n 1.0v 359.755n 1.0v 364.745n 1.0v 364.755n 1.0v 369.745n 1.0v 369.755n 1.0v 374.745n 1.0v 374.755n 1.0v 379.745n 1.0v 379.755n 0.0v 384.745n 0.0v 384.755n 0.0v 389.745n 0.0v 389.755n 1.0v 394.745n 1.0v 394.755n 1.0v 399.745n 1.0v 399.755n 1.0v 404.745n 1.0v 404.755n 1.0v 409.745n 1.0v 409.755n 1.0v 414.745n 1.0v 414.755n 1.0v 419.745n 1.0v 419.755n 0.0v 424.745n 0.0v 424.755n 0.0v 429.745n 0.0v 429.755n 0.0v 434.745n 0.0v 434.755n 0.0v 439.745n 0.0v 439.755n 0.0v 444.745n 0.0v 444.755n 0.0v 449.745n 0.0v 449.755n 0.0v 454.745n 0.0v 454.755n 0.0v 459.745n 0.0v 459.755n 0.0v 464.745n 0.0v 464.755n 1.0v 469.745n 1.0v 469.755n 1.0v 474.745n 1.0v 474.755n 1.0v 479.745n 1.0v 479.755n 1.0v 484.745n 1.0v 484.755n 1.0v 489.745n 1.0v 489.755n 1.0v 494.745n 1.0v 494.755n 1.0v 499.745n 1.0v 499.755n 1.0v 504.745n 1.0v 504.755n 1.0v 509.745n 1.0v 509.755n 1.0v 514.745n 1.0v 514.755n 1.0v 519.745n 1.0v 519.755n 0.0v 524.745n 0.0v 524.755n 0.0v 529.745n 0.0v 529.755n 0.0v 534.745n 0.0v 534.755n 0.0v 539.745n 0.0v 539.755n 0.0v 544.745n 0.0v 544.755n 0.0v 549.745n 0.0v 549.755n 0.0v 554.745n 0.0v 554.755n 0.0v 559.745n 0.0v 559.755n 0.0v 564.745n 0.0v 564.755n 0.0v 569.745n 0.0v 569.755n 0.0v 574.745n 0.0v 574.755n 0.0v 579.745n 0.0v 579.755n 0.0v 584.745n 0.0v 584.755n 1.0v 589.745n 1.0v 589.755n 1.0v 594.745n 1.0v 594.755n 1.0v 599.745n 1.0v 599.755n 1.0v 604.745n 1.0v 604.755n 1.0v 609.745n 1.0v 609.755n 1.0v 614.745n 1.0v 614.755n 0.0v 619.745n 0.0v 619.755n 0.0v 624.745n 0.0v 624.755n 0.0v 629.745n 0.0v 629.755n 0.0v 634.745n 0.0v 634.755n 0.0v 639.745n 0.0v 639.755n 0.0v 644.745n 0.0v 644.755n 0.0v 649.745n 0.0v 649.755n 0.0v 654.745n 0.0v 654.755n 0.0v 659.745n 0.0v 659.755n 0.0v 664.745n 0.0v 664.755n 0.0v 669.745n 0.0v 669.755n 0.0v 674.745n 0.0v 674.755n 0.0v 679.745n 0.0v 679.755n 0.0v 684.745n 0.0v 684.755n 0.0v 689.745n 0.0v 689.755n 0.0v 694.745n 0.0v 694.755n 0.0v 699.745n 0.0v 699.755n 0.0v 704.745n 0.0v 704.755n 0.0v 709.745n 0.0v 709.755n 0.0v 714.745n 0.0v 714.755n 0.0v 719.745n 0.0v 719.755n 0.0v 724.745n 0.0v 724.755n 0.0v 729.745n 0.0v 729.755n 0.0v 734.745n 0.0v 734.755n 0.0v 739.745n 0.0v 739.755n 0.0v 744.745n 0.0v 744.755n 0.0v 749.745n 0.0v 749.755n 0.0v 754.745n 0.0v 754.755n 0.0v 759.745n 0.0v 759.755n 1.0v 764.745n 1.0v 764.755n 1.0v 769.745n 1.0v 769.755n 0.0v 774.745n 0.0v 774.755n 0.0v 779.745n 0.0v 779.755n 0.0v 784.745n 0.0v 784.755n 0.0v 789.745n 0.0v 789.755n 1.0v 794.745n 1.0v 794.755n 1.0v 799.745n 1.0v 799.755n 1.0v 804.745n 1.0v 804.755n 1.0v 809.745n 1.0v 809.755n 0.0v 814.745n 0.0v 814.755n 0.0v 819.745n 0.0v 819.755n 0.0v 824.745n 0.0v 824.755n 0.0v 829.745n 0.0v 829.755n 1.0v 834.745n 1.0v 834.755n 1.0v 839.745n 1.0v 839.755n 1.0v 844.745n 1.0v 844.755n 1.0v 849.745n 1.0v 849.755n 1.0v 854.745n 1.0v 854.755n 1.0v 859.745n 1.0v 859.755n 1.0v 864.745n 1.0v 864.755n 1.0v 869.745n 1.0v 869.755n 1.0v 874.745n 1.0v 874.755n 1.0v 879.745n 1.0v 879.755n 1.0v 884.745n 1.0v 884.755n 1.0v 889.745n 1.0v 889.755n 1.0v 894.745n 1.0v 894.755n 1.0v 899.745n 1.0v 899.755n 1.0v 904.745n 1.0v 904.755n 1.0v 909.745n 1.0v 909.755n 1.0v 914.745n 1.0v 914.755n 1.0v 919.745n 1.0v 919.755n 1.0v 924.745n 1.0v 924.755n 1.0v 929.745n 1.0v 929.755n 0.0v 934.745n 0.0v 934.755n 0.0v 939.745n 0.0v 939.755n 0.0v 944.745n 0.0v 944.755n 1.0v 949.745n 1.0v 949.755n 1.0v 954.745n 1.0v 954.755n 1.0v 959.745n 1.0v 959.755n 1.0v 964.745n 1.0v 964.755n 1.0v 969.745n 1.0v 969.755n 1.0v 974.745n 1.0v 974.755n 1.0v 979.745n 1.0v 979.755n 1.0v 984.745n 1.0v 984.755n 1.0v 989.745n 1.0v 989.755n 1.0v 994.745n 1.0v 994.755n 1.0v 999.745n 1.0v 999.755n 1.0v 1004.745n 1.0v 1004.755n 1.0v 1009.745n 1.0v 1009.755n 1.0v 1014.745n 1.0v 1014.755n 1.0v 1019.745n 1.0v 1019.755n 1.0v 1024.745n 1.0v 1024.755n 1.0v )
* (time, data): [(0, 0), (5, 0), (10, 1), (15, 1), (20, 1), (25, 1), (30, 1), (35, 1), (40, 1), (45, 1), (50, 1), (55, 1), (60, 1), (65, 1), (70, 1), (75, 1), (80, 1), (85, 1), (90, 0), (95, 0), (100, 0), (105, 0), (110, 0), (115, 0), (120, 0), (125, 0), (130, 0), (135, 0), (140, 0), (145, 1), (150, 1), (155, 1), (160, 1), (165, 1), (170, 1), (175, 1), (180, 0), (185, 0), (190, 0), (195, 0), (200, 0), (205, 0), (210, 0), (215, 0), (220, 0), (225, 0), (230, 0), (235, 0), (240, 0), (245, 0), (250, 1), (255, 1), (260, 1), (265, 1), (270, 1), (275, 1), (280, 1), (285, 1), (290, 1), (295, 1), (300, 1), (305, 1), (310, 1), (315, 1), (320, 1), (325, 1), (330, 1), (335, 1), (340, 1), (345, 1), (350, 1), (355, 1), (360, 1), (365, 0), (370, 0), (375, 0), (380, 0), (385, 0), (390, 0), (395, 0), (400, 0), (405, 0), (410, 0), (415, 0), (420, 0), (425, 0), (430, 0), (435, 0), (440, 0), (445, 0), (450, 0), (455, 0), (460, 0), (465, 1), (470, 1), (475, 1), (480, 1), (485, 0), (490, 0), (495, 0), (500, 0), (505, 0), (510, 0), (515, 0), (520, 0), (525, 0), (530, 0), (535, 0), (540, 0), (545, 0), (550, 0), (555, 0), (560, 0), (565, 0), (570, 0), (575, 0), (580, 1), (585, 1), (590, 1), (595, 1), (600, 1), (605, 1), (610, 1), (615, 0), (620, 0), (625, 0), (630, 0), (635, 0), (640, 0), (645, 0), (650, 0), (655, 0), (660, 0), (665, 0), (670, 0), (675, 0), (680, 0), (685, 0), (690, 0), (695, 0), (700, 0), (705, 0), (710, 0), (715, 0), (720, 0), (725, 0), (730, 1), (735, 0), (740, 0), (745, 0), (750, 0), (755, 0), (760, 0), (765, 1), (770, 0), (775, 0), (780, 0), (785, 0), (790, 0), (795, 0), (800, 0), (805, 0), (810, 0), (815, 0), (820, 0), (825, 0), (830, 1), (835, 1), (840, 1), (845, 1), (850, 1), (855, 1), (860, 0), (865, 0), (870, 0), (875, 0), (880, 1), (885, 1), (890, 1), (895, 1), (900, 0), (905, 1), (910, 1), (915, 1), (920, 1), (925, 1), (930, 1), (935, 1), (940, 1), (945, 1), (950, 1), (955, 1), (960, 1), (965, 1), (970, 1), (975, 1), (980, 1), (985, 1), (990, 1), (995, 1), (1000, 0), (1005, 0), (1010, 0), (1015, 0), (1020, 1), (1025, 1)]
Vdin1_41  din1_41  0 PWL (0n 0.0v 4.745n 0.0v 4.755n 0.0v 9.745n 0.0v 9.755n 1.0v 14.745n 1.0v 14.755n 1.0v 19.745n 1.0v 19.755n 1.0v 24.745n 1.0v 24.755n 1.0v 29.745n 1.0v 29.755n 1.0v 34.745n 1.0v 34.755n 1.0v 39.745n 1.0v 39.755n 1.0v 44.745n 1.0v 44.755n 1.0v 49.745n 1.0v 49.755n 1.0v 54.745n 1.0v 54.755n 1.0v 59.745n 1.0v 59.755n 1.0v 64.745n 1.0v 64.755n 1.0v 69.745n 1.0v 69.755n 1.0v 74.745n 1.0v 74.755n 1.0v 79.745n 1.0v 79.755n 1.0v 84.745n 1.0v 84.755n 1.0v 89.745n 1.0v 89.755n 0.0v 94.745n 0.0v 94.755n 0.0v 99.745n 0.0v 99.755n 0.0v 104.745n 0.0v 104.755n 0.0v 109.745n 0.0v 109.755n 0.0v 114.745n 0.0v 114.755n 0.0v 119.745n 0.0v 119.755n 0.0v 124.745n 0.0v 124.755n 0.0v 129.745n 0.0v 129.755n 0.0v 134.745n 0.0v 134.755n 0.0v 139.745n 0.0v 139.755n 0.0v 144.745n 0.0v 144.755n 1.0v 149.745n 1.0v 149.755n 1.0v 154.745n 1.0v 154.755n 1.0v 159.745n 1.0v 159.755n 1.0v 164.745n 1.0v 164.755n 1.0v 169.745n 1.0v 169.755n 1.0v 174.745n 1.0v 174.755n 1.0v 179.745n 1.0v 179.755n 0.0v 184.745n 0.0v 184.755n 0.0v 189.745n 0.0v 189.755n 0.0v 194.745n 0.0v 194.755n 0.0v 199.745n 0.0v 199.755n 0.0v 204.745n 0.0v 204.755n 0.0v 209.745n 0.0v 209.755n 0.0v 214.745n 0.0v 214.755n 0.0v 219.745n 0.0v 219.755n 0.0v 224.745n 0.0v 224.755n 0.0v 229.745n 0.0v 229.755n 0.0v 234.745n 0.0v 234.755n 0.0v 239.745n 0.0v 239.755n 0.0v 244.745n 0.0v 244.755n 0.0v 249.745n 0.0v 249.755n 1.0v 254.745n 1.0v 254.755n 1.0v 259.745n 1.0v 259.755n 1.0v 264.745n 1.0v 264.755n 1.0v 269.745n 1.0v 269.755n 1.0v 274.745n 1.0v 274.755n 1.0v 279.745n 1.0v 279.755n 1.0v 284.745n 1.0v 284.755n 1.0v 289.745n 1.0v 289.755n 1.0v 294.745n 1.0v 294.755n 1.0v 299.745n 1.0v 299.755n 1.0v 304.745n 1.0v 304.755n 1.0v 309.745n 1.0v 309.755n 1.0v 314.745n 1.0v 314.755n 1.0v 319.745n 1.0v 319.755n 1.0v 324.745n 1.0v 324.755n 1.0v 329.745n 1.0v 329.755n 1.0v 334.745n 1.0v 334.755n 1.0v 339.745n 1.0v 339.755n 1.0v 344.745n 1.0v 344.755n 1.0v 349.745n 1.0v 349.755n 1.0v 354.745n 1.0v 354.755n 1.0v 359.745n 1.0v 359.755n 1.0v 364.745n 1.0v 364.755n 0.0v 369.745n 0.0v 369.755n 0.0v 374.745n 0.0v 374.755n 0.0v 379.745n 0.0v 379.755n 0.0v 384.745n 0.0v 384.755n 0.0v 389.745n 0.0v 389.755n 0.0v 394.745n 0.0v 394.755n 0.0v 399.745n 0.0v 399.755n 0.0v 404.745n 0.0v 404.755n 0.0v 409.745n 0.0v 409.755n 0.0v 414.745n 0.0v 414.755n 0.0v 419.745n 0.0v 419.755n 0.0v 424.745n 0.0v 424.755n 0.0v 429.745n 0.0v 429.755n 0.0v 434.745n 0.0v 434.755n 0.0v 439.745n 0.0v 439.755n 0.0v 444.745n 0.0v 444.755n 0.0v 449.745n 0.0v 449.755n 0.0v 454.745n 0.0v 454.755n 0.0v 459.745n 0.0v 459.755n 0.0v 464.745n 0.0v 464.755n 1.0v 469.745n 1.0v 469.755n 1.0v 474.745n 1.0v 474.755n 1.0v 479.745n 1.0v 479.755n 1.0v 484.745n 1.0v 484.755n 0.0v 489.745n 0.0v 489.755n 0.0v 494.745n 0.0v 494.755n 0.0v 499.745n 0.0v 499.755n 0.0v 504.745n 0.0v 504.755n 0.0v 509.745n 0.0v 509.755n 0.0v 514.745n 0.0v 514.755n 0.0v 519.745n 0.0v 519.755n 0.0v 524.745n 0.0v 524.755n 0.0v 529.745n 0.0v 529.755n 0.0v 534.745n 0.0v 534.755n 0.0v 539.745n 0.0v 539.755n 0.0v 544.745n 0.0v 544.755n 0.0v 549.745n 0.0v 549.755n 0.0v 554.745n 0.0v 554.755n 0.0v 559.745n 0.0v 559.755n 0.0v 564.745n 0.0v 564.755n 0.0v 569.745n 0.0v 569.755n 0.0v 574.745n 0.0v 574.755n 0.0v 579.745n 0.0v 579.755n 1.0v 584.745n 1.0v 584.755n 1.0v 589.745n 1.0v 589.755n 1.0v 594.745n 1.0v 594.755n 1.0v 599.745n 1.0v 599.755n 1.0v 604.745n 1.0v 604.755n 1.0v 609.745n 1.0v 609.755n 1.0v 614.745n 1.0v 614.755n 0.0v 619.745n 0.0v 619.755n 0.0v 624.745n 0.0v 624.755n 0.0v 629.745n 0.0v 629.755n 0.0v 634.745n 0.0v 634.755n 0.0v 639.745n 0.0v 639.755n 0.0v 644.745n 0.0v 644.755n 0.0v 649.745n 0.0v 649.755n 0.0v 654.745n 0.0v 654.755n 0.0v 659.745n 0.0v 659.755n 0.0v 664.745n 0.0v 664.755n 0.0v 669.745n 0.0v 669.755n 0.0v 674.745n 0.0v 674.755n 0.0v 679.745n 0.0v 679.755n 0.0v 684.745n 0.0v 684.755n 0.0v 689.745n 0.0v 689.755n 0.0v 694.745n 0.0v 694.755n 0.0v 699.745n 0.0v 699.755n 0.0v 704.745n 0.0v 704.755n 0.0v 709.745n 0.0v 709.755n 0.0v 714.745n 0.0v 714.755n 0.0v 719.745n 0.0v 719.755n 0.0v 724.745n 0.0v 724.755n 0.0v 729.745n 0.0v 729.755n 1.0v 734.745n 1.0v 734.755n 0.0v 739.745n 0.0v 739.755n 0.0v 744.745n 0.0v 744.755n 0.0v 749.745n 0.0v 749.755n 0.0v 754.745n 0.0v 754.755n 0.0v 759.745n 0.0v 759.755n 0.0v 764.745n 0.0v 764.755n 1.0v 769.745n 1.0v 769.755n 0.0v 774.745n 0.0v 774.755n 0.0v 779.745n 0.0v 779.755n 0.0v 784.745n 0.0v 784.755n 0.0v 789.745n 0.0v 789.755n 0.0v 794.745n 0.0v 794.755n 0.0v 799.745n 0.0v 799.755n 0.0v 804.745n 0.0v 804.755n 0.0v 809.745n 0.0v 809.755n 0.0v 814.745n 0.0v 814.755n 0.0v 819.745n 0.0v 819.755n 0.0v 824.745n 0.0v 824.755n 0.0v 829.745n 0.0v 829.755n 1.0v 834.745n 1.0v 834.755n 1.0v 839.745n 1.0v 839.755n 1.0v 844.745n 1.0v 844.755n 1.0v 849.745n 1.0v 849.755n 1.0v 854.745n 1.0v 854.755n 1.0v 859.745n 1.0v 859.755n 0.0v 864.745n 0.0v 864.755n 0.0v 869.745n 0.0v 869.755n 0.0v 874.745n 0.0v 874.755n 0.0v 879.745n 0.0v 879.755n 1.0v 884.745n 1.0v 884.755n 1.0v 889.745n 1.0v 889.755n 1.0v 894.745n 1.0v 894.755n 1.0v 899.745n 1.0v 899.755n 0.0v 904.745n 0.0v 904.755n 1.0v 909.745n 1.0v 909.755n 1.0v 914.745n 1.0v 914.755n 1.0v 919.745n 1.0v 919.755n 1.0v 924.745n 1.0v 924.755n 1.0v 929.745n 1.0v 929.755n 1.0v 934.745n 1.0v 934.755n 1.0v 939.745n 1.0v 939.755n 1.0v 944.745n 1.0v 944.755n 1.0v 949.745n 1.0v 949.755n 1.0v 954.745n 1.0v 954.755n 1.0v 959.745n 1.0v 959.755n 1.0v 964.745n 1.0v 964.755n 1.0v 969.745n 1.0v 969.755n 1.0v 974.745n 1.0v 974.755n 1.0v 979.745n 1.0v 979.755n 1.0v 984.745n 1.0v 984.755n 1.0v 989.745n 1.0v 989.755n 1.0v 994.745n 1.0v 994.755n 1.0v 999.745n 1.0v 999.755n 0.0v 1004.745n 0.0v 1004.755n 0.0v 1009.745n 0.0v 1009.755n 0.0v 1014.745n 0.0v 1014.755n 0.0v 1019.745n 0.0v 1019.755n 1.0v 1024.745n 1.0v 1024.755n 1.0v )
* (time, data): [(0, 0), (5, 1), (10, 1), (15, 0), (20, 0), (25, 0), (30, 0), (35, 0), (40, 0), (45, 0), (50, 0), (55, 0), (60, 1), (65, 1), (70, 1), (75, 1), (80, 1), (85, 1), (90, 1), (95, 1), (100, 1), (105, 1), (110, 1), (115, 1), (120, 1), (125, 1), (130, 1), (135, 1), (140, 1), (145, 0), (150, 0), (155, 0), (160, 0), (165, 0), (170, 0), (175, 1), (180, 1), (185, 1), (190, 1), (195, 1), (200, 1), (205, 1), (210, 1), (215, 1), (220, 1), (225, 1), (230, 1), (235, 1), (240, 1), (245, 1), (250, 1), (255, 1), (260, 1), (265, 1), (270, 1), (275, 1), (280, 1), (285, 1), (290, 1), (295, 1), (300, 1), (305, 1), (310, 1), (315, 1), (320, 1), (325, 1), (330, 1), (335, 1), (340, 1), (345, 1), (350, 1), (355, 1), (360, 1), (365, 1), (370, 1), (375, 1), (380, 0), (385, 0), (390, 0), (395, 1), (400, 0), (405, 0), (410, 0), (415, 0), (420, 0), (425, 0), (430, 0), (435, 0), (440, 0), (445, 0), (450, 0), (455, 0), (460, 0), (465, 0), (470, 0), (475, 0), (480, 0), (485, 0), (490, 0), (495, 0), (500, 0), (505, 0), (510, 0), (515, 0), (520, 0), (525, 0), (530, 0), (535, 0), (540, 0), (545, 0), (550, 0), (555, 0), (560, 0), (565, 0), (570, 0), (575, 0), (580, 0), (585, 0), (590, 0), (595, 0), (600, 0), (605, 1), (610, 1), (615, 0), (620, 0), (625, 0), (630, 0), (635, 0), (640, 0), (645, 0), (650, 0), (655, 0), (660, 0), (665, 0), (670, 0), (675, 0), (680, 0), (685, 0), (690, 1), (695, 1), (700, 1), (705, 1), (710, 1), (715, 1), (720, 1), (725, 1), (730, 0), (735, 0), (740, 0), (745, 0), (750, 0), (755, 0), (760, 0), (765, 1), (770, 0), (775, 0), (780, 0), (785, 0), (790, 0), (795, 0), (800, 0), (805, 0), (810, 0), (815, 0), (820, 0), (825, 0), (830, 1), (835, 1), (840, 1), (845, 1), (850, 1), (855, 1), (860, 1), (865, 1), (870, 1), (875, 1), (880, 0), (885, 0), (890, 0), (895, 0), (900, 1), (905, 1), (910, 1), (915, 1), (920, 1), (925, 1), (930, 1), (935, 1), (940, 1), (945, 0), (950, 0), (955, 0), (960, 0), (965, 0), (970, 0), (975, 0), (980, 0), (985, 0), (990, 0), (995, 0), (1000, 0), (1005, 0), (1010, 1), (1015, 1), (1020, 0), (1025, 0)]
Vdin1_42  din1_42  0 PWL (0n 0.0v 4.745n 0.0v 4.755n 1.0v 9.745n 1.0v 9.755n 1.0v 14.745n 1.0v 14.755n 0.0v 19.745n 0.0v 19.755n 0.0v 24.745n 0.0v 24.755n 0.0v 29.745n 0.0v 29.755n 0.0v 34.745n 0.0v 34.755n 0.0v 39.745n 0.0v 39.755n 0.0v 44.745n 0.0v 44.755n 0.0v 49.745n 0.0v 49.755n 0.0v 54.745n 0.0v 54.755n 0.0v 59.745n 0.0v 59.755n 1.0v 64.745n 1.0v 64.755n 1.0v 69.745n 1.0v 69.755n 1.0v 74.745n 1.0v 74.755n 1.0v 79.745n 1.0v 79.755n 1.0v 84.745n 1.0v 84.755n 1.0v 89.745n 1.0v 89.755n 1.0v 94.745n 1.0v 94.755n 1.0v 99.745n 1.0v 99.755n 1.0v 104.745n 1.0v 104.755n 1.0v 109.745n 1.0v 109.755n 1.0v 114.745n 1.0v 114.755n 1.0v 119.745n 1.0v 119.755n 1.0v 124.745n 1.0v 124.755n 1.0v 129.745n 1.0v 129.755n 1.0v 134.745n 1.0v 134.755n 1.0v 139.745n 1.0v 139.755n 1.0v 144.745n 1.0v 144.755n 0.0v 149.745n 0.0v 149.755n 0.0v 154.745n 0.0v 154.755n 0.0v 159.745n 0.0v 159.755n 0.0v 164.745n 0.0v 164.755n 0.0v 169.745n 0.0v 169.755n 0.0v 174.745n 0.0v 174.755n 1.0v 179.745n 1.0v 179.755n 1.0v 184.745n 1.0v 184.755n 1.0v 189.745n 1.0v 189.755n 1.0v 194.745n 1.0v 194.755n 1.0v 199.745n 1.0v 199.755n 1.0v 204.745n 1.0v 204.755n 1.0v 209.745n 1.0v 209.755n 1.0v 214.745n 1.0v 214.755n 1.0v 219.745n 1.0v 219.755n 1.0v 224.745n 1.0v 224.755n 1.0v 229.745n 1.0v 229.755n 1.0v 234.745n 1.0v 234.755n 1.0v 239.745n 1.0v 239.755n 1.0v 244.745n 1.0v 244.755n 1.0v 249.745n 1.0v 249.755n 1.0v 254.745n 1.0v 254.755n 1.0v 259.745n 1.0v 259.755n 1.0v 264.745n 1.0v 264.755n 1.0v 269.745n 1.0v 269.755n 1.0v 274.745n 1.0v 274.755n 1.0v 279.745n 1.0v 279.755n 1.0v 284.745n 1.0v 284.755n 1.0v 289.745n 1.0v 289.755n 1.0v 294.745n 1.0v 294.755n 1.0v 299.745n 1.0v 299.755n 1.0v 304.745n 1.0v 304.755n 1.0v 309.745n 1.0v 309.755n 1.0v 314.745n 1.0v 314.755n 1.0v 319.745n 1.0v 319.755n 1.0v 324.745n 1.0v 324.755n 1.0v 329.745n 1.0v 329.755n 1.0v 334.745n 1.0v 334.755n 1.0v 339.745n 1.0v 339.755n 1.0v 344.745n 1.0v 344.755n 1.0v 349.745n 1.0v 349.755n 1.0v 354.745n 1.0v 354.755n 1.0v 359.745n 1.0v 359.755n 1.0v 364.745n 1.0v 364.755n 1.0v 369.745n 1.0v 369.755n 1.0v 374.745n 1.0v 374.755n 1.0v 379.745n 1.0v 379.755n 0.0v 384.745n 0.0v 384.755n 0.0v 389.745n 0.0v 389.755n 0.0v 394.745n 0.0v 394.755n 1.0v 399.745n 1.0v 399.755n 0.0v 404.745n 0.0v 404.755n 0.0v 409.745n 0.0v 409.755n 0.0v 414.745n 0.0v 414.755n 0.0v 419.745n 0.0v 419.755n 0.0v 424.745n 0.0v 424.755n 0.0v 429.745n 0.0v 429.755n 0.0v 434.745n 0.0v 434.755n 0.0v 439.745n 0.0v 439.755n 0.0v 444.745n 0.0v 444.755n 0.0v 449.745n 0.0v 449.755n 0.0v 454.745n 0.0v 454.755n 0.0v 459.745n 0.0v 459.755n 0.0v 464.745n 0.0v 464.755n 0.0v 469.745n 0.0v 469.755n 0.0v 474.745n 0.0v 474.755n 0.0v 479.745n 0.0v 479.755n 0.0v 484.745n 0.0v 484.755n 0.0v 489.745n 0.0v 489.755n 0.0v 494.745n 0.0v 494.755n 0.0v 499.745n 0.0v 499.755n 0.0v 504.745n 0.0v 504.755n 0.0v 509.745n 0.0v 509.755n 0.0v 514.745n 0.0v 514.755n 0.0v 519.745n 0.0v 519.755n 0.0v 524.745n 0.0v 524.755n 0.0v 529.745n 0.0v 529.755n 0.0v 534.745n 0.0v 534.755n 0.0v 539.745n 0.0v 539.755n 0.0v 544.745n 0.0v 544.755n 0.0v 549.745n 0.0v 549.755n 0.0v 554.745n 0.0v 554.755n 0.0v 559.745n 0.0v 559.755n 0.0v 564.745n 0.0v 564.755n 0.0v 569.745n 0.0v 569.755n 0.0v 574.745n 0.0v 574.755n 0.0v 579.745n 0.0v 579.755n 0.0v 584.745n 0.0v 584.755n 0.0v 589.745n 0.0v 589.755n 0.0v 594.745n 0.0v 594.755n 0.0v 599.745n 0.0v 599.755n 0.0v 604.745n 0.0v 604.755n 1.0v 609.745n 1.0v 609.755n 1.0v 614.745n 1.0v 614.755n 0.0v 619.745n 0.0v 619.755n 0.0v 624.745n 0.0v 624.755n 0.0v 629.745n 0.0v 629.755n 0.0v 634.745n 0.0v 634.755n 0.0v 639.745n 0.0v 639.755n 0.0v 644.745n 0.0v 644.755n 0.0v 649.745n 0.0v 649.755n 0.0v 654.745n 0.0v 654.755n 0.0v 659.745n 0.0v 659.755n 0.0v 664.745n 0.0v 664.755n 0.0v 669.745n 0.0v 669.755n 0.0v 674.745n 0.0v 674.755n 0.0v 679.745n 0.0v 679.755n 0.0v 684.745n 0.0v 684.755n 0.0v 689.745n 0.0v 689.755n 1.0v 694.745n 1.0v 694.755n 1.0v 699.745n 1.0v 699.755n 1.0v 704.745n 1.0v 704.755n 1.0v 709.745n 1.0v 709.755n 1.0v 714.745n 1.0v 714.755n 1.0v 719.745n 1.0v 719.755n 1.0v 724.745n 1.0v 724.755n 1.0v 729.745n 1.0v 729.755n 0.0v 734.745n 0.0v 734.755n 0.0v 739.745n 0.0v 739.755n 0.0v 744.745n 0.0v 744.755n 0.0v 749.745n 0.0v 749.755n 0.0v 754.745n 0.0v 754.755n 0.0v 759.745n 0.0v 759.755n 0.0v 764.745n 0.0v 764.755n 1.0v 769.745n 1.0v 769.755n 0.0v 774.745n 0.0v 774.755n 0.0v 779.745n 0.0v 779.755n 0.0v 784.745n 0.0v 784.755n 0.0v 789.745n 0.0v 789.755n 0.0v 794.745n 0.0v 794.755n 0.0v 799.745n 0.0v 799.755n 0.0v 804.745n 0.0v 804.755n 0.0v 809.745n 0.0v 809.755n 0.0v 814.745n 0.0v 814.755n 0.0v 819.745n 0.0v 819.755n 0.0v 824.745n 0.0v 824.755n 0.0v 829.745n 0.0v 829.755n 1.0v 834.745n 1.0v 834.755n 1.0v 839.745n 1.0v 839.755n 1.0v 844.745n 1.0v 844.755n 1.0v 849.745n 1.0v 849.755n 1.0v 854.745n 1.0v 854.755n 1.0v 859.745n 1.0v 859.755n 1.0v 864.745n 1.0v 864.755n 1.0v 869.745n 1.0v 869.755n 1.0v 874.745n 1.0v 874.755n 1.0v 879.745n 1.0v 879.755n 0.0v 884.745n 0.0v 884.755n 0.0v 889.745n 0.0v 889.755n 0.0v 894.745n 0.0v 894.755n 0.0v 899.745n 0.0v 899.755n 1.0v 904.745n 1.0v 904.755n 1.0v 909.745n 1.0v 909.755n 1.0v 914.745n 1.0v 914.755n 1.0v 919.745n 1.0v 919.755n 1.0v 924.745n 1.0v 924.755n 1.0v 929.745n 1.0v 929.755n 1.0v 934.745n 1.0v 934.755n 1.0v 939.745n 1.0v 939.755n 1.0v 944.745n 1.0v 944.755n 0.0v 949.745n 0.0v 949.755n 0.0v 954.745n 0.0v 954.755n 0.0v 959.745n 0.0v 959.755n 0.0v 964.745n 0.0v 964.755n 0.0v 969.745n 0.0v 969.755n 0.0v 974.745n 0.0v 974.755n 0.0v 979.745n 0.0v 979.755n 0.0v 984.745n 0.0v 984.755n 0.0v 989.745n 0.0v 989.755n 0.0v 994.745n 0.0v 994.755n 0.0v 999.745n 0.0v 999.755n 0.0v 1004.745n 0.0v 1004.755n 0.0v 1009.745n 0.0v 1009.755n 1.0v 1014.745n 1.0v 1014.755n 1.0v 1019.745n 1.0v 1019.755n 0.0v 1024.745n 0.0v 1024.755n 0.0v )
* (time, data): [(0, 0), (5, 0), (10, 0), (15, 0), (20, 0), (25, 0), (30, 0), (35, 0), (40, 0), (45, 0), (50, 0), (55, 0), (60, 1), (65, 1), (70, 1), (75, 1), (80, 1), (85, 1), (90, 0), (95, 0), (100, 0), (105, 0), (110, 0), (115, 0), (120, 0), (125, 0), (130, 1), (135, 1), (140, 1), (145, 1), (150, 1), (155, 1), (160, 1), (165, 1), (170, 1), (175, 1), (180, 1), (185, 1), (190, 1), (195, 1), (200, 1), (205, 1), (210, 1), (215, 1), (220, 1), (225, 1), (230, 1), (235, 1), (240, 1), (245, 1), (250, 0), (255, 0), (260, 0), (265, 0), (270, 0), (275, 0), (280, 0), (285, 0), (290, 0), (295, 0), (300, 1), (305, 1), (310, 1), (315, 1), (320, 1), (325, 1), (330, 1), (335, 1), (340, 1), (345, 1), (350, 1), (355, 1), (360, 1), (365, 0), (370, 0), (375, 0), (380, 0), (385, 0), (390, 0), (395, 1), (400, 0), (405, 0), (410, 0), (415, 0), (420, 0), (425, 0), (430, 0), (435, 0), (440, 0), (445, 0), (450, 0), (455, 0), (460, 0), (465, 0), (470, 0), (475, 0), (480, 0), (485, 0), (490, 0), (495, 0), (500, 0), (505, 1), (510, 1), (515, 1), (520, 0), (525, 0), (530, 0), (535, 0), (540, 0), (545, 0), (550, 0), (555, 0), (560, 0), (565, 0), (570, 0), (575, 0), (580, 1), (585, 0), (590, 0), (595, 0), (600, 0), (605, 0), (610, 0), (615, 1), (620, 1), (625, 1), (630, 1), (635, 1), (640, 1), (645, 1), (650, 1), (655, 1), (660, 1), (665, 1), (670, 1), (675, 1), (680, 1), (685, 1), (690, 0), (695, 0), (700, 0), (705, 0), (710, 0), (715, 0), (720, 0), (725, 0), (730, 0), (735, 1), (740, 1), (745, 1), (750, 1), (755, 1), (760, 0), (765, 1), (770, 1), (775, 1), (780, 1), (785, 1), (790, 0), (795, 0), (800, 0), (805, 0), (810, 0), (815, 0), (820, 0), (825, 0), (830, 0), (835, 0), (840, 0), (845, 0), (850, 0), (855, 0), (860, 0), (865, 0), (870, 0), (875, 0), (880, 0), (885, 0), (890, 0), (895, 0), (900, 1), (905, 1), (910, 1), (915, 1), (920, 1), (925, 0), (930, 0), (935, 0), (940, 0), (945, 0), (950, 0), (955, 0), (960, 0), (965, 0), (970, 0), (975, 0), (980, 0), (985, 0), (990, 0), (995, 0), (1000, 1), (1005, 1), (1010, 1), (1015, 1), (1020, 1), (1025, 1)]
Vdin1_43  din1_43  0 PWL (0n 0.0v 4.745n 0.0v 4.755n 0.0v 9.745n 0.0v 9.755n 0.0v 14.745n 0.0v 14.755n 0.0v 19.745n 0.0v 19.755n 0.0v 24.745n 0.0v 24.755n 0.0v 29.745n 0.0v 29.755n 0.0v 34.745n 0.0v 34.755n 0.0v 39.745n 0.0v 39.755n 0.0v 44.745n 0.0v 44.755n 0.0v 49.745n 0.0v 49.755n 0.0v 54.745n 0.0v 54.755n 0.0v 59.745n 0.0v 59.755n 1.0v 64.745n 1.0v 64.755n 1.0v 69.745n 1.0v 69.755n 1.0v 74.745n 1.0v 74.755n 1.0v 79.745n 1.0v 79.755n 1.0v 84.745n 1.0v 84.755n 1.0v 89.745n 1.0v 89.755n 0.0v 94.745n 0.0v 94.755n 0.0v 99.745n 0.0v 99.755n 0.0v 104.745n 0.0v 104.755n 0.0v 109.745n 0.0v 109.755n 0.0v 114.745n 0.0v 114.755n 0.0v 119.745n 0.0v 119.755n 0.0v 124.745n 0.0v 124.755n 0.0v 129.745n 0.0v 129.755n 1.0v 134.745n 1.0v 134.755n 1.0v 139.745n 1.0v 139.755n 1.0v 144.745n 1.0v 144.755n 1.0v 149.745n 1.0v 149.755n 1.0v 154.745n 1.0v 154.755n 1.0v 159.745n 1.0v 159.755n 1.0v 164.745n 1.0v 164.755n 1.0v 169.745n 1.0v 169.755n 1.0v 174.745n 1.0v 174.755n 1.0v 179.745n 1.0v 179.755n 1.0v 184.745n 1.0v 184.755n 1.0v 189.745n 1.0v 189.755n 1.0v 194.745n 1.0v 194.755n 1.0v 199.745n 1.0v 199.755n 1.0v 204.745n 1.0v 204.755n 1.0v 209.745n 1.0v 209.755n 1.0v 214.745n 1.0v 214.755n 1.0v 219.745n 1.0v 219.755n 1.0v 224.745n 1.0v 224.755n 1.0v 229.745n 1.0v 229.755n 1.0v 234.745n 1.0v 234.755n 1.0v 239.745n 1.0v 239.755n 1.0v 244.745n 1.0v 244.755n 1.0v 249.745n 1.0v 249.755n 0.0v 254.745n 0.0v 254.755n 0.0v 259.745n 0.0v 259.755n 0.0v 264.745n 0.0v 264.755n 0.0v 269.745n 0.0v 269.755n 0.0v 274.745n 0.0v 274.755n 0.0v 279.745n 0.0v 279.755n 0.0v 284.745n 0.0v 284.755n 0.0v 289.745n 0.0v 289.755n 0.0v 294.745n 0.0v 294.755n 0.0v 299.745n 0.0v 299.755n 1.0v 304.745n 1.0v 304.755n 1.0v 309.745n 1.0v 309.755n 1.0v 314.745n 1.0v 314.755n 1.0v 319.745n 1.0v 319.755n 1.0v 324.745n 1.0v 324.755n 1.0v 329.745n 1.0v 329.755n 1.0v 334.745n 1.0v 334.755n 1.0v 339.745n 1.0v 339.755n 1.0v 344.745n 1.0v 344.755n 1.0v 349.745n 1.0v 349.755n 1.0v 354.745n 1.0v 354.755n 1.0v 359.745n 1.0v 359.755n 1.0v 364.745n 1.0v 364.755n 0.0v 369.745n 0.0v 369.755n 0.0v 374.745n 0.0v 374.755n 0.0v 379.745n 0.0v 379.755n 0.0v 384.745n 0.0v 384.755n 0.0v 389.745n 0.0v 389.755n 0.0v 394.745n 0.0v 394.755n 1.0v 399.745n 1.0v 399.755n 0.0v 404.745n 0.0v 404.755n 0.0v 409.745n 0.0v 409.755n 0.0v 414.745n 0.0v 414.755n 0.0v 419.745n 0.0v 419.755n 0.0v 424.745n 0.0v 424.755n 0.0v 429.745n 0.0v 429.755n 0.0v 434.745n 0.0v 434.755n 0.0v 439.745n 0.0v 439.755n 0.0v 444.745n 0.0v 444.755n 0.0v 449.745n 0.0v 449.755n 0.0v 454.745n 0.0v 454.755n 0.0v 459.745n 0.0v 459.755n 0.0v 464.745n 0.0v 464.755n 0.0v 469.745n 0.0v 469.755n 0.0v 474.745n 0.0v 474.755n 0.0v 479.745n 0.0v 479.755n 0.0v 484.745n 0.0v 484.755n 0.0v 489.745n 0.0v 489.755n 0.0v 494.745n 0.0v 494.755n 0.0v 499.745n 0.0v 499.755n 0.0v 504.745n 0.0v 504.755n 1.0v 509.745n 1.0v 509.755n 1.0v 514.745n 1.0v 514.755n 1.0v 519.745n 1.0v 519.755n 0.0v 524.745n 0.0v 524.755n 0.0v 529.745n 0.0v 529.755n 0.0v 534.745n 0.0v 534.755n 0.0v 539.745n 0.0v 539.755n 0.0v 544.745n 0.0v 544.755n 0.0v 549.745n 0.0v 549.755n 0.0v 554.745n 0.0v 554.755n 0.0v 559.745n 0.0v 559.755n 0.0v 564.745n 0.0v 564.755n 0.0v 569.745n 0.0v 569.755n 0.0v 574.745n 0.0v 574.755n 0.0v 579.745n 0.0v 579.755n 1.0v 584.745n 1.0v 584.755n 0.0v 589.745n 0.0v 589.755n 0.0v 594.745n 0.0v 594.755n 0.0v 599.745n 0.0v 599.755n 0.0v 604.745n 0.0v 604.755n 0.0v 609.745n 0.0v 609.755n 0.0v 614.745n 0.0v 614.755n 1.0v 619.745n 1.0v 619.755n 1.0v 624.745n 1.0v 624.755n 1.0v 629.745n 1.0v 629.755n 1.0v 634.745n 1.0v 634.755n 1.0v 639.745n 1.0v 639.755n 1.0v 644.745n 1.0v 644.755n 1.0v 649.745n 1.0v 649.755n 1.0v 654.745n 1.0v 654.755n 1.0v 659.745n 1.0v 659.755n 1.0v 664.745n 1.0v 664.755n 1.0v 669.745n 1.0v 669.755n 1.0v 674.745n 1.0v 674.755n 1.0v 679.745n 1.0v 679.755n 1.0v 684.745n 1.0v 684.755n 1.0v 689.745n 1.0v 689.755n 0.0v 694.745n 0.0v 694.755n 0.0v 699.745n 0.0v 699.755n 0.0v 704.745n 0.0v 704.755n 0.0v 709.745n 0.0v 709.755n 0.0v 714.745n 0.0v 714.755n 0.0v 719.745n 0.0v 719.755n 0.0v 724.745n 0.0v 724.755n 0.0v 729.745n 0.0v 729.755n 0.0v 734.745n 0.0v 734.755n 1.0v 739.745n 1.0v 739.755n 1.0v 744.745n 1.0v 744.755n 1.0v 749.745n 1.0v 749.755n 1.0v 754.745n 1.0v 754.755n 1.0v 759.745n 1.0v 759.755n 0.0v 764.745n 0.0v 764.755n 1.0v 769.745n 1.0v 769.755n 1.0v 774.745n 1.0v 774.755n 1.0v 779.745n 1.0v 779.755n 1.0v 784.745n 1.0v 784.755n 1.0v 789.745n 1.0v 789.755n 0.0v 794.745n 0.0v 794.755n 0.0v 799.745n 0.0v 799.755n 0.0v 804.745n 0.0v 804.755n 0.0v 809.745n 0.0v 809.755n 0.0v 814.745n 0.0v 814.755n 0.0v 819.745n 0.0v 819.755n 0.0v 824.745n 0.0v 824.755n 0.0v 829.745n 0.0v 829.755n 0.0v 834.745n 0.0v 834.755n 0.0v 839.745n 0.0v 839.755n 0.0v 844.745n 0.0v 844.755n 0.0v 849.745n 0.0v 849.755n 0.0v 854.745n 0.0v 854.755n 0.0v 859.745n 0.0v 859.755n 0.0v 864.745n 0.0v 864.755n 0.0v 869.745n 0.0v 869.755n 0.0v 874.745n 0.0v 874.755n 0.0v 879.745n 0.0v 879.755n 0.0v 884.745n 0.0v 884.755n 0.0v 889.745n 0.0v 889.755n 0.0v 894.745n 0.0v 894.755n 0.0v 899.745n 0.0v 899.755n 1.0v 904.745n 1.0v 904.755n 1.0v 909.745n 1.0v 909.755n 1.0v 914.745n 1.0v 914.755n 1.0v 919.745n 1.0v 919.755n 1.0v 924.745n 1.0v 924.755n 0.0v 929.745n 0.0v 929.755n 0.0v 934.745n 0.0v 934.755n 0.0v 939.745n 0.0v 939.755n 0.0v 944.745n 0.0v 944.755n 0.0v 949.745n 0.0v 949.755n 0.0v 954.745n 0.0v 954.755n 0.0v 959.745n 0.0v 959.755n 0.0v 964.745n 0.0v 964.755n 0.0v 969.745n 0.0v 969.755n 0.0v 974.745n 0.0v 974.755n 0.0v 979.745n 0.0v 979.755n 0.0v 984.745n 0.0v 984.755n 0.0v 989.745n 0.0v 989.755n 0.0v 994.745n 0.0v 994.755n 0.0v 999.745n 0.0v 999.755n 1.0v 1004.745n 1.0v 1004.755n 1.0v 1009.745n 1.0v 1009.755n 1.0v 1014.745n 1.0v 1014.755n 1.0v 1019.745n 1.0v 1019.755n 1.0v 1024.745n 1.0v 1024.755n 1.0v )
* (time, data): [(0, 0), (5, 1), (10, 0), (15, 1), (20, 1), (25, 1), (30, 1), (35, 1), (40, 1), (45, 1), (50, 1), (55, 1), (60, 0), (65, 0), (70, 0), (75, 0), (80, 1), (85, 1), (90, 1), (95, 1), (100, 1), (105, 1), (110, 1), (115, 1), (120, 1), (125, 1), (130, 1), (135, 1), (140, 1), (145, 1), (150, 1), (155, 1), (160, 1), (165, 1), (170, 1), (175, 0), (180, 1), (185, 1), (190, 1), (195, 1), (200, 1), (205, 1), (210, 1), (215, 1), (220, 1), (225, 1), (230, 1), (235, 1), (240, 1), (245, 1), (250, 0), (255, 0), (260, 0), (265, 0), (270, 0), (275, 0), (280, 0), (285, 0), (290, 0), (295, 0), (300, 1), (305, 1), (310, 1), (315, 1), (320, 1), (325, 1), (330, 1), (335, 1), (340, 1), (345, 1), (350, 1), (355, 1), (360, 1), (365, 1), (370, 1), (375, 1), (380, 0), (385, 0), (390, 0), (395, 1), (400, 1), (405, 1), (410, 1), (415, 1), (420, 0), (425, 0), (430, 0), (435, 0), (440, 0), (445, 0), (450, 0), (455, 0), (460, 0), (465, 1), (470, 1), (475, 1), (480, 1), (485, 0), (490, 0), (495, 0), (500, 0), (505, 0), (510, 0), (515, 0), (520, 1), (525, 1), (530, 1), (535, 1), (540, 1), (545, 1), (550, 1), (555, 1), (560, 1), (565, 1), (570, 1), (575, 1), (580, 1), (585, 1), (590, 1), (595, 1), (600, 1), (605, 0), (610, 0), (615, 1), (620, 1), (625, 1), (630, 1), (635, 1), (640, 1), (645, 1), (650, 1), (655, 1), (660, 1), (665, 1), (670, 1), (675, 1), (680, 1), (685, 1), (690, 0), (695, 0), (700, 0), (705, 0), (710, 0), (715, 0), (720, 0), (725, 0), (730, 1), (735, 1), (740, 1), (745, 1), (750, 1), (755, 1), (760, 0), (765, 0), (770, 1), (775, 1), (780, 1), (785, 1), (790, 0), (795, 0), (800, 0), (805, 0), (810, 0), (815, 0), (820, 0), (825, 0), (830, 0), (835, 0), (840, 0), (845, 0), (850, 0), (855, 0), (860, 1), (865, 1), (870, 1), (875, 1), (880, 1), (885, 1), (890, 1), (895, 1), (900, 0), (905, 0), (910, 0), (915, 0), (920, 0), (925, 0), (930, 0), (935, 0), (940, 0), (945, 0), (950, 0), (955, 0), (960, 0), (965, 0), (970, 0), (975, 0), (980, 0), (985, 0), (990, 0), (995, 0), (1000, 1), (1005, 1), (1010, 0), (1015, 0), (1020, 1), (1025, 1)]
Vdin1_44  din1_44  0 PWL (0n 0.0v 4.745n 0.0v 4.755n 1.0v 9.745n 1.0v 9.755n 0.0v 14.745n 0.0v 14.755n 1.0v 19.745n 1.0v 19.755n 1.0v 24.745n 1.0v 24.755n 1.0v 29.745n 1.0v 29.755n 1.0v 34.745n 1.0v 34.755n 1.0v 39.745n 1.0v 39.755n 1.0v 44.745n 1.0v 44.755n 1.0v 49.745n 1.0v 49.755n 1.0v 54.745n 1.0v 54.755n 1.0v 59.745n 1.0v 59.755n 0.0v 64.745n 0.0v 64.755n 0.0v 69.745n 0.0v 69.755n 0.0v 74.745n 0.0v 74.755n 0.0v 79.745n 0.0v 79.755n 1.0v 84.745n 1.0v 84.755n 1.0v 89.745n 1.0v 89.755n 1.0v 94.745n 1.0v 94.755n 1.0v 99.745n 1.0v 99.755n 1.0v 104.745n 1.0v 104.755n 1.0v 109.745n 1.0v 109.755n 1.0v 114.745n 1.0v 114.755n 1.0v 119.745n 1.0v 119.755n 1.0v 124.745n 1.0v 124.755n 1.0v 129.745n 1.0v 129.755n 1.0v 134.745n 1.0v 134.755n 1.0v 139.745n 1.0v 139.755n 1.0v 144.745n 1.0v 144.755n 1.0v 149.745n 1.0v 149.755n 1.0v 154.745n 1.0v 154.755n 1.0v 159.745n 1.0v 159.755n 1.0v 164.745n 1.0v 164.755n 1.0v 169.745n 1.0v 169.755n 1.0v 174.745n 1.0v 174.755n 0.0v 179.745n 0.0v 179.755n 1.0v 184.745n 1.0v 184.755n 1.0v 189.745n 1.0v 189.755n 1.0v 194.745n 1.0v 194.755n 1.0v 199.745n 1.0v 199.755n 1.0v 204.745n 1.0v 204.755n 1.0v 209.745n 1.0v 209.755n 1.0v 214.745n 1.0v 214.755n 1.0v 219.745n 1.0v 219.755n 1.0v 224.745n 1.0v 224.755n 1.0v 229.745n 1.0v 229.755n 1.0v 234.745n 1.0v 234.755n 1.0v 239.745n 1.0v 239.755n 1.0v 244.745n 1.0v 244.755n 1.0v 249.745n 1.0v 249.755n 0.0v 254.745n 0.0v 254.755n 0.0v 259.745n 0.0v 259.755n 0.0v 264.745n 0.0v 264.755n 0.0v 269.745n 0.0v 269.755n 0.0v 274.745n 0.0v 274.755n 0.0v 279.745n 0.0v 279.755n 0.0v 284.745n 0.0v 284.755n 0.0v 289.745n 0.0v 289.755n 0.0v 294.745n 0.0v 294.755n 0.0v 299.745n 0.0v 299.755n 1.0v 304.745n 1.0v 304.755n 1.0v 309.745n 1.0v 309.755n 1.0v 314.745n 1.0v 314.755n 1.0v 319.745n 1.0v 319.755n 1.0v 324.745n 1.0v 324.755n 1.0v 329.745n 1.0v 329.755n 1.0v 334.745n 1.0v 334.755n 1.0v 339.745n 1.0v 339.755n 1.0v 344.745n 1.0v 344.755n 1.0v 349.745n 1.0v 349.755n 1.0v 354.745n 1.0v 354.755n 1.0v 359.745n 1.0v 359.755n 1.0v 364.745n 1.0v 364.755n 1.0v 369.745n 1.0v 369.755n 1.0v 374.745n 1.0v 374.755n 1.0v 379.745n 1.0v 379.755n 0.0v 384.745n 0.0v 384.755n 0.0v 389.745n 0.0v 389.755n 0.0v 394.745n 0.0v 394.755n 1.0v 399.745n 1.0v 399.755n 1.0v 404.745n 1.0v 404.755n 1.0v 409.745n 1.0v 409.755n 1.0v 414.745n 1.0v 414.755n 1.0v 419.745n 1.0v 419.755n 0.0v 424.745n 0.0v 424.755n 0.0v 429.745n 0.0v 429.755n 0.0v 434.745n 0.0v 434.755n 0.0v 439.745n 0.0v 439.755n 0.0v 444.745n 0.0v 444.755n 0.0v 449.745n 0.0v 449.755n 0.0v 454.745n 0.0v 454.755n 0.0v 459.745n 0.0v 459.755n 0.0v 464.745n 0.0v 464.755n 1.0v 469.745n 1.0v 469.755n 1.0v 474.745n 1.0v 474.755n 1.0v 479.745n 1.0v 479.755n 1.0v 484.745n 1.0v 484.755n 0.0v 489.745n 0.0v 489.755n 0.0v 494.745n 0.0v 494.755n 0.0v 499.745n 0.0v 499.755n 0.0v 504.745n 0.0v 504.755n 0.0v 509.745n 0.0v 509.755n 0.0v 514.745n 0.0v 514.755n 0.0v 519.745n 0.0v 519.755n 1.0v 524.745n 1.0v 524.755n 1.0v 529.745n 1.0v 529.755n 1.0v 534.745n 1.0v 534.755n 1.0v 539.745n 1.0v 539.755n 1.0v 544.745n 1.0v 544.755n 1.0v 549.745n 1.0v 549.755n 1.0v 554.745n 1.0v 554.755n 1.0v 559.745n 1.0v 559.755n 1.0v 564.745n 1.0v 564.755n 1.0v 569.745n 1.0v 569.755n 1.0v 574.745n 1.0v 574.755n 1.0v 579.745n 1.0v 579.755n 1.0v 584.745n 1.0v 584.755n 1.0v 589.745n 1.0v 589.755n 1.0v 594.745n 1.0v 594.755n 1.0v 599.745n 1.0v 599.755n 1.0v 604.745n 1.0v 604.755n 0.0v 609.745n 0.0v 609.755n 0.0v 614.745n 0.0v 614.755n 1.0v 619.745n 1.0v 619.755n 1.0v 624.745n 1.0v 624.755n 1.0v 629.745n 1.0v 629.755n 1.0v 634.745n 1.0v 634.755n 1.0v 639.745n 1.0v 639.755n 1.0v 644.745n 1.0v 644.755n 1.0v 649.745n 1.0v 649.755n 1.0v 654.745n 1.0v 654.755n 1.0v 659.745n 1.0v 659.755n 1.0v 664.745n 1.0v 664.755n 1.0v 669.745n 1.0v 669.755n 1.0v 674.745n 1.0v 674.755n 1.0v 679.745n 1.0v 679.755n 1.0v 684.745n 1.0v 684.755n 1.0v 689.745n 1.0v 689.755n 0.0v 694.745n 0.0v 694.755n 0.0v 699.745n 0.0v 699.755n 0.0v 704.745n 0.0v 704.755n 0.0v 709.745n 0.0v 709.755n 0.0v 714.745n 0.0v 714.755n 0.0v 719.745n 0.0v 719.755n 0.0v 724.745n 0.0v 724.755n 0.0v 729.745n 0.0v 729.755n 1.0v 734.745n 1.0v 734.755n 1.0v 739.745n 1.0v 739.755n 1.0v 744.745n 1.0v 744.755n 1.0v 749.745n 1.0v 749.755n 1.0v 754.745n 1.0v 754.755n 1.0v 759.745n 1.0v 759.755n 0.0v 764.745n 0.0v 764.755n 0.0v 769.745n 0.0v 769.755n 1.0v 774.745n 1.0v 774.755n 1.0v 779.745n 1.0v 779.755n 1.0v 784.745n 1.0v 784.755n 1.0v 789.745n 1.0v 789.755n 0.0v 794.745n 0.0v 794.755n 0.0v 799.745n 0.0v 799.755n 0.0v 804.745n 0.0v 804.755n 0.0v 809.745n 0.0v 809.755n 0.0v 814.745n 0.0v 814.755n 0.0v 819.745n 0.0v 819.755n 0.0v 824.745n 0.0v 824.755n 0.0v 829.745n 0.0v 829.755n 0.0v 834.745n 0.0v 834.755n 0.0v 839.745n 0.0v 839.755n 0.0v 844.745n 0.0v 844.755n 0.0v 849.745n 0.0v 849.755n 0.0v 854.745n 0.0v 854.755n 0.0v 859.745n 0.0v 859.755n 1.0v 864.745n 1.0v 864.755n 1.0v 869.745n 1.0v 869.755n 1.0v 874.745n 1.0v 874.755n 1.0v 879.745n 1.0v 879.755n 1.0v 884.745n 1.0v 884.755n 1.0v 889.745n 1.0v 889.755n 1.0v 894.745n 1.0v 894.755n 1.0v 899.745n 1.0v 899.755n 0.0v 904.745n 0.0v 904.755n 0.0v 909.745n 0.0v 909.755n 0.0v 914.745n 0.0v 914.755n 0.0v 919.745n 0.0v 919.755n 0.0v 924.745n 0.0v 924.755n 0.0v 929.745n 0.0v 929.755n 0.0v 934.745n 0.0v 934.755n 0.0v 939.745n 0.0v 939.755n 0.0v 944.745n 0.0v 944.755n 0.0v 949.745n 0.0v 949.755n 0.0v 954.745n 0.0v 954.755n 0.0v 959.745n 0.0v 959.755n 0.0v 964.745n 0.0v 964.755n 0.0v 969.745n 0.0v 969.755n 0.0v 974.745n 0.0v 974.755n 0.0v 979.745n 0.0v 979.755n 0.0v 984.745n 0.0v 984.755n 0.0v 989.745n 0.0v 989.755n 0.0v 994.745n 0.0v 994.755n 0.0v 999.745n 0.0v 999.755n 1.0v 1004.745n 1.0v 1004.755n 1.0v 1009.745n 1.0v 1009.755n 0.0v 1014.745n 0.0v 1014.755n 0.0v 1019.745n 0.0v 1019.755n 1.0v 1024.745n 1.0v 1024.755n 1.0v )
* (time, data): [(0, 0), (5, 0), (10, 0), (15, 0), (20, 0), (25, 0), (30, 0), (35, 0), (40, 0), (45, 0), (50, 0), (55, 0), (60, 1), (65, 1), (70, 1), (75, 1), (80, 0), (85, 0), (90, 1), (95, 1), (100, 1), (105, 1), (110, 1), (115, 1), (120, 1), (125, 1), (130, 1), (135, 1), (140, 1), (145, 1), (150, 1), (155, 1), (160, 1), (165, 1), (170, 1), (175, 1), (180, 0), (185, 0), (190, 0), (195, 0), (200, 0), (205, 0), (210, 0), (215, 0), (220, 0), (225, 0), (230, 0), (235, 0), (240, 0), (245, 0), (250, 1), (255, 1), (260, 1), (265, 1), (270, 1), (275, 1), (280, 1), (285, 1), (290, 1), (295, 1), (300, 0), (305, 0), (310, 0), (315, 0), (320, 0), (325, 0), (330, 0), (335, 0), (340, 0), (345, 0), (350, 0), (355, 0), (360, 0), (365, 0), (370, 0), (375, 0), (380, 1), (385, 1), (390, 0), (395, 1), (400, 1), (405, 1), (410, 1), (415, 1), (420, 1), (425, 1), (430, 1), (435, 1), (440, 1), (445, 1), (450, 1), (455, 1), (460, 1), (465, 1), (470, 1), (475, 1), (480, 1), (485, 1), (490, 1), (495, 1), (500, 1), (505, 0), (510, 0), (515, 0), (520, 1), (525, 1), (530, 1), (535, 1), (540, 1), (545, 1), (550, 1), (555, 1), (560, 1), (565, 1), (570, 1), (575, 1), (580, 0), (585, 1), (590, 1), (595, 1), (600, 1), (605, 1), (610, 1), (615, 0), (620, 0), (625, 0), (630, 0), (635, 0), (640, 0), (645, 0), (650, 0), (655, 0), (660, 0), (665, 0), (670, 0), (675, 0), (680, 0), (685, 0), (690, 1), (695, 1), (700, 1), (705, 1), (710, 1), (715, 1), (720, 1), (725, 1), (730, 0), (735, 1), (740, 1), (745, 1), (750, 1), (755, 1), (760, 1), (765, 1), (770, 0), (775, 0), (780, 0), (785, 0), (790, 1), (795, 1), (800, 1), (805, 1), (810, 0), (815, 0), (820, 0), (825, 0), (830, 0), (835, 0), (840, 0), (845, 0), (850, 0), (855, 0), (860, 1), (865, 1), (870, 1), (875, 1), (880, 0), (885, 0), (890, 0), (895, 0), (900, 0), (905, 0), (910, 0), (915, 0), (920, 0), (925, 0), (930, 1), (935, 1), (940, 1), (945, 1), (950, 1), (955, 1), (960, 1), (965, 1), (970, 1), (975, 1), (980, 1), (985, 1), (990, 1), (995, 1), (1000, 1), (1005, 1), (1010, 1), (1015, 1), (1020, 0), (1025, 0)]
Vdin1_45  din1_45  0 PWL (0n 0.0v 4.745n 0.0v 4.755n 0.0v 9.745n 0.0v 9.755n 0.0v 14.745n 0.0v 14.755n 0.0v 19.745n 0.0v 19.755n 0.0v 24.745n 0.0v 24.755n 0.0v 29.745n 0.0v 29.755n 0.0v 34.745n 0.0v 34.755n 0.0v 39.745n 0.0v 39.755n 0.0v 44.745n 0.0v 44.755n 0.0v 49.745n 0.0v 49.755n 0.0v 54.745n 0.0v 54.755n 0.0v 59.745n 0.0v 59.755n 1.0v 64.745n 1.0v 64.755n 1.0v 69.745n 1.0v 69.755n 1.0v 74.745n 1.0v 74.755n 1.0v 79.745n 1.0v 79.755n 0.0v 84.745n 0.0v 84.755n 0.0v 89.745n 0.0v 89.755n 1.0v 94.745n 1.0v 94.755n 1.0v 99.745n 1.0v 99.755n 1.0v 104.745n 1.0v 104.755n 1.0v 109.745n 1.0v 109.755n 1.0v 114.745n 1.0v 114.755n 1.0v 119.745n 1.0v 119.755n 1.0v 124.745n 1.0v 124.755n 1.0v 129.745n 1.0v 129.755n 1.0v 134.745n 1.0v 134.755n 1.0v 139.745n 1.0v 139.755n 1.0v 144.745n 1.0v 144.755n 1.0v 149.745n 1.0v 149.755n 1.0v 154.745n 1.0v 154.755n 1.0v 159.745n 1.0v 159.755n 1.0v 164.745n 1.0v 164.755n 1.0v 169.745n 1.0v 169.755n 1.0v 174.745n 1.0v 174.755n 1.0v 179.745n 1.0v 179.755n 0.0v 184.745n 0.0v 184.755n 0.0v 189.745n 0.0v 189.755n 0.0v 194.745n 0.0v 194.755n 0.0v 199.745n 0.0v 199.755n 0.0v 204.745n 0.0v 204.755n 0.0v 209.745n 0.0v 209.755n 0.0v 214.745n 0.0v 214.755n 0.0v 219.745n 0.0v 219.755n 0.0v 224.745n 0.0v 224.755n 0.0v 229.745n 0.0v 229.755n 0.0v 234.745n 0.0v 234.755n 0.0v 239.745n 0.0v 239.755n 0.0v 244.745n 0.0v 244.755n 0.0v 249.745n 0.0v 249.755n 1.0v 254.745n 1.0v 254.755n 1.0v 259.745n 1.0v 259.755n 1.0v 264.745n 1.0v 264.755n 1.0v 269.745n 1.0v 269.755n 1.0v 274.745n 1.0v 274.755n 1.0v 279.745n 1.0v 279.755n 1.0v 284.745n 1.0v 284.755n 1.0v 289.745n 1.0v 289.755n 1.0v 294.745n 1.0v 294.755n 1.0v 299.745n 1.0v 299.755n 0.0v 304.745n 0.0v 304.755n 0.0v 309.745n 0.0v 309.755n 0.0v 314.745n 0.0v 314.755n 0.0v 319.745n 0.0v 319.755n 0.0v 324.745n 0.0v 324.755n 0.0v 329.745n 0.0v 329.755n 0.0v 334.745n 0.0v 334.755n 0.0v 339.745n 0.0v 339.755n 0.0v 344.745n 0.0v 344.755n 0.0v 349.745n 0.0v 349.755n 0.0v 354.745n 0.0v 354.755n 0.0v 359.745n 0.0v 359.755n 0.0v 364.745n 0.0v 364.755n 0.0v 369.745n 0.0v 369.755n 0.0v 374.745n 0.0v 374.755n 0.0v 379.745n 0.0v 379.755n 1.0v 384.745n 1.0v 384.755n 1.0v 389.745n 1.0v 389.755n 0.0v 394.745n 0.0v 394.755n 1.0v 399.745n 1.0v 399.755n 1.0v 404.745n 1.0v 404.755n 1.0v 409.745n 1.0v 409.755n 1.0v 414.745n 1.0v 414.755n 1.0v 419.745n 1.0v 419.755n 1.0v 424.745n 1.0v 424.755n 1.0v 429.745n 1.0v 429.755n 1.0v 434.745n 1.0v 434.755n 1.0v 439.745n 1.0v 439.755n 1.0v 444.745n 1.0v 444.755n 1.0v 449.745n 1.0v 449.755n 1.0v 454.745n 1.0v 454.755n 1.0v 459.745n 1.0v 459.755n 1.0v 464.745n 1.0v 464.755n 1.0v 469.745n 1.0v 469.755n 1.0v 474.745n 1.0v 474.755n 1.0v 479.745n 1.0v 479.755n 1.0v 484.745n 1.0v 484.755n 1.0v 489.745n 1.0v 489.755n 1.0v 494.745n 1.0v 494.755n 1.0v 499.745n 1.0v 499.755n 1.0v 504.745n 1.0v 504.755n 0.0v 509.745n 0.0v 509.755n 0.0v 514.745n 0.0v 514.755n 0.0v 519.745n 0.0v 519.755n 1.0v 524.745n 1.0v 524.755n 1.0v 529.745n 1.0v 529.755n 1.0v 534.745n 1.0v 534.755n 1.0v 539.745n 1.0v 539.755n 1.0v 544.745n 1.0v 544.755n 1.0v 549.745n 1.0v 549.755n 1.0v 554.745n 1.0v 554.755n 1.0v 559.745n 1.0v 559.755n 1.0v 564.745n 1.0v 564.755n 1.0v 569.745n 1.0v 569.755n 1.0v 574.745n 1.0v 574.755n 1.0v 579.745n 1.0v 579.755n 0.0v 584.745n 0.0v 584.755n 1.0v 589.745n 1.0v 589.755n 1.0v 594.745n 1.0v 594.755n 1.0v 599.745n 1.0v 599.755n 1.0v 604.745n 1.0v 604.755n 1.0v 609.745n 1.0v 609.755n 1.0v 614.745n 1.0v 614.755n 0.0v 619.745n 0.0v 619.755n 0.0v 624.745n 0.0v 624.755n 0.0v 629.745n 0.0v 629.755n 0.0v 634.745n 0.0v 634.755n 0.0v 639.745n 0.0v 639.755n 0.0v 644.745n 0.0v 644.755n 0.0v 649.745n 0.0v 649.755n 0.0v 654.745n 0.0v 654.755n 0.0v 659.745n 0.0v 659.755n 0.0v 664.745n 0.0v 664.755n 0.0v 669.745n 0.0v 669.755n 0.0v 674.745n 0.0v 674.755n 0.0v 679.745n 0.0v 679.755n 0.0v 684.745n 0.0v 684.755n 0.0v 689.745n 0.0v 689.755n 1.0v 694.745n 1.0v 694.755n 1.0v 699.745n 1.0v 699.755n 1.0v 704.745n 1.0v 704.755n 1.0v 709.745n 1.0v 709.755n 1.0v 714.745n 1.0v 714.755n 1.0v 719.745n 1.0v 719.755n 1.0v 724.745n 1.0v 724.755n 1.0v 729.745n 1.0v 729.755n 0.0v 734.745n 0.0v 734.755n 1.0v 739.745n 1.0v 739.755n 1.0v 744.745n 1.0v 744.755n 1.0v 749.745n 1.0v 749.755n 1.0v 754.745n 1.0v 754.755n 1.0v 759.745n 1.0v 759.755n 1.0v 764.745n 1.0v 764.755n 1.0v 769.745n 1.0v 769.755n 0.0v 774.745n 0.0v 774.755n 0.0v 779.745n 0.0v 779.755n 0.0v 784.745n 0.0v 784.755n 0.0v 789.745n 0.0v 789.755n 1.0v 794.745n 1.0v 794.755n 1.0v 799.745n 1.0v 799.755n 1.0v 804.745n 1.0v 804.755n 1.0v 809.745n 1.0v 809.755n 0.0v 814.745n 0.0v 814.755n 0.0v 819.745n 0.0v 819.755n 0.0v 824.745n 0.0v 824.755n 0.0v 829.745n 0.0v 829.755n 0.0v 834.745n 0.0v 834.755n 0.0v 839.745n 0.0v 839.755n 0.0v 844.745n 0.0v 844.755n 0.0v 849.745n 0.0v 849.755n 0.0v 854.745n 0.0v 854.755n 0.0v 859.745n 0.0v 859.755n 1.0v 864.745n 1.0v 864.755n 1.0v 869.745n 1.0v 869.755n 1.0v 874.745n 1.0v 874.755n 1.0v 879.745n 1.0v 879.755n 0.0v 884.745n 0.0v 884.755n 0.0v 889.745n 0.0v 889.755n 0.0v 894.745n 0.0v 894.755n 0.0v 899.745n 0.0v 899.755n 0.0v 904.745n 0.0v 904.755n 0.0v 909.745n 0.0v 909.755n 0.0v 914.745n 0.0v 914.755n 0.0v 919.745n 0.0v 919.755n 0.0v 924.745n 0.0v 924.755n 0.0v 929.745n 0.0v 929.755n 1.0v 934.745n 1.0v 934.755n 1.0v 939.745n 1.0v 939.755n 1.0v 944.745n 1.0v 944.755n 1.0v 949.745n 1.0v 949.755n 1.0v 954.745n 1.0v 954.755n 1.0v 959.745n 1.0v 959.755n 1.0v 964.745n 1.0v 964.755n 1.0v 969.745n 1.0v 969.755n 1.0v 974.745n 1.0v 974.755n 1.0v 979.745n 1.0v 979.755n 1.0v 984.745n 1.0v 984.755n 1.0v 989.745n 1.0v 989.755n 1.0v 994.745n 1.0v 994.755n 1.0v 999.745n 1.0v 999.755n 1.0v 1004.745n 1.0v 1004.755n 1.0v 1009.745n 1.0v 1009.755n 1.0v 1014.745n 1.0v 1014.755n 1.0v 1019.745n 1.0v 1019.755n 0.0v 1024.745n 0.0v 1024.755n 0.0v )
* (time, data): [(0, 0), (5, 1), (10, 1), (15, 0), (20, 0), (25, 0), (30, 0), (35, 0), (40, 0), (45, 0), (50, 0), (55, 0), (60, 0), (65, 0), (70, 0), (75, 0), (80, 1), (85, 1), (90, 0), (95, 0), (100, 0), (105, 0), (110, 0), (115, 0), (120, 0), (125, 0), (130, 1), (135, 1), (140, 1), (145, 1), (150, 1), (155, 1), (160, 1), (165, 1), (170, 1), (175, 0), (180, 0), (185, 0), (190, 0), (195, 0), (200, 0), (205, 0), (210, 0), (215, 0), (220, 0), (225, 0), (230, 0), (235, 0), (240, 0), (245, 1), (250, 1), (255, 1), (260, 1), (265, 1), (270, 1), (275, 1), (280, 1), (285, 1), (290, 1), (295, 1), (300, 0), (305, 0), (310, 0), (315, 0), (320, 0), (325, 0), (330, 0), (335, 0), (340, 0), (345, 0), (350, 0), (355, 0), (360, 0), (365, 0), (370, 0), (375, 0), (380, 1), (385, 1), (390, 0), (395, 0), (400, 0), (405, 0), (410, 0), (415, 0), (420, 1), (425, 1), (430, 1), (435, 1), (440, 1), (445, 1), (450, 1), (455, 1), (460, 1), (465, 0), (470, 0), (475, 0), (480, 0), (485, 1), (490, 1), (495, 1), (500, 1), (505, 0), (510, 0), (515, 0), (520, 0), (525, 0), (530, 0), (535, 0), (540, 0), (545, 0), (550, 0), (555, 0), (560, 0), (565, 0), (570, 0), (575, 0), (580, 1), (585, 1), (590, 1), (595, 1), (600, 1), (605, 1), (610, 1), (615, 0), (620, 0), (625, 0), (630, 0), (635, 0), (640, 0), (645, 0), (650, 0), (655, 0), (660, 0), (665, 0), (670, 0), (675, 0), (680, 0), (685, 0), (690, 1), (695, 1), (700, 1), (705, 1), (710, 1), (715, 1), (720, 1), (725, 1), (730, 1), (735, 1), (740, 1), (745, 1), (750, 1), (755, 1), (760, 1), (765, 1), (770, 0), (775, 0), (780, 0), (785, 0), (790, 0), (795, 0), (800, 0), (805, 0), (810, 1), (815, 1), (820, 1), (825, 1), (830, 1), (835, 1), (840, 1), (845, 1), (850, 1), (855, 1), (860, 1), (865, 1), (870, 1), (875, 1), (880, 1), (885, 1), (890, 1), (895, 1), (900, 1), (905, 1), (910, 1), (915, 1), (920, 1), (925, 0), (930, 0), (935, 0), (940, 0), (945, 1), (950, 1), (955, 1), (960, 1), (965, 1), (970, 1), (975, 1), (980, 1), (985, 1), (990, 1), (995, 1), (1000, 0), (1005, 0), (1010, 0), (1015, 0), (1020, 1), (1025, 1)]
Vdin1_46  din1_46  0 PWL (0n 0.0v 4.745n 0.0v 4.755n 1.0v 9.745n 1.0v 9.755n 1.0v 14.745n 1.0v 14.755n 0.0v 19.745n 0.0v 19.755n 0.0v 24.745n 0.0v 24.755n 0.0v 29.745n 0.0v 29.755n 0.0v 34.745n 0.0v 34.755n 0.0v 39.745n 0.0v 39.755n 0.0v 44.745n 0.0v 44.755n 0.0v 49.745n 0.0v 49.755n 0.0v 54.745n 0.0v 54.755n 0.0v 59.745n 0.0v 59.755n 0.0v 64.745n 0.0v 64.755n 0.0v 69.745n 0.0v 69.755n 0.0v 74.745n 0.0v 74.755n 0.0v 79.745n 0.0v 79.755n 1.0v 84.745n 1.0v 84.755n 1.0v 89.745n 1.0v 89.755n 0.0v 94.745n 0.0v 94.755n 0.0v 99.745n 0.0v 99.755n 0.0v 104.745n 0.0v 104.755n 0.0v 109.745n 0.0v 109.755n 0.0v 114.745n 0.0v 114.755n 0.0v 119.745n 0.0v 119.755n 0.0v 124.745n 0.0v 124.755n 0.0v 129.745n 0.0v 129.755n 1.0v 134.745n 1.0v 134.755n 1.0v 139.745n 1.0v 139.755n 1.0v 144.745n 1.0v 144.755n 1.0v 149.745n 1.0v 149.755n 1.0v 154.745n 1.0v 154.755n 1.0v 159.745n 1.0v 159.755n 1.0v 164.745n 1.0v 164.755n 1.0v 169.745n 1.0v 169.755n 1.0v 174.745n 1.0v 174.755n 0.0v 179.745n 0.0v 179.755n 0.0v 184.745n 0.0v 184.755n 0.0v 189.745n 0.0v 189.755n 0.0v 194.745n 0.0v 194.755n 0.0v 199.745n 0.0v 199.755n 0.0v 204.745n 0.0v 204.755n 0.0v 209.745n 0.0v 209.755n 0.0v 214.745n 0.0v 214.755n 0.0v 219.745n 0.0v 219.755n 0.0v 224.745n 0.0v 224.755n 0.0v 229.745n 0.0v 229.755n 0.0v 234.745n 0.0v 234.755n 0.0v 239.745n 0.0v 239.755n 0.0v 244.745n 0.0v 244.755n 1.0v 249.745n 1.0v 249.755n 1.0v 254.745n 1.0v 254.755n 1.0v 259.745n 1.0v 259.755n 1.0v 264.745n 1.0v 264.755n 1.0v 269.745n 1.0v 269.755n 1.0v 274.745n 1.0v 274.755n 1.0v 279.745n 1.0v 279.755n 1.0v 284.745n 1.0v 284.755n 1.0v 289.745n 1.0v 289.755n 1.0v 294.745n 1.0v 294.755n 1.0v 299.745n 1.0v 299.755n 0.0v 304.745n 0.0v 304.755n 0.0v 309.745n 0.0v 309.755n 0.0v 314.745n 0.0v 314.755n 0.0v 319.745n 0.0v 319.755n 0.0v 324.745n 0.0v 324.755n 0.0v 329.745n 0.0v 329.755n 0.0v 334.745n 0.0v 334.755n 0.0v 339.745n 0.0v 339.755n 0.0v 344.745n 0.0v 344.755n 0.0v 349.745n 0.0v 349.755n 0.0v 354.745n 0.0v 354.755n 0.0v 359.745n 0.0v 359.755n 0.0v 364.745n 0.0v 364.755n 0.0v 369.745n 0.0v 369.755n 0.0v 374.745n 0.0v 374.755n 0.0v 379.745n 0.0v 379.755n 1.0v 384.745n 1.0v 384.755n 1.0v 389.745n 1.0v 389.755n 0.0v 394.745n 0.0v 394.755n 0.0v 399.745n 0.0v 399.755n 0.0v 404.745n 0.0v 404.755n 0.0v 409.745n 0.0v 409.755n 0.0v 414.745n 0.0v 414.755n 0.0v 419.745n 0.0v 419.755n 1.0v 424.745n 1.0v 424.755n 1.0v 429.745n 1.0v 429.755n 1.0v 434.745n 1.0v 434.755n 1.0v 439.745n 1.0v 439.755n 1.0v 444.745n 1.0v 444.755n 1.0v 449.745n 1.0v 449.755n 1.0v 454.745n 1.0v 454.755n 1.0v 459.745n 1.0v 459.755n 1.0v 464.745n 1.0v 464.755n 0.0v 469.745n 0.0v 469.755n 0.0v 474.745n 0.0v 474.755n 0.0v 479.745n 0.0v 479.755n 0.0v 484.745n 0.0v 484.755n 1.0v 489.745n 1.0v 489.755n 1.0v 494.745n 1.0v 494.755n 1.0v 499.745n 1.0v 499.755n 1.0v 504.745n 1.0v 504.755n 0.0v 509.745n 0.0v 509.755n 0.0v 514.745n 0.0v 514.755n 0.0v 519.745n 0.0v 519.755n 0.0v 524.745n 0.0v 524.755n 0.0v 529.745n 0.0v 529.755n 0.0v 534.745n 0.0v 534.755n 0.0v 539.745n 0.0v 539.755n 0.0v 544.745n 0.0v 544.755n 0.0v 549.745n 0.0v 549.755n 0.0v 554.745n 0.0v 554.755n 0.0v 559.745n 0.0v 559.755n 0.0v 564.745n 0.0v 564.755n 0.0v 569.745n 0.0v 569.755n 0.0v 574.745n 0.0v 574.755n 0.0v 579.745n 0.0v 579.755n 1.0v 584.745n 1.0v 584.755n 1.0v 589.745n 1.0v 589.755n 1.0v 594.745n 1.0v 594.755n 1.0v 599.745n 1.0v 599.755n 1.0v 604.745n 1.0v 604.755n 1.0v 609.745n 1.0v 609.755n 1.0v 614.745n 1.0v 614.755n 0.0v 619.745n 0.0v 619.755n 0.0v 624.745n 0.0v 624.755n 0.0v 629.745n 0.0v 629.755n 0.0v 634.745n 0.0v 634.755n 0.0v 639.745n 0.0v 639.755n 0.0v 644.745n 0.0v 644.755n 0.0v 649.745n 0.0v 649.755n 0.0v 654.745n 0.0v 654.755n 0.0v 659.745n 0.0v 659.755n 0.0v 664.745n 0.0v 664.755n 0.0v 669.745n 0.0v 669.755n 0.0v 674.745n 0.0v 674.755n 0.0v 679.745n 0.0v 679.755n 0.0v 684.745n 0.0v 684.755n 0.0v 689.745n 0.0v 689.755n 1.0v 694.745n 1.0v 694.755n 1.0v 699.745n 1.0v 699.755n 1.0v 704.745n 1.0v 704.755n 1.0v 709.745n 1.0v 709.755n 1.0v 714.745n 1.0v 714.755n 1.0v 719.745n 1.0v 719.755n 1.0v 724.745n 1.0v 724.755n 1.0v 729.745n 1.0v 729.755n 1.0v 734.745n 1.0v 734.755n 1.0v 739.745n 1.0v 739.755n 1.0v 744.745n 1.0v 744.755n 1.0v 749.745n 1.0v 749.755n 1.0v 754.745n 1.0v 754.755n 1.0v 759.745n 1.0v 759.755n 1.0v 764.745n 1.0v 764.755n 1.0v 769.745n 1.0v 769.755n 0.0v 774.745n 0.0v 774.755n 0.0v 779.745n 0.0v 779.755n 0.0v 784.745n 0.0v 784.755n 0.0v 789.745n 0.0v 789.755n 0.0v 794.745n 0.0v 794.755n 0.0v 799.745n 0.0v 799.755n 0.0v 804.745n 0.0v 804.755n 0.0v 809.745n 0.0v 809.755n 1.0v 814.745n 1.0v 814.755n 1.0v 819.745n 1.0v 819.755n 1.0v 824.745n 1.0v 824.755n 1.0v 829.745n 1.0v 829.755n 1.0v 834.745n 1.0v 834.755n 1.0v 839.745n 1.0v 839.755n 1.0v 844.745n 1.0v 844.755n 1.0v 849.745n 1.0v 849.755n 1.0v 854.745n 1.0v 854.755n 1.0v 859.745n 1.0v 859.755n 1.0v 864.745n 1.0v 864.755n 1.0v 869.745n 1.0v 869.755n 1.0v 874.745n 1.0v 874.755n 1.0v 879.745n 1.0v 879.755n 1.0v 884.745n 1.0v 884.755n 1.0v 889.745n 1.0v 889.755n 1.0v 894.745n 1.0v 894.755n 1.0v 899.745n 1.0v 899.755n 1.0v 904.745n 1.0v 904.755n 1.0v 909.745n 1.0v 909.755n 1.0v 914.745n 1.0v 914.755n 1.0v 919.745n 1.0v 919.755n 1.0v 924.745n 1.0v 924.755n 0.0v 929.745n 0.0v 929.755n 0.0v 934.745n 0.0v 934.755n 0.0v 939.745n 0.0v 939.755n 0.0v 944.745n 0.0v 944.755n 1.0v 949.745n 1.0v 949.755n 1.0v 954.745n 1.0v 954.755n 1.0v 959.745n 1.0v 959.755n 1.0v 964.745n 1.0v 964.755n 1.0v 969.745n 1.0v 969.755n 1.0v 974.745n 1.0v 974.755n 1.0v 979.745n 1.0v 979.755n 1.0v 984.745n 1.0v 984.755n 1.0v 989.745n 1.0v 989.755n 1.0v 994.745n 1.0v 994.755n 1.0v 999.745n 1.0v 999.755n 0.0v 1004.745n 0.0v 1004.755n 0.0v 1009.745n 0.0v 1009.755n 0.0v 1014.745n 0.0v 1014.755n 0.0v 1019.745n 0.0v 1019.755n 1.0v 1024.745n 1.0v 1024.755n 1.0v )
* (time, data): [(0, 0), (5, 1), (10, 0), (15, 1), (20, 1), (25, 1), (30, 1), (35, 1), (40, 1), (45, 1), (50, 1), (55, 1), (60, 1), (65, 1), (70, 1), (75, 1), (80, 1), (85, 1), (90, 0), (95, 0), (100, 0), (105, 0), (110, 0), (115, 0), (120, 0), (125, 0), (130, 1), (135, 1), (140, 1), (145, 0), (150, 0), (155, 0), (160, 0), (165, 0), (170, 0), (175, 0), (180, 0), (185, 0), (190, 0), (195, 0), (200, 0), (205, 0), (210, 0), (215, 0), (220, 0), (225, 0), (230, 0), (235, 0), (240, 0), (245, 0), (250, 1), (255, 1), (260, 1), (265, 1), (270, 1), (275, 1), (280, 1), (285, 1), (290, 1), (295, 1), (300, 1), (305, 1), (310, 1), (315, 1), (320, 1), (325, 1), (330, 1), (335, 1), (340, 1), (345, 1), (350, 1), (355, 1), (360, 1), (365, 1), (370, 1), (375, 1), (380, 1), (385, 1), (390, 1), (395, 0), (400, 0), (405, 0), (410, 0), (415, 0), (420, 0), (425, 0), (430, 0), (435, 0), (440, 0), (445, 0), (450, 0), (455, 0), (460, 0), (465, 0), (470, 0), (475, 0), (480, 0), (485, 0), (490, 0), (495, 0), (500, 0), (505, 1), (510, 1), (515, 1), (520, 1), (525, 1), (530, 1), (535, 1), (540, 1), (545, 1), (550, 1), (555, 1), (560, 1), (565, 1), (570, 1), (575, 1), (580, 0), (585, 0), (590, 0), (595, 0), (600, 0), (605, 0), (610, 0), (615, 1), (620, 1), (625, 1), (630, 1), (635, 1), (640, 1), (645, 1), (650, 1), (655, 1), (660, 1), (665, 1), (670, 1), (675, 1), (680, 1), (685, 1), (690, 0), (695, 0), (700, 0), (705, 0), (710, 0), (715, 0), (720, 0), (725, 0), (730, 0), (735, 1), (740, 1), (745, 1), (750, 1), (755, 1), (760, 0), (765, 0), (770, 0), (775, 0), (780, 0), (785, 0), (790, 0), (795, 0), (800, 0), (805, 0), (810, 1), (815, 1), (820, 1), (825, 1), (830, 0), (835, 0), (840, 0), (845, 0), (850, 0), (855, 0), (860, 1), (865, 1), (870, 1), (875, 1), (880, 0), (885, 0), (890, 0), (895, 0), (900, 0), (905, 1), (910, 1), (915, 1), (920, 1), (925, 0), (930, 0), (935, 0), (940, 0), (945, 1), (950, 1), (955, 1), (960, 1), (965, 1), (970, 1), (975, 1), (980, 1), (985, 1), (990, 1), (995, 1), (1000, 1), (1005, 1), (1010, 1), (1015, 1), (1020, 0), (1025, 0)]
Vdin1_47  din1_47  0 PWL (0n 0.0v 4.745n 0.0v 4.755n 1.0v 9.745n 1.0v 9.755n 0.0v 14.745n 0.0v 14.755n 1.0v 19.745n 1.0v 19.755n 1.0v 24.745n 1.0v 24.755n 1.0v 29.745n 1.0v 29.755n 1.0v 34.745n 1.0v 34.755n 1.0v 39.745n 1.0v 39.755n 1.0v 44.745n 1.0v 44.755n 1.0v 49.745n 1.0v 49.755n 1.0v 54.745n 1.0v 54.755n 1.0v 59.745n 1.0v 59.755n 1.0v 64.745n 1.0v 64.755n 1.0v 69.745n 1.0v 69.755n 1.0v 74.745n 1.0v 74.755n 1.0v 79.745n 1.0v 79.755n 1.0v 84.745n 1.0v 84.755n 1.0v 89.745n 1.0v 89.755n 0.0v 94.745n 0.0v 94.755n 0.0v 99.745n 0.0v 99.755n 0.0v 104.745n 0.0v 104.755n 0.0v 109.745n 0.0v 109.755n 0.0v 114.745n 0.0v 114.755n 0.0v 119.745n 0.0v 119.755n 0.0v 124.745n 0.0v 124.755n 0.0v 129.745n 0.0v 129.755n 1.0v 134.745n 1.0v 134.755n 1.0v 139.745n 1.0v 139.755n 1.0v 144.745n 1.0v 144.755n 0.0v 149.745n 0.0v 149.755n 0.0v 154.745n 0.0v 154.755n 0.0v 159.745n 0.0v 159.755n 0.0v 164.745n 0.0v 164.755n 0.0v 169.745n 0.0v 169.755n 0.0v 174.745n 0.0v 174.755n 0.0v 179.745n 0.0v 179.755n 0.0v 184.745n 0.0v 184.755n 0.0v 189.745n 0.0v 189.755n 0.0v 194.745n 0.0v 194.755n 0.0v 199.745n 0.0v 199.755n 0.0v 204.745n 0.0v 204.755n 0.0v 209.745n 0.0v 209.755n 0.0v 214.745n 0.0v 214.755n 0.0v 219.745n 0.0v 219.755n 0.0v 224.745n 0.0v 224.755n 0.0v 229.745n 0.0v 229.755n 0.0v 234.745n 0.0v 234.755n 0.0v 239.745n 0.0v 239.755n 0.0v 244.745n 0.0v 244.755n 0.0v 249.745n 0.0v 249.755n 1.0v 254.745n 1.0v 254.755n 1.0v 259.745n 1.0v 259.755n 1.0v 264.745n 1.0v 264.755n 1.0v 269.745n 1.0v 269.755n 1.0v 274.745n 1.0v 274.755n 1.0v 279.745n 1.0v 279.755n 1.0v 284.745n 1.0v 284.755n 1.0v 289.745n 1.0v 289.755n 1.0v 294.745n 1.0v 294.755n 1.0v 299.745n 1.0v 299.755n 1.0v 304.745n 1.0v 304.755n 1.0v 309.745n 1.0v 309.755n 1.0v 314.745n 1.0v 314.755n 1.0v 319.745n 1.0v 319.755n 1.0v 324.745n 1.0v 324.755n 1.0v 329.745n 1.0v 329.755n 1.0v 334.745n 1.0v 334.755n 1.0v 339.745n 1.0v 339.755n 1.0v 344.745n 1.0v 344.755n 1.0v 349.745n 1.0v 349.755n 1.0v 354.745n 1.0v 354.755n 1.0v 359.745n 1.0v 359.755n 1.0v 364.745n 1.0v 364.755n 1.0v 369.745n 1.0v 369.755n 1.0v 374.745n 1.0v 374.755n 1.0v 379.745n 1.0v 379.755n 1.0v 384.745n 1.0v 384.755n 1.0v 389.745n 1.0v 389.755n 1.0v 394.745n 1.0v 394.755n 0.0v 399.745n 0.0v 399.755n 0.0v 404.745n 0.0v 404.755n 0.0v 409.745n 0.0v 409.755n 0.0v 414.745n 0.0v 414.755n 0.0v 419.745n 0.0v 419.755n 0.0v 424.745n 0.0v 424.755n 0.0v 429.745n 0.0v 429.755n 0.0v 434.745n 0.0v 434.755n 0.0v 439.745n 0.0v 439.755n 0.0v 444.745n 0.0v 444.755n 0.0v 449.745n 0.0v 449.755n 0.0v 454.745n 0.0v 454.755n 0.0v 459.745n 0.0v 459.755n 0.0v 464.745n 0.0v 464.755n 0.0v 469.745n 0.0v 469.755n 0.0v 474.745n 0.0v 474.755n 0.0v 479.745n 0.0v 479.755n 0.0v 484.745n 0.0v 484.755n 0.0v 489.745n 0.0v 489.755n 0.0v 494.745n 0.0v 494.755n 0.0v 499.745n 0.0v 499.755n 0.0v 504.745n 0.0v 504.755n 1.0v 509.745n 1.0v 509.755n 1.0v 514.745n 1.0v 514.755n 1.0v 519.745n 1.0v 519.755n 1.0v 524.745n 1.0v 524.755n 1.0v 529.745n 1.0v 529.755n 1.0v 534.745n 1.0v 534.755n 1.0v 539.745n 1.0v 539.755n 1.0v 544.745n 1.0v 544.755n 1.0v 549.745n 1.0v 549.755n 1.0v 554.745n 1.0v 554.755n 1.0v 559.745n 1.0v 559.755n 1.0v 564.745n 1.0v 564.755n 1.0v 569.745n 1.0v 569.755n 1.0v 574.745n 1.0v 574.755n 1.0v 579.745n 1.0v 579.755n 0.0v 584.745n 0.0v 584.755n 0.0v 589.745n 0.0v 589.755n 0.0v 594.745n 0.0v 594.755n 0.0v 599.745n 0.0v 599.755n 0.0v 604.745n 0.0v 604.755n 0.0v 609.745n 0.0v 609.755n 0.0v 614.745n 0.0v 614.755n 1.0v 619.745n 1.0v 619.755n 1.0v 624.745n 1.0v 624.755n 1.0v 629.745n 1.0v 629.755n 1.0v 634.745n 1.0v 634.755n 1.0v 639.745n 1.0v 639.755n 1.0v 644.745n 1.0v 644.755n 1.0v 649.745n 1.0v 649.755n 1.0v 654.745n 1.0v 654.755n 1.0v 659.745n 1.0v 659.755n 1.0v 664.745n 1.0v 664.755n 1.0v 669.745n 1.0v 669.755n 1.0v 674.745n 1.0v 674.755n 1.0v 679.745n 1.0v 679.755n 1.0v 684.745n 1.0v 684.755n 1.0v 689.745n 1.0v 689.755n 0.0v 694.745n 0.0v 694.755n 0.0v 699.745n 0.0v 699.755n 0.0v 704.745n 0.0v 704.755n 0.0v 709.745n 0.0v 709.755n 0.0v 714.745n 0.0v 714.755n 0.0v 719.745n 0.0v 719.755n 0.0v 724.745n 0.0v 724.755n 0.0v 729.745n 0.0v 729.755n 0.0v 734.745n 0.0v 734.755n 1.0v 739.745n 1.0v 739.755n 1.0v 744.745n 1.0v 744.755n 1.0v 749.745n 1.0v 749.755n 1.0v 754.745n 1.0v 754.755n 1.0v 759.745n 1.0v 759.755n 0.0v 764.745n 0.0v 764.755n 0.0v 769.745n 0.0v 769.755n 0.0v 774.745n 0.0v 774.755n 0.0v 779.745n 0.0v 779.755n 0.0v 784.745n 0.0v 784.755n 0.0v 789.745n 0.0v 789.755n 0.0v 794.745n 0.0v 794.755n 0.0v 799.745n 0.0v 799.755n 0.0v 804.745n 0.0v 804.755n 0.0v 809.745n 0.0v 809.755n 1.0v 814.745n 1.0v 814.755n 1.0v 819.745n 1.0v 819.755n 1.0v 824.745n 1.0v 824.755n 1.0v 829.745n 1.0v 829.755n 0.0v 834.745n 0.0v 834.755n 0.0v 839.745n 0.0v 839.755n 0.0v 844.745n 0.0v 844.755n 0.0v 849.745n 0.0v 849.755n 0.0v 854.745n 0.0v 854.755n 0.0v 859.745n 0.0v 859.755n 1.0v 864.745n 1.0v 864.755n 1.0v 869.745n 1.0v 869.755n 1.0v 874.745n 1.0v 874.755n 1.0v 879.745n 1.0v 879.755n 0.0v 884.745n 0.0v 884.755n 0.0v 889.745n 0.0v 889.755n 0.0v 894.745n 0.0v 894.755n 0.0v 899.745n 0.0v 899.755n 0.0v 904.745n 0.0v 904.755n 1.0v 909.745n 1.0v 909.755n 1.0v 914.745n 1.0v 914.755n 1.0v 919.745n 1.0v 919.755n 1.0v 924.745n 1.0v 924.755n 0.0v 929.745n 0.0v 929.755n 0.0v 934.745n 0.0v 934.755n 0.0v 939.745n 0.0v 939.755n 0.0v 944.745n 0.0v 944.755n 1.0v 949.745n 1.0v 949.755n 1.0v 954.745n 1.0v 954.755n 1.0v 959.745n 1.0v 959.755n 1.0v 964.745n 1.0v 964.755n 1.0v 969.745n 1.0v 969.755n 1.0v 974.745n 1.0v 974.755n 1.0v 979.745n 1.0v 979.755n 1.0v 984.745n 1.0v 984.755n 1.0v 989.745n 1.0v 989.755n 1.0v 994.745n 1.0v 994.755n 1.0v 999.745n 1.0v 999.755n 1.0v 1004.745n 1.0v 1004.755n 1.0v 1009.745n 1.0v 1009.755n 1.0v 1014.745n 1.0v 1014.755n 1.0v 1019.745n 1.0v 1019.755n 0.0v 1024.745n 0.0v 1024.755n 0.0v )
* (time, data): [(0, 0), (5, 1), (10, 1), (15, 1), (20, 1), (25, 1), (30, 1), (35, 1), (40, 1), (45, 1), (50, 1), (55, 1), (60, 1), (65, 1), (70, 1), (75, 1), (80, 0), (85, 0), (90, 0), (95, 0), (100, 0), (105, 0), (110, 0), (115, 0), (120, 0), (125, 0), (130, 1), (135, 1), (140, 1), (145, 0), (150, 0), (155, 0), (160, 0), (165, 0), (170, 0), (175, 1), (180, 0), (185, 0), (190, 0), (195, 0), (200, 0), (205, 0), (210, 0), (215, 0), (220, 0), (225, 0), (230, 0), (235, 0), (240, 0), (245, 0), (250, 1), (255, 1), (260, 1), (265, 1), (270, 1), (275, 1), (280, 1), (285, 1), (290, 1), (295, 1), (300, 1), (305, 1), (310, 1), (315, 1), (320, 1), (325, 1), (330, 1), (335, 1), (340, 1), (345, 1), (350, 1), (355, 1), (360, 1), (365, 0), (370, 0), (375, 0), (380, 0), (385, 0), (390, 0), (395, 0), (400, 0), (405, 0), (410, 0), (415, 0), (420, 0), (425, 0), (430, 0), (435, 0), (440, 0), (445, 0), (450, 0), (455, 0), (460, 0), (465, 1), (470, 1), (475, 1), (480, 1), (485, 1), (490, 1), (495, 1), (500, 1), (505, 1), (510, 1), (515, 1), (520, 1), (525, 1), (530, 1), (535, 1), (540, 1), (545, 1), (550, 1), (555, 1), (560, 1), (565, 1), (570, 1), (575, 1), (580, 0), (585, 0), (590, 0), (595, 0), (600, 0), (605, 1), (610, 1), (615, 1), (620, 1), (625, 1), (630, 1), (635, 1), (640, 1), (645, 1), (650, 1), (655, 1), (660, 1), (665, 1), (670, 1), (675, 1), (680, 1), (685, 1), (690, 1), (695, 1), (700, 1), (705, 1), (710, 1), (715, 1), (720, 1), (725, 1), (730, 0), (735, 0), (740, 0), (745, 0), (750, 0), (755, 0), (760, 0), (765, 1), (770, 0), (775, 0), (780, 0), (785, 0), (790, 0), (795, 0), (800, 0), (805, 0), (810, 1), (815, 1), (820, 1), (825, 1), (830, 0), (835, 0), (840, 0), (845, 0), (850, 0), (855, 0), (860, 1), (865, 1), (870, 1), (875, 1), (880, 0), (885, 0), (890, 0), (895, 0), (900, 0), (905, 1), (910, 1), (915, 1), (920, 1), (925, 1), (930, 0), (935, 0), (940, 0), (945, 1), (950, 1), (955, 1), (960, 1), (965, 1), (970, 1), (975, 1), (980, 1), (985, 1), (990, 1), (995, 1), (1000, 0), (1005, 0), (1010, 0), (1015, 0), (1020, 1), (1025, 1)]
Vdin1_48  din1_48  0 PWL (0n 0.0v 4.745n 0.0v 4.755n 1.0v 9.745n 1.0v 9.755n 1.0v 14.745n 1.0v 14.755n 1.0v 19.745n 1.0v 19.755n 1.0v 24.745n 1.0v 24.755n 1.0v 29.745n 1.0v 29.755n 1.0v 34.745n 1.0v 34.755n 1.0v 39.745n 1.0v 39.755n 1.0v 44.745n 1.0v 44.755n 1.0v 49.745n 1.0v 49.755n 1.0v 54.745n 1.0v 54.755n 1.0v 59.745n 1.0v 59.755n 1.0v 64.745n 1.0v 64.755n 1.0v 69.745n 1.0v 69.755n 1.0v 74.745n 1.0v 74.755n 1.0v 79.745n 1.0v 79.755n 0.0v 84.745n 0.0v 84.755n 0.0v 89.745n 0.0v 89.755n 0.0v 94.745n 0.0v 94.755n 0.0v 99.745n 0.0v 99.755n 0.0v 104.745n 0.0v 104.755n 0.0v 109.745n 0.0v 109.755n 0.0v 114.745n 0.0v 114.755n 0.0v 119.745n 0.0v 119.755n 0.0v 124.745n 0.0v 124.755n 0.0v 129.745n 0.0v 129.755n 1.0v 134.745n 1.0v 134.755n 1.0v 139.745n 1.0v 139.755n 1.0v 144.745n 1.0v 144.755n 0.0v 149.745n 0.0v 149.755n 0.0v 154.745n 0.0v 154.755n 0.0v 159.745n 0.0v 159.755n 0.0v 164.745n 0.0v 164.755n 0.0v 169.745n 0.0v 169.755n 0.0v 174.745n 0.0v 174.755n 1.0v 179.745n 1.0v 179.755n 0.0v 184.745n 0.0v 184.755n 0.0v 189.745n 0.0v 189.755n 0.0v 194.745n 0.0v 194.755n 0.0v 199.745n 0.0v 199.755n 0.0v 204.745n 0.0v 204.755n 0.0v 209.745n 0.0v 209.755n 0.0v 214.745n 0.0v 214.755n 0.0v 219.745n 0.0v 219.755n 0.0v 224.745n 0.0v 224.755n 0.0v 229.745n 0.0v 229.755n 0.0v 234.745n 0.0v 234.755n 0.0v 239.745n 0.0v 239.755n 0.0v 244.745n 0.0v 244.755n 0.0v 249.745n 0.0v 249.755n 1.0v 254.745n 1.0v 254.755n 1.0v 259.745n 1.0v 259.755n 1.0v 264.745n 1.0v 264.755n 1.0v 269.745n 1.0v 269.755n 1.0v 274.745n 1.0v 274.755n 1.0v 279.745n 1.0v 279.755n 1.0v 284.745n 1.0v 284.755n 1.0v 289.745n 1.0v 289.755n 1.0v 294.745n 1.0v 294.755n 1.0v 299.745n 1.0v 299.755n 1.0v 304.745n 1.0v 304.755n 1.0v 309.745n 1.0v 309.755n 1.0v 314.745n 1.0v 314.755n 1.0v 319.745n 1.0v 319.755n 1.0v 324.745n 1.0v 324.755n 1.0v 329.745n 1.0v 329.755n 1.0v 334.745n 1.0v 334.755n 1.0v 339.745n 1.0v 339.755n 1.0v 344.745n 1.0v 344.755n 1.0v 349.745n 1.0v 349.755n 1.0v 354.745n 1.0v 354.755n 1.0v 359.745n 1.0v 359.755n 1.0v 364.745n 1.0v 364.755n 0.0v 369.745n 0.0v 369.755n 0.0v 374.745n 0.0v 374.755n 0.0v 379.745n 0.0v 379.755n 0.0v 384.745n 0.0v 384.755n 0.0v 389.745n 0.0v 389.755n 0.0v 394.745n 0.0v 394.755n 0.0v 399.745n 0.0v 399.755n 0.0v 404.745n 0.0v 404.755n 0.0v 409.745n 0.0v 409.755n 0.0v 414.745n 0.0v 414.755n 0.0v 419.745n 0.0v 419.755n 0.0v 424.745n 0.0v 424.755n 0.0v 429.745n 0.0v 429.755n 0.0v 434.745n 0.0v 434.755n 0.0v 439.745n 0.0v 439.755n 0.0v 444.745n 0.0v 444.755n 0.0v 449.745n 0.0v 449.755n 0.0v 454.745n 0.0v 454.755n 0.0v 459.745n 0.0v 459.755n 0.0v 464.745n 0.0v 464.755n 1.0v 469.745n 1.0v 469.755n 1.0v 474.745n 1.0v 474.755n 1.0v 479.745n 1.0v 479.755n 1.0v 484.745n 1.0v 484.755n 1.0v 489.745n 1.0v 489.755n 1.0v 494.745n 1.0v 494.755n 1.0v 499.745n 1.0v 499.755n 1.0v 504.745n 1.0v 504.755n 1.0v 509.745n 1.0v 509.755n 1.0v 514.745n 1.0v 514.755n 1.0v 519.745n 1.0v 519.755n 1.0v 524.745n 1.0v 524.755n 1.0v 529.745n 1.0v 529.755n 1.0v 534.745n 1.0v 534.755n 1.0v 539.745n 1.0v 539.755n 1.0v 544.745n 1.0v 544.755n 1.0v 549.745n 1.0v 549.755n 1.0v 554.745n 1.0v 554.755n 1.0v 559.745n 1.0v 559.755n 1.0v 564.745n 1.0v 564.755n 1.0v 569.745n 1.0v 569.755n 1.0v 574.745n 1.0v 574.755n 1.0v 579.745n 1.0v 579.755n 0.0v 584.745n 0.0v 584.755n 0.0v 589.745n 0.0v 589.755n 0.0v 594.745n 0.0v 594.755n 0.0v 599.745n 0.0v 599.755n 0.0v 604.745n 0.0v 604.755n 1.0v 609.745n 1.0v 609.755n 1.0v 614.745n 1.0v 614.755n 1.0v 619.745n 1.0v 619.755n 1.0v 624.745n 1.0v 624.755n 1.0v 629.745n 1.0v 629.755n 1.0v 634.745n 1.0v 634.755n 1.0v 639.745n 1.0v 639.755n 1.0v 644.745n 1.0v 644.755n 1.0v 649.745n 1.0v 649.755n 1.0v 654.745n 1.0v 654.755n 1.0v 659.745n 1.0v 659.755n 1.0v 664.745n 1.0v 664.755n 1.0v 669.745n 1.0v 669.755n 1.0v 674.745n 1.0v 674.755n 1.0v 679.745n 1.0v 679.755n 1.0v 684.745n 1.0v 684.755n 1.0v 689.745n 1.0v 689.755n 1.0v 694.745n 1.0v 694.755n 1.0v 699.745n 1.0v 699.755n 1.0v 704.745n 1.0v 704.755n 1.0v 709.745n 1.0v 709.755n 1.0v 714.745n 1.0v 714.755n 1.0v 719.745n 1.0v 719.755n 1.0v 724.745n 1.0v 724.755n 1.0v 729.745n 1.0v 729.755n 0.0v 734.745n 0.0v 734.755n 0.0v 739.745n 0.0v 739.755n 0.0v 744.745n 0.0v 744.755n 0.0v 749.745n 0.0v 749.755n 0.0v 754.745n 0.0v 754.755n 0.0v 759.745n 0.0v 759.755n 0.0v 764.745n 0.0v 764.755n 1.0v 769.745n 1.0v 769.755n 0.0v 774.745n 0.0v 774.755n 0.0v 779.745n 0.0v 779.755n 0.0v 784.745n 0.0v 784.755n 0.0v 789.745n 0.0v 789.755n 0.0v 794.745n 0.0v 794.755n 0.0v 799.745n 0.0v 799.755n 0.0v 804.745n 0.0v 804.755n 0.0v 809.745n 0.0v 809.755n 1.0v 814.745n 1.0v 814.755n 1.0v 819.745n 1.0v 819.755n 1.0v 824.745n 1.0v 824.755n 1.0v 829.745n 1.0v 829.755n 0.0v 834.745n 0.0v 834.755n 0.0v 839.745n 0.0v 839.755n 0.0v 844.745n 0.0v 844.755n 0.0v 849.745n 0.0v 849.755n 0.0v 854.745n 0.0v 854.755n 0.0v 859.745n 0.0v 859.755n 1.0v 864.745n 1.0v 864.755n 1.0v 869.745n 1.0v 869.755n 1.0v 874.745n 1.0v 874.755n 1.0v 879.745n 1.0v 879.755n 0.0v 884.745n 0.0v 884.755n 0.0v 889.745n 0.0v 889.755n 0.0v 894.745n 0.0v 894.755n 0.0v 899.745n 0.0v 899.755n 0.0v 904.745n 0.0v 904.755n 1.0v 909.745n 1.0v 909.755n 1.0v 914.745n 1.0v 914.755n 1.0v 919.745n 1.0v 919.755n 1.0v 924.745n 1.0v 924.755n 1.0v 929.745n 1.0v 929.755n 0.0v 934.745n 0.0v 934.755n 0.0v 939.745n 0.0v 939.755n 0.0v 944.745n 0.0v 944.755n 1.0v 949.745n 1.0v 949.755n 1.0v 954.745n 1.0v 954.755n 1.0v 959.745n 1.0v 959.755n 1.0v 964.745n 1.0v 964.755n 1.0v 969.745n 1.0v 969.755n 1.0v 974.745n 1.0v 974.755n 1.0v 979.745n 1.0v 979.755n 1.0v 984.745n 1.0v 984.755n 1.0v 989.745n 1.0v 989.755n 1.0v 994.745n 1.0v 994.755n 1.0v 999.745n 1.0v 999.755n 0.0v 1004.745n 0.0v 1004.755n 0.0v 1009.745n 0.0v 1009.755n 0.0v 1014.745n 0.0v 1014.755n 0.0v 1019.745n 0.0v 1019.755n 1.0v 1024.745n 1.0v 1024.755n 1.0v )
* (time, data): [(0, 0), (5, 0), (10, 0), (15, 1), (20, 1), (25, 1), (30, 1), (35, 1), (40, 1), (45, 1), (50, 1), (55, 1), (60, 1), (65, 1), (70, 1), (75, 1), (80, 0), (85, 0), (90, 0), (95, 0), (100, 0), (105, 0), (110, 0), (115, 0), (120, 0), (125, 0), (130, 0), (135, 0), (140, 0), (145, 1), (150, 1), (155, 1), (160, 1), (165, 1), (170, 1), (175, 0), (180, 0), (185, 0), (190, 0), (195, 0), (200, 0), (205, 0), (210, 0), (215, 0), (220, 0), (225, 0), (230, 0), (235, 0), (240, 0), (245, 0), (250, 0), (255, 0), (260, 0), (265, 0), (270, 0), (275, 0), (280, 0), (285, 0), (290, 0), (295, 0), (300, 0), (305, 0), (310, 0), (315, 0), (320, 0), (325, 0), (330, 0), (335, 0), (340, 0), (345, 0), (350, 0), (355, 0), (360, 0), (365, 0), (370, 0), (375, 0), (380, 0), (385, 0), (390, 0), (395, 1), (400, 0), (405, 0), (410, 0), (415, 0), (420, 0), (425, 0), (430, 0), (435, 0), (440, 0), (445, 0), (450, 0), (455, 0), (460, 0), (465, 0), (470, 0), (475, 0), (480, 0), (485, 1), (490, 1), (495, 1), (500, 1), (505, 0), (510, 0), (515, 0), (520, 0), (525, 0), (530, 0), (535, 0), (540, 0), (545, 0), (550, 0), (555, 0), (560, 0), (565, 0), (570, 0), (575, 0), (580, 0), (585, 0), (590, 0), (595, 0), (600, 0), (605, 1), (610, 1), (615, 1), (620, 1), (625, 1), (630, 1), (635, 1), (640, 1), (645, 1), (650, 1), (655, 1), (660, 1), (665, 1), (670, 1), (675, 1), (680, 1), (685, 1), (690, 0), (695, 0), (700, 0), (705, 0), (710, 0), (715, 0), (720, 0), (725, 0), (730, 0), (735, 1), (740, 1), (745, 1), (750, 1), (755, 1), (760, 0), (765, 0), (770, 1), (775, 1), (780, 1), (785, 1), (790, 0), (795, 0), (800, 0), (805, 0), (810, 0), (815, 0), (820, 0), (825, 0), (830, 1), (835, 1), (840, 1), (845, 1), (850, 1), (855, 1), (860, 1), (865, 1), (870, 1), (875, 1), (880, 1), (885, 1), (890, 1), (895, 1), (900, 0), (905, 1), (910, 1), (915, 1), (920, 1), (925, 1), (930, 0), (935, 0), (940, 0), (945, 0), (950, 0), (955, 0), (960, 0), (965, 0), (970, 0), (975, 0), (980, 0), (985, 0), (990, 0), (995, 0), (1000, 1), (1005, 1), (1010, 0), (1015, 0), (1020, 1), (1025, 1)]
Vdin1_49  din1_49  0 PWL (0n 0.0v 4.745n 0.0v 4.755n 0.0v 9.745n 0.0v 9.755n 0.0v 14.745n 0.0v 14.755n 1.0v 19.745n 1.0v 19.755n 1.0v 24.745n 1.0v 24.755n 1.0v 29.745n 1.0v 29.755n 1.0v 34.745n 1.0v 34.755n 1.0v 39.745n 1.0v 39.755n 1.0v 44.745n 1.0v 44.755n 1.0v 49.745n 1.0v 49.755n 1.0v 54.745n 1.0v 54.755n 1.0v 59.745n 1.0v 59.755n 1.0v 64.745n 1.0v 64.755n 1.0v 69.745n 1.0v 69.755n 1.0v 74.745n 1.0v 74.755n 1.0v 79.745n 1.0v 79.755n 0.0v 84.745n 0.0v 84.755n 0.0v 89.745n 0.0v 89.755n 0.0v 94.745n 0.0v 94.755n 0.0v 99.745n 0.0v 99.755n 0.0v 104.745n 0.0v 104.755n 0.0v 109.745n 0.0v 109.755n 0.0v 114.745n 0.0v 114.755n 0.0v 119.745n 0.0v 119.755n 0.0v 124.745n 0.0v 124.755n 0.0v 129.745n 0.0v 129.755n 0.0v 134.745n 0.0v 134.755n 0.0v 139.745n 0.0v 139.755n 0.0v 144.745n 0.0v 144.755n 1.0v 149.745n 1.0v 149.755n 1.0v 154.745n 1.0v 154.755n 1.0v 159.745n 1.0v 159.755n 1.0v 164.745n 1.0v 164.755n 1.0v 169.745n 1.0v 169.755n 1.0v 174.745n 1.0v 174.755n 0.0v 179.745n 0.0v 179.755n 0.0v 184.745n 0.0v 184.755n 0.0v 189.745n 0.0v 189.755n 0.0v 194.745n 0.0v 194.755n 0.0v 199.745n 0.0v 199.755n 0.0v 204.745n 0.0v 204.755n 0.0v 209.745n 0.0v 209.755n 0.0v 214.745n 0.0v 214.755n 0.0v 219.745n 0.0v 219.755n 0.0v 224.745n 0.0v 224.755n 0.0v 229.745n 0.0v 229.755n 0.0v 234.745n 0.0v 234.755n 0.0v 239.745n 0.0v 239.755n 0.0v 244.745n 0.0v 244.755n 0.0v 249.745n 0.0v 249.755n 0.0v 254.745n 0.0v 254.755n 0.0v 259.745n 0.0v 259.755n 0.0v 264.745n 0.0v 264.755n 0.0v 269.745n 0.0v 269.755n 0.0v 274.745n 0.0v 274.755n 0.0v 279.745n 0.0v 279.755n 0.0v 284.745n 0.0v 284.755n 0.0v 289.745n 0.0v 289.755n 0.0v 294.745n 0.0v 294.755n 0.0v 299.745n 0.0v 299.755n 0.0v 304.745n 0.0v 304.755n 0.0v 309.745n 0.0v 309.755n 0.0v 314.745n 0.0v 314.755n 0.0v 319.745n 0.0v 319.755n 0.0v 324.745n 0.0v 324.755n 0.0v 329.745n 0.0v 329.755n 0.0v 334.745n 0.0v 334.755n 0.0v 339.745n 0.0v 339.755n 0.0v 344.745n 0.0v 344.755n 0.0v 349.745n 0.0v 349.755n 0.0v 354.745n 0.0v 354.755n 0.0v 359.745n 0.0v 359.755n 0.0v 364.745n 0.0v 364.755n 0.0v 369.745n 0.0v 369.755n 0.0v 374.745n 0.0v 374.755n 0.0v 379.745n 0.0v 379.755n 0.0v 384.745n 0.0v 384.755n 0.0v 389.745n 0.0v 389.755n 0.0v 394.745n 0.0v 394.755n 1.0v 399.745n 1.0v 399.755n 0.0v 404.745n 0.0v 404.755n 0.0v 409.745n 0.0v 409.755n 0.0v 414.745n 0.0v 414.755n 0.0v 419.745n 0.0v 419.755n 0.0v 424.745n 0.0v 424.755n 0.0v 429.745n 0.0v 429.755n 0.0v 434.745n 0.0v 434.755n 0.0v 439.745n 0.0v 439.755n 0.0v 444.745n 0.0v 444.755n 0.0v 449.745n 0.0v 449.755n 0.0v 454.745n 0.0v 454.755n 0.0v 459.745n 0.0v 459.755n 0.0v 464.745n 0.0v 464.755n 0.0v 469.745n 0.0v 469.755n 0.0v 474.745n 0.0v 474.755n 0.0v 479.745n 0.0v 479.755n 0.0v 484.745n 0.0v 484.755n 1.0v 489.745n 1.0v 489.755n 1.0v 494.745n 1.0v 494.755n 1.0v 499.745n 1.0v 499.755n 1.0v 504.745n 1.0v 504.755n 0.0v 509.745n 0.0v 509.755n 0.0v 514.745n 0.0v 514.755n 0.0v 519.745n 0.0v 519.755n 0.0v 524.745n 0.0v 524.755n 0.0v 529.745n 0.0v 529.755n 0.0v 534.745n 0.0v 534.755n 0.0v 539.745n 0.0v 539.755n 0.0v 544.745n 0.0v 544.755n 0.0v 549.745n 0.0v 549.755n 0.0v 554.745n 0.0v 554.755n 0.0v 559.745n 0.0v 559.755n 0.0v 564.745n 0.0v 564.755n 0.0v 569.745n 0.0v 569.755n 0.0v 574.745n 0.0v 574.755n 0.0v 579.745n 0.0v 579.755n 0.0v 584.745n 0.0v 584.755n 0.0v 589.745n 0.0v 589.755n 0.0v 594.745n 0.0v 594.755n 0.0v 599.745n 0.0v 599.755n 0.0v 604.745n 0.0v 604.755n 1.0v 609.745n 1.0v 609.755n 1.0v 614.745n 1.0v 614.755n 1.0v 619.745n 1.0v 619.755n 1.0v 624.745n 1.0v 624.755n 1.0v 629.745n 1.0v 629.755n 1.0v 634.745n 1.0v 634.755n 1.0v 639.745n 1.0v 639.755n 1.0v 644.745n 1.0v 644.755n 1.0v 649.745n 1.0v 649.755n 1.0v 654.745n 1.0v 654.755n 1.0v 659.745n 1.0v 659.755n 1.0v 664.745n 1.0v 664.755n 1.0v 669.745n 1.0v 669.755n 1.0v 674.745n 1.0v 674.755n 1.0v 679.745n 1.0v 679.755n 1.0v 684.745n 1.0v 684.755n 1.0v 689.745n 1.0v 689.755n 0.0v 694.745n 0.0v 694.755n 0.0v 699.745n 0.0v 699.755n 0.0v 704.745n 0.0v 704.755n 0.0v 709.745n 0.0v 709.755n 0.0v 714.745n 0.0v 714.755n 0.0v 719.745n 0.0v 719.755n 0.0v 724.745n 0.0v 724.755n 0.0v 729.745n 0.0v 729.755n 0.0v 734.745n 0.0v 734.755n 1.0v 739.745n 1.0v 739.755n 1.0v 744.745n 1.0v 744.755n 1.0v 749.745n 1.0v 749.755n 1.0v 754.745n 1.0v 754.755n 1.0v 759.745n 1.0v 759.755n 0.0v 764.745n 0.0v 764.755n 0.0v 769.745n 0.0v 769.755n 1.0v 774.745n 1.0v 774.755n 1.0v 779.745n 1.0v 779.755n 1.0v 784.745n 1.0v 784.755n 1.0v 789.745n 1.0v 789.755n 0.0v 794.745n 0.0v 794.755n 0.0v 799.745n 0.0v 799.755n 0.0v 804.745n 0.0v 804.755n 0.0v 809.745n 0.0v 809.755n 0.0v 814.745n 0.0v 814.755n 0.0v 819.745n 0.0v 819.755n 0.0v 824.745n 0.0v 824.755n 0.0v 829.745n 0.0v 829.755n 1.0v 834.745n 1.0v 834.755n 1.0v 839.745n 1.0v 839.755n 1.0v 844.745n 1.0v 844.755n 1.0v 849.745n 1.0v 849.755n 1.0v 854.745n 1.0v 854.755n 1.0v 859.745n 1.0v 859.755n 1.0v 864.745n 1.0v 864.755n 1.0v 869.745n 1.0v 869.755n 1.0v 874.745n 1.0v 874.755n 1.0v 879.745n 1.0v 879.755n 1.0v 884.745n 1.0v 884.755n 1.0v 889.745n 1.0v 889.755n 1.0v 894.745n 1.0v 894.755n 1.0v 899.745n 1.0v 899.755n 0.0v 904.745n 0.0v 904.755n 1.0v 909.745n 1.0v 909.755n 1.0v 914.745n 1.0v 914.755n 1.0v 919.745n 1.0v 919.755n 1.0v 924.745n 1.0v 924.755n 1.0v 929.745n 1.0v 929.755n 0.0v 934.745n 0.0v 934.755n 0.0v 939.745n 0.0v 939.755n 0.0v 944.745n 0.0v 944.755n 0.0v 949.745n 0.0v 949.755n 0.0v 954.745n 0.0v 954.755n 0.0v 959.745n 0.0v 959.755n 0.0v 964.745n 0.0v 964.755n 0.0v 969.745n 0.0v 969.755n 0.0v 974.745n 0.0v 974.755n 0.0v 979.745n 0.0v 979.755n 0.0v 984.745n 0.0v 984.755n 0.0v 989.745n 0.0v 989.755n 0.0v 994.745n 0.0v 994.755n 0.0v 999.745n 0.0v 999.755n 1.0v 1004.745n 1.0v 1004.755n 1.0v 1009.745n 1.0v 1009.755n 0.0v 1014.745n 0.0v 1014.755n 0.0v 1019.745n 0.0v 1019.755n 1.0v 1024.745n 1.0v 1024.755n 1.0v )
* (time, data): [(0, 0), (5, 1), (10, 0), (15, 1), (20, 1), (25, 1), (30, 1), (35, 1), (40, 1), (45, 1), (50, 1), (55, 1), (60, 0), (65, 0), (70, 0), (75, 0), (80, 1), (85, 1), (90, 1), (95, 1), (100, 1), (105, 1), (110, 1), (115, 1), (120, 1), (125, 1), (130, 0), (135, 0), (140, 0), (145, 0), (150, 0), (155, 0), (160, 0), (165, 0), (170, 0), (175, 0), (180, 1), (185, 1), (190, 1), (195, 1), (200, 1), (205, 1), (210, 1), (215, 1), (220, 1), (225, 1), (230, 1), (235, 1), (240, 1), (245, 0), (250, 0), (255, 0), (260, 0), (265, 0), (270, 0), (275, 0), (280, 0), (285, 1), (290, 1), (295, 1), (300, 1), (305, 1), (310, 1), (315, 1), (320, 1), (325, 1), (330, 1), (335, 1), (340, 1), (345, 1), (350, 1), (355, 1), (360, 1), (365, 1), (370, 1), (375, 1), (380, 0), (385, 0), (390, 1), (395, 1), (400, 1), (405, 1), (410, 1), (415, 1), (420, 1), (425, 1), (430, 1), (435, 1), (440, 1), (445, 1), (450, 1), (455, 1), (460, 1), (465, 1), (470, 1), (475, 1), (480, 1), (485, 1), (490, 1), (495, 1), (500, 1), (505, 0), (510, 0), (515, 0), (520, 0), (525, 0), (530, 0), (535, 0), (540, 0), (545, 0), (550, 0), (555, 0), (560, 0), (565, 0), (570, 0), (575, 0), (580, 1), (585, 0), (590, 0), (595, 0), (600, 0), (605, 0), (610, 0), (615, 0), (620, 0), (625, 0), (630, 0), (635, 0), (640, 0), (645, 0), (650, 0), (655, 0), (660, 0), (665, 0), (670, 0), (675, 0), (680, 0), (685, 0), (690, 1), (695, 1), (700, 1), (705, 1), (710, 1), (715, 1), (720, 1), (725, 1), (730, 0), (735, 1), (740, 1), (745, 1), (750, 1), (755, 1), (760, 0), (765, 0), (770, 1), (775, 1), (780, 1), (785, 1), (790, 1), (795, 1), (800, 1), (805, 1), (810, 0), (815, 0), (820, 0), (825, 0), (830, 1), (835, 1), (840, 1), (845, 1), (850, 1), (855, 1), (860, 1), (865, 1), (870, 1), (875, 1), (880, 1), (885, 1), (890, 1), (895, 1), (900, 0), (905, 1), (910, 1), (915, 1), (920, 1), (925, 1), (930, 1), (935, 1), (940, 1), (945, 0), (950, 0), (955, 0), (960, 0), (965, 0), (970, 0), (975, 0), (980, 0), (985, 0), (990, 0), (995, 0), (1000, 1), (1005, 1), (1010, 1), (1015, 1), (1020, 0), (1025, 0)]
Vdin1_50  din1_50  0 PWL (0n 0.0v 4.745n 0.0v 4.755n 1.0v 9.745n 1.0v 9.755n 0.0v 14.745n 0.0v 14.755n 1.0v 19.745n 1.0v 19.755n 1.0v 24.745n 1.0v 24.755n 1.0v 29.745n 1.0v 29.755n 1.0v 34.745n 1.0v 34.755n 1.0v 39.745n 1.0v 39.755n 1.0v 44.745n 1.0v 44.755n 1.0v 49.745n 1.0v 49.755n 1.0v 54.745n 1.0v 54.755n 1.0v 59.745n 1.0v 59.755n 0.0v 64.745n 0.0v 64.755n 0.0v 69.745n 0.0v 69.755n 0.0v 74.745n 0.0v 74.755n 0.0v 79.745n 0.0v 79.755n 1.0v 84.745n 1.0v 84.755n 1.0v 89.745n 1.0v 89.755n 1.0v 94.745n 1.0v 94.755n 1.0v 99.745n 1.0v 99.755n 1.0v 104.745n 1.0v 104.755n 1.0v 109.745n 1.0v 109.755n 1.0v 114.745n 1.0v 114.755n 1.0v 119.745n 1.0v 119.755n 1.0v 124.745n 1.0v 124.755n 1.0v 129.745n 1.0v 129.755n 0.0v 134.745n 0.0v 134.755n 0.0v 139.745n 0.0v 139.755n 0.0v 144.745n 0.0v 144.755n 0.0v 149.745n 0.0v 149.755n 0.0v 154.745n 0.0v 154.755n 0.0v 159.745n 0.0v 159.755n 0.0v 164.745n 0.0v 164.755n 0.0v 169.745n 0.0v 169.755n 0.0v 174.745n 0.0v 174.755n 0.0v 179.745n 0.0v 179.755n 1.0v 184.745n 1.0v 184.755n 1.0v 189.745n 1.0v 189.755n 1.0v 194.745n 1.0v 194.755n 1.0v 199.745n 1.0v 199.755n 1.0v 204.745n 1.0v 204.755n 1.0v 209.745n 1.0v 209.755n 1.0v 214.745n 1.0v 214.755n 1.0v 219.745n 1.0v 219.755n 1.0v 224.745n 1.0v 224.755n 1.0v 229.745n 1.0v 229.755n 1.0v 234.745n 1.0v 234.755n 1.0v 239.745n 1.0v 239.755n 1.0v 244.745n 1.0v 244.755n 0.0v 249.745n 0.0v 249.755n 0.0v 254.745n 0.0v 254.755n 0.0v 259.745n 0.0v 259.755n 0.0v 264.745n 0.0v 264.755n 0.0v 269.745n 0.0v 269.755n 0.0v 274.745n 0.0v 274.755n 0.0v 279.745n 0.0v 279.755n 0.0v 284.745n 0.0v 284.755n 1.0v 289.745n 1.0v 289.755n 1.0v 294.745n 1.0v 294.755n 1.0v 299.745n 1.0v 299.755n 1.0v 304.745n 1.0v 304.755n 1.0v 309.745n 1.0v 309.755n 1.0v 314.745n 1.0v 314.755n 1.0v 319.745n 1.0v 319.755n 1.0v 324.745n 1.0v 324.755n 1.0v 329.745n 1.0v 329.755n 1.0v 334.745n 1.0v 334.755n 1.0v 339.745n 1.0v 339.755n 1.0v 344.745n 1.0v 344.755n 1.0v 349.745n 1.0v 349.755n 1.0v 354.745n 1.0v 354.755n 1.0v 359.745n 1.0v 359.755n 1.0v 364.745n 1.0v 364.755n 1.0v 369.745n 1.0v 369.755n 1.0v 374.745n 1.0v 374.755n 1.0v 379.745n 1.0v 379.755n 0.0v 384.745n 0.0v 384.755n 0.0v 389.745n 0.0v 389.755n 1.0v 394.745n 1.0v 394.755n 1.0v 399.745n 1.0v 399.755n 1.0v 404.745n 1.0v 404.755n 1.0v 409.745n 1.0v 409.755n 1.0v 414.745n 1.0v 414.755n 1.0v 419.745n 1.0v 419.755n 1.0v 424.745n 1.0v 424.755n 1.0v 429.745n 1.0v 429.755n 1.0v 434.745n 1.0v 434.755n 1.0v 439.745n 1.0v 439.755n 1.0v 444.745n 1.0v 444.755n 1.0v 449.745n 1.0v 449.755n 1.0v 454.745n 1.0v 454.755n 1.0v 459.745n 1.0v 459.755n 1.0v 464.745n 1.0v 464.755n 1.0v 469.745n 1.0v 469.755n 1.0v 474.745n 1.0v 474.755n 1.0v 479.745n 1.0v 479.755n 1.0v 484.745n 1.0v 484.755n 1.0v 489.745n 1.0v 489.755n 1.0v 494.745n 1.0v 494.755n 1.0v 499.745n 1.0v 499.755n 1.0v 504.745n 1.0v 504.755n 0.0v 509.745n 0.0v 509.755n 0.0v 514.745n 0.0v 514.755n 0.0v 519.745n 0.0v 519.755n 0.0v 524.745n 0.0v 524.755n 0.0v 529.745n 0.0v 529.755n 0.0v 534.745n 0.0v 534.755n 0.0v 539.745n 0.0v 539.755n 0.0v 544.745n 0.0v 544.755n 0.0v 549.745n 0.0v 549.755n 0.0v 554.745n 0.0v 554.755n 0.0v 559.745n 0.0v 559.755n 0.0v 564.745n 0.0v 564.755n 0.0v 569.745n 0.0v 569.755n 0.0v 574.745n 0.0v 574.755n 0.0v 579.745n 0.0v 579.755n 1.0v 584.745n 1.0v 584.755n 0.0v 589.745n 0.0v 589.755n 0.0v 594.745n 0.0v 594.755n 0.0v 599.745n 0.0v 599.755n 0.0v 604.745n 0.0v 604.755n 0.0v 609.745n 0.0v 609.755n 0.0v 614.745n 0.0v 614.755n 0.0v 619.745n 0.0v 619.755n 0.0v 624.745n 0.0v 624.755n 0.0v 629.745n 0.0v 629.755n 0.0v 634.745n 0.0v 634.755n 0.0v 639.745n 0.0v 639.755n 0.0v 644.745n 0.0v 644.755n 0.0v 649.745n 0.0v 649.755n 0.0v 654.745n 0.0v 654.755n 0.0v 659.745n 0.0v 659.755n 0.0v 664.745n 0.0v 664.755n 0.0v 669.745n 0.0v 669.755n 0.0v 674.745n 0.0v 674.755n 0.0v 679.745n 0.0v 679.755n 0.0v 684.745n 0.0v 684.755n 0.0v 689.745n 0.0v 689.755n 1.0v 694.745n 1.0v 694.755n 1.0v 699.745n 1.0v 699.755n 1.0v 704.745n 1.0v 704.755n 1.0v 709.745n 1.0v 709.755n 1.0v 714.745n 1.0v 714.755n 1.0v 719.745n 1.0v 719.755n 1.0v 724.745n 1.0v 724.755n 1.0v 729.745n 1.0v 729.755n 0.0v 734.745n 0.0v 734.755n 1.0v 739.745n 1.0v 739.755n 1.0v 744.745n 1.0v 744.755n 1.0v 749.745n 1.0v 749.755n 1.0v 754.745n 1.0v 754.755n 1.0v 759.745n 1.0v 759.755n 0.0v 764.745n 0.0v 764.755n 0.0v 769.745n 0.0v 769.755n 1.0v 774.745n 1.0v 774.755n 1.0v 779.745n 1.0v 779.755n 1.0v 784.745n 1.0v 784.755n 1.0v 789.745n 1.0v 789.755n 1.0v 794.745n 1.0v 794.755n 1.0v 799.745n 1.0v 799.755n 1.0v 804.745n 1.0v 804.755n 1.0v 809.745n 1.0v 809.755n 0.0v 814.745n 0.0v 814.755n 0.0v 819.745n 0.0v 819.755n 0.0v 824.745n 0.0v 824.755n 0.0v 829.745n 0.0v 829.755n 1.0v 834.745n 1.0v 834.755n 1.0v 839.745n 1.0v 839.755n 1.0v 844.745n 1.0v 844.755n 1.0v 849.745n 1.0v 849.755n 1.0v 854.745n 1.0v 854.755n 1.0v 859.745n 1.0v 859.755n 1.0v 864.745n 1.0v 864.755n 1.0v 869.745n 1.0v 869.755n 1.0v 874.745n 1.0v 874.755n 1.0v 879.745n 1.0v 879.755n 1.0v 884.745n 1.0v 884.755n 1.0v 889.745n 1.0v 889.755n 1.0v 894.745n 1.0v 894.755n 1.0v 899.745n 1.0v 899.755n 0.0v 904.745n 0.0v 904.755n 1.0v 909.745n 1.0v 909.755n 1.0v 914.745n 1.0v 914.755n 1.0v 919.745n 1.0v 919.755n 1.0v 924.745n 1.0v 924.755n 1.0v 929.745n 1.0v 929.755n 1.0v 934.745n 1.0v 934.755n 1.0v 939.745n 1.0v 939.755n 1.0v 944.745n 1.0v 944.755n 0.0v 949.745n 0.0v 949.755n 0.0v 954.745n 0.0v 954.755n 0.0v 959.745n 0.0v 959.755n 0.0v 964.745n 0.0v 964.755n 0.0v 969.745n 0.0v 969.755n 0.0v 974.745n 0.0v 974.755n 0.0v 979.745n 0.0v 979.755n 0.0v 984.745n 0.0v 984.755n 0.0v 989.745n 0.0v 989.755n 0.0v 994.745n 0.0v 994.755n 0.0v 999.745n 0.0v 999.755n 1.0v 1004.745n 1.0v 1004.755n 1.0v 1009.745n 1.0v 1009.755n 1.0v 1014.745n 1.0v 1014.755n 1.0v 1019.745n 1.0v 1019.755n 0.0v 1024.745n 0.0v 1024.755n 0.0v )
* (time, data): [(0, 0), (5, 1), (10, 0), (15, 0), (20, 0), (25, 0), (30, 0), (35, 0), (40, 0), (45, 0), (50, 0), (55, 0), (60, 1), (65, 1), (70, 1), (75, 1), (80, 0), (85, 0), (90, 0), (95, 0), (100, 0), (105, 0), (110, 0), (115, 0), (120, 0), (125, 0), (130, 0), (135, 0), (140, 0), (145, 1), (150, 1), (155, 1), (160, 1), (165, 1), (170, 1), (175, 0), (180, 1), (185, 1), (190, 1), (195, 1), (200, 1), (205, 1), (210, 1), (215, 1), (220, 1), (225, 1), (230, 1), (235, 1), (240, 1), (245, 1), (250, 1), (255, 1), (260, 1), (265, 1), (270, 1), (275, 1), (280, 1), (285, 0), (290, 0), (295, 0), (300, 0), (305, 0), (310, 0), (315, 0), (320, 0), (325, 0), (330, 0), (335, 0), (340, 0), (345, 0), (350, 0), (355, 0), (360, 0), (365, 1), (370, 1), (375, 1), (380, 0), (385, 0), (390, 1), (395, 0), (400, 1), (405, 1), (410, 1), (415, 1), (420, 1), (425, 1), (430, 1), (435, 1), (440, 1), (445, 1), (450, 1), (455, 1), (460, 1), (465, 1), (470, 1), (475, 1), (480, 1), (485, 1), (490, 1), (495, 1), (500, 1), (505, 0), (510, 0), (515, 0), (520, 1), (525, 1), (530, 1), (535, 1), (540, 1), (545, 1), (550, 1), (555, 1), (560, 1), (565, 1), (570, 1), (575, 1), (580, 1), (585, 0), (590, 0), (595, 0), (600, 0), (605, 0), (610, 0), (615, 0), (620, 0), (625, 0), (630, 0), (635, 0), (640, 0), (645, 0), (650, 0), (655, 0), (660, 0), (665, 0), (670, 0), (675, 0), (680, 0), (685, 0), (690, 0), (695, 0), (700, 0), (705, 0), (710, 0), (715, 0), (720, 0), (725, 0), (730, 1), (735, 0), (740, 0), (745, 0), (750, 0), (755, 0), (760, 0), (765, 0), (770, 0), (775, 0), (780, 0), (785, 0), (790, 1), (795, 1), (800, 1), (805, 1), (810, 1), (815, 1), (820, 1), (825, 1), (830, 1), (835, 1), (840, 1), (845, 1), (850, 1), (855, 1), (860, 1), (865, 1), (870, 1), (875, 1), (880, 0), (885, 0), (890, 0), (895, 0), (900, 1), (905, 0), (910, 0), (915, 0), (920, 0), (925, 0), (930, 0), (935, 0), (940, 0), (945, 1), (950, 1), (955, 1), (960, 1), (965, 1), (970, 1), (975, 1), (980, 1), (985, 1), (990, 1), (995, 1), (1000, 0), (1005, 0), (1010, 1), (1015, 1), (1020, 1), (1025, 1)]
Vdin1_51  din1_51  0 PWL (0n 0.0v 4.745n 0.0v 4.755n 1.0v 9.745n 1.0v 9.755n 0.0v 14.745n 0.0v 14.755n 0.0v 19.745n 0.0v 19.755n 0.0v 24.745n 0.0v 24.755n 0.0v 29.745n 0.0v 29.755n 0.0v 34.745n 0.0v 34.755n 0.0v 39.745n 0.0v 39.755n 0.0v 44.745n 0.0v 44.755n 0.0v 49.745n 0.0v 49.755n 0.0v 54.745n 0.0v 54.755n 0.0v 59.745n 0.0v 59.755n 1.0v 64.745n 1.0v 64.755n 1.0v 69.745n 1.0v 69.755n 1.0v 74.745n 1.0v 74.755n 1.0v 79.745n 1.0v 79.755n 0.0v 84.745n 0.0v 84.755n 0.0v 89.745n 0.0v 89.755n 0.0v 94.745n 0.0v 94.755n 0.0v 99.745n 0.0v 99.755n 0.0v 104.745n 0.0v 104.755n 0.0v 109.745n 0.0v 109.755n 0.0v 114.745n 0.0v 114.755n 0.0v 119.745n 0.0v 119.755n 0.0v 124.745n 0.0v 124.755n 0.0v 129.745n 0.0v 129.755n 0.0v 134.745n 0.0v 134.755n 0.0v 139.745n 0.0v 139.755n 0.0v 144.745n 0.0v 144.755n 1.0v 149.745n 1.0v 149.755n 1.0v 154.745n 1.0v 154.755n 1.0v 159.745n 1.0v 159.755n 1.0v 164.745n 1.0v 164.755n 1.0v 169.745n 1.0v 169.755n 1.0v 174.745n 1.0v 174.755n 0.0v 179.745n 0.0v 179.755n 1.0v 184.745n 1.0v 184.755n 1.0v 189.745n 1.0v 189.755n 1.0v 194.745n 1.0v 194.755n 1.0v 199.745n 1.0v 199.755n 1.0v 204.745n 1.0v 204.755n 1.0v 209.745n 1.0v 209.755n 1.0v 214.745n 1.0v 214.755n 1.0v 219.745n 1.0v 219.755n 1.0v 224.745n 1.0v 224.755n 1.0v 229.745n 1.0v 229.755n 1.0v 234.745n 1.0v 234.755n 1.0v 239.745n 1.0v 239.755n 1.0v 244.745n 1.0v 244.755n 1.0v 249.745n 1.0v 249.755n 1.0v 254.745n 1.0v 254.755n 1.0v 259.745n 1.0v 259.755n 1.0v 264.745n 1.0v 264.755n 1.0v 269.745n 1.0v 269.755n 1.0v 274.745n 1.0v 274.755n 1.0v 279.745n 1.0v 279.755n 1.0v 284.745n 1.0v 284.755n 0.0v 289.745n 0.0v 289.755n 0.0v 294.745n 0.0v 294.755n 0.0v 299.745n 0.0v 299.755n 0.0v 304.745n 0.0v 304.755n 0.0v 309.745n 0.0v 309.755n 0.0v 314.745n 0.0v 314.755n 0.0v 319.745n 0.0v 319.755n 0.0v 324.745n 0.0v 324.755n 0.0v 329.745n 0.0v 329.755n 0.0v 334.745n 0.0v 334.755n 0.0v 339.745n 0.0v 339.755n 0.0v 344.745n 0.0v 344.755n 0.0v 349.745n 0.0v 349.755n 0.0v 354.745n 0.0v 354.755n 0.0v 359.745n 0.0v 359.755n 0.0v 364.745n 0.0v 364.755n 1.0v 369.745n 1.0v 369.755n 1.0v 374.745n 1.0v 374.755n 1.0v 379.745n 1.0v 379.755n 0.0v 384.745n 0.0v 384.755n 0.0v 389.745n 0.0v 389.755n 1.0v 394.745n 1.0v 394.755n 0.0v 399.745n 0.0v 399.755n 1.0v 404.745n 1.0v 404.755n 1.0v 409.745n 1.0v 409.755n 1.0v 414.745n 1.0v 414.755n 1.0v 419.745n 1.0v 419.755n 1.0v 424.745n 1.0v 424.755n 1.0v 429.745n 1.0v 429.755n 1.0v 434.745n 1.0v 434.755n 1.0v 439.745n 1.0v 439.755n 1.0v 444.745n 1.0v 444.755n 1.0v 449.745n 1.0v 449.755n 1.0v 454.745n 1.0v 454.755n 1.0v 459.745n 1.0v 459.755n 1.0v 464.745n 1.0v 464.755n 1.0v 469.745n 1.0v 469.755n 1.0v 474.745n 1.0v 474.755n 1.0v 479.745n 1.0v 479.755n 1.0v 484.745n 1.0v 484.755n 1.0v 489.745n 1.0v 489.755n 1.0v 494.745n 1.0v 494.755n 1.0v 499.745n 1.0v 499.755n 1.0v 504.745n 1.0v 504.755n 0.0v 509.745n 0.0v 509.755n 0.0v 514.745n 0.0v 514.755n 0.0v 519.745n 0.0v 519.755n 1.0v 524.745n 1.0v 524.755n 1.0v 529.745n 1.0v 529.755n 1.0v 534.745n 1.0v 534.755n 1.0v 539.745n 1.0v 539.755n 1.0v 544.745n 1.0v 544.755n 1.0v 549.745n 1.0v 549.755n 1.0v 554.745n 1.0v 554.755n 1.0v 559.745n 1.0v 559.755n 1.0v 564.745n 1.0v 564.755n 1.0v 569.745n 1.0v 569.755n 1.0v 574.745n 1.0v 574.755n 1.0v 579.745n 1.0v 579.755n 1.0v 584.745n 1.0v 584.755n 0.0v 589.745n 0.0v 589.755n 0.0v 594.745n 0.0v 594.755n 0.0v 599.745n 0.0v 599.755n 0.0v 604.745n 0.0v 604.755n 0.0v 609.745n 0.0v 609.755n 0.0v 614.745n 0.0v 614.755n 0.0v 619.745n 0.0v 619.755n 0.0v 624.745n 0.0v 624.755n 0.0v 629.745n 0.0v 629.755n 0.0v 634.745n 0.0v 634.755n 0.0v 639.745n 0.0v 639.755n 0.0v 644.745n 0.0v 644.755n 0.0v 649.745n 0.0v 649.755n 0.0v 654.745n 0.0v 654.755n 0.0v 659.745n 0.0v 659.755n 0.0v 664.745n 0.0v 664.755n 0.0v 669.745n 0.0v 669.755n 0.0v 674.745n 0.0v 674.755n 0.0v 679.745n 0.0v 679.755n 0.0v 684.745n 0.0v 684.755n 0.0v 689.745n 0.0v 689.755n 0.0v 694.745n 0.0v 694.755n 0.0v 699.745n 0.0v 699.755n 0.0v 704.745n 0.0v 704.755n 0.0v 709.745n 0.0v 709.755n 0.0v 714.745n 0.0v 714.755n 0.0v 719.745n 0.0v 719.755n 0.0v 724.745n 0.0v 724.755n 0.0v 729.745n 0.0v 729.755n 1.0v 734.745n 1.0v 734.755n 0.0v 739.745n 0.0v 739.755n 0.0v 744.745n 0.0v 744.755n 0.0v 749.745n 0.0v 749.755n 0.0v 754.745n 0.0v 754.755n 0.0v 759.745n 0.0v 759.755n 0.0v 764.745n 0.0v 764.755n 0.0v 769.745n 0.0v 769.755n 0.0v 774.745n 0.0v 774.755n 0.0v 779.745n 0.0v 779.755n 0.0v 784.745n 0.0v 784.755n 0.0v 789.745n 0.0v 789.755n 1.0v 794.745n 1.0v 794.755n 1.0v 799.745n 1.0v 799.755n 1.0v 804.745n 1.0v 804.755n 1.0v 809.745n 1.0v 809.755n 1.0v 814.745n 1.0v 814.755n 1.0v 819.745n 1.0v 819.755n 1.0v 824.745n 1.0v 824.755n 1.0v 829.745n 1.0v 829.755n 1.0v 834.745n 1.0v 834.755n 1.0v 839.745n 1.0v 839.755n 1.0v 844.745n 1.0v 844.755n 1.0v 849.745n 1.0v 849.755n 1.0v 854.745n 1.0v 854.755n 1.0v 859.745n 1.0v 859.755n 1.0v 864.745n 1.0v 864.755n 1.0v 869.745n 1.0v 869.755n 1.0v 874.745n 1.0v 874.755n 1.0v 879.745n 1.0v 879.755n 0.0v 884.745n 0.0v 884.755n 0.0v 889.745n 0.0v 889.755n 0.0v 894.745n 0.0v 894.755n 0.0v 899.745n 0.0v 899.755n 1.0v 904.745n 1.0v 904.755n 0.0v 909.745n 0.0v 909.755n 0.0v 914.745n 0.0v 914.755n 0.0v 919.745n 0.0v 919.755n 0.0v 924.745n 0.0v 924.755n 0.0v 929.745n 0.0v 929.755n 0.0v 934.745n 0.0v 934.755n 0.0v 939.745n 0.0v 939.755n 0.0v 944.745n 0.0v 944.755n 1.0v 949.745n 1.0v 949.755n 1.0v 954.745n 1.0v 954.755n 1.0v 959.745n 1.0v 959.755n 1.0v 964.745n 1.0v 964.755n 1.0v 969.745n 1.0v 969.755n 1.0v 974.745n 1.0v 974.755n 1.0v 979.745n 1.0v 979.755n 1.0v 984.745n 1.0v 984.755n 1.0v 989.745n 1.0v 989.755n 1.0v 994.745n 1.0v 994.755n 1.0v 999.745n 1.0v 999.755n 0.0v 1004.745n 0.0v 1004.755n 0.0v 1009.745n 0.0v 1009.755n 1.0v 1014.745n 1.0v 1014.755n 1.0v 1019.745n 1.0v 1019.755n 1.0v 1024.745n 1.0v 1024.755n 1.0v )
* (time, data): [(0, 0), (5, 1), (10, 1), (15, 1), (20, 1), (25, 1), (30, 1), (35, 1), (40, 1), (45, 1), (50, 1), (55, 1), (60, 1), (65, 1), (70, 1), (75, 1), (80, 0), (85, 0), (90, 0), (95, 0), (100, 0), (105, 0), (110, 0), (115, 0), (120, 0), (125, 0), (130, 1), (135, 1), (140, 1), (145, 1), (150, 1), (155, 1), (160, 1), (165, 1), (170, 1), (175, 0), (180, 1), (185, 1), (190, 1), (195, 1), (200, 1), (205, 1), (210, 1), (215, 1), (220, 1), (225, 1), (230, 1), (235, 1), (240, 1), (245, 1), (250, 1), (255, 1), (260, 1), (265, 1), (270, 1), (275, 1), (280, 1), (285, 1), (290, 1), (295, 1), (300, 0), (305, 0), (310, 0), (315, 0), (320, 0), (325, 0), (330, 0), (335, 0), (340, 0), (345, 0), (350, 0), (355, 0), (360, 0), (365, 1), (370, 1), (375, 1), (380, 1), (385, 1), (390, 0), (395, 1), (400, 0), (405, 0), (410, 0), (415, 0), (420, 1), (425, 1), (430, 1), (435, 1), (440, 1), (445, 1), (450, 1), (455, 1), (460, 1), (465, 0), (470, 0), (475, 0), (480, 0), (485, 0), (490, 0), (495, 0), (500, 0), (505, 0), (510, 0), (515, 0), (520, 0), (525, 0), (530, 0), (535, 0), (540, 0), (545, 0), (550, 0), (555, 0), (560, 0), (565, 0), (570, 0), (575, 0), (580, 0), (585, 1), (590, 1), (595, 1), (600, 1), (605, 1), (610, 1), (615, 1), (620, 1), (625, 1), (630, 1), (635, 1), (640, 1), (645, 1), (650, 1), (655, 1), (660, 1), (665, 1), (670, 1), (675, 1), (680, 1), (685, 1), (690, 0), (695, 0), (700, 0), (705, 0), (710, 0), (715, 0), (720, 0), (725, 0), (730, 1), (735, 0), (740, 0), (745, 0), (750, 0), (755, 0), (760, 1), (765, 1), (770, 1), (775, 1), (780, 1), (785, 1), (790, 0), (795, 0), (800, 0), (805, 0), (810, 1), (815, 1), (820, 1), (825, 1), (830, 0), (835, 0), (840, 0), (845, 0), (850, 0), (855, 0), (860, 1), (865, 1), (870, 1), (875, 1), (880, 1), (885, 1), (890, 1), (895, 1), (900, 1), (905, 0), (910, 0), (915, 0), (920, 0), (925, 0), (930, 1), (935, 1), (940, 1), (945, 0), (950, 0), (955, 0), (960, 0), (965, 0), (970, 0), (975, 0), (980, 0), (985, 0), (990, 0), (995, 0), (1000, 1), (1005, 1), (1010, 1), (1015, 1), (1020, 1), (1025, 1)]
Vdin1_52  din1_52  0 PWL (0n 0.0v 4.745n 0.0v 4.755n 1.0v 9.745n 1.0v 9.755n 1.0v 14.745n 1.0v 14.755n 1.0v 19.745n 1.0v 19.755n 1.0v 24.745n 1.0v 24.755n 1.0v 29.745n 1.0v 29.755n 1.0v 34.745n 1.0v 34.755n 1.0v 39.745n 1.0v 39.755n 1.0v 44.745n 1.0v 44.755n 1.0v 49.745n 1.0v 49.755n 1.0v 54.745n 1.0v 54.755n 1.0v 59.745n 1.0v 59.755n 1.0v 64.745n 1.0v 64.755n 1.0v 69.745n 1.0v 69.755n 1.0v 74.745n 1.0v 74.755n 1.0v 79.745n 1.0v 79.755n 0.0v 84.745n 0.0v 84.755n 0.0v 89.745n 0.0v 89.755n 0.0v 94.745n 0.0v 94.755n 0.0v 99.745n 0.0v 99.755n 0.0v 104.745n 0.0v 104.755n 0.0v 109.745n 0.0v 109.755n 0.0v 114.745n 0.0v 114.755n 0.0v 119.745n 0.0v 119.755n 0.0v 124.745n 0.0v 124.755n 0.0v 129.745n 0.0v 129.755n 1.0v 134.745n 1.0v 134.755n 1.0v 139.745n 1.0v 139.755n 1.0v 144.745n 1.0v 144.755n 1.0v 149.745n 1.0v 149.755n 1.0v 154.745n 1.0v 154.755n 1.0v 159.745n 1.0v 159.755n 1.0v 164.745n 1.0v 164.755n 1.0v 169.745n 1.0v 169.755n 1.0v 174.745n 1.0v 174.755n 0.0v 179.745n 0.0v 179.755n 1.0v 184.745n 1.0v 184.755n 1.0v 189.745n 1.0v 189.755n 1.0v 194.745n 1.0v 194.755n 1.0v 199.745n 1.0v 199.755n 1.0v 204.745n 1.0v 204.755n 1.0v 209.745n 1.0v 209.755n 1.0v 214.745n 1.0v 214.755n 1.0v 219.745n 1.0v 219.755n 1.0v 224.745n 1.0v 224.755n 1.0v 229.745n 1.0v 229.755n 1.0v 234.745n 1.0v 234.755n 1.0v 239.745n 1.0v 239.755n 1.0v 244.745n 1.0v 244.755n 1.0v 249.745n 1.0v 249.755n 1.0v 254.745n 1.0v 254.755n 1.0v 259.745n 1.0v 259.755n 1.0v 264.745n 1.0v 264.755n 1.0v 269.745n 1.0v 269.755n 1.0v 274.745n 1.0v 274.755n 1.0v 279.745n 1.0v 279.755n 1.0v 284.745n 1.0v 284.755n 1.0v 289.745n 1.0v 289.755n 1.0v 294.745n 1.0v 294.755n 1.0v 299.745n 1.0v 299.755n 0.0v 304.745n 0.0v 304.755n 0.0v 309.745n 0.0v 309.755n 0.0v 314.745n 0.0v 314.755n 0.0v 319.745n 0.0v 319.755n 0.0v 324.745n 0.0v 324.755n 0.0v 329.745n 0.0v 329.755n 0.0v 334.745n 0.0v 334.755n 0.0v 339.745n 0.0v 339.755n 0.0v 344.745n 0.0v 344.755n 0.0v 349.745n 0.0v 349.755n 0.0v 354.745n 0.0v 354.755n 0.0v 359.745n 0.0v 359.755n 0.0v 364.745n 0.0v 364.755n 1.0v 369.745n 1.0v 369.755n 1.0v 374.745n 1.0v 374.755n 1.0v 379.745n 1.0v 379.755n 1.0v 384.745n 1.0v 384.755n 1.0v 389.745n 1.0v 389.755n 0.0v 394.745n 0.0v 394.755n 1.0v 399.745n 1.0v 399.755n 0.0v 404.745n 0.0v 404.755n 0.0v 409.745n 0.0v 409.755n 0.0v 414.745n 0.0v 414.755n 0.0v 419.745n 0.0v 419.755n 1.0v 424.745n 1.0v 424.755n 1.0v 429.745n 1.0v 429.755n 1.0v 434.745n 1.0v 434.755n 1.0v 439.745n 1.0v 439.755n 1.0v 444.745n 1.0v 444.755n 1.0v 449.745n 1.0v 449.755n 1.0v 454.745n 1.0v 454.755n 1.0v 459.745n 1.0v 459.755n 1.0v 464.745n 1.0v 464.755n 0.0v 469.745n 0.0v 469.755n 0.0v 474.745n 0.0v 474.755n 0.0v 479.745n 0.0v 479.755n 0.0v 484.745n 0.0v 484.755n 0.0v 489.745n 0.0v 489.755n 0.0v 494.745n 0.0v 494.755n 0.0v 499.745n 0.0v 499.755n 0.0v 504.745n 0.0v 504.755n 0.0v 509.745n 0.0v 509.755n 0.0v 514.745n 0.0v 514.755n 0.0v 519.745n 0.0v 519.755n 0.0v 524.745n 0.0v 524.755n 0.0v 529.745n 0.0v 529.755n 0.0v 534.745n 0.0v 534.755n 0.0v 539.745n 0.0v 539.755n 0.0v 544.745n 0.0v 544.755n 0.0v 549.745n 0.0v 549.755n 0.0v 554.745n 0.0v 554.755n 0.0v 559.745n 0.0v 559.755n 0.0v 564.745n 0.0v 564.755n 0.0v 569.745n 0.0v 569.755n 0.0v 574.745n 0.0v 574.755n 0.0v 579.745n 0.0v 579.755n 0.0v 584.745n 0.0v 584.755n 1.0v 589.745n 1.0v 589.755n 1.0v 594.745n 1.0v 594.755n 1.0v 599.745n 1.0v 599.755n 1.0v 604.745n 1.0v 604.755n 1.0v 609.745n 1.0v 609.755n 1.0v 614.745n 1.0v 614.755n 1.0v 619.745n 1.0v 619.755n 1.0v 624.745n 1.0v 624.755n 1.0v 629.745n 1.0v 629.755n 1.0v 634.745n 1.0v 634.755n 1.0v 639.745n 1.0v 639.755n 1.0v 644.745n 1.0v 644.755n 1.0v 649.745n 1.0v 649.755n 1.0v 654.745n 1.0v 654.755n 1.0v 659.745n 1.0v 659.755n 1.0v 664.745n 1.0v 664.755n 1.0v 669.745n 1.0v 669.755n 1.0v 674.745n 1.0v 674.755n 1.0v 679.745n 1.0v 679.755n 1.0v 684.745n 1.0v 684.755n 1.0v 689.745n 1.0v 689.755n 0.0v 694.745n 0.0v 694.755n 0.0v 699.745n 0.0v 699.755n 0.0v 704.745n 0.0v 704.755n 0.0v 709.745n 0.0v 709.755n 0.0v 714.745n 0.0v 714.755n 0.0v 719.745n 0.0v 719.755n 0.0v 724.745n 0.0v 724.755n 0.0v 729.745n 0.0v 729.755n 1.0v 734.745n 1.0v 734.755n 0.0v 739.745n 0.0v 739.755n 0.0v 744.745n 0.0v 744.755n 0.0v 749.745n 0.0v 749.755n 0.0v 754.745n 0.0v 754.755n 0.0v 759.745n 0.0v 759.755n 1.0v 764.745n 1.0v 764.755n 1.0v 769.745n 1.0v 769.755n 1.0v 774.745n 1.0v 774.755n 1.0v 779.745n 1.0v 779.755n 1.0v 784.745n 1.0v 784.755n 1.0v 789.745n 1.0v 789.755n 0.0v 794.745n 0.0v 794.755n 0.0v 799.745n 0.0v 799.755n 0.0v 804.745n 0.0v 804.755n 0.0v 809.745n 0.0v 809.755n 1.0v 814.745n 1.0v 814.755n 1.0v 819.745n 1.0v 819.755n 1.0v 824.745n 1.0v 824.755n 1.0v 829.745n 1.0v 829.755n 0.0v 834.745n 0.0v 834.755n 0.0v 839.745n 0.0v 839.755n 0.0v 844.745n 0.0v 844.755n 0.0v 849.745n 0.0v 849.755n 0.0v 854.745n 0.0v 854.755n 0.0v 859.745n 0.0v 859.755n 1.0v 864.745n 1.0v 864.755n 1.0v 869.745n 1.0v 869.755n 1.0v 874.745n 1.0v 874.755n 1.0v 879.745n 1.0v 879.755n 1.0v 884.745n 1.0v 884.755n 1.0v 889.745n 1.0v 889.755n 1.0v 894.745n 1.0v 894.755n 1.0v 899.745n 1.0v 899.755n 1.0v 904.745n 1.0v 904.755n 0.0v 909.745n 0.0v 909.755n 0.0v 914.745n 0.0v 914.755n 0.0v 919.745n 0.0v 919.755n 0.0v 924.745n 0.0v 924.755n 0.0v 929.745n 0.0v 929.755n 1.0v 934.745n 1.0v 934.755n 1.0v 939.745n 1.0v 939.755n 1.0v 944.745n 1.0v 944.755n 0.0v 949.745n 0.0v 949.755n 0.0v 954.745n 0.0v 954.755n 0.0v 959.745n 0.0v 959.755n 0.0v 964.745n 0.0v 964.755n 0.0v 969.745n 0.0v 969.755n 0.0v 974.745n 0.0v 974.755n 0.0v 979.745n 0.0v 979.755n 0.0v 984.745n 0.0v 984.755n 0.0v 989.745n 0.0v 989.755n 0.0v 994.745n 0.0v 994.755n 0.0v 999.745n 0.0v 999.755n 1.0v 1004.745n 1.0v 1004.755n 1.0v 1009.745n 1.0v 1009.755n 1.0v 1014.745n 1.0v 1014.755n 1.0v 1019.745n 1.0v 1019.755n 1.0v 1024.745n 1.0v 1024.755n 1.0v )
* (time, data): [(0, 0), (5, 1), (10, 1), (15, 0), (20, 0), (25, 0), (30, 0), (35, 0), (40, 0), (45, 0), (50, 0), (55, 0), (60, 0), (65, 0), (70, 0), (75, 0), (80, 1), (85, 1), (90, 1), (95, 1), (100, 1), (105, 1), (110, 1), (115, 1), (120, 1), (125, 1), (130, 0), (135, 0), (140, 0), (145, 1), (150, 1), (155, 1), (160, 1), (165, 1), (170, 1), (175, 0), (180, 0), (185, 0), (190, 0), (195, 0), (200, 0), (205, 0), (210, 0), (215, 0), (220, 0), (225, 0), (230, 0), (235, 0), (240, 0), (245, 1), (250, 1), (255, 1), (260, 1), (265, 1), (270, 1), (275, 1), (280, 1), (285, 1), (290, 1), (295, 1), (300, 0), (305, 0), (310, 0), (315, 0), (320, 0), (325, 0), (330, 0), (335, 0), (340, 0), (345, 0), (350, 0), (355, 0), (360, 0), (365, 0), (370, 0), (375, 0), (380, 0), (385, 0), (390, 0), (395, 0), (400, 1), (405, 1), (410, 1), (415, 1), (420, 1), (425, 1), (430, 1), (435, 1), (440, 1), (445, 1), (450, 1), (455, 1), (460, 1), (465, 1), (470, 1), (475, 1), (480, 1), (485, 0), (490, 0), (495, 0), (500, 0), (505, 0), (510, 0), (515, 0), (520, 1), (525, 1), (530, 1), (535, 1), (540, 1), (545, 1), (550, 1), (555, 1), (560, 1), (565, 1), (570, 1), (575, 1), (580, 0), (585, 1), (590, 1), (595, 1), (600, 1), (605, 0), (610, 0), (615, 0), (620, 0), (625, 0), (630, 0), (635, 0), (640, 0), (645, 0), (650, 0), (655, 0), (660, 0), (665, 0), (670, 0), (675, 0), (680, 0), (685, 0), (690, 0), (695, 0), (700, 0), (705, 0), (710, 0), (715, 0), (720, 0), (725, 0), (730, 0), (735, 0), (740, 0), (745, 0), (750, 0), (755, 0), (760, 0), (765, 0), (770, 0), (775, 0), (780, 0), (785, 0), (790, 0), (795, 0), (800, 0), (805, 0), (810, 1), (815, 1), (820, 1), (825, 1), (830, 1), (835, 1), (840, 1), (845, 1), (850, 1), (855, 1), (860, 1), (865, 1), (870, 1), (875, 1), (880, 0), (885, 0), (890, 0), (895, 0), (900, 0), (905, 0), (910, 0), (915, 0), (920, 0), (925, 1), (930, 0), (935, 0), (940, 0), (945, 0), (950, 0), (955, 0), (960, 0), (965, 0), (970, 0), (975, 0), (980, 0), (985, 0), (990, 0), (995, 0), (1000, 0), (1005, 0), (1010, 1), (1015, 1), (1020, 1), (1025, 1)]
Vdin1_53  din1_53  0 PWL (0n 0.0v 4.745n 0.0v 4.755n 1.0v 9.745n 1.0v 9.755n 1.0v 14.745n 1.0v 14.755n 0.0v 19.745n 0.0v 19.755n 0.0v 24.745n 0.0v 24.755n 0.0v 29.745n 0.0v 29.755n 0.0v 34.745n 0.0v 34.755n 0.0v 39.745n 0.0v 39.755n 0.0v 44.745n 0.0v 44.755n 0.0v 49.745n 0.0v 49.755n 0.0v 54.745n 0.0v 54.755n 0.0v 59.745n 0.0v 59.755n 0.0v 64.745n 0.0v 64.755n 0.0v 69.745n 0.0v 69.755n 0.0v 74.745n 0.0v 74.755n 0.0v 79.745n 0.0v 79.755n 1.0v 84.745n 1.0v 84.755n 1.0v 89.745n 1.0v 89.755n 1.0v 94.745n 1.0v 94.755n 1.0v 99.745n 1.0v 99.755n 1.0v 104.745n 1.0v 104.755n 1.0v 109.745n 1.0v 109.755n 1.0v 114.745n 1.0v 114.755n 1.0v 119.745n 1.0v 119.755n 1.0v 124.745n 1.0v 124.755n 1.0v 129.745n 1.0v 129.755n 0.0v 134.745n 0.0v 134.755n 0.0v 139.745n 0.0v 139.755n 0.0v 144.745n 0.0v 144.755n 1.0v 149.745n 1.0v 149.755n 1.0v 154.745n 1.0v 154.755n 1.0v 159.745n 1.0v 159.755n 1.0v 164.745n 1.0v 164.755n 1.0v 169.745n 1.0v 169.755n 1.0v 174.745n 1.0v 174.755n 0.0v 179.745n 0.0v 179.755n 0.0v 184.745n 0.0v 184.755n 0.0v 189.745n 0.0v 189.755n 0.0v 194.745n 0.0v 194.755n 0.0v 199.745n 0.0v 199.755n 0.0v 204.745n 0.0v 204.755n 0.0v 209.745n 0.0v 209.755n 0.0v 214.745n 0.0v 214.755n 0.0v 219.745n 0.0v 219.755n 0.0v 224.745n 0.0v 224.755n 0.0v 229.745n 0.0v 229.755n 0.0v 234.745n 0.0v 234.755n 0.0v 239.745n 0.0v 239.755n 0.0v 244.745n 0.0v 244.755n 1.0v 249.745n 1.0v 249.755n 1.0v 254.745n 1.0v 254.755n 1.0v 259.745n 1.0v 259.755n 1.0v 264.745n 1.0v 264.755n 1.0v 269.745n 1.0v 269.755n 1.0v 274.745n 1.0v 274.755n 1.0v 279.745n 1.0v 279.755n 1.0v 284.745n 1.0v 284.755n 1.0v 289.745n 1.0v 289.755n 1.0v 294.745n 1.0v 294.755n 1.0v 299.745n 1.0v 299.755n 0.0v 304.745n 0.0v 304.755n 0.0v 309.745n 0.0v 309.755n 0.0v 314.745n 0.0v 314.755n 0.0v 319.745n 0.0v 319.755n 0.0v 324.745n 0.0v 324.755n 0.0v 329.745n 0.0v 329.755n 0.0v 334.745n 0.0v 334.755n 0.0v 339.745n 0.0v 339.755n 0.0v 344.745n 0.0v 344.755n 0.0v 349.745n 0.0v 349.755n 0.0v 354.745n 0.0v 354.755n 0.0v 359.745n 0.0v 359.755n 0.0v 364.745n 0.0v 364.755n 0.0v 369.745n 0.0v 369.755n 0.0v 374.745n 0.0v 374.755n 0.0v 379.745n 0.0v 379.755n 0.0v 384.745n 0.0v 384.755n 0.0v 389.745n 0.0v 389.755n 0.0v 394.745n 0.0v 394.755n 0.0v 399.745n 0.0v 399.755n 1.0v 404.745n 1.0v 404.755n 1.0v 409.745n 1.0v 409.755n 1.0v 414.745n 1.0v 414.755n 1.0v 419.745n 1.0v 419.755n 1.0v 424.745n 1.0v 424.755n 1.0v 429.745n 1.0v 429.755n 1.0v 434.745n 1.0v 434.755n 1.0v 439.745n 1.0v 439.755n 1.0v 444.745n 1.0v 444.755n 1.0v 449.745n 1.0v 449.755n 1.0v 454.745n 1.0v 454.755n 1.0v 459.745n 1.0v 459.755n 1.0v 464.745n 1.0v 464.755n 1.0v 469.745n 1.0v 469.755n 1.0v 474.745n 1.0v 474.755n 1.0v 479.745n 1.0v 479.755n 1.0v 484.745n 1.0v 484.755n 0.0v 489.745n 0.0v 489.755n 0.0v 494.745n 0.0v 494.755n 0.0v 499.745n 0.0v 499.755n 0.0v 504.745n 0.0v 504.755n 0.0v 509.745n 0.0v 509.755n 0.0v 514.745n 0.0v 514.755n 0.0v 519.745n 0.0v 519.755n 1.0v 524.745n 1.0v 524.755n 1.0v 529.745n 1.0v 529.755n 1.0v 534.745n 1.0v 534.755n 1.0v 539.745n 1.0v 539.755n 1.0v 544.745n 1.0v 544.755n 1.0v 549.745n 1.0v 549.755n 1.0v 554.745n 1.0v 554.755n 1.0v 559.745n 1.0v 559.755n 1.0v 564.745n 1.0v 564.755n 1.0v 569.745n 1.0v 569.755n 1.0v 574.745n 1.0v 574.755n 1.0v 579.745n 1.0v 579.755n 0.0v 584.745n 0.0v 584.755n 1.0v 589.745n 1.0v 589.755n 1.0v 594.745n 1.0v 594.755n 1.0v 599.745n 1.0v 599.755n 1.0v 604.745n 1.0v 604.755n 0.0v 609.745n 0.0v 609.755n 0.0v 614.745n 0.0v 614.755n 0.0v 619.745n 0.0v 619.755n 0.0v 624.745n 0.0v 624.755n 0.0v 629.745n 0.0v 629.755n 0.0v 634.745n 0.0v 634.755n 0.0v 639.745n 0.0v 639.755n 0.0v 644.745n 0.0v 644.755n 0.0v 649.745n 0.0v 649.755n 0.0v 654.745n 0.0v 654.755n 0.0v 659.745n 0.0v 659.755n 0.0v 664.745n 0.0v 664.755n 0.0v 669.745n 0.0v 669.755n 0.0v 674.745n 0.0v 674.755n 0.0v 679.745n 0.0v 679.755n 0.0v 684.745n 0.0v 684.755n 0.0v 689.745n 0.0v 689.755n 0.0v 694.745n 0.0v 694.755n 0.0v 699.745n 0.0v 699.755n 0.0v 704.745n 0.0v 704.755n 0.0v 709.745n 0.0v 709.755n 0.0v 714.745n 0.0v 714.755n 0.0v 719.745n 0.0v 719.755n 0.0v 724.745n 0.0v 724.755n 0.0v 729.745n 0.0v 729.755n 0.0v 734.745n 0.0v 734.755n 0.0v 739.745n 0.0v 739.755n 0.0v 744.745n 0.0v 744.755n 0.0v 749.745n 0.0v 749.755n 0.0v 754.745n 0.0v 754.755n 0.0v 759.745n 0.0v 759.755n 0.0v 764.745n 0.0v 764.755n 0.0v 769.745n 0.0v 769.755n 0.0v 774.745n 0.0v 774.755n 0.0v 779.745n 0.0v 779.755n 0.0v 784.745n 0.0v 784.755n 0.0v 789.745n 0.0v 789.755n 0.0v 794.745n 0.0v 794.755n 0.0v 799.745n 0.0v 799.755n 0.0v 804.745n 0.0v 804.755n 0.0v 809.745n 0.0v 809.755n 1.0v 814.745n 1.0v 814.755n 1.0v 819.745n 1.0v 819.755n 1.0v 824.745n 1.0v 824.755n 1.0v 829.745n 1.0v 829.755n 1.0v 834.745n 1.0v 834.755n 1.0v 839.745n 1.0v 839.755n 1.0v 844.745n 1.0v 844.755n 1.0v 849.745n 1.0v 849.755n 1.0v 854.745n 1.0v 854.755n 1.0v 859.745n 1.0v 859.755n 1.0v 864.745n 1.0v 864.755n 1.0v 869.745n 1.0v 869.755n 1.0v 874.745n 1.0v 874.755n 1.0v 879.745n 1.0v 879.755n 0.0v 884.745n 0.0v 884.755n 0.0v 889.745n 0.0v 889.755n 0.0v 894.745n 0.0v 894.755n 0.0v 899.745n 0.0v 899.755n 0.0v 904.745n 0.0v 904.755n 0.0v 909.745n 0.0v 909.755n 0.0v 914.745n 0.0v 914.755n 0.0v 919.745n 0.0v 919.755n 0.0v 924.745n 0.0v 924.755n 1.0v 929.745n 1.0v 929.755n 0.0v 934.745n 0.0v 934.755n 0.0v 939.745n 0.0v 939.755n 0.0v 944.745n 0.0v 944.755n 0.0v 949.745n 0.0v 949.755n 0.0v 954.745n 0.0v 954.755n 0.0v 959.745n 0.0v 959.755n 0.0v 964.745n 0.0v 964.755n 0.0v 969.745n 0.0v 969.755n 0.0v 974.745n 0.0v 974.755n 0.0v 979.745n 0.0v 979.755n 0.0v 984.745n 0.0v 984.755n 0.0v 989.745n 0.0v 989.755n 0.0v 994.745n 0.0v 994.755n 0.0v 999.745n 0.0v 999.755n 0.0v 1004.745n 0.0v 1004.755n 0.0v 1009.745n 0.0v 1009.755n 1.0v 1014.745n 1.0v 1014.755n 1.0v 1019.745n 1.0v 1019.755n 1.0v 1024.745n 1.0v 1024.755n 1.0v )
* (time, data): [(0, 0), (5, 1), (10, 1), (15, 1), (20, 1), (25, 1), (30, 1), (35, 1), (40, 1), (45, 1), (50, 1), (55, 1), (60, 0), (65, 0), (70, 0), (75, 0), (80, 0), (85, 0), (90, 1), (95, 1), (100, 1), (105, 1), (110, 1), (115, 1), (120, 1), (125, 1), (130, 0), (135, 0), (140, 0), (145, 1), (150, 1), (155, 1), (160, 1), (165, 1), (170, 1), (175, 1), (180, 1), (185, 1), (190, 1), (195, 1), (200, 1), (205, 1), (210, 1), (215, 1), (220, 1), (225, 1), (230, 1), (235, 1), (240, 1), (245, 1), (250, 0), (255, 0), (260, 0), (265, 0), (270, 0), (275, 0), (280, 0), (285, 1), (290, 1), (295, 1), (300, 0), (305, 0), (310, 0), (315, 0), (320, 0), (325, 0), (330, 0), (335, 0), (340, 0), (345, 0), (350, 0), (355, 0), (360, 0), (365, 0), (370, 0), (375, 0), (380, 0), (385, 0), (390, 0), (395, 0), (400, 0), (405, 0), (410, 0), (415, 0), (420, 1), (425, 1), (430, 1), (435, 1), (440, 1), (445, 1), (450, 1), (455, 1), (460, 1), (465, 1), (470, 1), (475, 1), (480, 1), (485, 0), (490, 0), (495, 0), (500, 0), (505, 0), (510, 0), (515, 0), (520, 0), (525, 0), (530, 0), (535, 0), (540, 0), (545, 0), (550, 0), (555, 0), (560, 0), (565, 0), (570, 0), (575, 0), (580, 1), (585, 0), (590, 0), (595, 0), (600, 0), (605, 1), (610, 1), (615, 0), (620, 0), (625, 0), (630, 0), (635, 0), (640, 0), (645, 0), (650, 0), (655, 0), (660, 0), (665, 0), (670, 0), (675, 0), (680, 0), (685, 0), (690, 0), (695, 0), (700, 0), (705, 0), (710, 0), (715, 0), (720, 0), (725, 0), (730, 1), (735, 1), (740, 1), (745, 1), (750, 1), (755, 1), (760, 1), (765, 1), (770, 0), (775, 0), (780, 0), (785, 0), (790, 0), (795, 0), (800, 0), (805, 0), (810, 1), (815, 1), (820, 1), (825, 1), (830, 1), (835, 1), (840, 1), (845, 1), (850, 1), (855, 1), (860, 0), (865, 0), (870, 0), (875, 0), (880, 0), (885, 0), (890, 0), (895, 0), (900, 0), (905, 0), (910, 0), (915, 0), (920, 0), (925, 0), (930, 1), (935, 1), (940, 1), (945, 0), (950, 0), (955, 0), (960, 0), (965, 0), (970, 0), (975, 0), (980, 0), (985, 0), (990, 0), (995, 0), (1000, 1), (1005, 1), (1010, 1), (1015, 1), (1020, 1), (1025, 1)]
Vdin1_54  din1_54  0 PWL (0n 0.0v 4.745n 0.0v 4.755n 1.0v 9.745n 1.0v 9.755n 1.0v 14.745n 1.0v 14.755n 1.0v 19.745n 1.0v 19.755n 1.0v 24.745n 1.0v 24.755n 1.0v 29.745n 1.0v 29.755n 1.0v 34.745n 1.0v 34.755n 1.0v 39.745n 1.0v 39.755n 1.0v 44.745n 1.0v 44.755n 1.0v 49.745n 1.0v 49.755n 1.0v 54.745n 1.0v 54.755n 1.0v 59.745n 1.0v 59.755n 0.0v 64.745n 0.0v 64.755n 0.0v 69.745n 0.0v 69.755n 0.0v 74.745n 0.0v 74.755n 0.0v 79.745n 0.0v 79.755n 0.0v 84.745n 0.0v 84.755n 0.0v 89.745n 0.0v 89.755n 1.0v 94.745n 1.0v 94.755n 1.0v 99.745n 1.0v 99.755n 1.0v 104.745n 1.0v 104.755n 1.0v 109.745n 1.0v 109.755n 1.0v 114.745n 1.0v 114.755n 1.0v 119.745n 1.0v 119.755n 1.0v 124.745n 1.0v 124.755n 1.0v 129.745n 1.0v 129.755n 0.0v 134.745n 0.0v 134.755n 0.0v 139.745n 0.0v 139.755n 0.0v 144.745n 0.0v 144.755n 1.0v 149.745n 1.0v 149.755n 1.0v 154.745n 1.0v 154.755n 1.0v 159.745n 1.0v 159.755n 1.0v 164.745n 1.0v 164.755n 1.0v 169.745n 1.0v 169.755n 1.0v 174.745n 1.0v 174.755n 1.0v 179.745n 1.0v 179.755n 1.0v 184.745n 1.0v 184.755n 1.0v 189.745n 1.0v 189.755n 1.0v 194.745n 1.0v 194.755n 1.0v 199.745n 1.0v 199.755n 1.0v 204.745n 1.0v 204.755n 1.0v 209.745n 1.0v 209.755n 1.0v 214.745n 1.0v 214.755n 1.0v 219.745n 1.0v 219.755n 1.0v 224.745n 1.0v 224.755n 1.0v 229.745n 1.0v 229.755n 1.0v 234.745n 1.0v 234.755n 1.0v 239.745n 1.0v 239.755n 1.0v 244.745n 1.0v 244.755n 1.0v 249.745n 1.0v 249.755n 0.0v 254.745n 0.0v 254.755n 0.0v 259.745n 0.0v 259.755n 0.0v 264.745n 0.0v 264.755n 0.0v 269.745n 0.0v 269.755n 0.0v 274.745n 0.0v 274.755n 0.0v 279.745n 0.0v 279.755n 0.0v 284.745n 0.0v 284.755n 1.0v 289.745n 1.0v 289.755n 1.0v 294.745n 1.0v 294.755n 1.0v 299.745n 1.0v 299.755n 0.0v 304.745n 0.0v 304.755n 0.0v 309.745n 0.0v 309.755n 0.0v 314.745n 0.0v 314.755n 0.0v 319.745n 0.0v 319.755n 0.0v 324.745n 0.0v 324.755n 0.0v 329.745n 0.0v 329.755n 0.0v 334.745n 0.0v 334.755n 0.0v 339.745n 0.0v 339.755n 0.0v 344.745n 0.0v 344.755n 0.0v 349.745n 0.0v 349.755n 0.0v 354.745n 0.0v 354.755n 0.0v 359.745n 0.0v 359.755n 0.0v 364.745n 0.0v 364.755n 0.0v 369.745n 0.0v 369.755n 0.0v 374.745n 0.0v 374.755n 0.0v 379.745n 0.0v 379.755n 0.0v 384.745n 0.0v 384.755n 0.0v 389.745n 0.0v 389.755n 0.0v 394.745n 0.0v 394.755n 0.0v 399.745n 0.0v 399.755n 0.0v 404.745n 0.0v 404.755n 0.0v 409.745n 0.0v 409.755n 0.0v 414.745n 0.0v 414.755n 0.0v 419.745n 0.0v 419.755n 1.0v 424.745n 1.0v 424.755n 1.0v 429.745n 1.0v 429.755n 1.0v 434.745n 1.0v 434.755n 1.0v 439.745n 1.0v 439.755n 1.0v 444.745n 1.0v 444.755n 1.0v 449.745n 1.0v 449.755n 1.0v 454.745n 1.0v 454.755n 1.0v 459.745n 1.0v 459.755n 1.0v 464.745n 1.0v 464.755n 1.0v 469.745n 1.0v 469.755n 1.0v 474.745n 1.0v 474.755n 1.0v 479.745n 1.0v 479.755n 1.0v 484.745n 1.0v 484.755n 0.0v 489.745n 0.0v 489.755n 0.0v 494.745n 0.0v 494.755n 0.0v 499.745n 0.0v 499.755n 0.0v 504.745n 0.0v 504.755n 0.0v 509.745n 0.0v 509.755n 0.0v 514.745n 0.0v 514.755n 0.0v 519.745n 0.0v 519.755n 0.0v 524.745n 0.0v 524.755n 0.0v 529.745n 0.0v 529.755n 0.0v 534.745n 0.0v 534.755n 0.0v 539.745n 0.0v 539.755n 0.0v 544.745n 0.0v 544.755n 0.0v 549.745n 0.0v 549.755n 0.0v 554.745n 0.0v 554.755n 0.0v 559.745n 0.0v 559.755n 0.0v 564.745n 0.0v 564.755n 0.0v 569.745n 0.0v 569.755n 0.0v 574.745n 0.0v 574.755n 0.0v 579.745n 0.0v 579.755n 1.0v 584.745n 1.0v 584.755n 0.0v 589.745n 0.0v 589.755n 0.0v 594.745n 0.0v 594.755n 0.0v 599.745n 0.0v 599.755n 0.0v 604.745n 0.0v 604.755n 1.0v 609.745n 1.0v 609.755n 1.0v 614.745n 1.0v 614.755n 0.0v 619.745n 0.0v 619.755n 0.0v 624.745n 0.0v 624.755n 0.0v 629.745n 0.0v 629.755n 0.0v 634.745n 0.0v 634.755n 0.0v 639.745n 0.0v 639.755n 0.0v 644.745n 0.0v 644.755n 0.0v 649.745n 0.0v 649.755n 0.0v 654.745n 0.0v 654.755n 0.0v 659.745n 0.0v 659.755n 0.0v 664.745n 0.0v 664.755n 0.0v 669.745n 0.0v 669.755n 0.0v 674.745n 0.0v 674.755n 0.0v 679.745n 0.0v 679.755n 0.0v 684.745n 0.0v 684.755n 0.0v 689.745n 0.0v 689.755n 0.0v 694.745n 0.0v 694.755n 0.0v 699.745n 0.0v 699.755n 0.0v 704.745n 0.0v 704.755n 0.0v 709.745n 0.0v 709.755n 0.0v 714.745n 0.0v 714.755n 0.0v 719.745n 0.0v 719.755n 0.0v 724.745n 0.0v 724.755n 0.0v 729.745n 0.0v 729.755n 1.0v 734.745n 1.0v 734.755n 1.0v 739.745n 1.0v 739.755n 1.0v 744.745n 1.0v 744.755n 1.0v 749.745n 1.0v 749.755n 1.0v 754.745n 1.0v 754.755n 1.0v 759.745n 1.0v 759.755n 1.0v 764.745n 1.0v 764.755n 1.0v 769.745n 1.0v 769.755n 0.0v 774.745n 0.0v 774.755n 0.0v 779.745n 0.0v 779.755n 0.0v 784.745n 0.0v 784.755n 0.0v 789.745n 0.0v 789.755n 0.0v 794.745n 0.0v 794.755n 0.0v 799.745n 0.0v 799.755n 0.0v 804.745n 0.0v 804.755n 0.0v 809.745n 0.0v 809.755n 1.0v 814.745n 1.0v 814.755n 1.0v 819.745n 1.0v 819.755n 1.0v 824.745n 1.0v 824.755n 1.0v 829.745n 1.0v 829.755n 1.0v 834.745n 1.0v 834.755n 1.0v 839.745n 1.0v 839.755n 1.0v 844.745n 1.0v 844.755n 1.0v 849.745n 1.0v 849.755n 1.0v 854.745n 1.0v 854.755n 1.0v 859.745n 1.0v 859.755n 0.0v 864.745n 0.0v 864.755n 0.0v 869.745n 0.0v 869.755n 0.0v 874.745n 0.0v 874.755n 0.0v 879.745n 0.0v 879.755n 0.0v 884.745n 0.0v 884.755n 0.0v 889.745n 0.0v 889.755n 0.0v 894.745n 0.0v 894.755n 0.0v 899.745n 0.0v 899.755n 0.0v 904.745n 0.0v 904.755n 0.0v 909.745n 0.0v 909.755n 0.0v 914.745n 0.0v 914.755n 0.0v 919.745n 0.0v 919.755n 0.0v 924.745n 0.0v 924.755n 0.0v 929.745n 0.0v 929.755n 1.0v 934.745n 1.0v 934.755n 1.0v 939.745n 1.0v 939.755n 1.0v 944.745n 1.0v 944.755n 0.0v 949.745n 0.0v 949.755n 0.0v 954.745n 0.0v 954.755n 0.0v 959.745n 0.0v 959.755n 0.0v 964.745n 0.0v 964.755n 0.0v 969.745n 0.0v 969.755n 0.0v 974.745n 0.0v 974.755n 0.0v 979.745n 0.0v 979.755n 0.0v 984.745n 0.0v 984.755n 0.0v 989.745n 0.0v 989.755n 0.0v 994.745n 0.0v 994.755n 0.0v 999.745n 0.0v 999.755n 1.0v 1004.745n 1.0v 1004.755n 1.0v 1009.745n 1.0v 1009.755n 1.0v 1014.745n 1.0v 1014.755n 1.0v 1019.745n 1.0v 1019.755n 1.0v 1024.745n 1.0v 1024.755n 1.0v )
* (time, data): [(0, 0), (5, 0), (10, 0), (15, 0), (20, 0), (25, 0), (30, 0), (35, 0), (40, 0), (45, 0), (50, 0), (55, 0), (60, 0), (65, 0), (70, 0), (75, 0), (80, 1), (85, 1), (90, 1), (95, 1), (100, 1), (105, 1), (110, 1), (115, 1), (120, 1), (125, 1), (130, 1), (135, 1), (140, 1), (145, 0), (150, 0), (155, 0), (160, 0), (165, 0), (170, 0), (175, 0), (180, 0), (185, 0), (190, 0), (195, 0), (200, 0), (205, 0), (210, 0), (215, 0), (220, 0), (225, 0), (230, 0), (235, 0), (240, 0), (245, 1), (250, 0), (255, 0), (260, 0), (265, 0), (270, 0), (275, 0), (280, 0), (285, 1), (290, 1), (295, 1), (300, 1), (305, 1), (310, 1), (315, 1), (320, 1), (325, 1), (330, 1), (335, 1), (340, 1), (345, 1), (350, 1), (355, 1), (360, 1), (365, 1), (370, 1), (375, 1), (380, 0), (385, 0), (390, 0), (395, 1), (400, 0), (405, 0), (410, 0), (415, 0), (420, 0), (425, 0), (430, 0), (435, 0), (440, 0), (445, 0), (450, 0), (455, 0), (460, 0), (465, 1), (470, 1), (475, 1), (480, 1), (485, 1), (490, 1), (495, 1), (500, 1), (505, 0), (510, 0), (515, 0), (520, 1), (525, 1), (530, 1), (535, 1), (540, 1), (545, 1), (550, 1), (555, 1), (560, 1), (565, 1), (570, 1), (575, 1), (580, 1), (585, 0), (590, 0), (595, 0), (600, 0), (605, 0), (610, 0), (615, 0), (620, 0), (625, 0), (630, 0), (635, 0), (640, 0), (645, 0), (650, 0), (655, 0), (660, 0), (665, 0), (670, 0), (675, 0), (680, 0), (685, 0), (690, 1), (695, 1), (700, 1), (705, 1), (710, 1), (715, 1), (720, 1), (725, 1), (730, 1), (735, 0), (740, 0), (745, 0), (750, 0), (755, 0), (760, 1), (765, 0), (770, 1), (775, 1), (780, 1), (785, 1), (790, 1), (795, 1), (800, 1), (805, 1), (810, 0), (815, 0), (820, 0), (825, 0), (830, 1), (835, 1), (840, 1), (845, 1), (850, 1), (855, 1), (860, 1), (865, 1), (870, 1), (875, 1), (880, 1), (885, 1), (890, 1), (895, 1), (900, 1), (905, 0), (910, 0), (915, 0), (920, 0), (925, 0), (930, 0), (935, 0), (940, 0), (945, 1), (950, 1), (955, 1), (960, 1), (965, 1), (970, 1), (975, 1), (980, 1), (985, 1), (990, 1), (995, 1), (1000, 1), (1005, 1), (1010, 1), (1015, 1), (1020, 0), (1025, 0)]
Vdin1_55  din1_55  0 PWL (0n 0.0v 4.745n 0.0v 4.755n 0.0v 9.745n 0.0v 9.755n 0.0v 14.745n 0.0v 14.755n 0.0v 19.745n 0.0v 19.755n 0.0v 24.745n 0.0v 24.755n 0.0v 29.745n 0.0v 29.755n 0.0v 34.745n 0.0v 34.755n 0.0v 39.745n 0.0v 39.755n 0.0v 44.745n 0.0v 44.755n 0.0v 49.745n 0.0v 49.755n 0.0v 54.745n 0.0v 54.755n 0.0v 59.745n 0.0v 59.755n 0.0v 64.745n 0.0v 64.755n 0.0v 69.745n 0.0v 69.755n 0.0v 74.745n 0.0v 74.755n 0.0v 79.745n 0.0v 79.755n 1.0v 84.745n 1.0v 84.755n 1.0v 89.745n 1.0v 89.755n 1.0v 94.745n 1.0v 94.755n 1.0v 99.745n 1.0v 99.755n 1.0v 104.745n 1.0v 104.755n 1.0v 109.745n 1.0v 109.755n 1.0v 114.745n 1.0v 114.755n 1.0v 119.745n 1.0v 119.755n 1.0v 124.745n 1.0v 124.755n 1.0v 129.745n 1.0v 129.755n 1.0v 134.745n 1.0v 134.755n 1.0v 139.745n 1.0v 139.755n 1.0v 144.745n 1.0v 144.755n 0.0v 149.745n 0.0v 149.755n 0.0v 154.745n 0.0v 154.755n 0.0v 159.745n 0.0v 159.755n 0.0v 164.745n 0.0v 164.755n 0.0v 169.745n 0.0v 169.755n 0.0v 174.745n 0.0v 174.755n 0.0v 179.745n 0.0v 179.755n 0.0v 184.745n 0.0v 184.755n 0.0v 189.745n 0.0v 189.755n 0.0v 194.745n 0.0v 194.755n 0.0v 199.745n 0.0v 199.755n 0.0v 204.745n 0.0v 204.755n 0.0v 209.745n 0.0v 209.755n 0.0v 214.745n 0.0v 214.755n 0.0v 219.745n 0.0v 219.755n 0.0v 224.745n 0.0v 224.755n 0.0v 229.745n 0.0v 229.755n 0.0v 234.745n 0.0v 234.755n 0.0v 239.745n 0.0v 239.755n 0.0v 244.745n 0.0v 244.755n 1.0v 249.745n 1.0v 249.755n 0.0v 254.745n 0.0v 254.755n 0.0v 259.745n 0.0v 259.755n 0.0v 264.745n 0.0v 264.755n 0.0v 269.745n 0.0v 269.755n 0.0v 274.745n 0.0v 274.755n 0.0v 279.745n 0.0v 279.755n 0.0v 284.745n 0.0v 284.755n 1.0v 289.745n 1.0v 289.755n 1.0v 294.745n 1.0v 294.755n 1.0v 299.745n 1.0v 299.755n 1.0v 304.745n 1.0v 304.755n 1.0v 309.745n 1.0v 309.755n 1.0v 314.745n 1.0v 314.755n 1.0v 319.745n 1.0v 319.755n 1.0v 324.745n 1.0v 324.755n 1.0v 329.745n 1.0v 329.755n 1.0v 334.745n 1.0v 334.755n 1.0v 339.745n 1.0v 339.755n 1.0v 344.745n 1.0v 344.755n 1.0v 349.745n 1.0v 349.755n 1.0v 354.745n 1.0v 354.755n 1.0v 359.745n 1.0v 359.755n 1.0v 364.745n 1.0v 364.755n 1.0v 369.745n 1.0v 369.755n 1.0v 374.745n 1.0v 374.755n 1.0v 379.745n 1.0v 379.755n 0.0v 384.745n 0.0v 384.755n 0.0v 389.745n 0.0v 389.755n 0.0v 394.745n 0.0v 394.755n 1.0v 399.745n 1.0v 399.755n 0.0v 404.745n 0.0v 404.755n 0.0v 409.745n 0.0v 409.755n 0.0v 414.745n 0.0v 414.755n 0.0v 419.745n 0.0v 419.755n 0.0v 424.745n 0.0v 424.755n 0.0v 429.745n 0.0v 429.755n 0.0v 434.745n 0.0v 434.755n 0.0v 439.745n 0.0v 439.755n 0.0v 444.745n 0.0v 444.755n 0.0v 449.745n 0.0v 449.755n 0.0v 454.745n 0.0v 454.755n 0.0v 459.745n 0.0v 459.755n 0.0v 464.745n 0.0v 464.755n 1.0v 469.745n 1.0v 469.755n 1.0v 474.745n 1.0v 474.755n 1.0v 479.745n 1.0v 479.755n 1.0v 484.745n 1.0v 484.755n 1.0v 489.745n 1.0v 489.755n 1.0v 494.745n 1.0v 494.755n 1.0v 499.745n 1.0v 499.755n 1.0v 504.745n 1.0v 504.755n 0.0v 509.745n 0.0v 509.755n 0.0v 514.745n 0.0v 514.755n 0.0v 519.745n 0.0v 519.755n 1.0v 524.745n 1.0v 524.755n 1.0v 529.745n 1.0v 529.755n 1.0v 534.745n 1.0v 534.755n 1.0v 539.745n 1.0v 539.755n 1.0v 544.745n 1.0v 544.755n 1.0v 549.745n 1.0v 549.755n 1.0v 554.745n 1.0v 554.755n 1.0v 559.745n 1.0v 559.755n 1.0v 564.745n 1.0v 564.755n 1.0v 569.745n 1.0v 569.755n 1.0v 574.745n 1.0v 574.755n 1.0v 579.745n 1.0v 579.755n 1.0v 584.745n 1.0v 584.755n 0.0v 589.745n 0.0v 589.755n 0.0v 594.745n 0.0v 594.755n 0.0v 599.745n 0.0v 599.755n 0.0v 604.745n 0.0v 604.755n 0.0v 609.745n 0.0v 609.755n 0.0v 614.745n 0.0v 614.755n 0.0v 619.745n 0.0v 619.755n 0.0v 624.745n 0.0v 624.755n 0.0v 629.745n 0.0v 629.755n 0.0v 634.745n 0.0v 634.755n 0.0v 639.745n 0.0v 639.755n 0.0v 644.745n 0.0v 644.755n 0.0v 649.745n 0.0v 649.755n 0.0v 654.745n 0.0v 654.755n 0.0v 659.745n 0.0v 659.755n 0.0v 664.745n 0.0v 664.755n 0.0v 669.745n 0.0v 669.755n 0.0v 674.745n 0.0v 674.755n 0.0v 679.745n 0.0v 679.755n 0.0v 684.745n 0.0v 684.755n 0.0v 689.745n 0.0v 689.755n 1.0v 694.745n 1.0v 694.755n 1.0v 699.745n 1.0v 699.755n 1.0v 704.745n 1.0v 704.755n 1.0v 709.745n 1.0v 709.755n 1.0v 714.745n 1.0v 714.755n 1.0v 719.745n 1.0v 719.755n 1.0v 724.745n 1.0v 724.755n 1.0v 729.745n 1.0v 729.755n 1.0v 734.745n 1.0v 734.755n 0.0v 739.745n 0.0v 739.755n 0.0v 744.745n 0.0v 744.755n 0.0v 749.745n 0.0v 749.755n 0.0v 754.745n 0.0v 754.755n 0.0v 759.745n 0.0v 759.755n 1.0v 764.745n 1.0v 764.755n 0.0v 769.745n 0.0v 769.755n 1.0v 774.745n 1.0v 774.755n 1.0v 779.745n 1.0v 779.755n 1.0v 784.745n 1.0v 784.755n 1.0v 789.745n 1.0v 789.755n 1.0v 794.745n 1.0v 794.755n 1.0v 799.745n 1.0v 799.755n 1.0v 804.745n 1.0v 804.755n 1.0v 809.745n 1.0v 809.755n 0.0v 814.745n 0.0v 814.755n 0.0v 819.745n 0.0v 819.755n 0.0v 824.745n 0.0v 824.755n 0.0v 829.745n 0.0v 829.755n 1.0v 834.745n 1.0v 834.755n 1.0v 839.745n 1.0v 839.755n 1.0v 844.745n 1.0v 844.755n 1.0v 849.745n 1.0v 849.755n 1.0v 854.745n 1.0v 854.755n 1.0v 859.745n 1.0v 859.755n 1.0v 864.745n 1.0v 864.755n 1.0v 869.745n 1.0v 869.755n 1.0v 874.745n 1.0v 874.755n 1.0v 879.745n 1.0v 879.755n 1.0v 884.745n 1.0v 884.755n 1.0v 889.745n 1.0v 889.755n 1.0v 894.745n 1.0v 894.755n 1.0v 899.745n 1.0v 899.755n 1.0v 904.745n 1.0v 904.755n 0.0v 909.745n 0.0v 909.755n 0.0v 914.745n 0.0v 914.755n 0.0v 919.745n 0.0v 919.755n 0.0v 924.745n 0.0v 924.755n 0.0v 929.745n 0.0v 929.755n 0.0v 934.745n 0.0v 934.755n 0.0v 939.745n 0.0v 939.755n 0.0v 944.745n 0.0v 944.755n 1.0v 949.745n 1.0v 949.755n 1.0v 954.745n 1.0v 954.755n 1.0v 959.745n 1.0v 959.755n 1.0v 964.745n 1.0v 964.755n 1.0v 969.745n 1.0v 969.755n 1.0v 974.745n 1.0v 974.755n 1.0v 979.745n 1.0v 979.755n 1.0v 984.745n 1.0v 984.755n 1.0v 989.745n 1.0v 989.755n 1.0v 994.745n 1.0v 994.755n 1.0v 999.745n 1.0v 999.755n 1.0v 1004.745n 1.0v 1004.755n 1.0v 1009.745n 1.0v 1009.755n 1.0v 1014.745n 1.0v 1014.755n 1.0v 1019.745n 1.0v 1019.755n 0.0v 1024.745n 0.0v 1024.755n 0.0v )
* (time, data): [(0, 0), (5, 1), (10, 0), (15, 0), (20, 0), (25, 0), (30, 0), (35, 0), (40, 0), (45, 0), (50, 0), (55, 0), (60, 1), (65, 1), (70, 1), (75, 1), (80, 1), (85, 1), (90, 0), (95, 0), (100, 0), (105, 0), (110, 0), (115, 0), (120, 0), (125, 0), (130, 1), (135, 1), (140, 1), (145, 1), (150, 1), (155, 1), (160, 1), (165, 1), (170, 1), (175, 1), (180, 1), (185, 1), (190, 1), (195, 1), (200, 1), (205, 1), (210, 1), (215, 1), (220, 1), (225, 1), (230, 1), (235, 1), (240, 1), (245, 0), (250, 1), (255, 1), (260, 1), (265, 1), (270, 1), (275, 1), (280, 1), (285, 0), (290, 0), (295, 0), (300, 0), (305, 0), (310, 0), (315, 0), (320, 0), (325, 0), (330, 0), (335, 0), (340, 0), (345, 0), (350, 0), (355, 0), (360, 0), (365, 1), (370, 1), (375, 1), (380, 1), (385, 1), (390, 0), (395, 0), (400, 1), (405, 1), (410, 1), (415, 1), (420, 0), (425, 0), (430, 0), (435, 0), (440, 0), (445, 0), (450, 0), (455, 0), (460, 0), (465, 0), (470, 0), (475, 0), (480, 0), (485, 0), (490, 0), (495, 0), (500, 0), (505, 0), (510, 0), (515, 0), (520, 1), (525, 1), (530, 1), (535, 1), (540, 1), (545, 1), (550, 1), (555, 1), (560, 1), (565, 1), (570, 1), (575, 1), (580, 1), (585, 1), (590, 1), (595, 1), (600, 1), (605, 1), (610, 1), (615, 1), (620, 1), (625, 1), (630, 1), (635, 1), (640, 1), (645, 1), (650, 1), (655, 1), (660, 1), (665, 1), (670, 1), (675, 1), (680, 1), (685, 1), (690, 0), (695, 0), (700, 0), (705, 0), (710, 0), (715, 0), (720, 0), (725, 0), (730, 0), (735, 0), (740, 0), (745, 0), (750, 0), (755, 0), (760, 1), (765, 1), (770, 1), (775, 1), (780, 1), (785, 1), (790, 0), (795, 0), (800, 0), (805, 0), (810, 0), (815, 0), (820, 0), (825, 0), (830, 0), (835, 0), (840, 0), (845, 0), (850, 0), (855, 0), (860, 1), (865, 1), (870, 1), (875, 1), (880, 1), (885, 1), (890, 1), (895, 1), (900, 1), (905, 1), (910, 1), (915, 1), (920, 1), (925, 1), (930, 0), (935, 0), (940, 0), (945, 1), (950, 1), (955, 1), (960, 1), (965, 1), (970, 1), (975, 1), (980, 1), (985, 1), (990, 1), (995, 1), (1000, 1), (1005, 1), (1010, 1), (1015, 1), (1020, 0), (1025, 0)]
Vdin1_56  din1_56  0 PWL (0n 0.0v 4.745n 0.0v 4.755n 1.0v 9.745n 1.0v 9.755n 0.0v 14.745n 0.0v 14.755n 0.0v 19.745n 0.0v 19.755n 0.0v 24.745n 0.0v 24.755n 0.0v 29.745n 0.0v 29.755n 0.0v 34.745n 0.0v 34.755n 0.0v 39.745n 0.0v 39.755n 0.0v 44.745n 0.0v 44.755n 0.0v 49.745n 0.0v 49.755n 0.0v 54.745n 0.0v 54.755n 0.0v 59.745n 0.0v 59.755n 1.0v 64.745n 1.0v 64.755n 1.0v 69.745n 1.0v 69.755n 1.0v 74.745n 1.0v 74.755n 1.0v 79.745n 1.0v 79.755n 1.0v 84.745n 1.0v 84.755n 1.0v 89.745n 1.0v 89.755n 0.0v 94.745n 0.0v 94.755n 0.0v 99.745n 0.0v 99.755n 0.0v 104.745n 0.0v 104.755n 0.0v 109.745n 0.0v 109.755n 0.0v 114.745n 0.0v 114.755n 0.0v 119.745n 0.0v 119.755n 0.0v 124.745n 0.0v 124.755n 0.0v 129.745n 0.0v 129.755n 1.0v 134.745n 1.0v 134.755n 1.0v 139.745n 1.0v 139.755n 1.0v 144.745n 1.0v 144.755n 1.0v 149.745n 1.0v 149.755n 1.0v 154.745n 1.0v 154.755n 1.0v 159.745n 1.0v 159.755n 1.0v 164.745n 1.0v 164.755n 1.0v 169.745n 1.0v 169.755n 1.0v 174.745n 1.0v 174.755n 1.0v 179.745n 1.0v 179.755n 1.0v 184.745n 1.0v 184.755n 1.0v 189.745n 1.0v 189.755n 1.0v 194.745n 1.0v 194.755n 1.0v 199.745n 1.0v 199.755n 1.0v 204.745n 1.0v 204.755n 1.0v 209.745n 1.0v 209.755n 1.0v 214.745n 1.0v 214.755n 1.0v 219.745n 1.0v 219.755n 1.0v 224.745n 1.0v 224.755n 1.0v 229.745n 1.0v 229.755n 1.0v 234.745n 1.0v 234.755n 1.0v 239.745n 1.0v 239.755n 1.0v 244.745n 1.0v 244.755n 0.0v 249.745n 0.0v 249.755n 1.0v 254.745n 1.0v 254.755n 1.0v 259.745n 1.0v 259.755n 1.0v 264.745n 1.0v 264.755n 1.0v 269.745n 1.0v 269.755n 1.0v 274.745n 1.0v 274.755n 1.0v 279.745n 1.0v 279.755n 1.0v 284.745n 1.0v 284.755n 0.0v 289.745n 0.0v 289.755n 0.0v 294.745n 0.0v 294.755n 0.0v 299.745n 0.0v 299.755n 0.0v 304.745n 0.0v 304.755n 0.0v 309.745n 0.0v 309.755n 0.0v 314.745n 0.0v 314.755n 0.0v 319.745n 0.0v 319.755n 0.0v 324.745n 0.0v 324.755n 0.0v 329.745n 0.0v 329.755n 0.0v 334.745n 0.0v 334.755n 0.0v 339.745n 0.0v 339.755n 0.0v 344.745n 0.0v 344.755n 0.0v 349.745n 0.0v 349.755n 0.0v 354.745n 0.0v 354.755n 0.0v 359.745n 0.0v 359.755n 0.0v 364.745n 0.0v 364.755n 1.0v 369.745n 1.0v 369.755n 1.0v 374.745n 1.0v 374.755n 1.0v 379.745n 1.0v 379.755n 1.0v 384.745n 1.0v 384.755n 1.0v 389.745n 1.0v 389.755n 0.0v 394.745n 0.0v 394.755n 0.0v 399.745n 0.0v 399.755n 1.0v 404.745n 1.0v 404.755n 1.0v 409.745n 1.0v 409.755n 1.0v 414.745n 1.0v 414.755n 1.0v 419.745n 1.0v 419.755n 0.0v 424.745n 0.0v 424.755n 0.0v 429.745n 0.0v 429.755n 0.0v 434.745n 0.0v 434.755n 0.0v 439.745n 0.0v 439.755n 0.0v 444.745n 0.0v 444.755n 0.0v 449.745n 0.0v 449.755n 0.0v 454.745n 0.0v 454.755n 0.0v 459.745n 0.0v 459.755n 0.0v 464.745n 0.0v 464.755n 0.0v 469.745n 0.0v 469.755n 0.0v 474.745n 0.0v 474.755n 0.0v 479.745n 0.0v 479.755n 0.0v 484.745n 0.0v 484.755n 0.0v 489.745n 0.0v 489.755n 0.0v 494.745n 0.0v 494.755n 0.0v 499.745n 0.0v 499.755n 0.0v 504.745n 0.0v 504.755n 0.0v 509.745n 0.0v 509.755n 0.0v 514.745n 0.0v 514.755n 0.0v 519.745n 0.0v 519.755n 1.0v 524.745n 1.0v 524.755n 1.0v 529.745n 1.0v 529.755n 1.0v 534.745n 1.0v 534.755n 1.0v 539.745n 1.0v 539.755n 1.0v 544.745n 1.0v 544.755n 1.0v 549.745n 1.0v 549.755n 1.0v 554.745n 1.0v 554.755n 1.0v 559.745n 1.0v 559.755n 1.0v 564.745n 1.0v 564.755n 1.0v 569.745n 1.0v 569.755n 1.0v 574.745n 1.0v 574.755n 1.0v 579.745n 1.0v 579.755n 1.0v 584.745n 1.0v 584.755n 1.0v 589.745n 1.0v 589.755n 1.0v 594.745n 1.0v 594.755n 1.0v 599.745n 1.0v 599.755n 1.0v 604.745n 1.0v 604.755n 1.0v 609.745n 1.0v 609.755n 1.0v 614.745n 1.0v 614.755n 1.0v 619.745n 1.0v 619.755n 1.0v 624.745n 1.0v 624.755n 1.0v 629.745n 1.0v 629.755n 1.0v 634.745n 1.0v 634.755n 1.0v 639.745n 1.0v 639.755n 1.0v 644.745n 1.0v 644.755n 1.0v 649.745n 1.0v 649.755n 1.0v 654.745n 1.0v 654.755n 1.0v 659.745n 1.0v 659.755n 1.0v 664.745n 1.0v 664.755n 1.0v 669.745n 1.0v 669.755n 1.0v 674.745n 1.0v 674.755n 1.0v 679.745n 1.0v 679.755n 1.0v 684.745n 1.0v 684.755n 1.0v 689.745n 1.0v 689.755n 0.0v 694.745n 0.0v 694.755n 0.0v 699.745n 0.0v 699.755n 0.0v 704.745n 0.0v 704.755n 0.0v 709.745n 0.0v 709.755n 0.0v 714.745n 0.0v 714.755n 0.0v 719.745n 0.0v 719.755n 0.0v 724.745n 0.0v 724.755n 0.0v 729.745n 0.0v 729.755n 0.0v 734.745n 0.0v 734.755n 0.0v 739.745n 0.0v 739.755n 0.0v 744.745n 0.0v 744.755n 0.0v 749.745n 0.0v 749.755n 0.0v 754.745n 0.0v 754.755n 0.0v 759.745n 0.0v 759.755n 1.0v 764.745n 1.0v 764.755n 1.0v 769.745n 1.0v 769.755n 1.0v 774.745n 1.0v 774.755n 1.0v 779.745n 1.0v 779.755n 1.0v 784.745n 1.0v 784.755n 1.0v 789.745n 1.0v 789.755n 0.0v 794.745n 0.0v 794.755n 0.0v 799.745n 0.0v 799.755n 0.0v 804.745n 0.0v 804.755n 0.0v 809.745n 0.0v 809.755n 0.0v 814.745n 0.0v 814.755n 0.0v 819.745n 0.0v 819.755n 0.0v 824.745n 0.0v 824.755n 0.0v 829.745n 0.0v 829.755n 0.0v 834.745n 0.0v 834.755n 0.0v 839.745n 0.0v 839.755n 0.0v 844.745n 0.0v 844.755n 0.0v 849.745n 0.0v 849.755n 0.0v 854.745n 0.0v 854.755n 0.0v 859.745n 0.0v 859.755n 1.0v 864.745n 1.0v 864.755n 1.0v 869.745n 1.0v 869.755n 1.0v 874.745n 1.0v 874.755n 1.0v 879.745n 1.0v 879.755n 1.0v 884.745n 1.0v 884.755n 1.0v 889.745n 1.0v 889.755n 1.0v 894.745n 1.0v 894.755n 1.0v 899.745n 1.0v 899.755n 1.0v 904.745n 1.0v 904.755n 1.0v 909.745n 1.0v 909.755n 1.0v 914.745n 1.0v 914.755n 1.0v 919.745n 1.0v 919.755n 1.0v 924.745n 1.0v 924.755n 1.0v 929.745n 1.0v 929.755n 0.0v 934.745n 0.0v 934.755n 0.0v 939.745n 0.0v 939.755n 0.0v 944.745n 0.0v 944.755n 1.0v 949.745n 1.0v 949.755n 1.0v 954.745n 1.0v 954.755n 1.0v 959.745n 1.0v 959.755n 1.0v 964.745n 1.0v 964.755n 1.0v 969.745n 1.0v 969.755n 1.0v 974.745n 1.0v 974.755n 1.0v 979.745n 1.0v 979.755n 1.0v 984.745n 1.0v 984.755n 1.0v 989.745n 1.0v 989.755n 1.0v 994.745n 1.0v 994.755n 1.0v 999.745n 1.0v 999.755n 1.0v 1004.745n 1.0v 1004.755n 1.0v 1009.745n 1.0v 1009.755n 1.0v 1014.745n 1.0v 1014.755n 1.0v 1019.745n 1.0v 1019.755n 0.0v 1024.745n 0.0v 1024.755n 0.0v )
* (time, data): [(0, 0), (5, 1), (10, 1), (15, 1), (20, 1), (25, 1), (30, 1), (35, 1), (40, 1), (45, 1), (50, 1), (55, 1), (60, 1), (65, 1), (70, 1), (75, 1), (80, 1), (85, 1), (90, 1), (95, 1), (100, 1), (105, 1), (110, 1), (115, 1), (120, 1), (125, 1), (130, 1), (135, 1), (140, 1), (145, 0), (150, 0), (155, 0), (160, 0), (165, 0), (170, 0), (175, 0), (180, 1), (185, 1), (190, 1), (195, 1), (200, 1), (205, 1), (210, 1), (215, 1), (220, 1), (225, 1), (230, 1), (235, 1), (240, 1), (245, 1), (250, 1), (255, 1), (260, 1), (265, 1), (270, 1), (275, 1), (280, 1), (285, 1), (290, 1), (295, 1), (300, 1), (305, 1), (310, 1), (315, 1), (320, 1), (325, 1), (330, 1), (335, 1), (340, 1), (345, 1), (350, 1), (355, 1), (360, 1), (365, 1), (370, 1), (375, 1), (380, 0), (385, 0), (390, 0), (395, 0), (400, 0), (405, 0), (410, 0), (415, 0), (420, 0), (425, 0), (430, 0), (435, 0), (440, 0), (445, 0), (450, 0), (455, 0), (460, 0), (465, 1), (470, 1), (475, 1), (480, 1), (485, 0), (490, 0), (495, 0), (500, 0), (505, 0), (510, 0), (515, 0), (520, 0), (525, 0), (530, 0), (535, 0), (540, 0), (545, 0), (550, 0), (555, 0), (560, 0), (565, 0), (570, 0), (575, 0), (580, 1), (585, 1), (590, 1), (595, 1), (600, 1), (605, 1), (610, 1), (615, 0), (620, 0), (625, 0), (630, 0), (635, 0), (640, 0), (645, 0), (650, 0), (655, 0), (660, 0), (665, 0), (670, 0), (675, 0), (680, 0), (685, 0), (690, 0), (695, 0), (700, 0), (705, 0), (710, 0), (715, 0), (720, 0), (725, 0), (730, 1), (735, 0), (740, 0), (745, 0), (750, 0), (755, 0), (760, 0), (765, 0), (770, 1), (775, 1), (780, 1), (785, 1), (790, 0), (795, 0), (800, 0), (805, 0), (810, 0), (815, 0), (820, 0), (825, 0), (830, 1), (835, 1), (840, 1), (845, 1), (850, 1), (855, 1), (860, 0), (865, 0), (870, 0), (875, 0), (880, 0), (885, 0), (890, 0), (895, 0), (900, 1), (905, 0), (910, 0), (915, 0), (920, 0), (925, 1), (930, 1), (935, 1), (940, 1), (945, 0), (950, 0), (955, 0), (960, 0), (965, 0), (970, 0), (975, 0), (980, 0), (985, 0), (990, 0), (995, 0), (1000, 1), (1005, 1), (1010, 1), (1015, 1), (1020, 1), (1025, 1)]
Vdin1_57  din1_57  0 PWL (0n 0.0v 4.745n 0.0v 4.755n 1.0v 9.745n 1.0v 9.755n 1.0v 14.745n 1.0v 14.755n 1.0v 19.745n 1.0v 19.755n 1.0v 24.745n 1.0v 24.755n 1.0v 29.745n 1.0v 29.755n 1.0v 34.745n 1.0v 34.755n 1.0v 39.745n 1.0v 39.755n 1.0v 44.745n 1.0v 44.755n 1.0v 49.745n 1.0v 49.755n 1.0v 54.745n 1.0v 54.755n 1.0v 59.745n 1.0v 59.755n 1.0v 64.745n 1.0v 64.755n 1.0v 69.745n 1.0v 69.755n 1.0v 74.745n 1.0v 74.755n 1.0v 79.745n 1.0v 79.755n 1.0v 84.745n 1.0v 84.755n 1.0v 89.745n 1.0v 89.755n 1.0v 94.745n 1.0v 94.755n 1.0v 99.745n 1.0v 99.755n 1.0v 104.745n 1.0v 104.755n 1.0v 109.745n 1.0v 109.755n 1.0v 114.745n 1.0v 114.755n 1.0v 119.745n 1.0v 119.755n 1.0v 124.745n 1.0v 124.755n 1.0v 129.745n 1.0v 129.755n 1.0v 134.745n 1.0v 134.755n 1.0v 139.745n 1.0v 139.755n 1.0v 144.745n 1.0v 144.755n 0.0v 149.745n 0.0v 149.755n 0.0v 154.745n 0.0v 154.755n 0.0v 159.745n 0.0v 159.755n 0.0v 164.745n 0.0v 164.755n 0.0v 169.745n 0.0v 169.755n 0.0v 174.745n 0.0v 174.755n 0.0v 179.745n 0.0v 179.755n 1.0v 184.745n 1.0v 184.755n 1.0v 189.745n 1.0v 189.755n 1.0v 194.745n 1.0v 194.755n 1.0v 199.745n 1.0v 199.755n 1.0v 204.745n 1.0v 204.755n 1.0v 209.745n 1.0v 209.755n 1.0v 214.745n 1.0v 214.755n 1.0v 219.745n 1.0v 219.755n 1.0v 224.745n 1.0v 224.755n 1.0v 229.745n 1.0v 229.755n 1.0v 234.745n 1.0v 234.755n 1.0v 239.745n 1.0v 239.755n 1.0v 244.745n 1.0v 244.755n 1.0v 249.745n 1.0v 249.755n 1.0v 254.745n 1.0v 254.755n 1.0v 259.745n 1.0v 259.755n 1.0v 264.745n 1.0v 264.755n 1.0v 269.745n 1.0v 269.755n 1.0v 274.745n 1.0v 274.755n 1.0v 279.745n 1.0v 279.755n 1.0v 284.745n 1.0v 284.755n 1.0v 289.745n 1.0v 289.755n 1.0v 294.745n 1.0v 294.755n 1.0v 299.745n 1.0v 299.755n 1.0v 304.745n 1.0v 304.755n 1.0v 309.745n 1.0v 309.755n 1.0v 314.745n 1.0v 314.755n 1.0v 319.745n 1.0v 319.755n 1.0v 324.745n 1.0v 324.755n 1.0v 329.745n 1.0v 329.755n 1.0v 334.745n 1.0v 334.755n 1.0v 339.745n 1.0v 339.755n 1.0v 344.745n 1.0v 344.755n 1.0v 349.745n 1.0v 349.755n 1.0v 354.745n 1.0v 354.755n 1.0v 359.745n 1.0v 359.755n 1.0v 364.745n 1.0v 364.755n 1.0v 369.745n 1.0v 369.755n 1.0v 374.745n 1.0v 374.755n 1.0v 379.745n 1.0v 379.755n 0.0v 384.745n 0.0v 384.755n 0.0v 389.745n 0.0v 389.755n 0.0v 394.745n 0.0v 394.755n 0.0v 399.745n 0.0v 399.755n 0.0v 404.745n 0.0v 404.755n 0.0v 409.745n 0.0v 409.755n 0.0v 414.745n 0.0v 414.755n 0.0v 419.745n 0.0v 419.755n 0.0v 424.745n 0.0v 424.755n 0.0v 429.745n 0.0v 429.755n 0.0v 434.745n 0.0v 434.755n 0.0v 439.745n 0.0v 439.755n 0.0v 444.745n 0.0v 444.755n 0.0v 449.745n 0.0v 449.755n 0.0v 454.745n 0.0v 454.755n 0.0v 459.745n 0.0v 459.755n 0.0v 464.745n 0.0v 464.755n 1.0v 469.745n 1.0v 469.755n 1.0v 474.745n 1.0v 474.755n 1.0v 479.745n 1.0v 479.755n 1.0v 484.745n 1.0v 484.755n 0.0v 489.745n 0.0v 489.755n 0.0v 494.745n 0.0v 494.755n 0.0v 499.745n 0.0v 499.755n 0.0v 504.745n 0.0v 504.755n 0.0v 509.745n 0.0v 509.755n 0.0v 514.745n 0.0v 514.755n 0.0v 519.745n 0.0v 519.755n 0.0v 524.745n 0.0v 524.755n 0.0v 529.745n 0.0v 529.755n 0.0v 534.745n 0.0v 534.755n 0.0v 539.745n 0.0v 539.755n 0.0v 544.745n 0.0v 544.755n 0.0v 549.745n 0.0v 549.755n 0.0v 554.745n 0.0v 554.755n 0.0v 559.745n 0.0v 559.755n 0.0v 564.745n 0.0v 564.755n 0.0v 569.745n 0.0v 569.755n 0.0v 574.745n 0.0v 574.755n 0.0v 579.745n 0.0v 579.755n 1.0v 584.745n 1.0v 584.755n 1.0v 589.745n 1.0v 589.755n 1.0v 594.745n 1.0v 594.755n 1.0v 599.745n 1.0v 599.755n 1.0v 604.745n 1.0v 604.755n 1.0v 609.745n 1.0v 609.755n 1.0v 614.745n 1.0v 614.755n 0.0v 619.745n 0.0v 619.755n 0.0v 624.745n 0.0v 624.755n 0.0v 629.745n 0.0v 629.755n 0.0v 634.745n 0.0v 634.755n 0.0v 639.745n 0.0v 639.755n 0.0v 644.745n 0.0v 644.755n 0.0v 649.745n 0.0v 649.755n 0.0v 654.745n 0.0v 654.755n 0.0v 659.745n 0.0v 659.755n 0.0v 664.745n 0.0v 664.755n 0.0v 669.745n 0.0v 669.755n 0.0v 674.745n 0.0v 674.755n 0.0v 679.745n 0.0v 679.755n 0.0v 684.745n 0.0v 684.755n 0.0v 689.745n 0.0v 689.755n 0.0v 694.745n 0.0v 694.755n 0.0v 699.745n 0.0v 699.755n 0.0v 704.745n 0.0v 704.755n 0.0v 709.745n 0.0v 709.755n 0.0v 714.745n 0.0v 714.755n 0.0v 719.745n 0.0v 719.755n 0.0v 724.745n 0.0v 724.755n 0.0v 729.745n 0.0v 729.755n 1.0v 734.745n 1.0v 734.755n 0.0v 739.745n 0.0v 739.755n 0.0v 744.745n 0.0v 744.755n 0.0v 749.745n 0.0v 749.755n 0.0v 754.745n 0.0v 754.755n 0.0v 759.745n 0.0v 759.755n 0.0v 764.745n 0.0v 764.755n 0.0v 769.745n 0.0v 769.755n 1.0v 774.745n 1.0v 774.755n 1.0v 779.745n 1.0v 779.755n 1.0v 784.745n 1.0v 784.755n 1.0v 789.745n 1.0v 789.755n 0.0v 794.745n 0.0v 794.755n 0.0v 799.745n 0.0v 799.755n 0.0v 804.745n 0.0v 804.755n 0.0v 809.745n 0.0v 809.755n 0.0v 814.745n 0.0v 814.755n 0.0v 819.745n 0.0v 819.755n 0.0v 824.745n 0.0v 824.755n 0.0v 829.745n 0.0v 829.755n 1.0v 834.745n 1.0v 834.755n 1.0v 839.745n 1.0v 839.755n 1.0v 844.745n 1.0v 844.755n 1.0v 849.745n 1.0v 849.755n 1.0v 854.745n 1.0v 854.755n 1.0v 859.745n 1.0v 859.755n 0.0v 864.745n 0.0v 864.755n 0.0v 869.745n 0.0v 869.755n 0.0v 874.745n 0.0v 874.755n 0.0v 879.745n 0.0v 879.755n 0.0v 884.745n 0.0v 884.755n 0.0v 889.745n 0.0v 889.755n 0.0v 894.745n 0.0v 894.755n 0.0v 899.745n 0.0v 899.755n 1.0v 904.745n 1.0v 904.755n 0.0v 909.745n 0.0v 909.755n 0.0v 914.745n 0.0v 914.755n 0.0v 919.745n 0.0v 919.755n 0.0v 924.745n 0.0v 924.755n 1.0v 929.745n 1.0v 929.755n 1.0v 934.745n 1.0v 934.755n 1.0v 939.745n 1.0v 939.755n 1.0v 944.745n 1.0v 944.755n 0.0v 949.745n 0.0v 949.755n 0.0v 954.745n 0.0v 954.755n 0.0v 959.745n 0.0v 959.755n 0.0v 964.745n 0.0v 964.755n 0.0v 969.745n 0.0v 969.755n 0.0v 974.745n 0.0v 974.755n 0.0v 979.745n 0.0v 979.755n 0.0v 984.745n 0.0v 984.755n 0.0v 989.745n 0.0v 989.755n 0.0v 994.745n 0.0v 994.755n 0.0v 999.745n 0.0v 999.755n 1.0v 1004.745n 1.0v 1004.755n 1.0v 1009.745n 1.0v 1009.755n 1.0v 1014.745n 1.0v 1014.755n 1.0v 1019.745n 1.0v 1019.755n 1.0v 1024.745n 1.0v 1024.755n 1.0v )
* (time, data): [(0, 0), (5, 1), (10, 0), (15, 1), (20, 1), (25, 1), (30, 1), (35, 1), (40, 1), (45, 1), (50, 1), (55, 1), (60, 0), (65, 0), (70, 0), (75, 0), (80, 1), (85, 1), (90, 0), (95, 0), (100, 0), (105, 0), (110, 0), (115, 0), (120, 0), (125, 0), (130, 0), (135, 0), (140, 0), (145, 0), (150, 0), (155, 0), (160, 0), (165, 0), (170, 0), (175, 1), (180, 1), (185, 1), (190, 1), (195, 1), (200, 1), (205, 1), (210, 1), (215, 1), (220, 1), (225, 1), (230, 1), (235, 1), (240, 1), (245, 1), (250, 0), (255, 0), (260, 0), (265, 0), (270, 0), (275, 0), (280, 0), (285, 0), (290, 0), (295, 0), (300, 1), (305, 1), (310, 1), (315, 1), (320, 1), (325, 1), (330, 1), (335, 1), (340, 1), (345, 1), (350, 1), (355, 1), (360, 1), (365, 1), (370, 1), (375, 1), (380, 1), (385, 1), (390, 0), (395, 1), (400, 0), (405, 0), (410, 0), (415, 0), (420, 0), (425, 0), (430, 0), (435, 0), (440, 0), (445, 0), (450, 0), (455, 0), (460, 0), (465, 1), (470, 1), (475, 1), (480, 1), (485, 1), (490, 1), (495, 1), (500, 1), (505, 1), (510, 1), (515, 1), (520, 1), (525, 1), (530, 1), (535, 1), (540, 1), (545, 1), (550, 1), (555, 1), (560, 1), (565, 1), (570, 1), (575, 1), (580, 1), (585, 1), (590, 1), (595, 1), (600, 1), (605, 0), (610, 0), (615, 0), (620, 0), (625, 0), (630, 0), (635, 0), (640, 0), (645, 0), (650, 0), (655, 0), (660, 0), (665, 0), (670, 0), (675, 0), (680, 0), (685, 0), (690, 1), (695, 1), (700, 1), (705, 1), (710, 1), (715, 1), (720, 1), (725, 1), (730, 0), (735, 0), (740, 0), (745, 0), (750, 0), (755, 0), (760, 1), (765, 0), (770, 0), (775, 0), (780, 0), (785, 0), (790, 0), (795, 0), (800, 0), (805, 0), (810, 0), (815, 0), (820, 0), (825, 0), (830, 0), (835, 0), (840, 0), (845, 0), (850, 0), (855, 0), (860, 1), (865, 1), (870, 1), (875, 1), (880, 0), (885, 0), (890, 0), (895, 0), (900, 0), (905, 0), (910, 0), (915, 0), (920, 0), (925, 1), (930, 1), (935, 1), (940, 1), (945, 0), (950, 0), (955, 0), (960, 0), (965, 0), (970, 0), (975, 0), (980, 0), (985, 0), (990, 0), (995, 0), (1000, 0), (1005, 0), (1010, 1), (1015, 1), (1020, 0), (1025, 0)]
Vdin1_58  din1_58  0 PWL (0n 0.0v 4.745n 0.0v 4.755n 1.0v 9.745n 1.0v 9.755n 0.0v 14.745n 0.0v 14.755n 1.0v 19.745n 1.0v 19.755n 1.0v 24.745n 1.0v 24.755n 1.0v 29.745n 1.0v 29.755n 1.0v 34.745n 1.0v 34.755n 1.0v 39.745n 1.0v 39.755n 1.0v 44.745n 1.0v 44.755n 1.0v 49.745n 1.0v 49.755n 1.0v 54.745n 1.0v 54.755n 1.0v 59.745n 1.0v 59.755n 0.0v 64.745n 0.0v 64.755n 0.0v 69.745n 0.0v 69.755n 0.0v 74.745n 0.0v 74.755n 0.0v 79.745n 0.0v 79.755n 1.0v 84.745n 1.0v 84.755n 1.0v 89.745n 1.0v 89.755n 0.0v 94.745n 0.0v 94.755n 0.0v 99.745n 0.0v 99.755n 0.0v 104.745n 0.0v 104.755n 0.0v 109.745n 0.0v 109.755n 0.0v 114.745n 0.0v 114.755n 0.0v 119.745n 0.0v 119.755n 0.0v 124.745n 0.0v 124.755n 0.0v 129.745n 0.0v 129.755n 0.0v 134.745n 0.0v 134.755n 0.0v 139.745n 0.0v 139.755n 0.0v 144.745n 0.0v 144.755n 0.0v 149.745n 0.0v 149.755n 0.0v 154.745n 0.0v 154.755n 0.0v 159.745n 0.0v 159.755n 0.0v 164.745n 0.0v 164.755n 0.0v 169.745n 0.0v 169.755n 0.0v 174.745n 0.0v 174.755n 1.0v 179.745n 1.0v 179.755n 1.0v 184.745n 1.0v 184.755n 1.0v 189.745n 1.0v 189.755n 1.0v 194.745n 1.0v 194.755n 1.0v 199.745n 1.0v 199.755n 1.0v 204.745n 1.0v 204.755n 1.0v 209.745n 1.0v 209.755n 1.0v 214.745n 1.0v 214.755n 1.0v 219.745n 1.0v 219.755n 1.0v 224.745n 1.0v 224.755n 1.0v 229.745n 1.0v 229.755n 1.0v 234.745n 1.0v 234.755n 1.0v 239.745n 1.0v 239.755n 1.0v 244.745n 1.0v 244.755n 1.0v 249.745n 1.0v 249.755n 0.0v 254.745n 0.0v 254.755n 0.0v 259.745n 0.0v 259.755n 0.0v 264.745n 0.0v 264.755n 0.0v 269.745n 0.0v 269.755n 0.0v 274.745n 0.0v 274.755n 0.0v 279.745n 0.0v 279.755n 0.0v 284.745n 0.0v 284.755n 0.0v 289.745n 0.0v 289.755n 0.0v 294.745n 0.0v 294.755n 0.0v 299.745n 0.0v 299.755n 1.0v 304.745n 1.0v 304.755n 1.0v 309.745n 1.0v 309.755n 1.0v 314.745n 1.0v 314.755n 1.0v 319.745n 1.0v 319.755n 1.0v 324.745n 1.0v 324.755n 1.0v 329.745n 1.0v 329.755n 1.0v 334.745n 1.0v 334.755n 1.0v 339.745n 1.0v 339.755n 1.0v 344.745n 1.0v 344.755n 1.0v 349.745n 1.0v 349.755n 1.0v 354.745n 1.0v 354.755n 1.0v 359.745n 1.0v 359.755n 1.0v 364.745n 1.0v 364.755n 1.0v 369.745n 1.0v 369.755n 1.0v 374.745n 1.0v 374.755n 1.0v 379.745n 1.0v 379.755n 1.0v 384.745n 1.0v 384.755n 1.0v 389.745n 1.0v 389.755n 0.0v 394.745n 0.0v 394.755n 1.0v 399.745n 1.0v 399.755n 0.0v 404.745n 0.0v 404.755n 0.0v 409.745n 0.0v 409.755n 0.0v 414.745n 0.0v 414.755n 0.0v 419.745n 0.0v 419.755n 0.0v 424.745n 0.0v 424.755n 0.0v 429.745n 0.0v 429.755n 0.0v 434.745n 0.0v 434.755n 0.0v 439.745n 0.0v 439.755n 0.0v 444.745n 0.0v 444.755n 0.0v 449.745n 0.0v 449.755n 0.0v 454.745n 0.0v 454.755n 0.0v 459.745n 0.0v 459.755n 0.0v 464.745n 0.0v 464.755n 1.0v 469.745n 1.0v 469.755n 1.0v 474.745n 1.0v 474.755n 1.0v 479.745n 1.0v 479.755n 1.0v 484.745n 1.0v 484.755n 1.0v 489.745n 1.0v 489.755n 1.0v 494.745n 1.0v 494.755n 1.0v 499.745n 1.0v 499.755n 1.0v 504.745n 1.0v 504.755n 1.0v 509.745n 1.0v 509.755n 1.0v 514.745n 1.0v 514.755n 1.0v 519.745n 1.0v 519.755n 1.0v 524.745n 1.0v 524.755n 1.0v 529.745n 1.0v 529.755n 1.0v 534.745n 1.0v 534.755n 1.0v 539.745n 1.0v 539.755n 1.0v 544.745n 1.0v 544.755n 1.0v 549.745n 1.0v 549.755n 1.0v 554.745n 1.0v 554.755n 1.0v 559.745n 1.0v 559.755n 1.0v 564.745n 1.0v 564.755n 1.0v 569.745n 1.0v 569.755n 1.0v 574.745n 1.0v 574.755n 1.0v 579.745n 1.0v 579.755n 1.0v 584.745n 1.0v 584.755n 1.0v 589.745n 1.0v 589.755n 1.0v 594.745n 1.0v 594.755n 1.0v 599.745n 1.0v 599.755n 1.0v 604.745n 1.0v 604.755n 0.0v 609.745n 0.0v 609.755n 0.0v 614.745n 0.0v 614.755n 0.0v 619.745n 0.0v 619.755n 0.0v 624.745n 0.0v 624.755n 0.0v 629.745n 0.0v 629.755n 0.0v 634.745n 0.0v 634.755n 0.0v 639.745n 0.0v 639.755n 0.0v 644.745n 0.0v 644.755n 0.0v 649.745n 0.0v 649.755n 0.0v 654.745n 0.0v 654.755n 0.0v 659.745n 0.0v 659.755n 0.0v 664.745n 0.0v 664.755n 0.0v 669.745n 0.0v 669.755n 0.0v 674.745n 0.0v 674.755n 0.0v 679.745n 0.0v 679.755n 0.0v 684.745n 0.0v 684.755n 0.0v 689.745n 0.0v 689.755n 1.0v 694.745n 1.0v 694.755n 1.0v 699.745n 1.0v 699.755n 1.0v 704.745n 1.0v 704.755n 1.0v 709.745n 1.0v 709.755n 1.0v 714.745n 1.0v 714.755n 1.0v 719.745n 1.0v 719.755n 1.0v 724.745n 1.0v 724.755n 1.0v 729.745n 1.0v 729.755n 0.0v 734.745n 0.0v 734.755n 0.0v 739.745n 0.0v 739.755n 0.0v 744.745n 0.0v 744.755n 0.0v 749.745n 0.0v 749.755n 0.0v 754.745n 0.0v 754.755n 0.0v 759.745n 0.0v 759.755n 1.0v 764.745n 1.0v 764.755n 0.0v 769.745n 0.0v 769.755n 0.0v 774.745n 0.0v 774.755n 0.0v 779.745n 0.0v 779.755n 0.0v 784.745n 0.0v 784.755n 0.0v 789.745n 0.0v 789.755n 0.0v 794.745n 0.0v 794.755n 0.0v 799.745n 0.0v 799.755n 0.0v 804.745n 0.0v 804.755n 0.0v 809.745n 0.0v 809.755n 0.0v 814.745n 0.0v 814.755n 0.0v 819.745n 0.0v 819.755n 0.0v 824.745n 0.0v 824.755n 0.0v 829.745n 0.0v 829.755n 0.0v 834.745n 0.0v 834.755n 0.0v 839.745n 0.0v 839.755n 0.0v 844.745n 0.0v 844.755n 0.0v 849.745n 0.0v 849.755n 0.0v 854.745n 0.0v 854.755n 0.0v 859.745n 0.0v 859.755n 1.0v 864.745n 1.0v 864.755n 1.0v 869.745n 1.0v 869.755n 1.0v 874.745n 1.0v 874.755n 1.0v 879.745n 1.0v 879.755n 0.0v 884.745n 0.0v 884.755n 0.0v 889.745n 0.0v 889.755n 0.0v 894.745n 0.0v 894.755n 0.0v 899.745n 0.0v 899.755n 0.0v 904.745n 0.0v 904.755n 0.0v 909.745n 0.0v 909.755n 0.0v 914.745n 0.0v 914.755n 0.0v 919.745n 0.0v 919.755n 0.0v 924.745n 0.0v 924.755n 1.0v 929.745n 1.0v 929.755n 1.0v 934.745n 1.0v 934.755n 1.0v 939.745n 1.0v 939.755n 1.0v 944.745n 1.0v 944.755n 0.0v 949.745n 0.0v 949.755n 0.0v 954.745n 0.0v 954.755n 0.0v 959.745n 0.0v 959.755n 0.0v 964.745n 0.0v 964.755n 0.0v 969.745n 0.0v 969.755n 0.0v 974.745n 0.0v 974.755n 0.0v 979.745n 0.0v 979.755n 0.0v 984.745n 0.0v 984.755n 0.0v 989.745n 0.0v 989.755n 0.0v 994.745n 0.0v 994.755n 0.0v 999.745n 0.0v 999.755n 0.0v 1004.745n 0.0v 1004.755n 0.0v 1009.745n 0.0v 1009.755n 1.0v 1014.745n 1.0v 1014.755n 1.0v 1019.745n 1.0v 1019.755n 0.0v 1024.745n 0.0v 1024.755n 0.0v )
* (time, data): [(0, 0), (5, 1), (10, 1), (15, 0), (20, 0), (25, 0), (30, 0), (35, 0), (40, 0), (45, 0), (50, 0), (55, 0), (60, 0), (65, 0), (70, 0), (75, 0), (80, 0), (85, 0), (90, 0), (95, 0), (100, 0), (105, 0), (110, 0), (115, 0), (120, 0), (125, 0), (130, 0), (135, 0), (140, 0), (145, 0), (150, 0), (155, 0), (160, 0), (165, 0), (170, 0), (175, 1), (180, 0), (185, 0), (190, 0), (195, 0), (200, 0), (205, 0), (210, 0), (215, 0), (220, 0), (225, 0), (230, 0), (235, 0), (240, 0), (245, 0), (250, 1), (255, 1), (260, 1), (265, 1), (270, 1), (275, 1), (280, 1), (285, 0), (290, 0), (295, 0), (300, 1), (305, 1), (310, 1), (315, 1), (320, 1), (325, 1), (330, 1), (335, 1), (340, 1), (345, 1), (350, 1), (355, 1), (360, 1), (365, 1), (370, 1), (375, 1), (380, 1), (385, 1), (390, 1), (395, 1), (400, 0), (405, 0), (410, 0), (415, 0), (420, 1), (425, 1), (430, 1), (435, 1), (440, 1), (445, 1), (450, 1), (455, 1), (460, 1), (465, 0), (470, 0), (475, 0), (480, 0), (485, 1), (490, 1), (495, 1), (500, 1), (505, 0), (510, 0), (515, 0), (520, 1), (525, 1), (530, 1), (535, 1), (540, 1), (545, 1), (550, 1), (555, 1), (560, 1), (565, 1), (570, 1), (575, 1), (580, 0), (585, 1), (590, 1), (595, 1), (600, 1), (605, 1), (610, 1), (615, 1), (620, 1), (625, 1), (630, 1), (635, 1), (640, 1), (645, 1), (650, 1), (655, 1), (660, 1), (665, 1), (670, 1), (675, 1), (680, 1), (685, 1), (690, 1), (695, 1), (700, 1), (705, 1), (710, 1), (715, 1), (720, 1), (725, 1), (730, 0), (735, 1), (740, 1), (745, 1), (750, 1), (755, 1), (760, 1), (765, 0), (770, 1), (775, 1), (780, 1), (785, 1), (790, 0), (795, 0), (800, 0), (805, 0), (810, 1), (815, 1), (820, 1), (825, 1), (830, 1), (835, 1), (840, 1), (845, 1), (850, 1), (855, 1), (860, 1), (865, 1), (870, 1), (875, 1), (880, 1), (885, 1), (890, 1), (895, 1), (900, 1), (905, 1), (910, 1), (915, 1), (920, 1), (925, 1), (930, 1), (935, 1), (940, 1), (945, 1), (950, 1), (955, 1), (960, 1), (965, 1), (970, 1), (975, 1), (980, 1), (985, 1), (990, 1), (995, 1), (1000, 0), (1005, 0), (1010, 1), (1015, 1), (1020, 1), (1025, 1)]
Vdin1_59  din1_59  0 PWL (0n 0.0v 4.745n 0.0v 4.755n 1.0v 9.745n 1.0v 9.755n 1.0v 14.745n 1.0v 14.755n 0.0v 19.745n 0.0v 19.755n 0.0v 24.745n 0.0v 24.755n 0.0v 29.745n 0.0v 29.755n 0.0v 34.745n 0.0v 34.755n 0.0v 39.745n 0.0v 39.755n 0.0v 44.745n 0.0v 44.755n 0.0v 49.745n 0.0v 49.755n 0.0v 54.745n 0.0v 54.755n 0.0v 59.745n 0.0v 59.755n 0.0v 64.745n 0.0v 64.755n 0.0v 69.745n 0.0v 69.755n 0.0v 74.745n 0.0v 74.755n 0.0v 79.745n 0.0v 79.755n 0.0v 84.745n 0.0v 84.755n 0.0v 89.745n 0.0v 89.755n 0.0v 94.745n 0.0v 94.755n 0.0v 99.745n 0.0v 99.755n 0.0v 104.745n 0.0v 104.755n 0.0v 109.745n 0.0v 109.755n 0.0v 114.745n 0.0v 114.755n 0.0v 119.745n 0.0v 119.755n 0.0v 124.745n 0.0v 124.755n 0.0v 129.745n 0.0v 129.755n 0.0v 134.745n 0.0v 134.755n 0.0v 139.745n 0.0v 139.755n 0.0v 144.745n 0.0v 144.755n 0.0v 149.745n 0.0v 149.755n 0.0v 154.745n 0.0v 154.755n 0.0v 159.745n 0.0v 159.755n 0.0v 164.745n 0.0v 164.755n 0.0v 169.745n 0.0v 169.755n 0.0v 174.745n 0.0v 174.755n 1.0v 179.745n 1.0v 179.755n 0.0v 184.745n 0.0v 184.755n 0.0v 189.745n 0.0v 189.755n 0.0v 194.745n 0.0v 194.755n 0.0v 199.745n 0.0v 199.755n 0.0v 204.745n 0.0v 204.755n 0.0v 209.745n 0.0v 209.755n 0.0v 214.745n 0.0v 214.755n 0.0v 219.745n 0.0v 219.755n 0.0v 224.745n 0.0v 224.755n 0.0v 229.745n 0.0v 229.755n 0.0v 234.745n 0.0v 234.755n 0.0v 239.745n 0.0v 239.755n 0.0v 244.745n 0.0v 244.755n 0.0v 249.745n 0.0v 249.755n 1.0v 254.745n 1.0v 254.755n 1.0v 259.745n 1.0v 259.755n 1.0v 264.745n 1.0v 264.755n 1.0v 269.745n 1.0v 269.755n 1.0v 274.745n 1.0v 274.755n 1.0v 279.745n 1.0v 279.755n 1.0v 284.745n 1.0v 284.755n 0.0v 289.745n 0.0v 289.755n 0.0v 294.745n 0.0v 294.755n 0.0v 299.745n 0.0v 299.755n 1.0v 304.745n 1.0v 304.755n 1.0v 309.745n 1.0v 309.755n 1.0v 314.745n 1.0v 314.755n 1.0v 319.745n 1.0v 319.755n 1.0v 324.745n 1.0v 324.755n 1.0v 329.745n 1.0v 329.755n 1.0v 334.745n 1.0v 334.755n 1.0v 339.745n 1.0v 339.755n 1.0v 344.745n 1.0v 344.755n 1.0v 349.745n 1.0v 349.755n 1.0v 354.745n 1.0v 354.755n 1.0v 359.745n 1.0v 359.755n 1.0v 364.745n 1.0v 364.755n 1.0v 369.745n 1.0v 369.755n 1.0v 374.745n 1.0v 374.755n 1.0v 379.745n 1.0v 379.755n 1.0v 384.745n 1.0v 384.755n 1.0v 389.745n 1.0v 389.755n 1.0v 394.745n 1.0v 394.755n 1.0v 399.745n 1.0v 399.755n 0.0v 404.745n 0.0v 404.755n 0.0v 409.745n 0.0v 409.755n 0.0v 414.745n 0.0v 414.755n 0.0v 419.745n 0.0v 419.755n 1.0v 424.745n 1.0v 424.755n 1.0v 429.745n 1.0v 429.755n 1.0v 434.745n 1.0v 434.755n 1.0v 439.745n 1.0v 439.755n 1.0v 444.745n 1.0v 444.755n 1.0v 449.745n 1.0v 449.755n 1.0v 454.745n 1.0v 454.755n 1.0v 459.745n 1.0v 459.755n 1.0v 464.745n 1.0v 464.755n 0.0v 469.745n 0.0v 469.755n 0.0v 474.745n 0.0v 474.755n 0.0v 479.745n 0.0v 479.755n 0.0v 484.745n 0.0v 484.755n 1.0v 489.745n 1.0v 489.755n 1.0v 494.745n 1.0v 494.755n 1.0v 499.745n 1.0v 499.755n 1.0v 504.745n 1.0v 504.755n 0.0v 509.745n 0.0v 509.755n 0.0v 514.745n 0.0v 514.755n 0.0v 519.745n 0.0v 519.755n 1.0v 524.745n 1.0v 524.755n 1.0v 529.745n 1.0v 529.755n 1.0v 534.745n 1.0v 534.755n 1.0v 539.745n 1.0v 539.755n 1.0v 544.745n 1.0v 544.755n 1.0v 549.745n 1.0v 549.755n 1.0v 554.745n 1.0v 554.755n 1.0v 559.745n 1.0v 559.755n 1.0v 564.745n 1.0v 564.755n 1.0v 569.745n 1.0v 569.755n 1.0v 574.745n 1.0v 574.755n 1.0v 579.745n 1.0v 579.755n 0.0v 584.745n 0.0v 584.755n 1.0v 589.745n 1.0v 589.755n 1.0v 594.745n 1.0v 594.755n 1.0v 599.745n 1.0v 599.755n 1.0v 604.745n 1.0v 604.755n 1.0v 609.745n 1.0v 609.755n 1.0v 614.745n 1.0v 614.755n 1.0v 619.745n 1.0v 619.755n 1.0v 624.745n 1.0v 624.755n 1.0v 629.745n 1.0v 629.755n 1.0v 634.745n 1.0v 634.755n 1.0v 639.745n 1.0v 639.755n 1.0v 644.745n 1.0v 644.755n 1.0v 649.745n 1.0v 649.755n 1.0v 654.745n 1.0v 654.755n 1.0v 659.745n 1.0v 659.755n 1.0v 664.745n 1.0v 664.755n 1.0v 669.745n 1.0v 669.755n 1.0v 674.745n 1.0v 674.755n 1.0v 679.745n 1.0v 679.755n 1.0v 684.745n 1.0v 684.755n 1.0v 689.745n 1.0v 689.755n 1.0v 694.745n 1.0v 694.755n 1.0v 699.745n 1.0v 699.755n 1.0v 704.745n 1.0v 704.755n 1.0v 709.745n 1.0v 709.755n 1.0v 714.745n 1.0v 714.755n 1.0v 719.745n 1.0v 719.755n 1.0v 724.745n 1.0v 724.755n 1.0v 729.745n 1.0v 729.755n 0.0v 734.745n 0.0v 734.755n 1.0v 739.745n 1.0v 739.755n 1.0v 744.745n 1.0v 744.755n 1.0v 749.745n 1.0v 749.755n 1.0v 754.745n 1.0v 754.755n 1.0v 759.745n 1.0v 759.755n 1.0v 764.745n 1.0v 764.755n 0.0v 769.745n 0.0v 769.755n 1.0v 774.745n 1.0v 774.755n 1.0v 779.745n 1.0v 779.755n 1.0v 784.745n 1.0v 784.755n 1.0v 789.745n 1.0v 789.755n 0.0v 794.745n 0.0v 794.755n 0.0v 799.745n 0.0v 799.755n 0.0v 804.745n 0.0v 804.755n 0.0v 809.745n 0.0v 809.755n 1.0v 814.745n 1.0v 814.755n 1.0v 819.745n 1.0v 819.755n 1.0v 824.745n 1.0v 824.755n 1.0v 829.745n 1.0v 829.755n 1.0v 834.745n 1.0v 834.755n 1.0v 839.745n 1.0v 839.755n 1.0v 844.745n 1.0v 844.755n 1.0v 849.745n 1.0v 849.755n 1.0v 854.745n 1.0v 854.755n 1.0v 859.745n 1.0v 859.755n 1.0v 864.745n 1.0v 864.755n 1.0v 869.745n 1.0v 869.755n 1.0v 874.745n 1.0v 874.755n 1.0v 879.745n 1.0v 879.755n 1.0v 884.745n 1.0v 884.755n 1.0v 889.745n 1.0v 889.755n 1.0v 894.745n 1.0v 894.755n 1.0v 899.745n 1.0v 899.755n 1.0v 904.745n 1.0v 904.755n 1.0v 909.745n 1.0v 909.755n 1.0v 914.745n 1.0v 914.755n 1.0v 919.745n 1.0v 919.755n 1.0v 924.745n 1.0v 924.755n 1.0v 929.745n 1.0v 929.755n 1.0v 934.745n 1.0v 934.755n 1.0v 939.745n 1.0v 939.755n 1.0v 944.745n 1.0v 944.755n 1.0v 949.745n 1.0v 949.755n 1.0v 954.745n 1.0v 954.755n 1.0v 959.745n 1.0v 959.755n 1.0v 964.745n 1.0v 964.755n 1.0v 969.745n 1.0v 969.755n 1.0v 974.745n 1.0v 974.755n 1.0v 979.745n 1.0v 979.755n 1.0v 984.745n 1.0v 984.755n 1.0v 989.745n 1.0v 989.755n 1.0v 994.745n 1.0v 994.755n 1.0v 999.745n 1.0v 999.755n 0.0v 1004.745n 0.0v 1004.755n 0.0v 1009.745n 0.0v 1009.755n 1.0v 1014.745n 1.0v 1014.755n 1.0v 1019.745n 1.0v 1019.755n 1.0v 1024.745n 1.0v 1024.755n 1.0v )
* (time, data): [(0, 0), (5, 0), (10, 1), (15, 1), (20, 1), (25, 1), (30, 1), (35, 1), (40, 1), (45, 1), (50, 1), (55, 1), (60, 1), (65, 1), (70, 1), (75, 1), (80, 0), (85, 0), (90, 0), (95, 0), (100, 0), (105, 0), (110, 0), (115, 0), (120, 0), (125, 0), (130, 1), (135, 1), (140, 1), (145, 1), (150, 1), (155, 1), (160, 1), (165, 1), (170, 1), (175, 1), (180, 0), (185, 0), (190, 0), (195, 0), (200, 0), (205, 0), (210, 0), (215, 0), (220, 0), (225, 0), (230, 0), (235, 0), (240, 0), (245, 1), (250, 0), (255, 0), (260, 0), (265, 0), (270, 0), (275, 0), (280, 0), (285, 1), (290, 1), (295, 1), (300, 1), (305, 1), (310, 1), (315, 1), (320, 1), (325, 1), (330, 1), (335, 1), (340, 1), (345, 1), (350, 1), (355, 1), (360, 1), (365, 1), (370, 1), (375, 1), (380, 1), (385, 1), (390, 0), (395, 1), (400, 1), (405, 1), (410, 1), (415, 1), (420, 1), (425, 1), (430, 1), (435, 1), (440, 1), (445, 1), (450, 1), (455, 1), (460, 1), (465, 0), (470, 0), (475, 0), (480, 0), (485, 1), (490, 1), (495, 1), (500, 1), (505, 1), (510, 1), (515, 1), (520, 0), (525, 0), (530, 0), (535, 0), (540, 0), (545, 0), (550, 0), (555, 0), (560, 0), (565, 0), (570, 0), (575, 0), (580, 1), (585, 1), (590, 1), (595, 1), (600, 1), (605, 1), (610, 1), (615, 0), (620, 0), (625, 0), (630, 0), (635, 0), (640, 0), (645, 0), (650, 0), (655, 0), (660, 0), (665, 0), (670, 0), (675, 0), (680, 0), (685, 0), (690, 0), (695, 0), (700, 0), (705, 0), (710, 0), (715, 0), (720, 0), (725, 0), (730, 0), (735, 0), (740, 0), (745, 0), (750, 0), (755, 0), (760, 0), (765, 1), (770, 1), (775, 1), (780, 1), (785, 1), (790, 0), (795, 0), (800, 0), (805, 0), (810, 1), (815, 1), (820, 1), (825, 1), (830, 0), (835, 0), (840, 0), (845, 0), (850, 0), (855, 0), (860, 1), (865, 1), (870, 1), (875, 1), (880, 0), (885, 0), (890, 0), (895, 0), (900, 1), (905, 1), (910, 1), (915, 1), (920, 1), (925, 1), (930, 0), (935, 0), (940, 0), (945, 0), (950, 0), (955, 0), (960, 0), (965, 0), (970, 0), (975, 0), (980, 0), (985, 0), (990, 0), (995, 0), (1000, 1), (1005, 1), (1010, 0), (1015, 0), (1020, 1), (1025, 1)]
Vdin1_60  din1_60  0 PWL (0n 0.0v 4.745n 0.0v 4.755n 0.0v 9.745n 0.0v 9.755n 1.0v 14.745n 1.0v 14.755n 1.0v 19.745n 1.0v 19.755n 1.0v 24.745n 1.0v 24.755n 1.0v 29.745n 1.0v 29.755n 1.0v 34.745n 1.0v 34.755n 1.0v 39.745n 1.0v 39.755n 1.0v 44.745n 1.0v 44.755n 1.0v 49.745n 1.0v 49.755n 1.0v 54.745n 1.0v 54.755n 1.0v 59.745n 1.0v 59.755n 1.0v 64.745n 1.0v 64.755n 1.0v 69.745n 1.0v 69.755n 1.0v 74.745n 1.0v 74.755n 1.0v 79.745n 1.0v 79.755n 0.0v 84.745n 0.0v 84.755n 0.0v 89.745n 0.0v 89.755n 0.0v 94.745n 0.0v 94.755n 0.0v 99.745n 0.0v 99.755n 0.0v 104.745n 0.0v 104.755n 0.0v 109.745n 0.0v 109.755n 0.0v 114.745n 0.0v 114.755n 0.0v 119.745n 0.0v 119.755n 0.0v 124.745n 0.0v 124.755n 0.0v 129.745n 0.0v 129.755n 1.0v 134.745n 1.0v 134.755n 1.0v 139.745n 1.0v 139.755n 1.0v 144.745n 1.0v 144.755n 1.0v 149.745n 1.0v 149.755n 1.0v 154.745n 1.0v 154.755n 1.0v 159.745n 1.0v 159.755n 1.0v 164.745n 1.0v 164.755n 1.0v 169.745n 1.0v 169.755n 1.0v 174.745n 1.0v 174.755n 1.0v 179.745n 1.0v 179.755n 0.0v 184.745n 0.0v 184.755n 0.0v 189.745n 0.0v 189.755n 0.0v 194.745n 0.0v 194.755n 0.0v 199.745n 0.0v 199.755n 0.0v 204.745n 0.0v 204.755n 0.0v 209.745n 0.0v 209.755n 0.0v 214.745n 0.0v 214.755n 0.0v 219.745n 0.0v 219.755n 0.0v 224.745n 0.0v 224.755n 0.0v 229.745n 0.0v 229.755n 0.0v 234.745n 0.0v 234.755n 0.0v 239.745n 0.0v 239.755n 0.0v 244.745n 0.0v 244.755n 1.0v 249.745n 1.0v 249.755n 0.0v 254.745n 0.0v 254.755n 0.0v 259.745n 0.0v 259.755n 0.0v 264.745n 0.0v 264.755n 0.0v 269.745n 0.0v 269.755n 0.0v 274.745n 0.0v 274.755n 0.0v 279.745n 0.0v 279.755n 0.0v 284.745n 0.0v 284.755n 1.0v 289.745n 1.0v 289.755n 1.0v 294.745n 1.0v 294.755n 1.0v 299.745n 1.0v 299.755n 1.0v 304.745n 1.0v 304.755n 1.0v 309.745n 1.0v 309.755n 1.0v 314.745n 1.0v 314.755n 1.0v 319.745n 1.0v 319.755n 1.0v 324.745n 1.0v 324.755n 1.0v 329.745n 1.0v 329.755n 1.0v 334.745n 1.0v 334.755n 1.0v 339.745n 1.0v 339.755n 1.0v 344.745n 1.0v 344.755n 1.0v 349.745n 1.0v 349.755n 1.0v 354.745n 1.0v 354.755n 1.0v 359.745n 1.0v 359.755n 1.0v 364.745n 1.0v 364.755n 1.0v 369.745n 1.0v 369.755n 1.0v 374.745n 1.0v 374.755n 1.0v 379.745n 1.0v 379.755n 1.0v 384.745n 1.0v 384.755n 1.0v 389.745n 1.0v 389.755n 0.0v 394.745n 0.0v 394.755n 1.0v 399.745n 1.0v 399.755n 1.0v 404.745n 1.0v 404.755n 1.0v 409.745n 1.0v 409.755n 1.0v 414.745n 1.0v 414.755n 1.0v 419.745n 1.0v 419.755n 1.0v 424.745n 1.0v 424.755n 1.0v 429.745n 1.0v 429.755n 1.0v 434.745n 1.0v 434.755n 1.0v 439.745n 1.0v 439.755n 1.0v 444.745n 1.0v 444.755n 1.0v 449.745n 1.0v 449.755n 1.0v 454.745n 1.0v 454.755n 1.0v 459.745n 1.0v 459.755n 1.0v 464.745n 1.0v 464.755n 0.0v 469.745n 0.0v 469.755n 0.0v 474.745n 0.0v 474.755n 0.0v 479.745n 0.0v 479.755n 0.0v 484.745n 0.0v 484.755n 1.0v 489.745n 1.0v 489.755n 1.0v 494.745n 1.0v 494.755n 1.0v 499.745n 1.0v 499.755n 1.0v 504.745n 1.0v 504.755n 1.0v 509.745n 1.0v 509.755n 1.0v 514.745n 1.0v 514.755n 1.0v 519.745n 1.0v 519.755n 0.0v 524.745n 0.0v 524.755n 0.0v 529.745n 0.0v 529.755n 0.0v 534.745n 0.0v 534.755n 0.0v 539.745n 0.0v 539.755n 0.0v 544.745n 0.0v 544.755n 0.0v 549.745n 0.0v 549.755n 0.0v 554.745n 0.0v 554.755n 0.0v 559.745n 0.0v 559.755n 0.0v 564.745n 0.0v 564.755n 0.0v 569.745n 0.0v 569.755n 0.0v 574.745n 0.0v 574.755n 0.0v 579.745n 0.0v 579.755n 1.0v 584.745n 1.0v 584.755n 1.0v 589.745n 1.0v 589.755n 1.0v 594.745n 1.0v 594.755n 1.0v 599.745n 1.0v 599.755n 1.0v 604.745n 1.0v 604.755n 1.0v 609.745n 1.0v 609.755n 1.0v 614.745n 1.0v 614.755n 0.0v 619.745n 0.0v 619.755n 0.0v 624.745n 0.0v 624.755n 0.0v 629.745n 0.0v 629.755n 0.0v 634.745n 0.0v 634.755n 0.0v 639.745n 0.0v 639.755n 0.0v 644.745n 0.0v 644.755n 0.0v 649.745n 0.0v 649.755n 0.0v 654.745n 0.0v 654.755n 0.0v 659.745n 0.0v 659.755n 0.0v 664.745n 0.0v 664.755n 0.0v 669.745n 0.0v 669.755n 0.0v 674.745n 0.0v 674.755n 0.0v 679.745n 0.0v 679.755n 0.0v 684.745n 0.0v 684.755n 0.0v 689.745n 0.0v 689.755n 0.0v 694.745n 0.0v 694.755n 0.0v 699.745n 0.0v 699.755n 0.0v 704.745n 0.0v 704.755n 0.0v 709.745n 0.0v 709.755n 0.0v 714.745n 0.0v 714.755n 0.0v 719.745n 0.0v 719.755n 0.0v 724.745n 0.0v 724.755n 0.0v 729.745n 0.0v 729.755n 0.0v 734.745n 0.0v 734.755n 0.0v 739.745n 0.0v 739.755n 0.0v 744.745n 0.0v 744.755n 0.0v 749.745n 0.0v 749.755n 0.0v 754.745n 0.0v 754.755n 0.0v 759.745n 0.0v 759.755n 0.0v 764.745n 0.0v 764.755n 1.0v 769.745n 1.0v 769.755n 1.0v 774.745n 1.0v 774.755n 1.0v 779.745n 1.0v 779.755n 1.0v 784.745n 1.0v 784.755n 1.0v 789.745n 1.0v 789.755n 0.0v 794.745n 0.0v 794.755n 0.0v 799.745n 0.0v 799.755n 0.0v 804.745n 0.0v 804.755n 0.0v 809.745n 0.0v 809.755n 1.0v 814.745n 1.0v 814.755n 1.0v 819.745n 1.0v 819.755n 1.0v 824.745n 1.0v 824.755n 1.0v 829.745n 1.0v 829.755n 0.0v 834.745n 0.0v 834.755n 0.0v 839.745n 0.0v 839.755n 0.0v 844.745n 0.0v 844.755n 0.0v 849.745n 0.0v 849.755n 0.0v 854.745n 0.0v 854.755n 0.0v 859.745n 0.0v 859.755n 1.0v 864.745n 1.0v 864.755n 1.0v 869.745n 1.0v 869.755n 1.0v 874.745n 1.0v 874.755n 1.0v 879.745n 1.0v 879.755n 0.0v 884.745n 0.0v 884.755n 0.0v 889.745n 0.0v 889.755n 0.0v 894.745n 0.0v 894.755n 0.0v 899.745n 0.0v 899.755n 1.0v 904.745n 1.0v 904.755n 1.0v 909.745n 1.0v 909.755n 1.0v 914.745n 1.0v 914.755n 1.0v 919.745n 1.0v 919.755n 1.0v 924.745n 1.0v 924.755n 1.0v 929.745n 1.0v 929.755n 0.0v 934.745n 0.0v 934.755n 0.0v 939.745n 0.0v 939.755n 0.0v 944.745n 0.0v 944.755n 0.0v 949.745n 0.0v 949.755n 0.0v 954.745n 0.0v 954.755n 0.0v 959.745n 0.0v 959.755n 0.0v 964.745n 0.0v 964.755n 0.0v 969.745n 0.0v 969.755n 0.0v 974.745n 0.0v 974.755n 0.0v 979.745n 0.0v 979.755n 0.0v 984.745n 0.0v 984.755n 0.0v 989.745n 0.0v 989.755n 0.0v 994.745n 0.0v 994.755n 0.0v 999.745n 0.0v 999.755n 1.0v 1004.745n 1.0v 1004.755n 1.0v 1009.745n 1.0v 1009.755n 0.0v 1014.745n 0.0v 1014.755n 0.0v 1019.745n 0.0v 1019.755n 1.0v 1024.745n 1.0v 1024.755n 1.0v )
* (time, data): [(0, 0), (5, 1), (10, 1), (15, 1), (20, 1), (25, 1), (30, 1), (35, 1), (40, 1), (45, 1), (50, 1), (55, 1), (60, 0), (65, 0), (70, 0), (75, 0), (80, 0), (85, 0), (90, 1), (95, 1), (100, 1), (105, 1), (110, 1), (115, 1), (120, 1), (125, 1), (130, 0), (135, 0), (140, 0), (145, 1), (150, 1), (155, 1), (160, 1), (165, 1), (170, 1), (175, 1), (180, 1), (185, 1), (190, 1), (195, 1), (200, 1), (205, 1), (210, 1), (215, 1), (220, 1), (225, 1), (230, 1), (235, 1), (240, 1), (245, 1), (250, 1), (255, 1), (260, 1), (265, 1), (270, 1), (275, 1), (280, 1), (285, 1), (290, 1), (295, 1), (300, 0), (305, 0), (310, 0), (315, 0), (320, 0), (325, 0), (330, 0), (335, 0), (340, 0), (345, 0), (350, 0), (355, 0), (360, 0), (365, 1), (370, 1), (375, 1), (380, 1), (385, 1), (390, 1), (395, 1), (400, 1), (405, 1), (410, 1), (415, 1), (420, 0), (425, 0), (430, 0), (435, 0), (440, 0), (445, 0), (450, 0), (455, 0), (460, 0), (465, 1), (470, 1), (475, 1), (480, 1), (485, 0), (490, 0), (495, 0), (500, 0), (505, 0), (510, 0), (515, 0), (520, 0), (525, 0), (530, 0), (535, 0), (540, 0), (545, 0), (550, 0), (555, 0), (560, 0), (565, 0), (570, 0), (575, 0), (580, 0), (585, 1), (590, 1), (595, 1), (600, 1), (605, 0), (610, 0), (615, 0), (620, 0), (625, 0), (630, 0), (635, 0), (640, 0), (645, 0), (650, 0), (655, 0), (660, 0), (665, 0), (670, 0), (675, 0), (680, 0), (685, 0), (690, 0), (695, 0), (700, 0), (705, 0), (710, 0), (715, 0), (720, 0), (725, 0), (730, 1), (735, 1), (740, 1), (745, 1), (750, 1), (755, 1), (760, 1), (765, 1), (770, 1), (775, 1), (780, 1), (785, 1), (790, 1), (795, 1), (800, 1), (805, 1), (810, 0), (815, 0), (820, 0), (825, 0), (830, 1), (835, 1), (840, 1), (845, 1), (850, 1), (855, 1), (860, 1), (865, 1), (870, 1), (875, 1), (880, 0), (885, 0), (890, 0), (895, 0), (900, 1), (905, 0), (910, 0), (915, 0), (920, 0), (925, 1), (930, 0), (935, 0), (940, 0), (945, 0), (950, 0), (955, 0), (960, 0), (965, 0), (970, 0), (975, 0), (980, 0), (985, 0), (990, 0), (995, 0), (1000, 1), (1005, 1), (1010, 1), (1015, 1), (1020, 1), (1025, 1)]
Vdin1_61  din1_61  0 PWL (0n 0.0v 4.745n 0.0v 4.755n 1.0v 9.745n 1.0v 9.755n 1.0v 14.745n 1.0v 14.755n 1.0v 19.745n 1.0v 19.755n 1.0v 24.745n 1.0v 24.755n 1.0v 29.745n 1.0v 29.755n 1.0v 34.745n 1.0v 34.755n 1.0v 39.745n 1.0v 39.755n 1.0v 44.745n 1.0v 44.755n 1.0v 49.745n 1.0v 49.755n 1.0v 54.745n 1.0v 54.755n 1.0v 59.745n 1.0v 59.755n 0.0v 64.745n 0.0v 64.755n 0.0v 69.745n 0.0v 69.755n 0.0v 74.745n 0.0v 74.755n 0.0v 79.745n 0.0v 79.755n 0.0v 84.745n 0.0v 84.755n 0.0v 89.745n 0.0v 89.755n 1.0v 94.745n 1.0v 94.755n 1.0v 99.745n 1.0v 99.755n 1.0v 104.745n 1.0v 104.755n 1.0v 109.745n 1.0v 109.755n 1.0v 114.745n 1.0v 114.755n 1.0v 119.745n 1.0v 119.755n 1.0v 124.745n 1.0v 124.755n 1.0v 129.745n 1.0v 129.755n 0.0v 134.745n 0.0v 134.755n 0.0v 139.745n 0.0v 139.755n 0.0v 144.745n 0.0v 144.755n 1.0v 149.745n 1.0v 149.755n 1.0v 154.745n 1.0v 154.755n 1.0v 159.745n 1.0v 159.755n 1.0v 164.745n 1.0v 164.755n 1.0v 169.745n 1.0v 169.755n 1.0v 174.745n 1.0v 174.755n 1.0v 179.745n 1.0v 179.755n 1.0v 184.745n 1.0v 184.755n 1.0v 189.745n 1.0v 189.755n 1.0v 194.745n 1.0v 194.755n 1.0v 199.745n 1.0v 199.755n 1.0v 204.745n 1.0v 204.755n 1.0v 209.745n 1.0v 209.755n 1.0v 214.745n 1.0v 214.755n 1.0v 219.745n 1.0v 219.755n 1.0v 224.745n 1.0v 224.755n 1.0v 229.745n 1.0v 229.755n 1.0v 234.745n 1.0v 234.755n 1.0v 239.745n 1.0v 239.755n 1.0v 244.745n 1.0v 244.755n 1.0v 249.745n 1.0v 249.755n 1.0v 254.745n 1.0v 254.755n 1.0v 259.745n 1.0v 259.755n 1.0v 264.745n 1.0v 264.755n 1.0v 269.745n 1.0v 269.755n 1.0v 274.745n 1.0v 274.755n 1.0v 279.745n 1.0v 279.755n 1.0v 284.745n 1.0v 284.755n 1.0v 289.745n 1.0v 289.755n 1.0v 294.745n 1.0v 294.755n 1.0v 299.745n 1.0v 299.755n 0.0v 304.745n 0.0v 304.755n 0.0v 309.745n 0.0v 309.755n 0.0v 314.745n 0.0v 314.755n 0.0v 319.745n 0.0v 319.755n 0.0v 324.745n 0.0v 324.755n 0.0v 329.745n 0.0v 329.755n 0.0v 334.745n 0.0v 334.755n 0.0v 339.745n 0.0v 339.755n 0.0v 344.745n 0.0v 344.755n 0.0v 349.745n 0.0v 349.755n 0.0v 354.745n 0.0v 354.755n 0.0v 359.745n 0.0v 359.755n 0.0v 364.745n 0.0v 364.755n 1.0v 369.745n 1.0v 369.755n 1.0v 374.745n 1.0v 374.755n 1.0v 379.745n 1.0v 379.755n 1.0v 384.745n 1.0v 384.755n 1.0v 389.745n 1.0v 389.755n 1.0v 394.745n 1.0v 394.755n 1.0v 399.745n 1.0v 399.755n 1.0v 404.745n 1.0v 404.755n 1.0v 409.745n 1.0v 409.755n 1.0v 414.745n 1.0v 414.755n 1.0v 419.745n 1.0v 419.755n 0.0v 424.745n 0.0v 424.755n 0.0v 429.745n 0.0v 429.755n 0.0v 434.745n 0.0v 434.755n 0.0v 439.745n 0.0v 439.755n 0.0v 444.745n 0.0v 444.755n 0.0v 449.745n 0.0v 449.755n 0.0v 454.745n 0.0v 454.755n 0.0v 459.745n 0.0v 459.755n 0.0v 464.745n 0.0v 464.755n 1.0v 469.745n 1.0v 469.755n 1.0v 474.745n 1.0v 474.755n 1.0v 479.745n 1.0v 479.755n 1.0v 484.745n 1.0v 484.755n 0.0v 489.745n 0.0v 489.755n 0.0v 494.745n 0.0v 494.755n 0.0v 499.745n 0.0v 499.755n 0.0v 504.745n 0.0v 504.755n 0.0v 509.745n 0.0v 509.755n 0.0v 514.745n 0.0v 514.755n 0.0v 519.745n 0.0v 519.755n 0.0v 524.745n 0.0v 524.755n 0.0v 529.745n 0.0v 529.755n 0.0v 534.745n 0.0v 534.755n 0.0v 539.745n 0.0v 539.755n 0.0v 544.745n 0.0v 544.755n 0.0v 549.745n 0.0v 549.755n 0.0v 554.745n 0.0v 554.755n 0.0v 559.745n 0.0v 559.755n 0.0v 564.745n 0.0v 564.755n 0.0v 569.745n 0.0v 569.755n 0.0v 574.745n 0.0v 574.755n 0.0v 579.745n 0.0v 579.755n 0.0v 584.745n 0.0v 584.755n 1.0v 589.745n 1.0v 589.755n 1.0v 594.745n 1.0v 594.755n 1.0v 599.745n 1.0v 599.755n 1.0v 604.745n 1.0v 604.755n 0.0v 609.745n 0.0v 609.755n 0.0v 614.745n 0.0v 614.755n 0.0v 619.745n 0.0v 619.755n 0.0v 624.745n 0.0v 624.755n 0.0v 629.745n 0.0v 629.755n 0.0v 634.745n 0.0v 634.755n 0.0v 639.745n 0.0v 639.755n 0.0v 644.745n 0.0v 644.755n 0.0v 649.745n 0.0v 649.755n 0.0v 654.745n 0.0v 654.755n 0.0v 659.745n 0.0v 659.755n 0.0v 664.745n 0.0v 664.755n 0.0v 669.745n 0.0v 669.755n 0.0v 674.745n 0.0v 674.755n 0.0v 679.745n 0.0v 679.755n 0.0v 684.745n 0.0v 684.755n 0.0v 689.745n 0.0v 689.755n 0.0v 694.745n 0.0v 694.755n 0.0v 699.745n 0.0v 699.755n 0.0v 704.745n 0.0v 704.755n 0.0v 709.745n 0.0v 709.755n 0.0v 714.745n 0.0v 714.755n 0.0v 719.745n 0.0v 719.755n 0.0v 724.745n 0.0v 724.755n 0.0v 729.745n 0.0v 729.755n 1.0v 734.745n 1.0v 734.755n 1.0v 739.745n 1.0v 739.755n 1.0v 744.745n 1.0v 744.755n 1.0v 749.745n 1.0v 749.755n 1.0v 754.745n 1.0v 754.755n 1.0v 759.745n 1.0v 759.755n 1.0v 764.745n 1.0v 764.755n 1.0v 769.745n 1.0v 769.755n 1.0v 774.745n 1.0v 774.755n 1.0v 779.745n 1.0v 779.755n 1.0v 784.745n 1.0v 784.755n 1.0v 789.745n 1.0v 789.755n 1.0v 794.745n 1.0v 794.755n 1.0v 799.745n 1.0v 799.755n 1.0v 804.745n 1.0v 804.755n 1.0v 809.745n 1.0v 809.755n 0.0v 814.745n 0.0v 814.755n 0.0v 819.745n 0.0v 819.755n 0.0v 824.745n 0.0v 824.755n 0.0v 829.745n 0.0v 829.755n 1.0v 834.745n 1.0v 834.755n 1.0v 839.745n 1.0v 839.755n 1.0v 844.745n 1.0v 844.755n 1.0v 849.745n 1.0v 849.755n 1.0v 854.745n 1.0v 854.755n 1.0v 859.745n 1.0v 859.755n 1.0v 864.745n 1.0v 864.755n 1.0v 869.745n 1.0v 869.755n 1.0v 874.745n 1.0v 874.755n 1.0v 879.745n 1.0v 879.755n 0.0v 884.745n 0.0v 884.755n 0.0v 889.745n 0.0v 889.755n 0.0v 894.745n 0.0v 894.755n 0.0v 899.745n 0.0v 899.755n 1.0v 904.745n 1.0v 904.755n 0.0v 909.745n 0.0v 909.755n 0.0v 914.745n 0.0v 914.755n 0.0v 919.745n 0.0v 919.755n 0.0v 924.745n 0.0v 924.755n 1.0v 929.745n 1.0v 929.755n 0.0v 934.745n 0.0v 934.755n 0.0v 939.745n 0.0v 939.755n 0.0v 944.745n 0.0v 944.755n 0.0v 949.745n 0.0v 949.755n 0.0v 954.745n 0.0v 954.755n 0.0v 959.745n 0.0v 959.755n 0.0v 964.745n 0.0v 964.755n 0.0v 969.745n 0.0v 969.755n 0.0v 974.745n 0.0v 974.755n 0.0v 979.745n 0.0v 979.755n 0.0v 984.745n 0.0v 984.755n 0.0v 989.745n 0.0v 989.755n 0.0v 994.745n 0.0v 994.755n 0.0v 999.745n 0.0v 999.755n 1.0v 1004.745n 1.0v 1004.755n 1.0v 1009.745n 1.0v 1009.755n 1.0v 1014.745n 1.0v 1014.755n 1.0v 1019.745n 1.0v 1019.755n 1.0v 1024.745n 1.0v 1024.755n 1.0v )
* (time, data): [(0, 0), (5, 1), (10, 0), (15, 1), (20, 1), (25, 1), (30, 1), (35, 1), (40, 1), (45, 1), (50, 1), (55, 1), (60, 1), (65, 1), (70, 1), (75, 1), (80, 1), (85, 1), (90, 1), (95, 1), (100, 1), (105, 1), (110, 1), (115, 1), (120, 1), (125, 1), (130, 1), (135, 1), (140, 1), (145, 0), (150, 0), (155, 0), (160, 0), (165, 0), (170, 0), (175, 0), (180, 1), (185, 1), (190, 1), (195, 1), (200, 1), (205, 1), (210, 1), (215, 1), (220, 1), (225, 1), (230, 1), (235, 1), (240, 1), (245, 1), (250, 0), (255, 0), (260, 0), (265, 0), (270, 0), (275, 0), (280, 0), (285, 1), (290, 1), (295, 1), (300, 0), (305, 0), (310, 0), (315, 0), (320, 0), (325, 0), (330, 0), (335, 0), (340, 0), (345, 0), (350, 0), (355, 0), (360, 0), (365, 1), (370, 1), (375, 1), (380, 0), (385, 0), (390, 0), (395, 0), (400, 0), (405, 0), (410, 0), (415, 0), (420, 0), (425, 0), (430, 0), (435, 0), (440, 0), (445, 0), (450, 0), (455, 0), (460, 0), (465, 1), (470, 1), (475, 1), (480, 1), (485, 1), (490, 1), (495, 1), (500, 1), (505, 0), (510, 0), (515, 0), (520, 0), (525, 0), (530, 0), (535, 0), (540, 0), (545, 0), (550, 0), (555, 0), (560, 0), (565, 0), (570, 0), (575, 0), (580, 0), (585, 0), (590, 0), (595, 0), (600, 0), (605, 0), (610, 0), (615, 1), (620, 1), (625, 1), (630, 1), (635, 1), (640, 1), (645, 1), (650, 1), (655, 1), (660, 1), (665, 1), (670, 1), (675, 1), (680, 1), (685, 1), (690, 0), (695, 0), (700, 0), (705, 0), (710, 0), (715, 0), (720, 0), (725, 0), (730, 1), (735, 1), (740, 1), (745, 1), (750, 1), (755, 1), (760, 1), (765, 1), (770, 1), (775, 1), (780, 1), (785, 1), (790, 0), (795, 0), (800, 0), (805, 0), (810, 1), (815, 1), (820, 1), (825, 1), (830, 1), (835, 1), (840, 1), (845, 1), (850, 1), (855, 1), (860, 1), (865, 1), (870, 1), (875, 1), (880, 0), (885, 0), (890, 0), (895, 0), (900, 1), (905, 0), (910, 0), (915, 0), (920, 0), (925, 1), (930, 0), (935, 0), (940, 0), (945, 0), (950, 0), (955, 0), (960, 0), (965, 0), (970, 0), (975, 0), (980, 0), (985, 0), (990, 0), (995, 0), (1000, 1), (1005, 1), (1010, 0), (1015, 0), (1020, 1), (1025, 1)]
Vdin1_62  din1_62  0 PWL (0n 0.0v 4.745n 0.0v 4.755n 1.0v 9.745n 1.0v 9.755n 0.0v 14.745n 0.0v 14.755n 1.0v 19.745n 1.0v 19.755n 1.0v 24.745n 1.0v 24.755n 1.0v 29.745n 1.0v 29.755n 1.0v 34.745n 1.0v 34.755n 1.0v 39.745n 1.0v 39.755n 1.0v 44.745n 1.0v 44.755n 1.0v 49.745n 1.0v 49.755n 1.0v 54.745n 1.0v 54.755n 1.0v 59.745n 1.0v 59.755n 1.0v 64.745n 1.0v 64.755n 1.0v 69.745n 1.0v 69.755n 1.0v 74.745n 1.0v 74.755n 1.0v 79.745n 1.0v 79.755n 1.0v 84.745n 1.0v 84.755n 1.0v 89.745n 1.0v 89.755n 1.0v 94.745n 1.0v 94.755n 1.0v 99.745n 1.0v 99.755n 1.0v 104.745n 1.0v 104.755n 1.0v 109.745n 1.0v 109.755n 1.0v 114.745n 1.0v 114.755n 1.0v 119.745n 1.0v 119.755n 1.0v 124.745n 1.0v 124.755n 1.0v 129.745n 1.0v 129.755n 1.0v 134.745n 1.0v 134.755n 1.0v 139.745n 1.0v 139.755n 1.0v 144.745n 1.0v 144.755n 0.0v 149.745n 0.0v 149.755n 0.0v 154.745n 0.0v 154.755n 0.0v 159.745n 0.0v 159.755n 0.0v 164.745n 0.0v 164.755n 0.0v 169.745n 0.0v 169.755n 0.0v 174.745n 0.0v 174.755n 0.0v 179.745n 0.0v 179.755n 1.0v 184.745n 1.0v 184.755n 1.0v 189.745n 1.0v 189.755n 1.0v 194.745n 1.0v 194.755n 1.0v 199.745n 1.0v 199.755n 1.0v 204.745n 1.0v 204.755n 1.0v 209.745n 1.0v 209.755n 1.0v 214.745n 1.0v 214.755n 1.0v 219.745n 1.0v 219.755n 1.0v 224.745n 1.0v 224.755n 1.0v 229.745n 1.0v 229.755n 1.0v 234.745n 1.0v 234.755n 1.0v 239.745n 1.0v 239.755n 1.0v 244.745n 1.0v 244.755n 1.0v 249.745n 1.0v 249.755n 0.0v 254.745n 0.0v 254.755n 0.0v 259.745n 0.0v 259.755n 0.0v 264.745n 0.0v 264.755n 0.0v 269.745n 0.0v 269.755n 0.0v 274.745n 0.0v 274.755n 0.0v 279.745n 0.0v 279.755n 0.0v 284.745n 0.0v 284.755n 1.0v 289.745n 1.0v 289.755n 1.0v 294.745n 1.0v 294.755n 1.0v 299.745n 1.0v 299.755n 0.0v 304.745n 0.0v 304.755n 0.0v 309.745n 0.0v 309.755n 0.0v 314.745n 0.0v 314.755n 0.0v 319.745n 0.0v 319.755n 0.0v 324.745n 0.0v 324.755n 0.0v 329.745n 0.0v 329.755n 0.0v 334.745n 0.0v 334.755n 0.0v 339.745n 0.0v 339.755n 0.0v 344.745n 0.0v 344.755n 0.0v 349.745n 0.0v 349.755n 0.0v 354.745n 0.0v 354.755n 0.0v 359.745n 0.0v 359.755n 0.0v 364.745n 0.0v 364.755n 1.0v 369.745n 1.0v 369.755n 1.0v 374.745n 1.0v 374.755n 1.0v 379.745n 1.0v 379.755n 0.0v 384.745n 0.0v 384.755n 0.0v 389.745n 0.0v 389.755n 0.0v 394.745n 0.0v 394.755n 0.0v 399.745n 0.0v 399.755n 0.0v 404.745n 0.0v 404.755n 0.0v 409.745n 0.0v 409.755n 0.0v 414.745n 0.0v 414.755n 0.0v 419.745n 0.0v 419.755n 0.0v 424.745n 0.0v 424.755n 0.0v 429.745n 0.0v 429.755n 0.0v 434.745n 0.0v 434.755n 0.0v 439.745n 0.0v 439.755n 0.0v 444.745n 0.0v 444.755n 0.0v 449.745n 0.0v 449.755n 0.0v 454.745n 0.0v 454.755n 0.0v 459.745n 0.0v 459.755n 0.0v 464.745n 0.0v 464.755n 1.0v 469.745n 1.0v 469.755n 1.0v 474.745n 1.0v 474.755n 1.0v 479.745n 1.0v 479.755n 1.0v 484.745n 1.0v 484.755n 1.0v 489.745n 1.0v 489.755n 1.0v 494.745n 1.0v 494.755n 1.0v 499.745n 1.0v 499.755n 1.0v 504.745n 1.0v 504.755n 0.0v 509.745n 0.0v 509.755n 0.0v 514.745n 0.0v 514.755n 0.0v 519.745n 0.0v 519.755n 0.0v 524.745n 0.0v 524.755n 0.0v 529.745n 0.0v 529.755n 0.0v 534.745n 0.0v 534.755n 0.0v 539.745n 0.0v 539.755n 0.0v 544.745n 0.0v 544.755n 0.0v 549.745n 0.0v 549.755n 0.0v 554.745n 0.0v 554.755n 0.0v 559.745n 0.0v 559.755n 0.0v 564.745n 0.0v 564.755n 0.0v 569.745n 0.0v 569.755n 0.0v 574.745n 0.0v 574.755n 0.0v 579.745n 0.0v 579.755n 0.0v 584.745n 0.0v 584.755n 0.0v 589.745n 0.0v 589.755n 0.0v 594.745n 0.0v 594.755n 0.0v 599.745n 0.0v 599.755n 0.0v 604.745n 0.0v 604.755n 0.0v 609.745n 0.0v 609.755n 0.0v 614.745n 0.0v 614.755n 1.0v 619.745n 1.0v 619.755n 1.0v 624.745n 1.0v 624.755n 1.0v 629.745n 1.0v 629.755n 1.0v 634.745n 1.0v 634.755n 1.0v 639.745n 1.0v 639.755n 1.0v 644.745n 1.0v 644.755n 1.0v 649.745n 1.0v 649.755n 1.0v 654.745n 1.0v 654.755n 1.0v 659.745n 1.0v 659.755n 1.0v 664.745n 1.0v 664.755n 1.0v 669.745n 1.0v 669.755n 1.0v 674.745n 1.0v 674.755n 1.0v 679.745n 1.0v 679.755n 1.0v 684.745n 1.0v 684.755n 1.0v 689.745n 1.0v 689.755n 0.0v 694.745n 0.0v 694.755n 0.0v 699.745n 0.0v 699.755n 0.0v 704.745n 0.0v 704.755n 0.0v 709.745n 0.0v 709.755n 0.0v 714.745n 0.0v 714.755n 0.0v 719.745n 0.0v 719.755n 0.0v 724.745n 0.0v 724.755n 0.0v 729.745n 0.0v 729.755n 1.0v 734.745n 1.0v 734.755n 1.0v 739.745n 1.0v 739.755n 1.0v 744.745n 1.0v 744.755n 1.0v 749.745n 1.0v 749.755n 1.0v 754.745n 1.0v 754.755n 1.0v 759.745n 1.0v 759.755n 1.0v 764.745n 1.0v 764.755n 1.0v 769.745n 1.0v 769.755n 1.0v 774.745n 1.0v 774.755n 1.0v 779.745n 1.0v 779.755n 1.0v 784.745n 1.0v 784.755n 1.0v 789.745n 1.0v 789.755n 0.0v 794.745n 0.0v 794.755n 0.0v 799.745n 0.0v 799.755n 0.0v 804.745n 0.0v 804.755n 0.0v 809.745n 0.0v 809.755n 1.0v 814.745n 1.0v 814.755n 1.0v 819.745n 1.0v 819.755n 1.0v 824.745n 1.0v 824.755n 1.0v 829.745n 1.0v 829.755n 1.0v 834.745n 1.0v 834.755n 1.0v 839.745n 1.0v 839.755n 1.0v 844.745n 1.0v 844.755n 1.0v 849.745n 1.0v 849.755n 1.0v 854.745n 1.0v 854.755n 1.0v 859.745n 1.0v 859.755n 1.0v 864.745n 1.0v 864.755n 1.0v 869.745n 1.0v 869.755n 1.0v 874.745n 1.0v 874.755n 1.0v 879.745n 1.0v 879.755n 0.0v 884.745n 0.0v 884.755n 0.0v 889.745n 0.0v 889.755n 0.0v 894.745n 0.0v 894.755n 0.0v 899.745n 0.0v 899.755n 1.0v 904.745n 1.0v 904.755n 0.0v 909.745n 0.0v 909.755n 0.0v 914.745n 0.0v 914.755n 0.0v 919.745n 0.0v 919.755n 0.0v 924.745n 0.0v 924.755n 1.0v 929.745n 1.0v 929.755n 0.0v 934.745n 0.0v 934.755n 0.0v 939.745n 0.0v 939.755n 0.0v 944.745n 0.0v 944.755n 0.0v 949.745n 0.0v 949.755n 0.0v 954.745n 0.0v 954.755n 0.0v 959.745n 0.0v 959.755n 0.0v 964.745n 0.0v 964.755n 0.0v 969.745n 0.0v 969.755n 0.0v 974.745n 0.0v 974.755n 0.0v 979.745n 0.0v 979.755n 0.0v 984.745n 0.0v 984.755n 0.0v 989.745n 0.0v 989.755n 0.0v 994.745n 0.0v 994.755n 0.0v 999.745n 0.0v 999.755n 1.0v 1004.745n 1.0v 1004.755n 1.0v 1009.745n 1.0v 1009.755n 0.0v 1014.745n 0.0v 1014.755n 0.0v 1019.745n 0.0v 1019.755n 1.0v 1024.745n 1.0v 1024.755n 1.0v )
* (time, data): [(0, 0), (5, 1), (10, 1), (15, 1), (20, 1), (25, 1), (30, 1), (35, 1), (40, 1), (45, 1), (50, 1), (55, 1), (60, 0), (65, 0), (70, 0), (75, 0), (80, 1), (85, 1), (90, 0), (95, 0), (100, 0), (105, 0), (110, 0), (115, 0), (120, 0), (125, 0), (130, 1), (135, 1), (140, 1), (145, 0), (150, 0), (155, 0), (160, 0), (165, 0), (170, 0), (175, 0), (180, 1), (185, 1), (190, 1), (195, 1), (200, 1), (205, 1), (210, 1), (215, 1), (220, 1), (225, 1), (230, 1), (235, 1), (240, 1), (245, 0), (250, 1), (255, 1), (260, 1), (265, 1), (270, 1), (275, 1), (280, 1), (285, 0), (290, 0), (295, 0), (300, 0), (305, 0), (310, 0), (315, 0), (320, 0), (325, 0), (330, 0), (335, 0), (340, 0), (345, 0), (350, 0), (355, 0), (360, 0), (365, 0), (370, 0), (375, 0), (380, 1), (385, 1), (390, 0), (395, 1), (400, 0), (405, 0), (410, 0), (415, 0), (420, 0), (425, 0), (430, 0), (435, 0), (440, 0), (445, 0), (450, 0), (455, 0), (460, 0), (465, 1), (470, 1), (475, 1), (480, 1), (485, 0), (490, 0), (495, 0), (500, 0), (505, 1), (510, 1), (515, 1), (520, 0), (525, 0), (530, 0), (535, 0), (540, 0), (545, 0), (550, 0), (555, 0), (560, 0), (565, 0), (570, 0), (575, 0), (580, 1), (585, 0), (590, 0), (595, 0), (600, 0), (605, 1), (610, 1), (615, 0), (620, 0), (625, 0), (630, 0), (635, 0), (640, 0), (645, 0), (650, 0), (655, 0), (660, 0), (665, 0), (670, 0), (675, 0), (680, 0), (685, 0), (690, 1), (695, 1), (700, 1), (705, 1), (710, 1), (715, 1), (720, 1), (725, 1), (730, 0), (735, 0), (740, 0), (745, 0), (750, 0), (755, 0), (760, 1), (765, 1), (770, 1), (775, 1), (780, 1), (785, 1), (790, 0), (795, 0), (800, 0), (805, 0), (810, 1), (815, 1), (820, 1), (825, 1), (830, 0), (835, 0), (840, 0), (845, 0), (850, 0), (855, 0), (860, 0), (865, 0), (870, 0), (875, 0), (880, 1), (885, 1), (890, 1), (895, 1), (900, 1), (905, 1), (910, 1), (915, 1), (920, 1), (925, 0), (930, 1), (935, 1), (940, 1), (945, 0), (950, 0), (955, 0), (960, 0), (965, 0), (970, 0), (975, 0), (980, 0), (985, 0), (990, 0), (995, 0), (1000, 1), (1005, 1), (1010, 0), (1015, 0), (1020, 1), (1025, 1)]
Vdin1_63  din1_63  0 PWL (0n 0.0v 4.745n 0.0v 4.755n 1.0v 9.745n 1.0v 9.755n 1.0v 14.745n 1.0v 14.755n 1.0v 19.745n 1.0v 19.755n 1.0v 24.745n 1.0v 24.755n 1.0v 29.745n 1.0v 29.755n 1.0v 34.745n 1.0v 34.755n 1.0v 39.745n 1.0v 39.755n 1.0v 44.745n 1.0v 44.755n 1.0v 49.745n 1.0v 49.755n 1.0v 54.745n 1.0v 54.755n 1.0v 59.745n 1.0v 59.755n 0.0v 64.745n 0.0v 64.755n 0.0v 69.745n 0.0v 69.755n 0.0v 74.745n 0.0v 74.755n 0.0v 79.745n 0.0v 79.755n 1.0v 84.745n 1.0v 84.755n 1.0v 89.745n 1.0v 89.755n 0.0v 94.745n 0.0v 94.755n 0.0v 99.745n 0.0v 99.755n 0.0v 104.745n 0.0v 104.755n 0.0v 109.745n 0.0v 109.755n 0.0v 114.745n 0.0v 114.755n 0.0v 119.745n 0.0v 119.755n 0.0v 124.745n 0.0v 124.755n 0.0v 129.745n 0.0v 129.755n 1.0v 134.745n 1.0v 134.755n 1.0v 139.745n 1.0v 139.755n 1.0v 144.745n 1.0v 144.755n 0.0v 149.745n 0.0v 149.755n 0.0v 154.745n 0.0v 154.755n 0.0v 159.745n 0.0v 159.755n 0.0v 164.745n 0.0v 164.755n 0.0v 169.745n 0.0v 169.755n 0.0v 174.745n 0.0v 174.755n 0.0v 179.745n 0.0v 179.755n 1.0v 184.745n 1.0v 184.755n 1.0v 189.745n 1.0v 189.755n 1.0v 194.745n 1.0v 194.755n 1.0v 199.745n 1.0v 199.755n 1.0v 204.745n 1.0v 204.755n 1.0v 209.745n 1.0v 209.755n 1.0v 214.745n 1.0v 214.755n 1.0v 219.745n 1.0v 219.755n 1.0v 224.745n 1.0v 224.755n 1.0v 229.745n 1.0v 229.755n 1.0v 234.745n 1.0v 234.755n 1.0v 239.745n 1.0v 239.755n 1.0v 244.745n 1.0v 244.755n 0.0v 249.745n 0.0v 249.755n 1.0v 254.745n 1.0v 254.755n 1.0v 259.745n 1.0v 259.755n 1.0v 264.745n 1.0v 264.755n 1.0v 269.745n 1.0v 269.755n 1.0v 274.745n 1.0v 274.755n 1.0v 279.745n 1.0v 279.755n 1.0v 284.745n 1.0v 284.755n 0.0v 289.745n 0.0v 289.755n 0.0v 294.745n 0.0v 294.755n 0.0v 299.745n 0.0v 299.755n 0.0v 304.745n 0.0v 304.755n 0.0v 309.745n 0.0v 309.755n 0.0v 314.745n 0.0v 314.755n 0.0v 319.745n 0.0v 319.755n 0.0v 324.745n 0.0v 324.755n 0.0v 329.745n 0.0v 329.755n 0.0v 334.745n 0.0v 334.755n 0.0v 339.745n 0.0v 339.755n 0.0v 344.745n 0.0v 344.755n 0.0v 349.745n 0.0v 349.755n 0.0v 354.745n 0.0v 354.755n 0.0v 359.745n 0.0v 359.755n 0.0v 364.745n 0.0v 364.755n 0.0v 369.745n 0.0v 369.755n 0.0v 374.745n 0.0v 374.755n 0.0v 379.745n 0.0v 379.755n 1.0v 384.745n 1.0v 384.755n 1.0v 389.745n 1.0v 389.755n 0.0v 394.745n 0.0v 394.755n 1.0v 399.745n 1.0v 399.755n 0.0v 404.745n 0.0v 404.755n 0.0v 409.745n 0.0v 409.755n 0.0v 414.745n 0.0v 414.755n 0.0v 419.745n 0.0v 419.755n 0.0v 424.745n 0.0v 424.755n 0.0v 429.745n 0.0v 429.755n 0.0v 434.745n 0.0v 434.755n 0.0v 439.745n 0.0v 439.755n 0.0v 444.745n 0.0v 444.755n 0.0v 449.745n 0.0v 449.755n 0.0v 454.745n 0.0v 454.755n 0.0v 459.745n 0.0v 459.755n 0.0v 464.745n 0.0v 464.755n 1.0v 469.745n 1.0v 469.755n 1.0v 474.745n 1.0v 474.755n 1.0v 479.745n 1.0v 479.755n 1.0v 484.745n 1.0v 484.755n 0.0v 489.745n 0.0v 489.755n 0.0v 494.745n 0.0v 494.755n 0.0v 499.745n 0.0v 499.755n 0.0v 504.745n 0.0v 504.755n 1.0v 509.745n 1.0v 509.755n 1.0v 514.745n 1.0v 514.755n 1.0v 519.745n 1.0v 519.755n 0.0v 524.745n 0.0v 524.755n 0.0v 529.745n 0.0v 529.755n 0.0v 534.745n 0.0v 534.755n 0.0v 539.745n 0.0v 539.755n 0.0v 544.745n 0.0v 544.755n 0.0v 549.745n 0.0v 549.755n 0.0v 554.745n 0.0v 554.755n 0.0v 559.745n 0.0v 559.755n 0.0v 564.745n 0.0v 564.755n 0.0v 569.745n 0.0v 569.755n 0.0v 574.745n 0.0v 574.755n 0.0v 579.745n 0.0v 579.755n 1.0v 584.745n 1.0v 584.755n 0.0v 589.745n 0.0v 589.755n 0.0v 594.745n 0.0v 594.755n 0.0v 599.745n 0.0v 599.755n 0.0v 604.745n 0.0v 604.755n 1.0v 609.745n 1.0v 609.755n 1.0v 614.745n 1.0v 614.755n 0.0v 619.745n 0.0v 619.755n 0.0v 624.745n 0.0v 624.755n 0.0v 629.745n 0.0v 629.755n 0.0v 634.745n 0.0v 634.755n 0.0v 639.745n 0.0v 639.755n 0.0v 644.745n 0.0v 644.755n 0.0v 649.745n 0.0v 649.755n 0.0v 654.745n 0.0v 654.755n 0.0v 659.745n 0.0v 659.755n 0.0v 664.745n 0.0v 664.755n 0.0v 669.745n 0.0v 669.755n 0.0v 674.745n 0.0v 674.755n 0.0v 679.745n 0.0v 679.755n 0.0v 684.745n 0.0v 684.755n 0.0v 689.745n 0.0v 689.755n 1.0v 694.745n 1.0v 694.755n 1.0v 699.745n 1.0v 699.755n 1.0v 704.745n 1.0v 704.755n 1.0v 709.745n 1.0v 709.755n 1.0v 714.745n 1.0v 714.755n 1.0v 719.745n 1.0v 719.755n 1.0v 724.745n 1.0v 724.755n 1.0v 729.745n 1.0v 729.755n 0.0v 734.745n 0.0v 734.755n 0.0v 739.745n 0.0v 739.755n 0.0v 744.745n 0.0v 744.755n 0.0v 749.745n 0.0v 749.755n 0.0v 754.745n 0.0v 754.755n 0.0v 759.745n 0.0v 759.755n 1.0v 764.745n 1.0v 764.755n 1.0v 769.745n 1.0v 769.755n 1.0v 774.745n 1.0v 774.755n 1.0v 779.745n 1.0v 779.755n 1.0v 784.745n 1.0v 784.755n 1.0v 789.745n 1.0v 789.755n 0.0v 794.745n 0.0v 794.755n 0.0v 799.745n 0.0v 799.755n 0.0v 804.745n 0.0v 804.755n 0.0v 809.745n 0.0v 809.755n 1.0v 814.745n 1.0v 814.755n 1.0v 819.745n 1.0v 819.755n 1.0v 824.745n 1.0v 824.755n 1.0v 829.745n 1.0v 829.755n 0.0v 834.745n 0.0v 834.755n 0.0v 839.745n 0.0v 839.755n 0.0v 844.745n 0.0v 844.755n 0.0v 849.745n 0.0v 849.755n 0.0v 854.745n 0.0v 854.755n 0.0v 859.745n 0.0v 859.755n 0.0v 864.745n 0.0v 864.755n 0.0v 869.745n 0.0v 869.755n 0.0v 874.745n 0.0v 874.755n 0.0v 879.745n 0.0v 879.755n 1.0v 884.745n 1.0v 884.755n 1.0v 889.745n 1.0v 889.755n 1.0v 894.745n 1.0v 894.755n 1.0v 899.745n 1.0v 899.755n 1.0v 904.745n 1.0v 904.755n 1.0v 909.745n 1.0v 909.755n 1.0v 914.745n 1.0v 914.755n 1.0v 919.745n 1.0v 919.755n 1.0v 924.745n 1.0v 924.755n 0.0v 929.745n 0.0v 929.755n 1.0v 934.745n 1.0v 934.755n 1.0v 939.745n 1.0v 939.755n 1.0v 944.745n 1.0v 944.755n 0.0v 949.745n 0.0v 949.755n 0.0v 954.745n 0.0v 954.755n 0.0v 959.745n 0.0v 959.755n 0.0v 964.745n 0.0v 964.755n 0.0v 969.745n 0.0v 969.755n 0.0v 974.745n 0.0v 974.755n 0.0v 979.745n 0.0v 979.755n 0.0v 984.745n 0.0v 984.755n 0.0v 989.745n 0.0v 989.755n 0.0v 994.745n 0.0v 994.755n 0.0v 999.745n 0.0v 999.755n 1.0v 1004.745n 1.0v 1004.755n 1.0v 1009.745n 1.0v 1009.755n 0.0v 1014.745n 0.0v 1014.755n 0.0v 1019.745n 0.0v 1019.755n 1.0v 1024.745n 1.0v 1024.755n 1.0v )
* (time, data): [(0, 0), (5, 1), (10, 0), (15, 0), (20, 1), (25, 1), (30, 1), (35, 1), (40, 1), (45, 1), (50, 0), (55, 1), (60, 0), (65, 0), (70, 1), (75, 1), (80, 1), (85, 0), (90, 0), (95, 1), (100, 1), (105, 0), (110, 0), (115, 0), (120, 1), (125, 1), (130, 1), (135, 0), (140, 0), (145, 1), (150, 1), (155, 0), (160, 0), (165, 0), (170, 0), (175, 0), (180, 0), (185, 1), (190, 1), (195, 1), (200, 0), (205, 0), (210, 1), (215, 1), (220, 1), (225, 1), (230, 0), (235, 1), (240, 1), (245, 0), (250, 0), (255, 0), (260, 0), (265, 1), (270, 1), (275, 0), (280, 0), (285, 1), (290, 0), (295, 0), (300, 0), (305, 0), (310, 1), (315, 1), (320, 1), (325, 1), (330, 1), (335, 0), (340, 0), (345, 0), (350, 0), (355, 0), (360, 0), (365, 0), (370, 0), (375, 0), (380, 0), (385, 0), (390, 0), (395, 0), (400, 0), (405, 1), (410, 1), (415, 0), (420, 0), (425, 0), (430, 1), (435, 0), (440, 0), (445, 0), (450, 1), (455, 1), (460, 1), (465, 1), (470, 1), (475, 0), (480, 1), (485, 0), (490, 0), (495, 1), (500, 0), (505, 0), (510, 0), (515, 0), (520, 1), (525, 1), (530, 1), (535, 1), (540, 1), (545, 1), (550, 1), (555, 1), (560, 1), (565, 1), (570, 0), (575, 1), (580, 1), (585, 1), (590, 1), (595, 1), (600, 1), (605, 0), (610, 1), (615, 1), (620, 0), (625, 1), (630, 0), (635, 1), (640, 1), (645, 1), (650, 0), (655, 1), (660, 1), (665, 0), (670, 1), (675, 0), (680, 1), (685, 0), (690, 1), (695, 1), (700, 1), (705, 0), (710, 1), (715, 1), (720, 1), (725, 1), (730, 1), (735, 0), (740, 1), (745, 1), (750, 0), (755, 0), (760, 0), (765, 0), (770, 0), (775, 0), (780, 1), (785, 1), (790, 0), (795, 1), (800, 1), (805, 1), (810, 1), (815, 1), (820, 0), (825, 1), (830, 1), (835, 1), (840, 0), (845, 0), (850, 1), (855, 1), (860, 0), (865, 0), (870, 1), (875, 1), (880, 1), (885, 0), (890, 0), (895, 0), (900, 1), (905, 0), (910, 0), (915, 0), (920, 0), (925, 1), (930, 1), (935, 1), (940, 0), (945, 1), (950, 1), (955, 1), (960, 1), (965, 0), (970, 0), (975, 0), (980, 0), (985, 0), (990, 0), (995, 0), (1000, 1), (1005, 0), (1010, 0), (1015, 0), (1020, 1), (1025, 1)]
Va0_0  a0_0  0 PWL (0n 0.0v 4.745n 0.0v 4.755n 1.0v 9.745n 1.0v 9.755n 0.0v 14.745n 0.0v 14.755n 0.0v 19.745n 0.0v 19.755n 1.0v 24.745n 1.0v 24.755n 1.0v 29.745n 1.0v 29.755n 1.0v 34.745n 1.0v 34.755n 1.0v 39.745n 1.0v 39.755n 1.0v 44.745n 1.0v 44.755n 1.0v 49.745n 1.0v 49.755n 0.0v 54.745n 0.0v 54.755n 1.0v 59.745n 1.0v 59.755n 0.0v 64.745n 0.0v 64.755n 0.0v 69.745n 0.0v 69.755n 1.0v 74.745n 1.0v 74.755n 1.0v 79.745n 1.0v 79.755n 1.0v 84.745n 1.0v 84.755n 0.0v 89.745n 0.0v 89.755n 0.0v 94.745n 0.0v 94.755n 1.0v 99.745n 1.0v 99.755n 1.0v 104.745n 1.0v 104.755n 0.0v 109.745n 0.0v 109.755n 0.0v 114.745n 0.0v 114.755n 0.0v 119.745n 0.0v 119.755n 1.0v 124.745n 1.0v 124.755n 1.0v 129.745n 1.0v 129.755n 1.0v 134.745n 1.0v 134.755n 0.0v 139.745n 0.0v 139.755n 0.0v 144.745n 0.0v 144.755n 1.0v 149.745n 1.0v 149.755n 1.0v 154.745n 1.0v 154.755n 0.0v 159.745n 0.0v 159.755n 0.0v 164.745n 0.0v 164.755n 0.0v 169.745n 0.0v 169.755n 0.0v 174.745n 0.0v 174.755n 0.0v 179.745n 0.0v 179.755n 0.0v 184.745n 0.0v 184.755n 1.0v 189.745n 1.0v 189.755n 1.0v 194.745n 1.0v 194.755n 1.0v 199.745n 1.0v 199.755n 0.0v 204.745n 0.0v 204.755n 0.0v 209.745n 0.0v 209.755n 1.0v 214.745n 1.0v 214.755n 1.0v 219.745n 1.0v 219.755n 1.0v 224.745n 1.0v 224.755n 1.0v 229.745n 1.0v 229.755n 0.0v 234.745n 0.0v 234.755n 1.0v 239.745n 1.0v 239.755n 1.0v 244.745n 1.0v 244.755n 0.0v 249.745n 0.0v 249.755n 0.0v 254.745n 0.0v 254.755n 0.0v 259.745n 0.0v 259.755n 0.0v 264.745n 0.0v 264.755n 1.0v 269.745n 1.0v 269.755n 1.0v 274.745n 1.0v 274.755n 0.0v 279.745n 0.0v 279.755n 0.0v 284.745n 0.0v 284.755n 1.0v 289.745n 1.0v 289.755n 0.0v 294.745n 0.0v 294.755n 0.0v 299.745n 0.0v 299.755n 0.0v 304.745n 0.0v 304.755n 0.0v 309.745n 0.0v 309.755n 1.0v 314.745n 1.0v 314.755n 1.0v 319.745n 1.0v 319.755n 1.0v 324.745n 1.0v 324.755n 1.0v 329.745n 1.0v 329.755n 1.0v 334.745n 1.0v 334.755n 0.0v 339.745n 0.0v 339.755n 0.0v 344.745n 0.0v 344.755n 0.0v 349.745n 0.0v 349.755n 0.0v 354.745n 0.0v 354.755n 0.0v 359.745n 0.0v 359.755n 0.0v 364.745n 0.0v 364.755n 0.0v 369.745n 0.0v 369.755n 0.0v 374.745n 0.0v 374.755n 0.0v 379.745n 0.0v 379.755n 0.0v 384.745n 0.0v 384.755n 0.0v 389.745n 0.0v 389.755n 0.0v 394.745n 0.0v 394.755n 0.0v 399.745n 0.0v 399.755n 0.0v 404.745n 0.0v 404.755n 1.0v 409.745n 1.0v 409.755n 1.0v 414.745n 1.0v 414.755n 0.0v 419.745n 0.0v 419.755n 0.0v 424.745n 0.0v 424.755n 0.0v 429.745n 0.0v 429.755n 1.0v 434.745n 1.0v 434.755n 0.0v 439.745n 0.0v 439.755n 0.0v 444.745n 0.0v 444.755n 0.0v 449.745n 0.0v 449.755n 1.0v 454.745n 1.0v 454.755n 1.0v 459.745n 1.0v 459.755n 1.0v 464.745n 1.0v 464.755n 1.0v 469.745n 1.0v 469.755n 1.0v 474.745n 1.0v 474.755n 0.0v 479.745n 0.0v 479.755n 1.0v 484.745n 1.0v 484.755n 0.0v 489.745n 0.0v 489.755n 0.0v 494.745n 0.0v 494.755n 1.0v 499.745n 1.0v 499.755n 0.0v 504.745n 0.0v 504.755n 0.0v 509.745n 0.0v 509.755n 0.0v 514.745n 0.0v 514.755n 0.0v 519.745n 0.0v 519.755n 1.0v 524.745n 1.0v 524.755n 1.0v 529.745n 1.0v 529.755n 1.0v 534.745n 1.0v 534.755n 1.0v 539.745n 1.0v 539.755n 1.0v 544.745n 1.0v 544.755n 1.0v 549.745n 1.0v 549.755n 1.0v 554.745n 1.0v 554.755n 1.0v 559.745n 1.0v 559.755n 1.0v 564.745n 1.0v 564.755n 1.0v 569.745n 1.0v 569.755n 0.0v 574.745n 0.0v 574.755n 1.0v 579.745n 1.0v 579.755n 1.0v 584.745n 1.0v 584.755n 1.0v 589.745n 1.0v 589.755n 1.0v 594.745n 1.0v 594.755n 1.0v 599.745n 1.0v 599.755n 1.0v 604.745n 1.0v 604.755n 0.0v 609.745n 0.0v 609.755n 1.0v 614.745n 1.0v 614.755n 1.0v 619.745n 1.0v 619.755n 0.0v 624.745n 0.0v 624.755n 1.0v 629.745n 1.0v 629.755n 0.0v 634.745n 0.0v 634.755n 1.0v 639.745n 1.0v 639.755n 1.0v 644.745n 1.0v 644.755n 1.0v 649.745n 1.0v 649.755n 0.0v 654.745n 0.0v 654.755n 1.0v 659.745n 1.0v 659.755n 1.0v 664.745n 1.0v 664.755n 0.0v 669.745n 0.0v 669.755n 1.0v 674.745n 1.0v 674.755n 0.0v 679.745n 0.0v 679.755n 1.0v 684.745n 1.0v 684.755n 0.0v 689.745n 0.0v 689.755n 1.0v 694.745n 1.0v 694.755n 1.0v 699.745n 1.0v 699.755n 1.0v 704.745n 1.0v 704.755n 0.0v 709.745n 0.0v 709.755n 1.0v 714.745n 1.0v 714.755n 1.0v 719.745n 1.0v 719.755n 1.0v 724.745n 1.0v 724.755n 1.0v 729.745n 1.0v 729.755n 1.0v 734.745n 1.0v 734.755n 0.0v 739.745n 0.0v 739.755n 1.0v 744.745n 1.0v 744.755n 1.0v 749.745n 1.0v 749.755n 0.0v 754.745n 0.0v 754.755n 0.0v 759.745n 0.0v 759.755n 0.0v 764.745n 0.0v 764.755n 0.0v 769.745n 0.0v 769.755n 0.0v 774.745n 0.0v 774.755n 0.0v 779.745n 0.0v 779.755n 1.0v 784.745n 1.0v 784.755n 1.0v 789.745n 1.0v 789.755n 0.0v 794.745n 0.0v 794.755n 1.0v 799.745n 1.0v 799.755n 1.0v 804.745n 1.0v 804.755n 1.0v 809.745n 1.0v 809.755n 1.0v 814.745n 1.0v 814.755n 1.0v 819.745n 1.0v 819.755n 0.0v 824.745n 0.0v 824.755n 1.0v 829.745n 1.0v 829.755n 1.0v 834.745n 1.0v 834.755n 1.0v 839.745n 1.0v 839.755n 0.0v 844.745n 0.0v 844.755n 0.0v 849.745n 0.0v 849.755n 1.0v 854.745n 1.0v 854.755n 1.0v 859.745n 1.0v 859.755n 0.0v 864.745n 0.0v 864.755n 0.0v 869.745n 0.0v 869.755n 1.0v 874.745n 1.0v 874.755n 1.0v 879.745n 1.0v 879.755n 1.0v 884.745n 1.0v 884.755n 0.0v 889.745n 0.0v 889.755n 0.0v 894.745n 0.0v 894.755n 0.0v 899.745n 0.0v 899.755n 1.0v 904.745n 1.0v 904.755n 0.0v 909.745n 0.0v 909.755n 0.0v 914.745n 0.0v 914.755n 0.0v 919.745n 0.0v 919.755n 0.0v 924.745n 0.0v 924.755n 1.0v 929.745n 1.0v 929.755n 1.0v 934.745n 1.0v 934.755n 1.0v 939.745n 1.0v 939.755n 0.0v 944.745n 0.0v 944.755n 1.0v 949.745n 1.0v 949.755n 1.0v 954.745n 1.0v 954.755n 1.0v 959.745n 1.0v 959.755n 1.0v 964.745n 1.0v 964.755n 0.0v 969.745n 0.0v 969.755n 0.0v 974.745n 0.0v 974.755n 0.0v 979.745n 0.0v 979.755n 0.0v 984.745n 0.0v 984.755n 0.0v 989.745n 0.0v 989.755n 0.0v 994.745n 0.0v 994.755n 0.0v 999.745n 0.0v 999.755n 1.0v 1004.745n 1.0v 1004.755n 0.0v 1009.745n 0.0v 1009.755n 0.0v 1014.745n 0.0v 1014.755n 0.0v 1019.745n 0.0v 1019.755n 1.0v 1024.745n 1.0v 1024.755n 1.0v )
* (time, data): [(0, 0), (5, 1), (10, 1), (15, 1), (20, 1), (25, 0), (30, 0), (35, 1), (40, 0), (45, 0), (50, 0), (55, 0), (60, 1), (65, 1), (70, 1), (75, 0), (80, 1), (85, 0), (90, 0), (95, 0), (100, 0), (105, 0), (110, 0), (115, 0), (120, 1), (125, 1), (130, 0), (135, 1), (140, 0), (145, 0), (150, 0), (155, 1), (160, 1), (165, 1), (170, 0), (175, 1), (180, 1), (185, 1), (190, 1), (195, 1), (200, 1), (205, 0), (210, 1), (215, 0), (220, 1), (225, 1), (230, 0), (235, 1), (240, 0), (245, 0), (250, 0), (255, 0), (260, 0), (265, 0), (270, 0), (275, 0), (280, 0), (285, 1), (290, 1), (295, 0), (300, 0), (305, 0), (310, 0), (315, 0), (320, 0), (325, 0), (330, 0), (335, 1), (340, 0), (345, 1), (350, 0), (355, 0), (360, 0), (365, 1), (370, 1), (375, 1), (380, 0), (385, 0), (390, 0), (395, 0), (400, 0), (405, 0), (410, 0), (415, 1), (420, 1), (425, 1), (430, 1), (435, 1), (440, 1), (445, 1), (450, 1), (455, 0), (460, 1), (465, 0), (470, 0), (475, 0), (480, 1), (485, 1), (490, 1), (495, 1), (500, 1), (505, 0), (510, 0), (515, 1), (520, 0), (525, 1), (530, 1), (535, 1), (540, 0), (545, 0), (550, 1), (555, 0), (560, 1), (565, 0), (570, 0), (575, 1), (580, 1), (585, 1), (590, 1), (595, 0), (600, 1), (605, 0), (610, 0), (615, 1), (620, 1), (625, 0), (630, 1), (635, 1), (640, 1), (645, 0), (650, 1), (655, 0), (660, 0), (665, 1), (670, 1), (675, 1), (680, 0), (685, 0), (690, 1), (695, 0), (700, 1), (705, 0), (710, 1), (715, 1), (720, 1), (725, 0), (730, 1), (735, 0), (740, 0), (745, 0), (750, 0), (755, 0), (760, 1), (765, 1), (770, 0), (775, 1), (780, 1), (785, 0), (790, 0), (795, 1), (800, 1), (805, 0), (810, 0), (815, 0), (820, 1), (825, 0), (830, 1), (835, 1), (840, 0), (845, 0), (850, 0), (855, 1), (860, 1), (865, 0), (870, 0), (875, 0), (880, 0), (885, 0), (890, 1), (895, 1), (900, 1), (905, 0), (910, 0), (915, 1), (920, 1), (925, 1), (930, 0), (935, 0), (940, 0), (945, 1), (950, 1), (955, 0), (960, 0), (965, 1), (970, 1), (975, 0), (980, 0), (985, 0), (990, 0), (995, 0), (1000, 0), (1005, 0), (1010, 0), (1015, 1), (1020, 1), (1025, 1)]
Va0_1  a0_1  0 PWL (0n 0.0v 4.745n 0.0v 4.755n 1.0v 9.745n 1.0v 9.755n 1.0v 14.745n 1.0v 14.755n 1.0v 19.745n 1.0v 19.755n 1.0v 24.745n 1.0v 24.755n 0.0v 29.745n 0.0v 29.755n 0.0v 34.745n 0.0v 34.755n 1.0v 39.745n 1.0v 39.755n 0.0v 44.745n 0.0v 44.755n 0.0v 49.745n 0.0v 49.755n 0.0v 54.745n 0.0v 54.755n 0.0v 59.745n 0.0v 59.755n 1.0v 64.745n 1.0v 64.755n 1.0v 69.745n 1.0v 69.755n 1.0v 74.745n 1.0v 74.755n 0.0v 79.745n 0.0v 79.755n 1.0v 84.745n 1.0v 84.755n 0.0v 89.745n 0.0v 89.755n 0.0v 94.745n 0.0v 94.755n 0.0v 99.745n 0.0v 99.755n 0.0v 104.745n 0.0v 104.755n 0.0v 109.745n 0.0v 109.755n 0.0v 114.745n 0.0v 114.755n 0.0v 119.745n 0.0v 119.755n 1.0v 124.745n 1.0v 124.755n 1.0v 129.745n 1.0v 129.755n 0.0v 134.745n 0.0v 134.755n 1.0v 139.745n 1.0v 139.755n 0.0v 144.745n 0.0v 144.755n 0.0v 149.745n 0.0v 149.755n 0.0v 154.745n 0.0v 154.755n 1.0v 159.745n 1.0v 159.755n 1.0v 164.745n 1.0v 164.755n 1.0v 169.745n 1.0v 169.755n 0.0v 174.745n 0.0v 174.755n 1.0v 179.745n 1.0v 179.755n 1.0v 184.745n 1.0v 184.755n 1.0v 189.745n 1.0v 189.755n 1.0v 194.745n 1.0v 194.755n 1.0v 199.745n 1.0v 199.755n 1.0v 204.745n 1.0v 204.755n 0.0v 209.745n 0.0v 209.755n 1.0v 214.745n 1.0v 214.755n 0.0v 219.745n 0.0v 219.755n 1.0v 224.745n 1.0v 224.755n 1.0v 229.745n 1.0v 229.755n 0.0v 234.745n 0.0v 234.755n 1.0v 239.745n 1.0v 239.755n 0.0v 244.745n 0.0v 244.755n 0.0v 249.745n 0.0v 249.755n 0.0v 254.745n 0.0v 254.755n 0.0v 259.745n 0.0v 259.755n 0.0v 264.745n 0.0v 264.755n 0.0v 269.745n 0.0v 269.755n 0.0v 274.745n 0.0v 274.755n 0.0v 279.745n 0.0v 279.755n 0.0v 284.745n 0.0v 284.755n 1.0v 289.745n 1.0v 289.755n 1.0v 294.745n 1.0v 294.755n 0.0v 299.745n 0.0v 299.755n 0.0v 304.745n 0.0v 304.755n 0.0v 309.745n 0.0v 309.755n 0.0v 314.745n 0.0v 314.755n 0.0v 319.745n 0.0v 319.755n 0.0v 324.745n 0.0v 324.755n 0.0v 329.745n 0.0v 329.755n 0.0v 334.745n 0.0v 334.755n 1.0v 339.745n 1.0v 339.755n 0.0v 344.745n 0.0v 344.755n 1.0v 349.745n 1.0v 349.755n 0.0v 354.745n 0.0v 354.755n 0.0v 359.745n 0.0v 359.755n 0.0v 364.745n 0.0v 364.755n 1.0v 369.745n 1.0v 369.755n 1.0v 374.745n 1.0v 374.755n 1.0v 379.745n 1.0v 379.755n 0.0v 384.745n 0.0v 384.755n 0.0v 389.745n 0.0v 389.755n 0.0v 394.745n 0.0v 394.755n 0.0v 399.745n 0.0v 399.755n 0.0v 404.745n 0.0v 404.755n 0.0v 409.745n 0.0v 409.755n 0.0v 414.745n 0.0v 414.755n 1.0v 419.745n 1.0v 419.755n 1.0v 424.745n 1.0v 424.755n 1.0v 429.745n 1.0v 429.755n 1.0v 434.745n 1.0v 434.755n 1.0v 439.745n 1.0v 439.755n 1.0v 444.745n 1.0v 444.755n 1.0v 449.745n 1.0v 449.755n 1.0v 454.745n 1.0v 454.755n 0.0v 459.745n 0.0v 459.755n 1.0v 464.745n 1.0v 464.755n 0.0v 469.745n 0.0v 469.755n 0.0v 474.745n 0.0v 474.755n 0.0v 479.745n 0.0v 479.755n 1.0v 484.745n 1.0v 484.755n 1.0v 489.745n 1.0v 489.755n 1.0v 494.745n 1.0v 494.755n 1.0v 499.745n 1.0v 499.755n 1.0v 504.745n 1.0v 504.755n 0.0v 509.745n 0.0v 509.755n 0.0v 514.745n 0.0v 514.755n 1.0v 519.745n 1.0v 519.755n 0.0v 524.745n 0.0v 524.755n 1.0v 529.745n 1.0v 529.755n 1.0v 534.745n 1.0v 534.755n 1.0v 539.745n 1.0v 539.755n 0.0v 544.745n 0.0v 544.755n 0.0v 549.745n 0.0v 549.755n 1.0v 554.745n 1.0v 554.755n 0.0v 559.745n 0.0v 559.755n 1.0v 564.745n 1.0v 564.755n 0.0v 569.745n 0.0v 569.755n 0.0v 574.745n 0.0v 574.755n 1.0v 579.745n 1.0v 579.755n 1.0v 584.745n 1.0v 584.755n 1.0v 589.745n 1.0v 589.755n 1.0v 594.745n 1.0v 594.755n 0.0v 599.745n 0.0v 599.755n 1.0v 604.745n 1.0v 604.755n 0.0v 609.745n 0.0v 609.755n 0.0v 614.745n 0.0v 614.755n 1.0v 619.745n 1.0v 619.755n 1.0v 624.745n 1.0v 624.755n 0.0v 629.745n 0.0v 629.755n 1.0v 634.745n 1.0v 634.755n 1.0v 639.745n 1.0v 639.755n 1.0v 644.745n 1.0v 644.755n 0.0v 649.745n 0.0v 649.755n 1.0v 654.745n 1.0v 654.755n 0.0v 659.745n 0.0v 659.755n 0.0v 664.745n 0.0v 664.755n 1.0v 669.745n 1.0v 669.755n 1.0v 674.745n 1.0v 674.755n 1.0v 679.745n 1.0v 679.755n 0.0v 684.745n 0.0v 684.755n 0.0v 689.745n 0.0v 689.755n 1.0v 694.745n 1.0v 694.755n 0.0v 699.745n 0.0v 699.755n 1.0v 704.745n 1.0v 704.755n 0.0v 709.745n 0.0v 709.755n 1.0v 714.745n 1.0v 714.755n 1.0v 719.745n 1.0v 719.755n 1.0v 724.745n 1.0v 724.755n 0.0v 729.745n 0.0v 729.755n 1.0v 734.745n 1.0v 734.755n 0.0v 739.745n 0.0v 739.755n 0.0v 744.745n 0.0v 744.755n 0.0v 749.745n 0.0v 749.755n 0.0v 754.745n 0.0v 754.755n 0.0v 759.745n 0.0v 759.755n 1.0v 764.745n 1.0v 764.755n 1.0v 769.745n 1.0v 769.755n 0.0v 774.745n 0.0v 774.755n 1.0v 779.745n 1.0v 779.755n 1.0v 784.745n 1.0v 784.755n 0.0v 789.745n 0.0v 789.755n 0.0v 794.745n 0.0v 794.755n 1.0v 799.745n 1.0v 799.755n 1.0v 804.745n 1.0v 804.755n 0.0v 809.745n 0.0v 809.755n 0.0v 814.745n 0.0v 814.755n 0.0v 819.745n 0.0v 819.755n 1.0v 824.745n 1.0v 824.755n 0.0v 829.745n 0.0v 829.755n 1.0v 834.745n 1.0v 834.755n 1.0v 839.745n 1.0v 839.755n 0.0v 844.745n 0.0v 844.755n 0.0v 849.745n 0.0v 849.755n 0.0v 854.745n 0.0v 854.755n 1.0v 859.745n 1.0v 859.755n 1.0v 864.745n 1.0v 864.755n 0.0v 869.745n 0.0v 869.755n 0.0v 874.745n 0.0v 874.755n 0.0v 879.745n 0.0v 879.755n 0.0v 884.745n 0.0v 884.755n 0.0v 889.745n 0.0v 889.755n 1.0v 894.745n 1.0v 894.755n 1.0v 899.745n 1.0v 899.755n 1.0v 904.745n 1.0v 904.755n 0.0v 909.745n 0.0v 909.755n 0.0v 914.745n 0.0v 914.755n 1.0v 919.745n 1.0v 919.755n 1.0v 924.745n 1.0v 924.755n 1.0v 929.745n 1.0v 929.755n 0.0v 934.745n 0.0v 934.755n 0.0v 939.745n 0.0v 939.755n 0.0v 944.745n 0.0v 944.755n 1.0v 949.745n 1.0v 949.755n 1.0v 954.745n 1.0v 954.755n 0.0v 959.745n 0.0v 959.755n 0.0v 964.745n 0.0v 964.755n 1.0v 969.745n 1.0v 969.755n 1.0v 974.745n 1.0v 974.755n 0.0v 979.745n 0.0v 979.755n 0.0v 984.745n 0.0v 984.755n 0.0v 989.745n 0.0v 989.755n 0.0v 994.745n 0.0v 994.755n 0.0v 999.745n 0.0v 999.755n 0.0v 1004.745n 0.0v 1004.755n 0.0v 1009.745n 0.0v 1009.755n 0.0v 1014.745n 0.0v 1014.755n 1.0v 1019.745n 1.0v 1019.755n 1.0v 1024.745n 1.0v 1024.755n 1.0v )
* (time, data): [(0, 0), (5, 0), (10, 0), (15, 0), (20, 0), (25, 0), (30, 0), (35, 0), (40, 0), (45, 0), (50, 1), (55, 1), (60, 0), (65, 0), (70, 0), (75, 0), (80, 0), (85, 0), (90, 0), (95, 1), (100, 1), (105, 0), (110, 0), (115, 0), (120, 0), (125, 0), (130, 1), (135, 0), (140, 0), (145, 1), (150, 1), (155, 0), (160, 0), (165, 0), (170, 1), (175, 1), (180, 1), (185, 0), (190, 0), (195, 0), (200, 0), (205, 0), (210, 0), (215, 0), (220, 0), (225, 0), (230, 1), (235, 0), (240, 1), (245, 0), (250, 1), (255, 1), (260, 1), (265, 0), (270, 0), (275, 0), (280, 0), (285, 0), (290, 1), (295, 1), (300, 0), (305, 0), (310, 1), (315, 1), (320, 1), (325, 1), (330, 1), (335, 1), (340, 1), (345, 0), (350, 1), (355, 1), (360, 1), (365, 1), (370, 1), (375, 1), (380, 1), (385, 1), (390, 0), (395, 1), (400, 1), (405, 0), (410, 0), (415, 0), (420, 1), (425, 1), (430, 0), (435, 0), (440, 0), (445, 0), (450, 0), (455, 0), (460, 0), (465, 0), (470, 1), (475, 1), (480, 0), (485, 1), (490, 1), (495, 0), (500, 1), (505, 1), (510, 1), (515, 0), (520, 1), (525, 0), (530, 0), (535, 0), (540, 0), (545, 0), (550, 0), (555, 1), (560, 0), (565, 0), (570, 1), (575, 0), (580, 0), (585, 0), (590, 0), (595, 0), (600, 0), (605, 1), (610, 1), (615, 0), (620, 0), (625, 0), (630, 1), (635, 0), (640, 0), (645, 1), (650, 0), (655, 1), (660, 1), (665, 1), (670, 0), (675, 1), (680, 1), (685, 1), (690, 0), (695, 1), (700, 0), (705, 0), (710, 0), (715, 0), (720, 0), (725, 1), (730, 0), (735, 1), (740, 1), (745, 0), (750, 1), (755, 1), (760, 1), (765, 0), (770, 1), (775, 0), (780, 0), (785, 1), (790, 0), (795, 0), (800, 0), (805, 0), (810, 1), (815, 0), (820, 1), (825, 1), (830, 0), (835, 0), (840, 1), (845, 1), (850, 0), (855, 0), (860, 0), (865, 1), (870, 0), (875, 1), (880, 0), (885, 0), (890, 0), (895, 1), (900, 0), (905, 0), (910, 1), (915, 0), (920, 0), (925, 0), (930, 1), (935, 1), (940, 0), (945, 0), (950, 0), (955, 1), (960, 1), (965, 0), (970, 1), (975, 0), (980, 0), (985, 0), (990, 0), (995, 0), (1000, 1), (1005, 1), (1010, 1), (1015, 0), (1020, 0), (1025, 0)]
Va0_2  a0_2  0 PWL (0n 0.0v 4.745n 0.0v 4.755n 0.0v 9.745n 0.0v 9.755n 0.0v 14.745n 0.0v 14.755n 0.0v 19.745n 0.0v 19.755n 0.0v 24.745n 0.0v 24.755n 0.0v 29.745n 0.0v 29.755n 0.0v 34.745n 0.0v 34.755n 0.0v 39.745n 0.0v 39.755n 0.0v 44.745n 0.0v 44.755n 0.0v 49.745n 0.0v 49.755n 1.0v 54.745n 1.0v 54.755n 1.0v 59.745n 1.0v 59.755n 0.0v 64.745n 0.0v 64.755n 0.0v 69.745n 0.0v 69.755n 0.0v 74.745n 0.0v 74.755n 0.0v 79.745n 0.0v 79.755n 0.0v 84.745n 0.0v 84.755n 0.0v 89.745n 0.0v 89.755n 0.0v 94.745n 0.0v 94.755n 1.0v 99.745n 1.0v 99.755n 1.0v 104.745n 1.0v 104.755n 0.0v 109.745n 0.0v 109.755n 0.0v 114.745n 0.0v 114.755n 0.0v 119.745n 0.0v 119.755n 0.0v 124.745n 0.0v 124.755n 0.0v 129.745n 0.0v 129.755n 1.0v 134.745n 1.0v 134.755n 0.0v 139.745n 0.0v 139.755n 0.0v 144.745n 0.0v 144.755n 1.0v 149.745n 1.0v 149.755n 1.0v 154.745n 1.0v 154.755n 0.0v 159.745n 0.0v 159.755n 0.0v 164.745n 0.0v 164.755n 0.0v 169.745n 0.0v 169.755n 1.0v 174.745n 1.0v 174.755n 1.0v 179.745n 1.0v 179.755n 1.0v 184.745n 1.0v 184.755n 0.0v 189.745n 0.0v 189.755n 0.0v 194.745n 0.0v 194.755n 0.0v 199.745n 0.0v 199.755n 0.0v 204.745n 0.0v 204.755n 0.0v 209.745n 0.0v 209.755n 0.0v 214.745n 0.0v 214.755n 0.0v 219.745n 0.0v 219.755n 0.0v 224.745n 0.0v 224.755n 0.0v 229.745n 0.0v 229.755n 1.0v 234.745n 1.0v 234.755n 0.0v 239.745n 0.0v 239.755n 1.0v 244.745n 1.0v 244.755n 0.0v 249.745n 0.0v 249.755n 1.0v 254.745n 1.0v 254.755n 1.0v 259.745n 1.0v 259.755n 1.0v 264.745n 1.0v 264.755n 0.0v 269.745n 0.0v 269.755n 0.0v 274.745n 0.0v 274.755n 0.0v 279.745n 0.0v 279.755n 0.0v 284.745n 0.0v 284.755n 0.0v 289.745n 0.0v 289.755n 1.0v 294.745n 1.0v 294.755n 1.0v 299.745n 1.0v 299.755n 0.0v 304.745n 0.0v 304.755n 0.0v 309.745n 0.0v 309.755n 1.0v 314.745n 1.0v 314.755n 1.0v 319.745n 1.0v 319.755n 1.0v 324.745n 1.0v 324.755n 1.0v 329.745n 1.0v 329.755n 1.0v 334.745n 1.0v 334.755n 1.0v 339.745n 1.0v 339.755n 1.0v 344.745n 1.0v 344.755n 0.0v 349.745n 0.0v 349.755n 1.0v 354.745n 1.0v 354.755n 1.0v 359.745n 1.0v 359.755n 1.0v 364.745n 1.0v 364.755n 1.0v 369.745n 1.0v 369.755n 1.0v 374.745n 1.0v 374.755n 1.0v 379.745n 1.0v 379.755n 1.0v 384.745n 1.0v 384.755n 1.0v 389.745n 1.0v 389.755n 0.0v 394.745n 0.0v 394.755n 1.0v 399.745n 1.0v 399.755n 1.0v 404.745n 1.0v 404.755n 0.0v 409.745n 0.0v 409.755n 0.0v 414.745n 0.0v 414.755n 0.0v 419.745n 0.0v 419.755n 1.0v 424.745n 1.0v 424.755n 1.0v 429.745n 1.0v 429.755n 0.0v 434.745n 0.0v 434.755n 0.0v 439.745n 0.0v 439.755n 0.0v 444.745n 0.0v 444.755n 0.0v 449.745n 0.0v 449.755n 0.0v 454.745n 0.0v 454.755n 0.0v 459.745n 0.0v 459.755n 0.0v 464.745n 0.0v 464.755n 0.0v 469.745n 0.0v 469.755n 1.0v 474.745n 1.0v 474.755n 1.0v 479.745n 1.0v 479.755n 0.0v 484.745n 0.0v 484.755n 1.0v 489.745n 1.0v 489.755n 1.0v 494.745n 1.0v 494.755n 0.0v 499.745n 0.0v 499.755n 1.0v 504.745n 1.0v 504.755n 1.0v 509.745n 1.0v 509.755n 1.0v 514.745n 1.0v 514.755n 0.0v 519.745n 0.0v 519.755n 1.0v 524.745n 1.0v 524.755n 0.0v 529.745n 0.0v 529.755n 0.0v 534.745n 0.0v 534.755n 0.0v 539.745n 0.0v 539.755n 0.0v 544.745n 0.0v 544.755n 0.0v 549.745n 0.0v 549.755n 0.0v 554.745n 0.0v 554.755n 1.0v 559.745n 1.0v 559.755n 0.0v 564.745n 0.0v 564.755n 0.0v 569.745n 0.0v 569.755n 1.0v 574.745n 1.0v 574.755n 0.0v 579.745n 0.0v 579.755n 0.0v 584.745n 0.0v 584.755n 0.0v 589.745n 0.0v 589.755n 0.0v 594.745n 0.0v 594.755n 0.0v 599.745n 0.0v 599.755n 0.0v 604.745n 0.0v 604.755n 1.0v 609.745n 1.0v 609.755n 1.0v 614.745n 1.0v 614.755n 0.0v 619.745n 0.0v 619.755n 0.0v 624.745n 0.0v 624.755n 0.0v 629.745n 0.0v 629.755n 1.0v 634.745n 1.0v 634.755n 0.0v 639.745n 0.0v 639.755n 0.0v 644.745n 0.0v 644.755n 1.0v 649.745n 1.0v 649.755n 0.0v 654.745n 0.0v 654.755n 1.0v 659.745n 1.0v 659.755n 1.0v 664.745n 1.0v 664.755n 1.0v 669.745n 1.0v 669.755n 0.0v 674.745n 0.0v 674.755n 1.0v 679.745n 1.0v 679.755n 1.0v 684.745n 1.0v 684.755n 1.0v 689.745n 1.0v 689.755n 0.0v 694.745n 0.0v 694.755n 1.0v 699.745n 1.0v 699.755n 0.0v 704.745n 0.0v 704.755n 0.0v 709.745n 0.0v 709.755n 0.0v 714.745n 0.0v 714.755n 0.0v 719.745n 0.0v 719.755n 0.0v 724.745n 0.0v 724.755n 1.0v 729.745n 1.0v 729.755n 0.0v 734.745n 0.0v 734.755n 1.0v 739.745n 1.0v 739.755n 1.0v 744.745n 1.0v 744.755n 0.0v 749.745n 0.0v 749.755n 1.0v 754.745n 1.0v 754.755n 1.0v 759.745n 1.0v 759.755n 1.0v 764.745n 1.0v 764.755n 0.0v 769.745n 0.0v 769.755n 1.0v 774.745n 1.0v 774.755n 0.0v 779.745n 0.0v 779.755n 0.0v 784.745n 0.0v 784.755n 1.0v 789.745n 1.0v 789.755n 0.0v 794.745n 0.0v 794.755n 0.0v 799.745n 0.0v 799.755n 0.0v 804.745n 0.0v 804.755n 0.0v 809.745n 0.0v 809.755n 1.0v 814.745n 1.0v 814.755n 0.0v 819.745n 0.0v 819.755n 1.0v 824.745n 1.0v 824.755n 1.0v 829.745n 1.0v 829.755n 0.0v 834.745n 0.0v 834.755n 0.0v 839.745n 0.0v 839.755n 1.0v 844.745n 1.0v 844.755n 1.0v 849.745n 1.0v 849.755n 0.0v 854.745n 0.0v 854.755n 0.0v 859.745n 0.0v 859.755n 0.0v 864.745n 0.0v 864.755n 1.0v 869.745n 1.0v 869.755n 0.0v 874.745n 0.0v 874.755n 1.0v 879.745n 1.0v 879.755n 0.0v 884.745n 0.0v 884.755n 0.0v 889.745n 0.0v 889.755n 0.0v 894.745n 0.0v 894.755n 1.0v 899.745n 1.0v 899.755n 0.0v 904.745n 0.0v 904.755n 0.0v 909.745n 0.0v 909.755n 1.0v 914.745n 1.0v 914.755n 0.0v 919.745n 0.0v 919.755n 0.0v 924.745n 0.0v 924.755n 0.0v 929.745n 0.0v 929.755n 1.0v 934.745n 1.0v 934.755n 1.0v 939.745n 1.0v 939.755n 0.0v 944.745n 0.0v 944.755n 0.0v 949.745n 0.0v 949.755n 0.0v 954.745n 0.0v 954.755n 1.0v 959.745n 1.0v 959.755n 1.0v 964.745n 1.0v 964.755n 0.0v 969.745n 0.0v 969.755n 1.0v 974.745n 1.0v 974.755n 0.0v 979.745n 0.0v 979.755n 0.0v 984.745n 0.0v 984.755n 0.0v 989.745n 0.0v 989.755n 0.0v 994.745n 0.0v 994.755n 0.0v 999.745n 0.0v 999.755n 1.0v 1004.745n 1.0v 1004.755n 1.0v 1009.745n 1.0v 1009.755n 1.0v 1014.745n 1.0v 1014.755n 0.0v 1019.745n 0.0v 1019.755n 0.0v 1024.745n 0.0v 1024.755n 0.0v )
* (time, data): [(0, 0), (5, 0), (10, 0), (15, 0), (20, 0), (25, 0), (30, 0), (35, 0), (40, 0), (45, 0), (50, 1), (55, 1), (60, 0), (65, 0), (70, 0), (75, 0), (80, 0), (85, 0), (90, 0), (95, 1), (100, 1), (105, 0), (110, 0), (115, 0), (120, 0), (125, 0), (130, 1), (135, 0), (140, 0), (145, 1), (150, 1), (155, 0), (160, 0), (165, 0), (170, 1), (175, 1), (180, 1), (185, 1), (190, 0), (195, 1), (200, 0), (205, 0), (210, 1), (215, 0), (220, 0), (225, 0), (230, 1), (235, 1), (240, 1), (245, 0), (250, 1), (255, 1), (260, 1), (265, 0), (270, 0), (275, 0), (280, 0), (285, 0), (290, 1), (295, 1), (300, 0), (305, 0), (310, 1), (315, 1), (320, 1), (325, 1), (330, 1), (335, 1), (340, 1), (345, 0), (350, 1), (355, 1), (360, 1), (365, 1), (370, 1), (375, 1), (380, 1), (385, 1), (390, 0), (395, 1), (400, 1), (405, 0), (410, 0), (415, 0), (420, 1), (425, 1), (430, 1), (435, 0), (440, 0), (445, 0), (450, 1), (455, 0), (460, 0), (465, 0), (470, 1), (475, 1), (480, 1), (485, 1), (490, 1), (495, 1), (500, 1), (505, 1), (510, 1), (515, 0), (520, 1), (525, 1), (530, 1), (535, 0), (540, 0), (545, 0), (550, 0), (555, 1), (560, 1), (565, 0), (570, 1), (575, 0), (580, 0), (585, 0), (590, 0), (595, 0), (600, 1), (605, 1), (610, 1), (615, 1), (620, 0), (625, 0), (630, 1), (635, 0), (640, 0), (645, 1), (650, 0), (655, 1), (660, 1), (665, 1), (670, 0), (675, 1), (680, 1), (685, 1), (690, 1), (695, 1), (700, 1), (705, 0), (710, 0), (715, 1), (720, 1), (725, 1), (730, 0), (735, 1), (740, 1), (745, 0), (750, 1), (755, 1), (760, 1), (765, 0), (770, 1), (775, 0), (780, 1), (785, 1), (790, 0), (795, 1), (800, 1), (805, 0), (810, 1), (815, 0), (820, 1), (825, 1), (830, 0), (835, 1), (840, 1), (845, 1), (850, 0), (855, 1), (860, 0), (865, 1), (870, 0), (875, 1), (880, 0), (885, 0), (890, 0), (895, 1), (900, 0), (905, 0), (910, 1), (915, 0), (920, 0), (925, 0), (930, 1), (935, 1), (940, 0), (945, 1), (950, 1), (955, 1), (960, 1), (965, 0), (970, 1), (975, 0), (980, 0), (985, 0), (990, 0), (995, 0), (1000, 1), (1005, 1), (1010, 1), (1015, 0), (1020, 1), (1025, 1)]
Va0_3  a0_3  0 PWL (0n 0.0v 4.745n 0.0v 4.755n 0.0v 9.745n 0.0v 9.755n 0.0v 14.745n 0.0v 14.755n 0.0v 19.745n 0.0v 19.755n 0.0v 24.745n 0.0v 24.755n 0.0v 29.745n 0.0v 29.755n 0.0v 34.745n 0.0v 34.755n 0.0v 39.745n 0.0v 39.755n 0.0v 44.745n 0.0v 44.755n 0.0v 49.745n 0.0v 49.755n 1.0v 54.745n 1.0v 54.755n 1.0v 59.745n 1.0v 59.755n 0.0v 64.745n 0.0v 64.755n 0.0v 69.745n 0.0v 69.755n 0.0v 74.745n 0.0v 74.755n 0.0v 79.745n 0.0v 79.755n 0.0v 84.745n 0.0v 84.755n 0.0v 89.745n 0.0v 89.755n 0.0v 94.745n 0.0v 94.755n 1.0v 99.745n 1.0v 99.755n 1.0v 104.745n 1.0v 104.755n 0.0v 109.745n 0.0v 109.755n 0.0v 114.745n 0.0v 114.755n 0.0v 119.745n 0.0v 119.755n 0.0v 124.745n 0.0v 124.755n 0.0v 129.745n 0.0v 129.755n 1.0v 134.745n 1.0v 134.755n 0.0v 139.745n 0.0v 139.755n 0.0v 144.745n 0.0v 144.755n 1.0v 149.745n 1.0v 149.755n 1.0v 154.745n 1.0v 154.755n 0.0v 159.745n 0.0v 159.755n 0.0v 164.745n 0.0v 164.755n 0.0v 169.745n 0.0v 169.755n 1.0v 174.745n 1.0v 174.755n 1.0v 179.745n 1.0v 179.755n 1.0v 184.745n 1.0v 184.755n 1.0v 189.745n 1.0v 189.755n 0.0v 194.745n 0.0v 194.755n 1.0v 199.745n 1.0v 199.755n 0.0v 204.745n 0.0v 204.755n 0.0v 209.745n 0.0v 209.755n 1.0v 214.745n 1.0v 214.755n 0.0v 219.745n 0.0v 219.755n 0.0v 224.745n 0.0v 224.755n 0.0v 229.745n 0.0v 229.755n 1.0v 234.745n 1.0v 234.755n 1.0v 239.745n 1.0v 239.755n 1.0v 244.745n 1.0v 244.755n 0.0v 249.745n 0.0v 249.755n 1.0v 254.745n 1.0v 254.755n 1.0v 259.745n 1.0v 259.755n 1.0v 264.745n 1.0v 264.755n 0.0v 269.745n 0.0v 269.755n 0.0v 274.745n 0.0v 274.755n 0.0v 279.745n 0.0v 279.755n 0.0v 284.745n 0.0v 284.755n 0.0v 289.745n 0.0v 289.755n 1.0v 294.745n 1.0v 294.755n 1.0v 299.745n 1.0v 299.755n 0.0v 304.745n 0.0v 304.755n 0.0v 309.745n 0.0v 309.755n 1.0v 314.745n 1.0v 314.755n 1.0v 319.745n 1.0v 319.755n 1.0v 324.745n 1.0v 324.755n 1.0v 329.745n 1.0v 329.755n 1.0v 334.745n 1.0v 334.755n 1.0v 339.745n 1.0v 339.755n 1.0v 344.745n 1.0v 344.755n 0.0v 349.745n 0.0v 349.755n 1.0v 354.745n 1.0v 354.755n 1.0v 359.745n 1.0v 359.755n 1.0v 364.745n 1.0v 364.755n 1.0v 369.745n 1.0v 369.755n 1.0v 374.745n 1.0v 374.755n 1.0v 379.745n 1.0v 379.755n 1.0v 384.745n 1.0v 384.755n 1.0v 389.745n 1.0v 389.755n 0.0v 394.745n 0.0v 394.755n 1.0v 399.745n 1.0v 399.755n 1.0v 404.745n 1.0v 404.755n 0.0v 409.745n 0.0v 409.755n 0.0v 414.745n 0.0v 414.755n 0.0v 419.745n 0.0v 419.755n 1.0v 424.745n 1.0v 424.755n 1.0v 429.745n 1.0v 429.755n 1.0v 434.745n 1.0v 434.755n 0.0v 439.745n 0.0v 439.755n 0.0v 444.745n 0.0v 444.755n 0.0v 449.745n 0.0v 449.755n 1.0v 454.745n 1.0v 454.755n 0.0v 459.745n 0.0v 459.755n 0.0v 464.745n 0.0v 464.755n 0.0v 469.745n 0.0v 469.755n 1.0v 474.745n 1.0v 474.755n 1.0v 479.745n 1.0v 479.755n 1.0v 484.745n 1.0v 484.755n 1.0v 489.745n 1.0v 489.755n 1.0v 494.745n 1.0v 494.755n 1.0v 499.745n 1.0v 499.755n 1.0v 504.745n 1.0v 504.755n 1.0v 509.745n 1.0v 509.755n 1.0v 514.745n 1.0v 514.755n 0.0v 519.745n 0.0v 519.755n 1.0v 524.745n 1.0v 524.755n 1.0v 529.745n 1.0v 529.755n 1.0v 534.745n 1.0v 534.755n 0.0v 539.745n 0.0v 539.755n 0.0v 544.745n 0.0v 544.755n 0.0v 549.745n 0.0v 549.755n 0.0v 554.745n 0.0v 554.755n 1.0v 559.745n 1.0v 559.755n 1.0v 564.745n 1.0v 564.755n 0.0v 569.745n 0.0v 569.755n 1.0v 574.745n 1.0v 574.755n 0.0v 579.745n 0.0v 579.755n 0.0v 584.745n 0.0v 584.755n 0.0v 589.745n 0.0v 589.755n 0.0v 594.745n 0.0v 594.755n 0.0v 599.745n 0.0v 599.755n 1.0v 604.745n 1.0v 604.755n 1.0v 609.745n 1.0v 609.755n 1.0v 614.745n 1.0v 614.755n 1.0v 619.745n 1.0v 619.755n 0.0v 624.745n 0.0v 624.755n 0.0v 629.745n 0.0v 629.755n 1.0v 634.745n 1.0v 634.755n 0.0v 639.745n 0.0v 639.755n 0.0v 644.745n 0.0v 644.755n 1.0v 649.745n 1.0v 649.755n 0.0v 654.745n 0.0v 654.755n 1.0v 659.745n 1.0v 659.755n 1.0v 664.745n 1.0v 664.755n 1.0v 669.745n 1.0v 669.755n 0.0v 674.745n 0.0v 674.755n 1.0v 679.745n 1.0v 679.755n 1.0v 684.745n 1.0v 684.755n 1.0v 689.745n 1.0v 689.755n 1.0v 694.745n 1.0v 694.755n 1.0v 699.745n 1.0v 699.755n 1.0v 704.745n 1.0v 704.755n 0.0v 709.745n 0.0v 709.755n 0.0v 714.745n 0.0v 714.755n 1.0v 719.745n 1.0v 719.755n 1.0v 724.745n 1.0v 724.755n 1.0v 729.745n 1.0v 729.755n 0.0v 734.745n 0.0v 734.755n 1.0v 739.745n 1.0v 739.755n 1.0v 744.745n 1.0v 744.755n 0.0v 749.745n 0.0v 749.755n 1.0v 754.745n 1.0v 754.755n 1.0v 759.745n 1.0v 759.755n 1.0v 764.745n 1.0v 764.755n 0.0v 769.745n 0.0v 769.755n 1.0v 774.745n 1.0v 774.755n 0.0v 779.745n 0.0v 779.755n 1.0v 784.745n 1.0v 784.755n 1.0v 789.745n 1.0v 789.755n 0.0v 794.745n 0.0v 794.755n 1.0v 799.745n 1.0v 799.755n 1.0v 804.745n 1.0v 804.755n 0.0v 809.745n 0.0v 809.755n 1.0v 814.745n 1.0v 814.755n 0.0v 819.745n 0.0v 819.755n 1.0v 824.745n 1.0v 824.755n 1.0v 829.745n 1.0v 829.755n 0.0v 834.745n 0.0v 834.755n 1.0v 839.745n 1.0v 839.755n 1.0v 844.745n 1.0v 844.755n 1.0v 849.745n 1.0v 849.755n 0.0v 854.745n 0.0v 854.755n 1.0v 859.745n 1.0v 859.755n 0.0v 864.745n 0.0v 864.755n 1.0v 869.745n 1.0v 869.755n 0.0v 874.745n 0.0v 874.755n 1.0v 879.745n 1.0v 879.755n 0.0v 884.745n 0.0v 884.755n 0.0v 889.745n 0.0v 889.755n 0.0v 894.745n 0.0v 894.755n 1.0v 899.745n 1.0v 899.755n 0.0v 904.745n 0.0v 904.755n 0.0v 909.745n 0.0v 909.755n 1.0v 914.745n 1.0v 914.755n 0.0v 919.745n 0.0v 919.755n 0.0v 924.745n 0.0v 924.755n 0.0v 929.745n 0.0v 929.755n 1.0v 934.745n 1.0v 934.755n 1.0v 939.745n 1.0v 939.755n 0.0v 944.745n 0.0v 944.755n 1.0v 949.745n 1.0v 949.755n 1.0v 954.745n 1.0v 954.755n 1.0v 959.745n 1.0v 959.755n 1.0v 964.745n 1.0v 964.755n 0.0v 969.745n 0.0v 969.755n 1.0v 974.745n 1.0v 974.755n 0.0v 979.745n 0.0v 979.755n 0.0v 984.745n 0.0v 984.755n 0.0v 989.745n 0.0v 989.755n 0.0v 994.745n 0.0v 994.755n 0.0v 999.745n 0.0v 999.755n 1.0v 1004.745n 1.0v 1004.755n 1.0v 1009.745n 1.0v 1009.755n 1.0v 1014.745n 1.0v 1014.755n 0.0v 1019.745n 0.0v 1019.755n 1.0v 1024.745n 1.0v 1024.755n 1.0v )
* (time, data): [(0, 0), (5, 0), (10, 0), (15, 0), (20, 0), (25, 0), (30, 0), (35, 0), (40, 0), (45, 0), (50, 1), (55, 1), (60, 0), (65, 0), (70, 0), (75, 0), (80, 0), (85, 0), (90, 0), (95, 1), (100, 1), (105, 0), (110, 0), (115, 0), (120, 0), (125, 0), (130, 1), (135, 0), (140, 0), (145, 1), (150, 1), (155, 0), (160, 0), (165, 0), (170, 1), (175, 1), (180, 1), (185, 1), (190, 0), (195, 1), (200, 0), (205, 0), (210, 1), (215, 0), (220, 0), (225, 0), (230, 1), (235, 1), (240, 1), (245, 0), (250, 1), (255, 1), (260, 1), (265, 0), (270, 0), (275, 0), (280, 0), (285, 0), (290, 1), (295, 1), (300, 0), (305, 0), (310, 1), (315, 1), (320, 1), (325, 1), (330, 1), (335, 1), (340, 1), (345, 0), (350, 1), (355, 1), (360, 1), (365, 1), (370, 1), (375, 1), (380, 1), (385, 1), (390, 0), (395, 1), (400, 1), (405, 0), (410, 0), (415, 0), (420, 1), (425, 1), (430, 1), (435, 0), (440, 0), (445, 0), (450, 1), (455, 0), (460, 0), (465, 0), (470, 1), (475, 1), (480, 1), (485, 1), (490, 1), (495, 1), (500, 1), (505, 1), (510, 1), (515, 0), (520, 1), (525, 1), (530, 1), (535, 0), (540, 0), (545, 0), (550, 0), (555, 1), (560, 1), (565, 0), (570, 1), (575, 0), (580, 0), (585, 0), (590, 0), (595, 0), (600, 1), (605, 1), (610, 1), (615, 1), (620, 0), (625, 0), (630, 1), (635, 0), (640, 0), (645, 1), (650, 0), (655, 1), (660, 1), (665, 1), (670, 0), (675, 1), (680, 1), (685, 1), (690, 1), (695, 1), (700, 1), (705, 0), (710, 0), (715, 1), (720, 1), (725, 1), (730, 0), (735, 1), (740, 1), (745, 0), (750, 1), (755, 1), (760, 1), (765, 0), (770, 1), (775, 0), (780, 1), (785, 1), (790, 0), (795, 1), (800, 1), (805, 0), (810, 1), (815, 0), (820, 1), (825, 1), (830, 0), (835, 1), (840, 1), (845, 1), (850, 0), (855, 1), (860, 0), (865, 1), (870, 0), (875, 1), (880, 0), (885, 0), (890, 0), (895, 1), (900, 0), (905, 0), (910, 1), (915, 0), (920, 0), (925, 0), (930, 1), (935, 1), (940, 0), (945, 1), (950, 1), (955, 1), (960, 1), (965, 0), (970, 1), (975, 0), (980, 0), (985, 0), (990, 0), (995, 0), (1000, 1), (1005, 1), (1010, 1), (1015, 0), (1020, 1), (1025, 1)]
Va0_4  a0_4  0 PWL (0n 0.0v 4.745n 0.0v 4.755n 0.0v 9.745n 0.0v 9.755n 0.0v 14.745n 0.0v 14.755n 0.0v 19.745n 0.0v 19.755n 0.0v 24.745n 0.0v 24.755n 0.0v 29.745n 0.0v 29.755n 0.0v 34.745n 0.0v 34.755n 0.0v 39.745n 0.0v 39.755n 0.0v 44.745n 0.0v 44.755n 0.0v 49.745n 0.0v 49.755n 1.0v 54.745n 1.0v 54.755n 1.0v 59.745n 1.0v 59.755n 0.0v 64.745n 0.0v 64.755n 0.0v 69.745n 0.0v 69.755n 0.0v 74.745n 0.0v 74.755n 0.0v 79.745n 0.0v 79.755n 0.0v 84.745n 0.0v 84.755n 0.0v 89.745n 0.0v 89.755n 0.0v 94.745n 0.0v 94.755n 1.0v 99.745n 1.0v 99.755n 1.0v 104.745n 1.0v 104.755n 0.0v 109.745n 0.0v 109.755n 0.0v 114.745n 0.0v 114.755n 0.0v 119.745n 0.0v 119.755n 0.0v 124.745n 0.0v 124.755n 0.0v 129.745n 0.0v 129.755n 1.0v 134.745n 1.0v 134.755n 0.0v 139.745n 0.0v 139.755n 0.0v 144.745n 0.0v 144.755n 1.0v 149.745n 1.0v 149.755n 1.0v 154.745n 1.0v 154.755n 0.0v 159.745n 0.0v 159.755n 0.0v 164.745n 0.0v 164.755n 0.0v 169.745n 0.0v 169.755n 1.0v 174.745n 1.0v 174.755n 1.0v 179.745n 1.0v 179.755n 1.0v 184.745n 1.0v 184.755n 1.0v 189.745n 1.0v 189.755n 0.0v 194.745n 0.0v 194.755n 1.0v 199.745n 1.0v 199.755n 0.0v 204.745n 0.0v 204.755n 0.0v 209.745n 0.0v 209.755n 1.0v 214.745n 1.0v 214.755n 0.0v 219.745n 0.0v 219.755n 0.0v 224.745n 0.0v 224.755n 0.0v 229.745n 0.0v 229.755n 1.0v 234.745n 1.0v 234.755n 1.0v 239.745n 1.0v 239.755n 1.0v 244.745n 1.0v 244.755n 0.0v 249.745n 0.0v 249.755n 1.0v 254.745n 1.0v 254.755n 1.0v 259.745n 1.0v 259.755n 1.0v 264.745n 1.0v 264.755n 0.0v 269.745n 0.0v 269.755n 0.0v 274.745n 0.0v 274.755n 0.0v 279.745n 0.0v 279.755n 0.0v 284.745n 0.0v 284.755n 0.0v 289.745n 0.0v 289.755n 1.0v 294.745n 1.0v 294.755n 1.0v 299.745n 1.0v 299.755n 0.0v 304.745n 0.0v 304.755n 0.0v 309.745n 0.0v 309.755n 1.0v 314.745n 1.0v 314.755n 1.0v 319.745n 1.0v 319.755n 1.0v 324.745n 1.0v 324.755n 1.0v 329.745n 1.0v 329.755n 1.0v 334.745n 1.0v 334.755n 1.0v 339.745n 1.0v 339.755n 1.0v 344.745n 1.0v 344.755n 0.0v 349.745n 0.0v 349.755n 1.0v 354.745n 1.0v 354.755n 1.0v 359.745n 1.0v 359.755n 1.0v 364.745n 1.0v 364.755n 1.0v 369.745n 1.0v 369.755n 1.0v 374.745n 1.0v 374.755n 1.0v 379.745n 1.0v 379.755n 1.0v 384.745n 1.0v 384.755n 1.0v 389.745n 1.0v 389.755n 0.0v 394.745n 0.0v 394.755n 1.0v 399.745n 1.0v 399.755n 1.0v 404.745n 1.0v 404.755n 0.0v 409.745n 0.0v 409.755n 0.0v 414.745n 0.0v 414.755n 0.0v 419.745n 0.0v 419.755n 1.0v 424.745n 1.0v 424.755n 1.0v 429.745n 1.0v 429.755n 1.0v 434.745n 1.0v 434.755n 0.0v 439.745n 0.0v 439.755n 0.0v 444.745n 0.0v 444.755n 0.0v 449.745n 0.0v 449.755n 1.0v 454.745n 1.0v 454.755n 0.0v 459.745n 0.0v 459.755n 0.0v 464.745n 0.0v 464.755n 0.0v 469.745n 0.0v 469.755n 1.0v 474.745n 1.0v 474.755n 1.0v 479.745n 1.0v 479.755n 1.0v 484.745n 1.0v 484.755n 1.0v 489.745n 1.0v 489.755n 1.0v 494.745n 1.0v 494.755n 1.0v 499.745n 1.0v 499.755n 1.0v 504.745n 1.0v 504.755n 1.0v 509.745n 1.0v 509.755n 1.0v 514.745n 1.0v 514.755n 0.0v 519.745n 0.0v 519.755n 1.0v 524.745n 1.0v 524.755n 1.0v 529.745n 1.0v 529.755n 1.0v 534.745n 1.0v 534.755n 0.0v 539.745n 0.0v 539.755n 0.0v 544.745n 0.0v 544.755n 0.0v 549.745n 0.0v 549.755n 0.0v 554.745n 0.0v 554.755n 1.0v 559.745n 1.0v 559.755n 1.0v 564.745n 1.0v 564.755n 0.0v 569.745n 0.0v 569.755n 1.0v 574.745n 1.0v 574.755n 0.0v 579.745n 0.0v 579.755n 0.0v 584.745n 0.0v 584.755n 0.0v 589.745n 0.0v 589.755n 0.0v 594.745n 0.0v 594.755n 0.0v 599.745n 0.0v 599.755n 1.0v 604.745n 1.0v 604.755n 1.0v 609.745n 1.0v 609.755n 1.0v 614.745n 1.0v 614.755n 1.0v 619.745n 1.0v 619.755n 0.0v 624.745n 0.0v 624.755n 0.0v 629.745n 0.0v 629.755n 1.0v 634.745n 1.0v 634.755n 0.0v 639.745n 0.0v 639.755n 0.0v 644.745n 0.0v 644.755n 1.0v 649.745n 1.0v 649.755n 0.0v 654.745n 0.0v 654.755n 1.0v 659.745n 1.0v 659.755n 1.0v 664.745n 1.0v 664.755n 1.0v 669.745n 1.0v 669.755n 0.0v 674.745n 0.0v 674.755n 1.0v 679.745n 1.0v 679.755n 1.0v 684.745n 1.0v 684.755n 1.0v 689.745n 1.0v 689.755n 1.0v 694.745n 1.0v 694.755n 1.0v 699.745n 1.0v 699.755n 1.0v 704.745n 1.0v 704.755n 0.0v 709.745n 0.0v 709.755n 0.0v 714.745n 0.0v 714.755n 1.0v 719.745n 1.0v 719.755n 1.0v 724.745n 1.0v 724.755n 1.0v 729.745n 1.0v 729.755n 0.0v 734.745n 0.0v 734.755n 1.0v 739.745n 1.0v 739.755n 1.0v 744.745n 1.0v 744.755n 0.0v 749.745n 0.0v 749.755n 1.0v 754.745n 1.0v 754.755n 1.0v 759.745n 1.0v 759.755n 1.0v 764.745n 1.0v 764.755n 0.0v 769.745n 0.0v 769.755n 1.0v 774.745n 1.0v 774.755n 0.0v 779.745n 0.0v 779.755n 1.0v 784.745n 1.0v 784.755n 1.0v 789.745n 1.0v 789.755n 0.0v 794.745n 0.0v 794.755n 1.0v 799.745n 1.0v 799.755n 1.0v 804.745n 1.0v 804.755n 0.0v 809.745n 0.0v 809.755n 1.0v 814.745n 1.0v 814.755n 0.0v 819.745n 0.0v 819.755n 1.0v 824.745n 1.0v 824.755n 1.0v 829.745n 1.0v 829.755n 0.0v 834.745n 0.0v 834.755n 1.0v 839.745n 1.0v 839.755n 1.0v 844.745n 1.0v 844.755n 1.0v 849.745n 1.0v 849.755n 0.0v 854.745n 0.0v 854.755n 1.0v 859.745n 1.0v 859.755n 0.0v 864.745n 0.0v 864.755n 1.0v 869.745n 1.0v 869.755n 0.0v 874.745n 0.0v 874.755n 1.0v 879.745n 1.0v 879.755n 0.0v 884.745n 0.0v 884.755n 0.0v 889.745n 0.0v 889.755n 0.0v 894.745n 0.0v 894.755n 1.0v 899.745n 1.0v 899.755n 0.0v 904.745n 0.0v 904.755n 0.0v 909.745n 0.0v 909.755n 1.0v 914.745n 1.0v 914.755n 0.0v 919.745n 0.0v 919.755n 0.0v 924.745n 0.0v 924.755n 0.0v 929.745n 0.0v 929.755n 1.0v 934.745n 1.0v 934.755n 1.0v 939.745n 1.0v 939.755n 0.0v 944.745n 0.0v 944.755n 1.0v 949.745n 1.0v 949.755n 1.0v 954.745n 1.0v 954.755n 1.0v 959.745n 1.0v 959.755n 1.0v 964.745n 1.0v 964.755n 0.0v 969.745n 0.0v 969.755n 1.0v 974.745n 1.0v 974.755n 0.0v 979.745n 0.0v 979.755n 0.0v 984.745n 0.0v 984.755n 0.0v 989.745n 0.0v 989.755n 0.0v 994.745n 0.0v 994.755n 0.0v 999.745n 0.0v 999.755n 1.0v 1004.745n 1.0v 1004.755n 1.0v 1009.745n 1.0v 1009.755n 1.0v 1014.745n 1.0v 1014.755n 0.0v 1019.745n 0.0v 1019.755n 1.0v 1024.745n 1.0v 1024.755n 1.0v )
* (time, data): [(0, 0), (5, 0), (10, 0), (15, 0), (20, 0), (25, 0), (30, 0), (35, 0), (40, 0), (45, 0), (50, 1), (55, 1), (60, 0), (65, 0), (70, 0), (75, 0), (80, 0), (85, 0), (90, 0), (95, 1), (100, 1), (105, 0), (110, 0), (115, 0), (120, 0), (125, 0), (130, 1), (135, 0), (140, 0), (145, 1), (150, 1), (155, 0), (160, 0), (165, 0), (170, 1), (175, 1), (180, 1), (185, 1), (190, 0), (195, 1), (200, 0), (205, 0), (210, 1), (215, 0), (220, 0), (225, 0), (230, 1), (235, 1), (240, 1), (245, 0), (250, 1), (255, 1), (260, 1), (265, 0), (270, 0), (275, 0), (280, 0), (285, 0), (290, 1), (295, 1), (300, 0), (305, 0), (310, 1), (315, 1), (320, 1), (325, 1), (330, 1), (335, 1), (340, 1), (345, 0), (350, 1), (355, 1), (360, 1), (365, 1), (370, 1), (375, 1), (380, 1), (385, 1), (390, 0), (395, 1), (400, 1), (405, 0), (410, 0), (415, 0), (420, 1), (425, 1), (430, 1), (435, 0), (440, 0), (445, 0), (450, 1), (455, 0), (460, 0), (465, 0), (470, 1), (475, 1), (480, 1), (485, 1), (490, 1), (495, 1), (500, 1), (505, 1), (510, 1), (515, 0), (520, 1), (525, 1), (530, 1), (535, 0), (540, 0), (545, 0), (550, 0), (555, 1), (560, 1), (565, 0), (570, 1), (575, 0), (580, 0), (585, 0), (590, 0), (595, 0), (600, 1), (605, 1), (610, 1), (615, 1), (620, 0), (625, 0), (630, 1), (635, 0), (640, 0), (645, 1), (650, 0), (655, 1), (660, 1), (665, 1), (670, 0), (675, 1), (680, 1), (685, 1), (690, 1), (695, 1), (700, 1), (705, 0), (710, 0), (715, 1), (720, 1), (725, 1), (730, 0), (735, 1), (740, 1), (745, 0), (750, 1), (755, 1), (760, 1), (765, 0), (770, 1), (775, 0), (780, 1), (785, 1), (790, 0), (795, 1), (800, 1), (805, 0), (810, 1), (815, 0), (820, 1), (825, 1), (830, 0), (835, 1), (840, 1), (845, 1), (850, 0), (855, 1), (860, 0), (865, 1), (870, 0), (875, 1), (880, 0), (885, 0), (890, 0), (895, 1), (900, 0), (905, 0), (910, 1), (915, 0), (920, 0), (925, 0), (930, 1), (935, 1), (940, 0), (945, 1), (950, 1), (955, 1), (960, 1), (965, 0), (970, 1), (975, 0), (980, 0), (985, 0), (990, 0), (995, 0), (1000, 1), (1005, 1), (1010, 1), (1015, 0), (1020, 1), (1025, 1)]
Va0_5  a0_5  0 PWL (0n 0.0v 4.745n 0.0v 4.755n 0.0v 9.745n 0.0v 9.755n 0.0v 14.745n 0.0v 14.755n 0.0v 19.745n 0.0v 19.755n 0.0v 24.745n 0.0v 24.755n 0.0v 29.745n 0.0v 29.755n 0.0v 34.745n 0.0v 34.755n 0.0v 39.745n 0.0v 39.755n 0.0v 44.745n 0.0v 44.755n 0.0v 49.745n 0.0v 49.755n 1.0v 54.745n 1.0v 54.755n 1.0v 59.745n 1.0v 59.755n 0.0v 64.745n 0.0v 64.755n 0.0v 69.745n 0.0v 69.755n 0.0v 74.745n 0.0v 74.755n 0.0v 79.745n 0.0v 79.755n 0.0v 84.745n 0.0v 84.755n 0.0v 89.745n 0.0v 89.755n 0.0v 94.745n 0.0v 94.755n 1.0v 99.745n 1.0v 99.755n 1.0v 104.745n 1.0v 104.755n 0.0v 109.745n 0.0v 109.755n 0.0v 114.745n 0.0v 114.755n 0.0v 119.745n 0.0v 119.755n 0.0v 124.745n 0.0v 124.755n 0.0v 129.745n 0.0v 129.755n 1.0v 134.745n 1.0v 134.755n 0.0v 139.745n 0.0v 139.755n 0.0v 144.745n 0.0v 144.755n 1.0v 149.745n 1.0v 149.755n 1.0v 154.745n 1.0v 154.755n 0.0v 159.745n 0.0v 159.755n 0.0v 164.745n 0.0v 164.755n 0.0v 169.745n 0.0v 169.755n 1.0v 174.745n 1.0v 174.755n 1.0v 179.745n 1.0v 179.755n 1.0v 184.745n 1.0v 184.755n 1.0v 189.745n 1.0v 189.755n 0.0v 194.745n 0.0v 194.755n 1.0v 199.745n 1.0v 199.755n 0.0v 204.745n 0.0v 204.755n 0.0v 209.745n 0.0v 209.755n 1.0v 214.745n 1.0v 214.755n 0.0v 219.745n 0.0v 219.755n 0.0v 224.745n 0.0v 224.755n 0.0v 229.745n 0.0v 229.755n 1.0v 234.745n 1.0v 234.755n 1.0v 239.745n 1.0v 239.755n 1.0v 244.745n 1.0v 244.755n 0.0v 249.745n 0.0v 249.755n 1.0v 254.745n 1.0v 254.755n 1.0v 259.745n 1.0v 259.755n 1.0v 264.745n 1.0v 264.755n 0.0v 269.745n 0.0v 269.755n 0.0v 274.745n 0.0v 274.755n 0.0v 279.745n 0.0v 279.755n 0.0v 284.745n 0.0v 284.755n 0.0v 289.745n 0.0v 289.755n 1.0v 294.745n 1.0v 294.755n 1.0v 299.745n 1.0v 299.755n 0.0v 304.745n 0.0v 304.755n 0.0v 309.745n 0.0v 309.755n 1.0v 314.745n 1.0v 314.755n 1.0v 319.745n 1.0v 319.755n 1.0v 324.745n 1.0v 324.755n 1.0v 329.745n 1.0v 329.755n 1.0v 334.745n 1.0v 334.755n 1.0v 339.745n 1.0v 339.755n 1.0v 344.745n 1.0v 344.755n 0.0v 349.745n 0.0v 349.755n 1.0v 354.745n 1.0v 354.755n 1.0v 359.745n 1.0v 359.755n 1.0v 364.745n 1.0v 364.755n 1.0v 369.745n 1.0v 369.755n 1.0v 374.745n 1.0v 374.755n 1.0v 379.745n 1.0v 379.755n 1.0v 384.745n 1.0v 384.755n 1.0v 389.745n 1.0v 389.755n 0.0v 394.745n 0.0v 394.755n 1.0v 399.745n 1.0v 399.755n 1.0v 404.745n 1.0v 404.755n 0.0v 409.745n 0.0v 409.755n 0.0v 414.745n 0.0v 414.755n 0.0v 419.745n 0.0v 419.755n 1.0v 424.745n 1.0v 424.755n 1.0v 429.745n 1.0v 429.755n 1.0v 434.745n 1.0v 434.755n 0.0v 439.745n 0.0v 439.755n 0.0v 444.745n 0.0v 444.755n 0.0v 449.745n 0.0v 449.755n 1.0v 454.745n 1.0v 454.755n 0.0v 459.745n 0.0v 459.755n 0.0v 464.745n 0.0v 464.755n 0.0v 469.745n 0.0v 469.755n 1.0v 474.745n 1.0v 474.755n 1.0v 479.745n 1.0v 479.755n 1.0v 484.745n 1.0v 484.755n 1.0v 489.745n 1.0v 489.755n 1.0v 494.745n 1.0v 494.755n 1.0v 499.745n 1.0v 499.755n 1.0v 504.745n 1.0v 504.755n 1.0v 509.745n 1.0v 509.755n 1.0v 514.745n 1.0v 514.755n 0.0v 519.745n 0.0v 519.755n 1.0v 524.745n 1.0v 524.755n 1.0v 529.745n 1.0v 529.755n 1.0v 534.745n 1.0v 534.755n 0.0v 539.745n 0.0v 539.755n 0.0v 544.745n 0.0v 544.755n 0.0v 549.745n 0.0v 549.755n 0.0v 554.745n 0.0v 554.755n 1.0v 559.745n 1.0v 559.755n 1.0v 564.745n 1.0v 564.755n 0.0v 569.745n 0.0v 569.755n 1.0v 574.745n 1.0v 574.755n 0.0v 579.745n 0.0v 579.755n 0.0v 584.745n 0.0v 584.755n 0.0v 589.745n 0.0v 589.755n 0.0v 594.745n 0.0v 594.755n 0.0v 599.745n 0.0v 599.755n 1.0v 604.745n 1.0v 604.755n 1.0v 609.745n 1.0v 609.755n 1.0v 614.745n 1.0v 614.755n 1.0v 619.745n 1.0v 619.755n 0.0v 624.745n 0.0v 624.755n 0.0v 629.745n 0.0v 629.755n 1.0v 634.745n 1.0v 634.755n 0.0v 639.745n 0.0v 639.755n 0.0v 644.745n 0.0v 644.755n 1.0v 649.745n 1.0v 649.755n 0.0v 654.745n 0.0v 654.755n 1.0v 659.745n 1.0v 659.755n 1.0v 664.745n 1.0v 664.755n 1.0v 669.745n 1.0v 669.755n 0.0v 674.745n 0.0v 674.755n 1.0v 679.745n 1.0v 679.755n 1.0v 684.745n 1.0v 684.755n 1.0v 689.745n 1.0v 689.755n 1.0v 694.745n 1.0v 694.755n 1.0v 699.745n 1.0v 699.755n 1.0v 704.745n 1.0v 704.755n 0.0v 709.745n 0.0v 709.755n 0.0v 714.745n 0.0v 714.755n 1.0v 719.745n 1.0v 719.755n 1.0v 724.745n 1.0v 724.755n 1.0v 729.745n 1.0v 729.755n 0.0v 734.745n 0.0v 734.755n 1.0v 739.745n 1.0v 739.755n 1.0v 744.745n 1.0v 744.755n 0.0v 749.745n 0.0v 749.755n 1.0v 754.745n 1.0v 754.755n 1.0v 759.745n 1.0v 759.755n 1.0v 764.745n 1.0v 764.755n 0.0v 769.745n 0.0v 769.755n 1.0v 774.745n 1.0v 774.755n 0.0v 779.745n 0.0v 779.755n 1.0v 784.745n 1.0v 784.755n 1.0v 789.745n 1.0v 789.755n 0.0v 794.745n 0.0v 794.755n 1.0v 799.745n 1.0v 799.755n 1.0v 804.745n 1.0v 804.755n 0.0v 809.745n 0.0v 809.755n 1.0v 814.745n 1.0v 814.755n 0.0v 819.745n 0.0v 819.755n 1.0v 824.745n 1.0v 824.755n 1.0v 829.745n 1.0v 829.755n 0.0v 834.745n 0.0v 834.755n 1.0v 839.745n 1.0v 839.755n 1.0v 844.745n 1.0v 844.755n 1.0v 849.745n 1.0v 849.755n 0.0v 854.745n 0.0v 854.755n 1.0v 859.745n 1.0v 859.755n 0.0v 864.745n 0.0v 864.755n 1.0v 869.745n 1.0v 869.755n 0.0v 874.745n 0.0v 874.755n 1.0v 879.745n 1.0v 879.755n 0.0v 884.745n 0.0v 884.755n 0.0v 889.745n 0.0v 889.755n 0.0v 894.745n 0.0v 894.755n 1.0v 899.745n 1.0v 899.755n 0.0v 904.745n 0.0v 904.755n 0.0v 909.745n 0.0v 909.755n 1.0v 914.745n 1.0v 914.755n 0.0v 919.745n 0.0v 919.755n 0.0v 924.745n 0.0v 924.755n 0.0v 929.745n 0.0v 929.755n 1.0v 934.745n 1.0v 934.755n 1.0v 939.745n 1.0v 939.755n 0.0v 944.745n 0.0v 944.755n 1.0v 949.745n 1.0v 949.755n 1.0v 954.745n 1.0v 954.755n 1.0v 959.745n 1.0v 959.755n 1.0v 964.745n 1.0v 964.755n 0.0v 969.745n 0.0v 969.755n 1.0v 974.745n 1.0v 974.755n 0.0v 979.745n 0.0v 979.755n 0.0v 984.745n 0.0v 984.755n 0.0v 989.745n 0.0v 989.755n 0.0v 994.745n 0.0v 994.755n 0.0v 999.745n 0.0v 999.755n 1.0v 1004.745n 1.0v 1004.755n 1.0v 1009.745n 1.0v 1009.755n 1.0v 1014.745n 1.0v 1014.755n 0.0v 1019.745n 0.0v 1019.755n 1.0v 1024.745n 1.0v 1024.755n 1.0v )
* (time, data): [(0, 0), (5, 0), (10, 0), (15, 0), (20, 0), (25, 0), (30, 0), (35, 0), (40, 0), (45, 0), (50, 1), (55, 1), (60, 0), (65, 0), (70, 0), (75, 0), (80, 0), (85, 0), (90, 0), (95, 1), (100, 1), (105, 0), (110, 0), (115, 0), (120, 0), (125, 0), (130, 1), (135, 0), (140, 0), (145, 1), (150, 1), (155, 0), (160, 0), (165, 0), (170, 1), (175, 1), (180, 1), (185, 1), (190, 0), (195, 1), (200, 0), (205, 0), (210, 1), (215, 0), (220, 0), (225, 0), (230, 1), (235, 1), (240, 1), (245, 0), (250, 1), (255, 1), (260, 1), (265, 0), (270, 0), (275, 0), (280, 0), (285, 0), (290, 1), (295, 1), (300, 0), (305, 0), (310, 1), (315, 1), (320, 1), (325, 1), (330, 1), (335, 1), (340, 1), (345, 0), (350, 1), (355, 1), (360, 1), (365, 1), (370, 1), (375, 1), (380, 1), (385, 1), (390, 0), (395, 1), (400, 1), (405, 0), (410, 0), (415, 0), (420, 1), (425, 1), (430, 1), (435, 0), (440, 0), (445, 0), (450, 1), (455, 0), (460, 0), (465, 0), (470, 1), (475, 1), (480, 1), (485, 1), (490, 1), (495, 1), (500, 1), (505, 1), (510, 1), (515, 0), (520, 1), (525, 1), (530, 1), (535, 0), (540, 0), (545, 0), (550, 0), (555, 1), (560, 1), (565, 0), (570, 1), (575, 0), (580, 0), (585, 0), (590, 0), (595, 0), (600, 1), (605, 1), (610, 1), (615, 1), (620, 0), (625, 0), (630, 1), (635, 0), (640, 0), (645, 1), (650, 0), (655, 1), (660, 1), (665, 1), (670, 0), (675, 1), (680, 1), (685, 1), (690, 1), (695, 1), (700, 1), (705, 0), (710, 0), (715, 1), (720, 1), (725, 1), (730, 0), (735, 1), (740, 1), (745, 0), (750, 1), (755, 1), (760, 1), (765, 0), (770, 1), (775, 0), (780, 1), (785, 1), (790, 0), (795, 1), (800, 1), (805, 0), (810, 1), (815, 0), (820, 1), (825, 1), (830, 0), (835, 1), (840, 1), (845, 1), (850, 0), (855, 1), (860, 0), (865, 1), (870, 0), (875, 1), (880, 0), (885, 0), (890, 0), (895, 1), (900, 0), (905, 0), (910, 1), (915, 0), (920, 0), (925, 0), (930, 1), (935, 1), (940, 0), (945, 1), (950, 1), (955, 1), (960, 1), (965, 0), (970, 1), (975, 0), (980, 0), (985, 0), (990, 0), (995, 0), (1000, 1), (1005, 1), (1010, 1), (1015, 0), (1020, 1), (1025, 1)]
Va0_6  a0_6  0 PWL (0n 0.0v 4.745n 0.0v 4.755n 0.0v 9.745n 0.0v 9.755n 0.0v 14.745n 0.0v 14.755n 0.0v 19.745n 0.0v 19.755n 0.0v 24.745n 0.0v 24.755n 0.0v 29.745n 0.0v 29.755n 0.0v 34.745n 0.0v 34.755n 0.0v 39.745n 0.0v 39.755n 0.0v 44.745n 0.0v 44.755n 0.0v 49.745n 0.0v 49.755n 1.0v 54.745n 1.0v 54.755n 1.0v 59.745n 1.0v 59.755n 0.0v 64.745n 0.0v 64.755n 0.0v 69.745n 0.0v 69.755n 0.0v 74.745n 0.0v 74.755n 0.0v 79.745n 0.0v 79.755n 0.0v 84.745n 0.0v 84.755n 0.0v 89.745n 0.0v 89.755n 0.0v 94.745n 0.0v 94.755n 1.0v 99.745n 1.0v 99.755n 1.0v 104.745n 1.0v 104.755n 0.0v 109.745n 0.0v 109.755n 0.0v 114.745n 0.0v 114.755n 0.0v 119.745n 0.0v 119.755n 0.0v 124.745n 0.0v 124.755n 0.0v 129.745n 0.0v 129.755n 1.0v 134.745n 1.0v 134.755n 0.0v 139.745n 0.0v 139.755n 0.0v 144.745n 0.0v 144.755n 1.0v 149.745n 1.0v 149.755n 1.0v 154.745n 1.0v 154.755n 0.0v 159.745n 0.0v 159.755n 0.0v 164.745n 0.0v 164.755n 0.0v 169.745n 0.0v 169.755n 1.0v 174.745n 1.0v 174.755n 1.0v 179.745n 1.0v 179.755n 1.0v 184.745n 1.0v 184.755n 1.0v 189.745n 1.0v 189.755n 0.0v 194.745n 0.0v 194.755n 1.0v 199.745n 1.0v 199.755n 0.0v 204.745n 0.0v 204.755n 0.0v 209.745n 0.0v 209.755n 1.0v 214.745n 1.0v 214.755n 0.0v 219.745n 0.0v 219.755n 0.0v 224.745n 0.0v 224.755n 0.0v 229.745n 0.0v 229.755n 1.0v 234.745n 1.0v 234.755n 1.0v 239.745n 1.0v 239.755n 1.0v 244.745n 1.0v 244.755n 0.0v 249.745n 0.0v 249.755n 1.0v 254.745n 1.0v 254.755n 1.0v 259.745n 1.0v 259.755n 1.0v 264.745n 1.0v 264.755n 0.0v 269.745n 0.0v 269.755n 0.0v 274.745n 0.0v 274.755n 0.0v 279.745n 0.0v 279.755n 0.0v 284.745n 0.0v 284.755n 0.0v 289.745n 0.0v 289.755n 1.0v 294.745n 1.0v 294.755n 1.0v 299.745n 1.0v 299.755n 0.0v 304.745n 0.0v 304.755n 0.0v 309.745n 0.0v 309.755n 1.0v 314.745n 1.0v 314.755n 1.0v 319.745n 1.0v 319.755n 1.0v 324.745n 1.0v 324.755n 1.0v 329.745n 1.0v 329.755n 1.0v 334.745n 1.0v 334.755n 1.0v 339.745n 1.0v 339.755n 1.0v 344.745n 1.0v 344.755n 0.0v 349.745n 0.0v 349.755n 1.0v 354.745n 1.0v 354.755n 1.0v 359.745n 1.0v 359.755n 1.0v 364.745n 1.0v 364.755n 1.0v 369.745n 1.0v 369.755n 1.0v 374.745n 1.0v 374.755n 1.0v 379.745n 1.0v 379.755n 1.0v 384.745n 1.0v 384.755n 1.0v 389.745n 1.0v 389.755n 0.0v 394.745n 0.0v 394.755n 1.0v 399.745n 1.0v 399.755n 1.0v 404.745n 1.0v 404.755n 0.0v 409.745n 0.0v 409.755n 0.0v 414.745n 0.0v 414.755n 0.0v 419.745n 0.0v 419.755n 1.0v 424.745n 1.0v 424.755n 1.0v 429.745n 1.0v 429.755n 1.0v 434.745n 1.0v 434.755n 0.0v 439.745n 0.0v 439.755n 0.0v 444.745n 0.0v 444.755n 0.0v 449.745n 0.0v 449.755n 1.0v 454.745n 1.0v 454.755n 0.0v 459.745n 0.0v 459.755n 0.0v 464.745n 0.0v 464.755n 0.0v 469.745n 0.0v 469.755n 1.0v 474.745n 1.0v 474.755n 1.0v 479.745n 1.0v 479.755n 1.0v 484.745n 1.0v 484.755n 1.0v 489.745n 1.0v 489.755n 1.0v 494.745n 1.0v 494.755n 1.0v 499.745n 1.0v 499.755n 1.0v 504.745n 1.0v 504.755n 1.0v 509.745n 1.0v 509.755n 1.0v 514.745n 1.0v 514.755n 0.0v 519.745n 0.0v 519.755n 1.0v 524.745n 1.0v 524.755n 1.0v 529.745n 1.0v 529.755n 1.0v 534.745n 1.0v 534.755n 0.0v 539.745n 0.0v 539.755n 0.0v 544.745n 0.0v 544.755n 0.0v 549.745n 0.0v 549.755n 0.0v 554.745n 0.0v 554.755n 1.0v 559.745n 1.0v 559.755n 1.0v 564.745n 1.0v 564.755n 0.0v 569.745n 0.0v 569.755n 1.0v 574.745n 1.0v 574.755n 0.0v 579.745n 0.0v 579.755n 0.0v 584.745n 0.0v 584.755n 0.0v 589.745n 0.0v 589.755n 0.0v 594.745n 0.0v 594.755n 0.0v 599.745n 0.0v 599.755n 1.0v 604.745n 1.0v 604.755n 1.0v 609.745n 1.0v 609.755n 1.0v 614.745n 1.0v 614.755n 1.0v 619.745n 1.0v 619.755n 0.0v 624.745n 0.0v 624.755n 0.0v 629.745n 0.0v 629.755n 1.0v 634.745n 1.0v 634.755n 0.0v 639.745n 0.0v 639.755n 0.0v 644.745n 0.0v 644.755n 1.0v 649.745n 1.0v 649.755n 0.0v 654.745n 0.0v 654.755n 1.0v 659.745n 1.0v 659.755n 1.0v 664.745n 1.0v 664.755n 1.0v 669.745n 1.0v 669.755n 0.0v 674.745n 0.0v 674.755n 1.0v 679.745n 1.0v 679.755n 1.0v 684.745n 1.0v 684.755n 1.0v 689.745n 1.0v 689.755n 1.0v 694.745n 1.0v 694.755n 1.0v 699.745n 1.0v 699.755n 1.0v 704.745n 1.0v 704.755n 0.0v 709.745n 0.0v 709.755n 0.0v 714.745n 0.0v 714.755n 1.0v 719.745n 1.0v 719.755n 1.0v 724.745n 1.0v 724.755n 1.0v 729.745n 1.0v 729.755n 0.0v 734.745n 0.0v 734.755n 1.0v 739.745n 1.0v 739.755n 1.0v 744.745n 1.0v 744.755n 0.0v 749.745n 0.0v 749.755n 1.0v 754.745n 1.0v 754.755n 1.0v 759.745n 1.0v 759.755n 1.0v 764.745n 1.0v 764.755n 0.0v 769.745n 0.0v 769.755n 1.0v 774.745n 1.0v 774.755n 0.0v 779.745n 0.0v 779.755n 1.0v 784.745n 1.0v 784.755n 1.0v 789.745n 1.0v 789.755n 0.0v 794.745n 0.0v 794.755n 1.0v 799.745n 1.0v 799.755n 1.0v 804.745n 1.0v 804.755n 0.0v 809.745n 0.0v 809.755n 1.0v 814.745n 1.0v 814.755n 0.0v 819.745n 0.0v 819.755n 1.0v 824.745n 1.0v 824.755n 1.0v 829.745n 1.0v 829.755n 0.0v 834.745n 0.0v 834.755n 1.0v 839.745n 1.0v 839.755n 1.0v 844.745n 1.0v 844.755n 1.0v 849.745n 1.0v 849.755n 0.0v 854.745n 0.0v 854.755n 1.0v 859.745n 1.0v 859.755n 0.0v 864.745n 0.0v 864.755n 1.0v 869.745n 1.0v 869.755n 0.0v 874.745n 0.0v 874.755n 1.0v 879.745n 1.0v 879.755n 0.0v 884.745n 0.0v 884.755n 0.0v 889.745n 0.0v 889.755n 0.0v 894.745n 0.0v 894.755n 1.0v 899.745n 1.0v 899.755n 0.0v 904.745n 0.0v 904.755n 0.0v 909.745n 0.0v 909.755n 1.0v 914.745n 1.0v 914.755n 0.0v 919.745n 0.0v 919.755n 0.0v 924.745n 0.0v 924.755n 0.0v 929.745n 0.0v 929.755n 1.0v 934.745n 1.0v 934.755n 1.0v 939.745n 1.0v 939.755n 0.0v 944.745n 0.0v 944.755n 1.0v 949.745n 1.0v 949.755n 1.0v 954.745n 1.0v 954.755n 1.0v 959.745n 1.0v 959.755n 1.0v 964.745n 1.0v 964.755n 0.0v 969.745n 0.0v 969.755n 1.0v 974.745n 1.0v 974.755n 0.0v 979.745n 0.0v 979.755n 0.0v 984.745n 0.0v 984.755n 0.0v 989.745n 0.0v 989.755n 0.0v 994.745n 0.0v 994.755n 0.0v 999.745n 0.0v 999.755n 1.0v 1004.745n 1.0v 1004.755n 1.0v 1009.745n 1.0v 1009.755n 1.0v 1014.745n 1.0v 1014.755n 0.0v 1019.745n 0.0v 1019.755n 1.0v 1024.745n 1.0v 1024.755n 1.0v )
* (time, data): [(0, 0), (5, 0), (10, 0), (15, 0), (20, 0), (25, 0), (30, 0), (35, 0), (40, 0), (45, 0), (50, 1), (55, 1), (60, 0), (65, 0), (70, 0), (75, 0), (80, 0), (85, 0), (90, 0), (95, 1), (100, 1), (105, 0), (110, 0), (115, 0), (120, 0), (125, 0), (130, 1), (135, 0), (140, 0), (145, 1), (150, 1), (155, 0), (160, 0), (165, 0), (170, 1), (175, 1), (180, 1), (185, 1), (190, 0), (195, 1), (200, 0), (205, 0), (210, 1), (215, 0), (220, 0), (225, 0), (230, 1), (235, 1), (240, 1), (245, 0), (250, 1), (255, 1), (260, 1), (265, 0), (270, 0), (275, 0), (280, 0), (285, 0), (290, 1), (295, 1), (300, 0), (305, 0), (310, 1), (315, 1), (320, 1), (325, 1), (330, 1), (335, 1), (340, 1), (345, 0), (350, 1), (355, 1), (360, 1), (365, 1), (370, 1), (375, 1), (380, 1), (385, 1), (390, 0), (395, 1), (400, 1), (405, 0), (410, 0), (415, 0), (420, 1), (425, 1), (430, 1), (435, 0), (440, 0), (445, 0), (450, 1), (455, 0), (460, 0), (465, 0), (470, 1), (475, 1), (480, 1), (485, 1), (490, 1), (495, 1), (500, 1), (505, 1), (510, 1), (515, 0), (520, 1), (525, 1), (530, 1), (535, 0), (540, 0), (545, 0), (550, 0), (555, 1), (560, 1), (565, 0), (570, 1), (575, 0), (580, 0), (585, 0), (590, 0), (595, 0), (600, 1), (605, 1), (610, 1), (615, 1), (620, 0), (625, 0), (630, 1), (635, 0), (640, 0), (645, 1), (650, 0), (655, 1), (660, 1), (665, 1), (670, 0), (675, 1), (680, 1), (685, 1), (690, 1), (695, 1), (700, 1), (705, 0), (710, 0), (715, 1), (720, 1), (725, 1), (730, 0), (735, 1), (740, 1), (745, 0), (750, 1), (755, 1), (760, 1), (765, 0), (770, 1), (775, 0), (780, 1), (785, 1), (790, 0), (795, 1), (800, 1), (805, 0), (810, 1), (815, 0), (820, 1), (825, 1), (830, 0), (835, 1), (840, 1), (845, 1), (850, 0), (855, 1), (860, 0), (865, 1), (870, 0), (875, 1), (880, 0), (885, 0), (890, 0), (895, 1), (900, 0), (905, 0), (910, 1), (915, 0), (920, 0), (925, 0), (930, 1), (935, 1), (940, 0), (945, 1), (950, 1), (955, 1), (960, 1), (965, 0), (970, 1), (975, 0), (980, 0), (985, 0), (990, 0), (995, 0), (1000, 1), (1005, 1), (1010, 1), (1015, 0), (1020, 1), (1025, 1)]
Va0_7  a0_7  0 PWL (0n 0.0v 4.745n 0.0v 4.755n 0.0v 9.745n 0.0v 9.755n 0.0v 14.745n 0.0v 14.755n 0.0v 19.745n 0.0v 19.755n 0.0v 24.745n 0.0v 24.755n 0.0v 29.745n 0.0v 29.755n 0.0v 34.745n 0.0v 34.755n 0.0v 39.745n 0.0v 39.755n 0.0v 44.745n 0.0v 44.755n 0.0v 49.745n 0.0v 49.755n 1.0v 54.745n 1.0v 54.755n 1.0v 59.745n 1.0v 59.755n 0.0v 64.745n 0.0v 64.755n 0.0v 69.745n 0.0v 69.755n 0.0v 74.745n 0.0v 74.755n 0.0v 79.745n 0.0v 79.755n 0.0v 84.745n 0.0v 84.755n 0.0v 89.745n 0.0v 89.755n 0.0v 94.745n 0.0v 94.755n 1.0v 99.745n 1.0v 99.755n 1.0v 104.745n 1.0v 104.755n 0.0v 109.745n 0.0v 109.755n 0.0v 114.745n 0.0v 114.755n 0.0v 119.745n 0.0v 119.755n 0.0v 124.745n 0.0v 124.755n 0.0v 129.745n 0.0v 129.755n 1.0v 134.745n 1.0v 134.755n 0.0v 139.745n 0.0v 139.755n 0.0v 144.745n 0.0v 144.755n 1.0v 149.745n 1.0v 149.755n 1.0v 154.745n 1.0v 154.755n 0.0v 159.745n 0.0v 159.755n 0.0v 164.745n 0.0v 164.755n 0.0v 169.745n 0.0v 169.755n 1.0v 174.745n 1.0v 174.755n 1.0v 179.745n 1.0v 179.755n 1.0v 184.745n 1.0v 184.755n 1.0v 189.745n 1.0v 189.755n 0.0v 194.745n 0.0v 194.755n 1.0v 199.745n 1.0v 199.755n 0.0v 204.745n 0.0v 204.755n 0.0v 209.745n 0.0v 209.755n 1.0v 214.745n 1.0v 214.755n 0.0v 219.745n 0.0v 219.755n 0.0v 224.745n 0.0v 224.755n 0.0v 229.745n 0.0v 229.755n 1.0v 234.745n 1.0v 234.755n 1.0v 239.745n 1.0v 239.755n 1.0v 244.745n 1.0v 244.755n 0.0v 249.745n 0.0v 249.755n 1.0v 254.745n 1.0v 254.755n 1.0v 259.745n 1.0v 259.755n 1.0v 264.745n 1.0v 264.755n 0.0v 269.745n 0.0v 269.755n 0.0v 274.745n 0.0v 274.755n 0.0v 279.745n 0.0v 279.755n 0.0v 284.745n 0.0v 284.755n 0.0v 289.745n 0.0v 289.755n 1.0v 294.745n 1.0v 294.755n 1.0v 299.745n 1.0v 299.755n 0.0v 304.745n 0.0v 304.755n 0.0v 309.745n 0.0v 309.755n 1.0v 314.745n 1.0v 314.755n 1.0v 319.745n 1.0v 319.755n 1.0v 324.745n 1.0v 324.755n 1.0v 329.745n 1.0v 329.755n 1.0v 334.745n 1.0v 334.755n 1.0v 339.745n 1.0v 339.755n 1.0v 344.745n 1.0v 344.755n 0.0v 349.745n 0.0v 349.755n 1.0v 354.745n 1.0v 354.755n 1.0v 359.745n 1.0v 359.755n 1.0v 364.745n 1.0v 364.755n 1.0v 369.745n 1.0v 369.755n 1.0v 374.745n 1.0v 374.755n 1.0v 379.745n 1.0v 379.755n 1.0v 384.745n 1.0v 384.755n 1.0v 389.745n 1.0v 389.755n 0.0v 394.745n 0.0v 394.755n 1.0v 399.745n 1.0v 399.755n 1.0v 404.745n 1.0v 404.755n 0.0v 409.745n 0.0v 409.755n 0.0v 414.745n 0.0v 414.755n 0.0v 419.745n 0.0v 419.755n 1.0v 424.745n 1.0v 424.755n 1.0v 429.745n 1.0v 429.755n 1.0v 434.745n 1.0v 434.755n 0.0v 439.745n 0.0v 439.755n 0.0v 444.745n 0.0v 444.755n 0.0v 449.745n 0.0v 449.755n 1.0v 454.745n 1.0v 454.755n 0.0v 459.745n 0.0v 459.755n 0.0v 464.745n 0.0v 464.755n 0.0v 469.745n 0.0v 469.755n 1.0v 474.745n 1.0v 474.755n 1.0v 479.745n 1.0v 479.755n 1.0v 484.745n 1.0v 484.755n 1.0v 489.745n 1.0v 489.755n 1.0v 494.745n 1.0v 494.755n 1.0v 499.745n 1.0v 499.755n 1.0v 504.745n 1.0v 504.755n 1.0v 509.745n 1.0v 509.755n 1.0v 514.745n 1.0v 514.755n 0.0v 519.745n 0.0v 519.755n 1.0v 524.745n 1.0v 524.755n 1.0v 529.745n 1.0v 529.755n 1.0v 534.745n 1.0v 534.755n 0.0v 539.745n 0.0v 539.755n 0.0v 544.745n 0.0v 544.755n 0.0v 549.745n 0.0v 549.755n 0.0v 554.745n 0.0v 554.755n 1.0v 559.745n 1.0v 559.755n 1.0v 564.745n 1.0v 564.755n 0.0v 569.745n 0.0v 569.755n 1.0v 574.745n 1.0v 574.755n 0.0v 579.745n 0.0v 579.755n 0.0v 584.745n 0.0v 584.755n 0.0v 589.745n 0.0v 589.755n 0.0v 594.745n 0.0v 594.755n 0.0v 599.745n 0.0v 599.755n 1.0v 604.745n 1.0v 604.755n 1.0v 609.745n 1.0v 609.755n 1.0v 614.745n 1.0v 614.755n 1.0v 619.745n 1.0v 619.755n 0.0v 624.745n 0.0v 624.755n 0.0v 629.745n 0.0v 629.755n 1.0v 634.745n 1.0v 634.755n 0.0v 639.745n 0.0v 639.755n 0.0v 644.745n 0.0v 644.755n 1.0v 649.745n 1.0v 649.755n 0.0v 654.745n 0.0v 654.755n 1.0v 659.745n 1.0v 659.755n 1.0v 664.745n 1.0v 664.755n 1.0v 669.745n 1.0v 669.755n 0.0v 674.745n 0.0v 674.755n 1.0v 679.745n 1.0v 679.755n 1.0v 684.745n 1.0v 684.755n 1.0v 689.745n 1.0v 689.755n 1.0v 694.745n 1.0v 694.755n 1.0v 699.745n 1.0v 699.755n 1.0v 704.745n 1.0v 704.755n 0.0v 709.745n 0.0v 709.755n 0.0v 714.745n 0.0v 714.755n 1.0v 719.745n 1.0v 719.755n 1.0v 724.745n 1.0v 724.755n 1.0v 729.745n 1.0v 729.755n 0.0v 734.745n 0.0v 734.755n 1.0v 739.745n 1.0v 739.755n 1.0v 744.745n 1.0v 744.755n 0.0v 749.745n 0.0v 749.755n 1.0v 754.745n 1.0v 754.755n 1.0v 759.745n 1.0v 759.755n 1.0v 764.745n 1.0v 764.755n 0.0v 769.745n 0.0v 769.755n 1.0v 774.745n 1.0v 774.755n 0.0v 779.745n 0.0v 779.755n 1.0v 784.745n 1.0v 784.755n 1.0v 789.745n 1.0v 789.755n 0.0v 794.745n 0.0v 794.755n 1.0v 799.745n 1.0v 799.755n 1.0v 804.745n 1.0v 804.755n 0.0v 809.745n 0.0v 809.755n 1.0v 814.745n 1.0v 814.755n 0.0v 819.745n 0.0v 819.755n 1.0v 824.745n 1.0v 824.755n 1.0v 829.745n 1.0v 829.755n 0.0v 834.745n 0.0v 834.755n 1.0v 839.745n 1.0v 839.755n 1.0v 844.745n 1.0v 844.755n 1.0v 849.745n 1.0v 849.755n 0.0v 854.745n 0.0v 854.755n 1.0v 859.745n 1.0v 859.755n 0.0v 864.745n 0.0v 864.755n 1.0v 869.745n 1.0v 869.755n 0.0v 874.745n 0.0v 874.755n 1.0v 879.745n 1.0v 879.755n 0.0v 884.745n 0.0v 884.755n 0.0v 889.745n 0.0v 889.755n 0.0v 894.745n 0.0v 894.755n 1.0v 899.745n 1.0v 899.755n 0.0v 904.745n 0.0v 904.755n 0.0v 909.745n 0.0v 909.755n 1.0v 914.745n 1.0v 914.755n 0.0v 919.745n 0.0v 919.755n 0.0v 924.745n 0.0v 924.755n 0.0v 929.745n 0.0v 929.755n 1.0v 934.745n 1.0v 934.755n 1.0v 939.745n 1.0v 939.755n 0.0v 944.745n 0.0v 944.755n 1.0v 949.745n 1.0v 949.755n 1.0v 954.745n 1.0v 954.755n 1.0v 959.745n 1.0v 959.755n 1.0v 964.745n 1.0v 964.755n 0.0v 969.745n 0.0v 969.755n 1.0v 974.745n 1.0v 974.755n 0.0v 979.745n 0.0v 979.755n 0.0v 984.745n 0.0v 984.755n 0.0v 989.745n 0.0v 989.755n 0.0v 994.745n 0.0v 994.755n 0.0v 999.745n 0.0v 999.755n 1.0v 1004.745n 1.0v 1004.755n 1.0v 1009.745n 1.0v 1009.755n 1.0v 1014.745n 1.0v 1014.755n 0.0v 1019.745n 0.0v 1019.755n 1.0v 1024.745n 1.0v 1024.755n 1.0v )
* (time, data): [(0, 0), (5, 0), (10, 0), (15, 0), (20, 0), (25, 0), (30, 0), (35, 0), (40, 0), (45, 0), (50, 1), (55, 1), (60, 0), (65, 0), (70, 0), (75, 0), (80, 0), (85, 0), (90, 0), (95, 1), (100, 1), (105, 0), (110, 0), (115, 0), (120, 0), (125, 0), (130, 1), (135, 0), (140, 0), (145, 1), (150, 1), (155, 0), (160, 0), (165, 0), (170, 1), (175, 1), (180, 1), (185, 1), (190, 0), (195, 1), (200, 0), (205, 0), (210, 1), (215, 0), (220, 0), (225, 0), (230, 1), (235, 1), (240, 1), (245, 0), (250, 1), (255, 1), (260, 1), (265, 0), (270, 0), (275, 0), (280, 0), (285, 0), (290, 1), (295, 1), (300, 0), (305, 0), (310, 1), (315, 1), (320, 1), (325, 1), (330, 1), (335, 1), (340, 1), (345, 0), (350, 1), (355, 1), (360, 1), (365, 1), (370, 1), (375, 1), (380, 1), (385, 1), (390, 0), (395, 1), (400, 1), (405, 0), (410, 0), (415, 0), (420, 1), (425, 1), (430, 1), (435, 0), (440, 0), (445, 0), (450, 1), (455, 0), (460, 0), (465, 0), (470, 1), (475, 1), (480, 1), (485, 1), (490, 1), (495, 1), (500, 1), (505, 1), (510, 1), (515, 0), (520, 1), (525, 1), (530, 1), (535, 0), (540, 0), (545, 0), (550, 0), (555, 1), (560, 1), (565, 0), (570, 1), (575, 0), (580, 0), (585, 0), (590, 0), (595, 0), (600, 1), (605, 1), (610, 1), (615, 1), (620, 0), (625, 0), (630, 1), (635, 0), (640, 0), (645, 1), (650, 0), (655, 1), (660, 1), (665, 1), (670, 0), (675, 1), (680, 1), (685, 1), (690, 1), (695, 1), (700, 1), (705, 0), (710, 0), (715, 1), (720, 1), (725, 1), (730, 0), (735, 1), (740, 1), (745, 0), (750, 1), (755, 1), (760, 1), (765, 0), (770, 1), (775, 0), (780, 1), (785, 1), (790, 0), (795, 1), (800, 1), (805, 0), (810, 1), (815, 0), (820, 1), (825, 1), (830, 0), (835, 1), (840, 1), (845, 1), (850, 0), (855, 1), (860, 0), (865, 1), (870, 0), (875, 1), (880, 0), (885, 0), (890, 0), (895, 1), (900, 0), (905, 0), (910, 1), (915, 0), (920, 0), (925, 0), (930, 1), (935, 1), (940, 0), (945, 1), (950, 1), (955, 1), (960, 1), (965, 0), (970, 1), (975, 0), (980, 0), (985, 0), (990, 0), (995, 0), (1000, 1), (1005, 1), (1010, 1), (1015, 0), (1020, 1), (1025, 1)]
Va0_8  a0_8  0 PWL (0n 0.0v 4.745n 0.0v 4.755n 0.0v 9.745n 0.0v 9.755n 0.0v 14.745n 0.0v 14.755n 0.0v 19.745n 0.0v 19.755n 0.0v 24.745n 0.0v 24.755n 0.0v 29.745n 0.0v 29.755n 0.0v 34.745n 0.0v 34.755n 0.0v 39.745n 0.0v 39.755n 0.0v 44.745n 0.0v 44.755n 0.0v 49.745n 0.0v 49.755n 1.0v 54.745n 1.0v 54.755n 1.0v 59.745n 1.0v 59.755n 0.0v 64.745n 0.0v 64.755n 0.0v 69.745n 0.0v 69.755n 0.0v 74.745n 0.0v 74.755n 0.0v 79.745n 0.0v 79.755n 0.0v 84.745n 0.0v 84.755n 0.0v 89.745n 0.0v 89.755n 0.0v 94.745n 0.0v 94.755n 1.0v 99.745n 1.0v 99.755n 1.0v 104.745n 1.0v 104.755n 0.0v 109.745n 0.0v 109.755n 0.0v 114.745n 0.0v 114.755n 0.0v 119.745n 0.0v 119.755n 0.0v 124.745n 0.0v 124.755n 0.0v 129.745n 0.0v 129.755n 1.0v 134.745n 1.0v 134.755n 0.0v 139.745n 0.0v 139.755n 0.0v 144.745n 0.0v 144.755n 1.0v 149.745n 1.0v 149.755n 1.0v 154.745n 1.0v 154.755n 0.0v 159.745n 0.0v 159.755n 0.0v 164.745n 0.0v 164.755n 0.0v 169.745n 0.0v 169.755n 1.0v 174.745n 1.0v 174.755n 1.0v 179.745n 1.0v 179.755n 1.0v 184.745n 1.0v 184.755n 1.0v 189.745n 1.0v 189.755n 0.0v 194.745n 0.0v 194.755n 1.0v 199.745n 1.0v 199.755n 0.0v 204.745n 0.0v 204.755n 0.0v 209.745n 0.0v 209.755n 1.0v 214.745n 1.0v 214.755n 0.0v 219.745n 0.0v 219.755n 0.0v 224.745n 0.0v 224.755n 0.0v 229.745n 0.0v 229.755n 1.0v 234.745n 1.0v 234.755n 1.0v 239.745n 1.0v 239.755n 1.0v 244.745n 1.0v 244.755n 0.0v 249.745n 0.0v 249.755n 1.0v 254.745n 1.0v 254.755n 1.0v 259.745n 1.0v 259.755n 1.0v 264.745n 1.0v 264.755n 0.0v 269.745n 0.0v 269.755n 0.0v 274.745n 0.0v 274.755n 0.0v 279.745n 0.0v 279.755n 0.0v 284.745n 0.0v 284.755n 0.0v 289.745n 0.0v 289.755n 1.0v 294.745n 1.0v 294.755n 1.0v 299.745n 1.0v 299.755n 0.0v 304.745n 0.0v 304.755n 0.0v 309.745n 0.0v 309.755n 1.0v 314.745n 1.0v 314.755n 1.0v 319.745n 1.0v 319.755n 1.0v 324.745n 1.0v 324.755n 1.0v 329.745n 1.0v 329.755n 1.0v 334.745n 1.0v 334.755n 1.0v 339.745n 1.0v 339.755n 1.0v 344.745n 1.0v 344.755n 0.0v 349.745n 0.0v 349.755n 1.0v 354.745n 1.0v 354.755n 1.0v 359.745n 1.0v 359.755n 1.0v 364.745n 1.0v 364.755n 1.0v 369.745n 1.0v 369.755n 1.0v 374.745n 1.0v 374.755n 1.0v 379.745n 1.0v 379.755n 1.0v 384.745n 1.0v 384.755n 1.0v 389.745n 1.0v 389.755n 0.0v 394.745n 0.0v 394.755n 1.0v 399.745n 1.0v 399.755n 1.0v 404.745n 1.0v 404.755n 0.0v 409.745n 0.0v 409.755n 0.0v 414.745n 0.0v 414.755n 0.0v 419.745n 0.0v 419.755n 1.0v 424.745n 1.0v 424.755n 1.0v 429.745n 1.0v 429.755n 1.0v 434.745n 1.0v 434.755n 0.0v 439.745n 0.0v 439.755n 0.0v 444.745n 0.0v 444.755n 0.0v 449.745n 0.0v 449.755n 1.0v 454.745n 1.0v 454.755n 0.0v 459.745n 0.0v 459.755n 0.0v 464.745n 0.0v 464.755n 0.0v 469.745n 0.0v 469.755n 1.0v 474.745n 1.0v 474.755n 1.0v 479.745n 1.0v 479.755n 1.0v 484.745n 1.0v 484.755n 1.0v 489.745n 1.0v 489.755n 1.0v 494.745n 1.0v 494.755n 1.0v 499.745n 1.0v 499.755n 1.0v 504.745n 1.0v 504.755n 1.0v 509.745n 1.0v 509.755n 1.0v 514.745n 1.0v 514.755n 0.0v 519.745n 0.0v 519.755n 1.0v 524.745n 1.0v 524.755n 1.0v 529.745n 1.0v 529.755n 1.0v 534.745n 1.0v 534.755n 0.0v 539.745n 0.0v 539.755n 0.0v 544.745n 0.0v 544.755n 0.0v 549.745n 0.0v 549.755n 0.0v 554.745n 0.0v 554.755n 1.0v 559.745n 1.0v 559.755n 1.0v 564.745n 1.0v 564.755n 0.0v 569.745n 0.0v 569.755n 1.0v 574.745n 1.0v 574.755n 0.0v 579.745n 0.0v 579.755n 0.0v 584.745n 0.0v 584.755n 0.0v 589.745n 0.0v 589.755n 0.0v 594.745n 0.0v 594.755n 0.0v 599.745n 0.0v 599.755n 1.0v 604.745n 1.0v 604.755n 1.0v 609.745n 1.0v 609.755n 1.0v 614.745n 1.0v 614.755n 1.0v 619.745n 1.0v 619.755n 0.0v 624.745n 0.0v 624.755n 0.0v 629.745n 0.0v 629.755n 1.0v 634.745n 1.0v 634.755n 0.0v 639.745n 0.0v 639.755n 0.0v 644.745n 0.0v 644.755n 1.0v 649.745n 1.0v 649.755n 0.0v 654.745n 0.0v 654.755n 1.0v 659.745n 1.0v 659.755n 1.0v 664.745n 1.0v 664.755n 1.0v 669.745n 1.0v 669.755n 0.0v 674.745n 0.0v 674.755n 1.0v 679.745n 1.0v 679.755n 1.0v 684.745n 1.0v 684.755n 1.0v 689.745n 1.0v 689.755n 1.0v 694.745n 1.0v 694.755n 1.0v 699.745n 1.0v 699.755n 1.0v 704.745n 1.0v 704.755n 0.0v 709.745n 0.0v 709.755n 0.0v 714.745n 0.0v 714.755n 1.0v 719.745n 1.0v 719.755n 1.0v 724.745n 1.0v 724.755n 1.0v 729.745n 1.0v 729.755n 0.0v 734.745n 0.0v 734.755n 1.0v 739.745n 1.0v 739.755n 1.0v 744.745n 1.0v 744.755n 0.0v 749.745n 0.0v 749.755n 1.0v 754.745n 1.0v 754.755n 1.0v 759.745n 1.0v 759.755n 1.0v 764.745n 1.0v 764.755n 0.0v 769.745n 0.0v 769.755n 1.0v 774.745n 1.0v 774.755n 0.0v 779.745n 0.0v 779.755n 1.0v 784.745n 1.0v 784.755n 1.0v 789.745n 1.0v 789.755n 0.0v 794.745n 0.0v 794.755n 1.0v 799.745n 1.0v 799.755n 1.0v 804.745n 1.0v 804.755n 0.0v 809.745n 0.0v 809.755n 1.0v 814.745n 1.0v 814.755n 0.0v 819.745n 0.0v 819.755n 1.0v 824.745n 1.0v 824.755n 1.0v 829.745n 1.0v 829.755n 0.0v 834.745n 0.0v 834.755n 1.0v 839.745n 1.0v 839.755n 1.0v 844.745n 1.0v 844.755n 1.0v 849.745n 1.0v 849.755n 0.0v 854.745n 0.0v 854.755n 1.0v 859.745n 1.0v 859.755n 0.0v 864.745n 0.0v 864.755n 1.0v 869.745n 1.0v 869.755n 0.0v 874.745n 0.0v 874.755n 1.0v 879.745n 1.0v 879.755n 0.0v 884.745n 0.0v 884.755n 0.0v 889.745n 0.0v 889.755n 0.0v 894.745n 0.0v 894.755n 1.0v 899.745n 1.0v 899.755n 0.0v 904.745n 0.0v 904.755n 0.0v 909.745n 0.0v 909.755n 1.0v 914.745n 1.0v 914.755n 0.0v 919.745n 0.0v 919.755n 0.0v 924.745n 0.0v 924.755n 0.0v 929.745n 0.0v 929.755n 1.0v 934.745n 1.0v 934.755n 1.0v 939.745n 1.0v 939.755n 0.0v 944.745n 0.0v 944.755n 1.0v 949.745n 1.0v 949.755n 1.0v 954.745n 1.0v 954.755n 1.0v 959.745n 1.0v 959.755n 1.0v 964.745n 1.0v 964.755n 0.0v 969.745n 0.0v 969.755n 1.0v 974.745n 1.0v 974.755n 0.0v 979.745n 0.0v 979.755n 0.0v 984.745n 0.0v 984.755n 0.0v 989.745n 0.0v 989.755n 0.0v 994.745n 0.0v 994.755n 0.0v 999.745n 0.0v 999.755n 1.0v 1004.745n 1.0v 1004.755n 1.0v 1009.745n 1.0v 1009.755n 1.0v 1014.745n 1.0v 1014.755n 0.0v 1019.745n 0.0v 1019.755n 1.0v 1024.745n 1.0v 1024.755n 1.0v )
* (time, data): [(0, 0), (5, 0), (10, 1), (15, 1), (20, 1), (25, 0), (30, 0), (35, 0), (40, 1), (45, 1), (50, 1), (55, 1), (60, 0), (65, 1), (70, 1), (75, 0), (80, 1), (85, 0), (90, 0), (95, 0), (100, 0), (105, 1), (110, 0), (115, 0), (120, 0), (125, 0), (130, 1), (135, 0), (140, 1), (145, 1), (150, 1), (155, 1), (160, 1), (165, 1), (170, 1), (175, 0), (180, 1), (185, 1), (190, 1), (195, 1), (200, 1), (205, 0), (210, 0), (215, 0), (220, 1), (225, 1), (230, 1), (235, 0), (240, 0), (245, 0), (250, 0), (255, 0), (260, 0), (265, 1), (270, 1), (275, 0), (280, 0), (285, 1), (290, 1), (295, 1), (300, 1), (305, 1), (310, 1), (315, 1), (320, 0), (325, 1), (330, 1), (335, 1), (340, 1), (345, 0), (350, 1), (355, 1), (360, 1), (365, 1), (370, 1), (375, 1), (380, 1), (385, 0), (390, 0), (395, 0), (400, 1), (405, 1), (410, 0), (415, 0), (420, 0), (425, 0), (430, 1), (435, 1), (440, 0), (445, 0), (450, 0), (455, 0), (460, 1), (465, 0), (470, 0), (475, 1), (480, 1), (485, 1), (490, 1), (495, 1), (500, 1), (505, 0), (510, 0), (515, 0), (520, 0), (525, 0), (530, 0), (535, 0), (540, 0), (545, 0), (550, 0), (555, 1), (560, 0), (565, 1), (570, 0), (575, 0), (580, 0), (585, 0), (590, 0), (595, 1), (600, 0), (605, 0), (610, 0), (615, 0), (620, 1), (625, 1), (630, 1), (635, 1), (640, 0), (645, 0), (650, 1), (655, 1), (660, 1), (665, 1), (670, 1), (675, 0), (680, 1), (685, 1), (690, 1), (695, 0), (700, 0), (705, 1), (710, 1), (715, 0), (720, 0), (725, 1), (730, 1), (735, 0), (740, 0), (745, 1), (750, 0), (755, 0), (760, 1), (765, 1), (770, 1), (775, 0), (780, 0), (785, 0), (790, 0), (795, 0), (800, 0), (805, 1), (810, 1), (815, 1), (820, 0), (825, 0), (830, 1), (835, 1), (840, 0), (845, 1), (850, 0), (855, 1), (860, 0), (865, 0), (870, 0), (875, 1), (880, 1), (885, 1), (890, 1), (895, 1), (900, 1), (905, 0), (910, 0), (915, 0), (920, 1), (925, 0), (930, 0), (935, 0), (940, 1), (945, 1), (950, 1), (955, 1), (960, 0), (965, 1), (970, 0), (975, 0), (980, 0), (985, 0), (990, 0), (995, 1), (1000, 0), (1005, 0), (1010, 0), (1015, 1), (1020, 0), (1025, 0)]
Va1_0  a1_0  0 PWL (0n 0.0v 4.745n 0.0v 4.755n 0.0v 9.745n 0.0v 9.755n 1.0v 14.745n 1.0v 14.755n 1.0v 19.745n 1.0v 19.755n 1.0v 24.745n 1.0v 24.755n 0.0v 29.745n 0.0v 29.755n 0.0v 34.745n 0.0v 34.755n 0.0v 39.745n 0.0v 39.755n 1.0v 44.745n 1.0v 44.755n 1.0v 49.745n 1.0v 49.755n 1.0v 54.745n 1.0v 54.755n 1.0v 59.745n 1.0v 59.755n 0.0v 64.745n 0.0v 64.755n 1.0v 69.745n 1.0v 69.755n 1.0v 74.745n 1.0v 74.755n 0.0v 79.745n 0.0v 79.755n 1.0v 84.745n 1.0v 84.755n 0.0v 89.745n 0.0v 89.755n 0.0v 94.745n 0.0v 94.755n 0.0v 99.745n 0.0v 99.755n 0.0v 104.745n 0.0v 104.755n 1.0v 109.745n 1.0v 109.755n 0.0v 114.745n 0.0v 114.755n 0.0v 119.745n 0.0v 119.755n 0.0v 124.745n 0.0v 124.755n 0.0v 129.745n 0.0v 129.755n 1.0v 134.745n 1.0v 134.755n 0.0v 139.745n 0.0v 139.755n 1.0v 144.745n 1.0v 144.755n 1.0v 149.745n 1.0v 149.755n 1.0v 154.745n 1.0v 154.755n 1.0v 159.745n 1.0v 159.755n 1.0v 164.745n 1.0v 164.755n 1.0v 169.745n 1.0v 169.755n 1.0v 174.745n 1.0v 174.755n 0.0v 179.745n 0.0v 179.755n 1.0v 184.745n 1.0v 184.755n 1.0v 189.745n 1.0v 189.755n 1.0v 194.745n 1.0v 194.755n 1.0v 199.745n 1.0v 199.755n 1.0v 204.745n 1.0v 204.755n 0.0v 209.745n 0.0v 209.755n 0.0v 214.745n 0.0v 214.755n 0.0v 219.745n 0.0v 219.755n 1.0v 224.745n 1.0v 224.755n 1.0v 229.745n 1.0v 229.755n 1.0v 234.745n 1.0v 234.755n 0.0v 239.745n 0.0v 239.755n 0.0v 244.745n 0.0v 244.755n 0.0v 249.745n 0.0v 249.755n 0.0v 254.745n 0.0v 254.755n 0.0v 259.745n 0.0v 259.755n 0.0v 264.745n 0.0v 264.755n 1.0v 269.745n 1.0v 269.755n 1.0v 274.745n 1.0v 274.755n 0.0v 279.745n 0.0v 279.755n 0.0v 284.745n 0.0v 284.755n 1.0v 289.745n 1.0v 289.755n 1.0v 294.745n 1.0v 294.755n 1.0v 299.745n 1.0v 299.755n 1.0v 304.745n 1.0v 304.755n 1.0v 309.745n 1.0v 309.755n 1.0v 314.745n 1.0v 314.755n 1.0v 319.745n 1.0v 319.755n 0.0v 324.745n 0.0v 324.755n 1.0v 329.745n 1.0v 329.755n 1.0v 334.745n 1.0v 334.755n 1.0v 339.745n 1.0v 339.755n 1.0v 344.745n 1.0v 344.755n 0.0v 349.745n 0.0v 349.755n 1.0v 354.745n 1.0v 354.755n 1.0v 359.745n 1.0v 359.755n 1.0v 364.745n 1.0v 364.755n 1.0v 369.745n 1.0v 369.755n 1.0v 374.745n 1.0v 374.755n 1.0v 379.745n 1.0v 379.755n 1.0v 384.745n 1.0v 384.755n 0.0v 389.745n 0.0v 389.755n 0.0v 394.745n 0.0v 394.755n 0.0v 399.745n 0.0v 399.755n 1.0v 404.745n 1.0v 404.755n 1.0v 409.745n 1.0v 409.755n 0.0v 414.745n 0.0v 414.755n 0.0v 419.745n 0.0v 419.755n 0.0v 424.745n 0.0v 424.755n 0.0v 429.745n 0.0v 429.755n 1.0v 434.745n 1.0v 434.755n 1.0v 439.745n 1.0v 439.755n 0.0v 444.745n 0.0v 444.755n 0.0v 449.745n 0.0v 449.755n 0.0v 454.745n 0.0v 454.755n 0.0v 459.745n 0.0v 459.755n 1.0v 464.745n 1.0v 464.755n 0.0v 469.745n 0.0v 469.755n 0.0v 474.745n 0.0v 474.755n 1.0v 479.745n 1.0v 479.755n 1.0v 484.745n 1.0v 484.755n 1.0v 489.745n 1.0v 489.755n 1.0v 494.745n 1.0v 494.755n 1.0v 499.745n 1.0v 499.755n 1.0v 504.745n 1.0v 504.755n 0.0v 509.745n 0.0v 509.755n 0.0v 514.745n 0.0v 514.755n 0.0v 519.745n 0.0v 519.755n 0.0v 524.745n 0.0v 524.755n 0.0v 529.745n 0.0v 529.755n 0.0v 534.745n 0.0v 534.755n 0.0v 539.745n 0.0v 539.755n 0.0v 544.745n 0.0v 544.755n 0.0v 549.745n 0.0v 549.755n 0.0v 554.745n 0.0v 554.755n 1.0v 559.745n 1.0v 559.755n 0.0v 564.745n 0.0v 564.755n 1.0v 569.745n 1.0v 569.755n 0.0v 574.745n 0.0v 574.755n 0.0v 579.745n 0.0v 579.755n 0.0v 584.745n 0.0v 584.755n 0.0v 589.745n 0.0v 589.755n 0.0v 594.745n 0.0v 594.755n 1.0v 599.745n 1.0v 599.755n 0.0v 604.745n 0.0v 604.755n 0.0v 609.745n 0.0v 609.755n 0.0v 614.745n 0.0v 614.755n 0.0v 619.745n 0.0v 619.755n 1.0v 624.745n 1.0v 624.755n 1.0v 629.745n 1.0v 629.755n 1.0v 634.745n 1.0v 634.755n 1.0v 639.745n 1.0v 639.755n 0.0v 644.745n 0.0v 644.755n 0.0v 649.745n 0.0v 649.755n 1.0v 654.745n 1.0v 654.755n 1.0v 659.745n 1.0v 659.755n 1.0v 664.745n 1.0v 664.755n 1.0v 669.745n 1.0v 669.755n 1.0v 674.745n 1.0v 674.755n 0.0v 679.745n 0.0v 679.755n 1.0v 684.745n 1.0v 684.755n 1.0v 689.745n 1.0v 689.755n 1.0v 694.745n 1.0v 694.755n 0.0v 699.745n 0.0v 699.755n 0.0v 704.745n 0.0v 704.755n 1.0v 709.745n 1.0v 709.755n 1.0v 714.745n 1.0v 714.755n 0.0v 719.745n 0.0v 719.755n 0.0v 724.745n 0.0v 724.755n 1.0v 729.745n 1.0v 729.755n 1.0v 734.745n 1.0v 734.755n 0.0v 739.745n 0.0v 739.755n 0.0v 744.745n 0.0v 744.755n 1.0v 749.745n 1.0v 749.755n 0.0v 754.745n 0.0v 754.755n 0.0v 759.745n 0.0v 759.755n 1.0v 764.745n 1.0v 764.755n 1.0v 769.745n 1.0v 769.755n 1.0v 774.745n 1.0v 774.755n 0.0v 779.745n 0.0v 779.755n 0.0v 784.745n 0.0v 784.755n 0.0v 789.745n 0.0v 789.755n 0.0v 794.745n 0.0v 794.755n 0.0v 799.745n 0.0v 799.755n 0.0v 804.745n 0.0v 804.755n 1.0v 809.745n 1.0v 809.755n 1.0v 814.745n 1.0v 814.755n 1.0v 819.745n 1.0v 819.755n 0.0v 824.745n 0.0v 824.755n 0.0v 829.745n 0.0v 829.755n 1.0v 834.745n 1.0v 834.755n 1.0v 839.745n 1.0v 839.755n 0.0v 844.745n 0.0v 844.755n 1.0v 849.745n 1.0v 849.755n 0.0v 854.745n 0.0v 854.755n 1.0v 859.745n 1.0v 859.755n 0.0v 864.745n 0.0v 864.755n 0.0v 869.745n 0.0v 869.755n 0.0v 874.745n 0.0v 874.755n 1.0v 879.745n 1.0v 879.755n 1.0v 884.745n 1.0v 884.755n 1.0v 889.745n 1.0v 889.755n 1.0v 894.745n 1.0v 894.755n 1.0v 899.745n 1.0v 899.755n 1.0v 904.745n 1.0v 904.755n 0.0v 909.745n 0.0v 909.755n 0.0v 914.745n 0.0v 914.755n 0.0v 919.745n 0.0v 919.755n 1.0v 924.745n 1.0v 924.755n 0.0v 929.745n 0.0v 929.755n 0.0v 934.745n 0.0v 934.755n 0.0v 939.745n 0.0v 939.755n 1.0v 944.745n 1.0v 944.755n 1.0v 949.745n 1.0v 949.755n 1.0v 954.745n 1.0v 954.755n 1.0v 959.745n 1.0v 959.755n 0.0v 964.745n 0.0v 964.755n 1.0v 969.745n 1.0v 969.755n 0.0v 974.745n 0.0v 974.755n 0.0v 979.745n 0.0v 979.755n 0.0v 984.745n 0.0v 984.755n 0.0v 989.745n 0.0v 989.755n 0.0v 994.745n 0.0v 994.755n 1.0v 999.745n 1.0v 999.755n 0.0v 1004.745n 0.0v 1004.755n 0.0v 1009.745n 0.0v 1009.755n 0.0v 1014.745n 0.0v 1014.755n 1.0v 1019.745n 1.0v 1019.755n 0.0v 1024.745n 0.0v 1024.755n 0.0v )
* (time, data): [(0, 0), (5, 1), (10, 0), (15, 0), (20, 0), (25, 1), (30, 1), (35, 1), (40, 0), (45, 0), (50, 1), (55, 0), (60, 0), (65, 1), (70, 1), (75, 1), (80, 0), (85, 0), (90, 0), (95, 0), (100, 0), (105, 0), (110, 0), (115, 0), (120, 0), (125, 0), (130, 1), (135, 0), (140, 0), (145, 1), (150, 1), (155, 1), (160, 1), (165, 0), (170, 0), (175, 1), (180, 0), (185, 0), (190, 0), (195, 0), (200, 0), (205, 0), (210, 0), (215, 0), (220, 1), (225, 1), (230, 0), (235, 0), (240, 1), (245, 0), (250, 1), (255, 1), (260, 1), (265, 1), (270, 1), (275, 0), (280, 0), (285, 0), (290, 0), (295, 1), (300, 1), (305, 1), (310, 0), (315, 0), (320, 0), (325, 1), (330, 1), (335, 1), (340, 1), (345, 0), (350, 1), (355, 0), (360, 0), (365, 1), (370, 1), (375, 0), (380, 1), (385, 0), (390, 0), (395, 0), (400, 0), (405, 0), (410, 0), (415, 1), (420, 1), (425, 1), (430, 0), (435, 0), (440, 0), (445, 0), (450, 0), (455, 1), (460, 1), (465, 0), (470, 0), (475, 0), (480, 0), (485, 0), (490, 1), (495, 0), (500, 1), (505, 1), (510, 0), (515, 1), (520, 1), (525, 1), (530, 1), (535, 1), (540, 1), (545, 1), (550, 1), (555, 0), (560, 1), (565, 0), (570, 0), (575, 0), (580, 1), (585, 1), (590, 0), (595, 0), (600, 0), (605, 0), (610, 0), (615, 0), (620, 0), (625, 0), (630, 0), (635, 0), (640, 1), (645, 1), (650, 0), (655, 1), (660, 1), (665, 1), (670, 1), (675, 1), (680, 0), (685, 0), (690, 1), (695, 0), (700, 0), (705, 0), (710, 0), (715, 1), (720, 1), (725, 0), (730, 1), (735, 1), (740, 1), (745, 1), (750, 0), (755, 0), (760, 0), (765, 1), (770, 0), (775, 0), (780, 0), (785, 0), (790, 1), (795, 1), (800, 1), (805, 1), (810, 0), (815, 0), (820, 1), (825, 1), (830, 1), (835, 1), (840, 0), (845, 0), (850, 0), (855, 0), (860, 1), (865, 1), (870, 1), (875, 1), (880, 0), (885, 0), (890, 0), (895, 1), (900, 1), (905, 0), (910, 0), (915, 0), (920, 1), (925, 1), (930, 0), (935, 0), (940, 0), (945, 0), (950, 1), (955, 1), (960, 1), (965, 1), (970, 1), (975, 1), (980, 1), (985, 1), (990, 0), (995, 1), (1000, 0), (1005, 0), (1010, 1), (1015, 0), (1020, 1), (1025, 1)]
Va1_1  a1_1  0 PWL (0n 0.0v 4.745n 0.0v 4.755n 1.0v 9.745n 1.0v 9.755n 0.0v 14.745n 0.0v 14.755n 0.0v 19.745n 0.0v 19.755n 0.0v 24.745n 0.0v 24.755n 1.0v 29.745n 1.0v 29.755n 1.0v 34.745n 1.0v 34.755n 1.0v 39.745n 1.0v 39.755n 0.0v 44.745n 0.0v 44.755n 0.0v 49.745n 0.0v 49.755n 1.0v 54.745n 1.0v 54.755n 0.0v 59.745n 0.0v 59.755n 0.0v 64.745n 0.0v 64.755n 1.0v 69.745n 1.0v 69.755n 1.0v 74.745n 1.0v 74.755n 1.0v 79.745n 1.0v 79.755n 0.0v 84.745n 0.0v 84.755n 0.0v 89.745n 0.0v 89.755n 0.0v 94.745n 0.0v 94.755n 0.0v 99.745n 0.0v 99.755n 0.0v 104.745n 0.0v 104.755n 0.0v 109.745n 0.0v 109.755n 0.0v 114.745n 0.0v 114.755n 0.0v 119.745n 0.0v 119.755n 0.0v 124.745n 0.0v 124.755n 0.0v 129.745n 0.0v 129.755n 1.0v 134.745n 1.0v 134.755n 0.0v 139.745n 0.0v 139.755n 0.0v 144.745n 0.0v 144.755n 1.0v 149.745n 1.0v 149.755n 1.0v 154.745n 1.0v 154.755n 1.0v 159.745n 1.0v 159.755n 1.0v 164.745n 1.0v 164.755n 0.0v 169.745n 0.0v 169.755n 0.0v 174.745n 0.0v 174.755n 1.0v 179.745n 1.0v 179.755n 0.0v 184.745n 0.0v 184.755n 0.0v 189.745n 0.0v 189.755n 0.0v 194.745n 0.0v 194.755n 0.0v 199.745n 0.0v 199.755n 0.0v 204.745n 0.0v 204.755n 0.0v 209.745n 0.0v 209.755n 0.0v 214.745n 0.0v 214.755n 0.0v 219.745n 0.0v 219.755n 1.0v 224.745n 1.0v 224.755n 1.0v 229.745n 1.0v 229.755n 0.0v 234.745n 0.0v 234.755n 0.0v 239.745n 0.0v 239.755n 1.0v 244.745n 1.0v 244.755n 0.0v 249.745n 0.0v 249.755n 1.0v 254.745n 1.0v 254.755n 1.0v 259.745n 1.0v 259.755n 1.0v 264.745n 1.0v 264.755n 1.0v 269.745n 1.0v 269.755n 1.0v 274.745n 1.0v 274.755n 0.0v 279.745n 0.0v 279.755n 0.0v 284.745n 0.0v 284.755n 0.0v 289.745n 0.0v 289.755n 0.0v 294.745n 0.0v 294.755n 1.0v 299.745n 1.0v 299.755n 1.0v 304.745n 1.0v 304.755n 1.0v 309.745n 1.0v 309.755n 0.0v 314.745n 0.0v 314.755n 0.0v 319.745n 0.0v 319.755n 0.0v 324.745n 0.0v 324.755n 1.0v 329.745n 1.0v 329.755n 1.0v 334.745n 1.0v 334.755n 1.0v 339.745n 1.0v 339.755n 1.0v 344.745n 1.0v 344.755n 0.0v 349.745n 0.0v 349.755n 1.0v 354.745n 1.0v 354.755n 0.0v 359.745n 0.0v 359.755n 0.0v 364.745n 0.0v 364.755n 1.0v 369.745n 1.0v 369.755n 1.0v 374.745n 1.0v 374.755n 0.0v 379.745n 0.0v 379.755n 1.0v 384.745n 1.0v 384.755n 0.0v 389.745n 0.0v 389.755n 0.0v 394.745n 0.0v 394.755n 0.0v 399.745n 0.0v 399.755n 0.0v 404.745n 0.0v 404.755n 0.0v 409.745n 0.0v 409.755n 0.0v 414.745n 0.0v 414.755n 1.0v 419.745n 1.0v 419.755n 1.0v 424.745n 1.0v 424.755n 1.0v 429.745n 1.0v 429.755n 0.0v 434.745n 0.0v 434.755n 0.0v 439.745n 0.0v 439.755n 0.0v 444.745n 0.0v 444.755n 0.0v 449.745n 0.0v 449.755n 0.0v 454.745n 0.0v 454.755n 1.0v 459.745n 1.0v 459.755n 1.0v 464.745n 1.0v 464.755n 0.0v 469.745n 0.0v 469.755n 0.0v 474.745n 0.0v 474.755n 0.0v 479.745n 0.0v 479.755n 0.0v 484.745n 0.0v 484.755n 0.0v 489.745n 0.0v 489.755n 1.0v 494.745n 1.0v 494.755n 0.0v 499.745n 0.0v 499.755n 1.0v 504.745n 1.0v 504.755n 1.0v 509.745n 1.0v 509.755n 0.0v 514.745n 0.0v 514.755n 1.0v 519.745n 1.0v 519.755n 1.0v 524.745n 1.0v 524.755n 1.0v 529.745n 1.0v 529.755n 1.0v 534.745n 1.0v 534.755n 1.0v 539.745n 1.0v 539.755n 1.0v 544.745n 1.0v 544.755n 1.0v 549.745n 1.0v 549.755n 1.0v 554.745n 1.0v 554.755n 0.0v 559.745n 0.0v 559.755n 1.0v 564.745n 1.0v 564.755n 0.0v 569.745n 0.0v 569.755n 0.0v 574.745n 0.0v 574.755n 0.0v 579.745n 0.0v 579.755n 1.0v 584.745n 1.0v 584.755n 1.0v 589.745n 1.0v 589.755n 0.0v 594.745n 0.0v 594.755n 0.0v 599.745n 0.0v 599.755n 0.0v 604.745n 0.0v 604.755n 0.0v 609.745n 0.0v 609.755n 0.0v 614.745n 0.0v 614.755n 0.0v 619.745n 0.0v 619.755n 0.0v 624.745n 0.0v 624.755n 0.0v 629.745n 0.0v 629.755n 0.0v 634.745n 0.0v 634.755n 0.0v 639.745n 0.0v 639.755n 1.0v 644.745n 1.0v 644.755n 1.0v 649.745n 1.0v 649.755n 0.0v 654.745n 0.0v 654.755n 1.0v 659.745n 1.0v 659.755n 1.0v 664.745n 1.0v 664.755n 1.0v 669.745n 1.0v 669.755n 1.0v 674.745n 1.0v 674.755n 1.0v 679.745n 1.0v 679.755n 0.0v 684.745n 0.0v 684.755n 0.0v 689.745n 0.0v 689.755n 1.0v 694.745n 1.0v 694.755n 0.0v 699.745n 0.0v 699.755n 0.0v 704.745n 0.0v 704.755n 0.0v 709.745n 0.0v 709.755n 0.0v 714.745n 0.0v 714.755n 1.0v 719.745n 1.0v 719.755n 1.0v 724.745n 1.0v 724.755n 0.0v 729.745n 0.0v 729.755n 1.0v 734.745n 1.0v 734.755n 1.0v 739.745n 1.0v 739.755n 1.0v 744.745n 1.0v 744.755n 1.0v 749.745n 1.0v 749.755n 0.0v 754.745n 0.0v 754.755n 0.0v 759.745n 0.0v 759.755n 0.0v 764.745n 0.0v 764.755n 1.0v 769.745n 1.0v 769.755n 0.0v 774.745n 0.0v 774.755n 0.0v 779.745n 0.0v 779.755n 0.0v 784.745n 0.0v 784.755n 0.0v 789.745n 0.0v 789.755n 1.0v 794.745n 1.0v 794.755n 1.0v 799.745n 1.0v 799.755n 1.0v 804.745n 1.0v 804.755n 1.0v 809.745n 1.0v 809.755n 0.0v 814.745n 0.0v 814.755n 0.0v 819.745n 0.0v 819.755n 1.0v 824.745n 1.0v 824.755n 1.0v 829.745n 1.0v 829.755n 1.0v 834.745n 1.0v 834.755n 1.0v 839.745n 1.0v 839.755n 0.0v 844.745n 0.0v 844.755n 0.0v 849.745n 0.0v 849.755n 0.0v 854.745n 0.0v 854.755n 0.0v 859.745n 0.0v 859.755n 1.0v 864.745n 1.0v 864.755n 1.0v 869.745n 1.0v 869.755n 1.0v 874.745n 1.0v 874.755n 1.0v 879.745n 1.0v 879.755n 0.0v 884.745n 0.0v 884.755n 0.0v 889.745n 0.0v 889.755n 0.0v 894.745n 0.0v 894.755n 1.0v 899.745n 1.0v 899.755n 1.0v 904.745n 1.0v 904.755n 0.0v 909.745n 0.0v 909.755n 0.0v 914.745n 0.0v 914.755n 0.0v 919.745n 0.0v 919.755n 1.0v 924.745n 1.0v 924.755n 1.0v 929.745n 1.0v 929.755n 0.0v 934.745n 0.0v 934.755n 0.0v 939.745n 0.0v 939.755n 0.0v 944.745n 0.0v 944.755n 0.0v 949.745n 0.0v 949.755n 1.0v 954.745n 1.0v 954.755n 1.0v 959.745n 1.0v 959.755n 1.0v 964.745n 1.0v 964.755n 1.0v 969.745n 1.0v 969.755n 1.0v 974.745n 1.0v 974.755n 1.0v 979.745n 1.0v 979.755n 1.0v 984.745n 1.0v 984.755n 1.0v 989.745n 1.0v 989.755n 0.0v 994.745n 0.0v 994.755n 1.0v 999.745n 1.0v 999.755n 0.0v 1004.745n 0.0v 1004.755n 0.0v 1009.745n 0.0v 1009.755n 1.0v 1014.745n 1.0v 1014.755n 0.0v 1019.745n 0.0v 1019.755n 1.0v 1024.745n 1.0v 1024.755n 1.0v )
* (time, data): [(0, 0), (5, 0), (10, 0), (15, 1), (20, 1), (25, 0), (30, 0), (35, 0), (40, 1), (45, 1), (50, 0), (55, 1), (60, 1), (65, 0), (70, 0), (75, 0), (80, 1), (85, 1), (90, 1), (95, 1), (100, 1), (105, 0), (110, 1), (115, 1), (120, 1), (125, 1), (130, 0), (135, 1), (140, 0), (145, 0), (150, 0), (155, 0), (160, 0), (165, 0), (170, 0), (175, 0), (180, 1), (185, 1), (190, 1), (195, 1), (200, 1), (205, 1), (210, 0), (215, 1), (220, 0), (225, 0), (230, 1), (235, 0), (240, 1), (245, 1), (250, 1), (255, 1), (260, 1), (265, 0), (270, 0), (275, 0), (280, 0), (285, 0), (290, 0), (295, 0), (300, 0), (305, 0), (310, 1), (315, 1), (320, 1), (325, 0), (330, 0), (335, 0), (340, 0), (345, 1), (350, 0), (355, 1), (360, 1), (365, 0), (370, 0), (375, 0), (380, 0), (385, 0), (390, 1), (395, 1), (400, 1), (405, 0), (410, 1), (415, 1), (420, 1), (425, 1), (430, 0), (435, 0), (440, 0), (445, 0), (450, 0), (455, 0), (460, 0), (465, 0), (470, 0), (475, 0), (480, 0), (485, 0), (490, 0), (495, 0), (500, 0), (505, 1), (510, 1), (515, 1), (520, 1), (525, 1), (530, 1), (535, 0), (540, 0), (545, 0), (550, 0), (555, 0), (560, 1), (565, 1), (570, 1), (575, 1), (580, 1), (585, 1), (590, 1), (595, 1), (600, 0), (605, 1), (610, 1), (615, 1), (620, 0), (625, 0), (630, 0), (635, 0), (640, 0), (645, 0), (650, 1), (655, 0), (660, 0), (665, 0), (670, 0), (675, 0), (680, 0), (685, 1), (690, 0), (695, 0), (700, 0), (705, 0), (710, 0), (715, 1), (720, 0), (725, 1), (730, 0), (735, 1), (740, 1), (745, 0), (750, 1), (755, 0), (760, 1), (765, 0), (770, 0), (775, 0), (780, 0), (785, 0), (790, 1), (795, 1), (800, 1), (805, 0), (810, 0), (815, 0), (820, 0), (825, 0), (830, 0), (835, 0), (840, 0), (845, 0), (850, 0), (855, 0), (860, 0), (865, 0), (870, 0), (875, 0), (880, 1), (885, 1), (890, 1), (895, 0), (900, 0), (905, 0), (910, 0), (915, 1), (920, 0), (925, 0), (930, 1), (935, 1), (940, 0), (945, 0), (950, 0), (955, 0), (960, 0), (965, 0), (970, 0), (975, 0), (980, 0), (985, 0), (990, 0), (995, 0), (1000, 1), (1005, 1), (1010, 0), (1015, 1), (1020, 1), (1025, 1)]
Va1_2  a1_2  0 PWL (0n 0.0v 4.745n 0.0v 4.755n 0.0v 9.745n 0.0v 9.755n 0.0v 14.745n 0.0v 14.755n 1.0v 19.745n 1.0v 19.755n 1.0v 24.745n 1.0v 24.755n 0.0v 29.745n 0.0v 29.755n 0.0v 34.745n 0.0v 34.755n 0.0v 39.745n 0.0v 39.755n 1.0v 44.745n 1.0v 44.755n 1.0v 49.745n 1.0v 49.755n 0.0v 54.745n 0.0v 54.755n 1.0v 59.745n 1.0v 59.755n 1.0v 64.745n 1.0v 64.755n 0.0v 69.745n 0.0v 69.755n 0.0v 74.745n 0.0v 74.755n 0.0v 79.745n 0.0v 79.755n 1.0v 84.745n 1.0v 84.755n 1.0v 89.745n 1.0v 89.755n 1.0v 94.745n 1.0v 94.755n 1.0v 99.745n 1.0v 99.755n 1.0v 104.745n 1.0v 104.755n 0.0v 109.745n 0.0v 109.755n 1.0v 114.745n 1.0v 114.755n 1.0v 119.745n 1.0v 119.755n 1.0v 124.745n 1.0v 124.755n 1.0v 129.745n 1.0v 129.755n 0.0v 134.745n 0.0v 134.755n 1.0v 139.745n 1.0v 139.755n 0.0v 144.745n 0.0v 144.755n 0.0v 149.745n 0.0v 149.755n 0.0v 154.745n 0.0v 154.755n 0.0v 159.745n 0.0v 159.755n 0.0v 164.745n 0.0v 164.755n 0.0v 169.745n 0.0v 169.755n 0.0v 174.745n 0.0v 174.755n 0.0v 179.745n 0.0v 179.755n 1.0v 184.745n 1.0v 184.755n 1.0v 189.745n 1.0v 189.755n 1.0v 194.745n 1.0v 194.755n 1.0v 199.745n 1.0v 199.755n 1.0v 204.745n 1.0v 204.755n 1.0v 209.745n 1.0v 209.755n 0.0v 214.745n 0.0v 214.755n 1.0v 219.745n 1.0v 219.755n 0.0v 224.745n 0.0v 224.755n 0.0v 229.745n 0.0v 229.755n 1.0v 234.745n 1.0v 234.755n 0.0v 239.745n 0.0v 239.755n 1.0v 244.745n 1.0v 244.755n 1.0v 249.745n 1.0v 249.755n 1.0v 254.745n 1.0v 254.755n 1.0v 259.745n 1.0v 259.755n 1.0v 264.745n 1.0v 264.755n 0.0v 269.745n 0.0v 269.755n 0.0v 274.745n 0.0v 274.755n 0.0v 279.745n 0.0v 279.755n 0.0v 284.745n 0.0v 284.755n 0.0v 289.745n 0.0v 289.755n 0.0v 294.745n 0.0v 294.755n 0.0v 299.745n 0.0v 299.755n 0.0v 304.745n 0.0v 304.755n 0.0v 309.745n 0.0v 309.755n 1.0v 314.745n 1.0v 314.755n 1.0v 319.745n 1.0v 319.755n 1.0v 324.745n 1.0v 324.755n 0.0v 329.745n 0.0v 329.755n 0.0v 334.745n 0.0v 334.755n 0.0v 339.745n 0.0v 339.755n 0.0v 344.745n 0.0v 344.755n 1.0v 349.745n 1.0v 349.755n 0.0v 354.745n 0.0v 354.755n 1.0v 359.745n 1.0v 359.755n 1.0v 364.745n 1.0v 364.755n 0.0v 369.745n 0.0v 369.755n 0.0v 374.745n 0.0v 374.755n 0.0v 379.745n 0.0v 379.755n 0.0v 384.745n 0.0v 384.755n 0.0v 389.745n 0.0v 389.755n 1.0v 394.745n 1.0v 394.755n 1.0v 399.745n 1.0v 399.755n 1.0v 404.745n 1.0v 404.755n 0.0v 409.745n 0.0v 409.755n 1.0v 414.745n 1.0v 414.755n 1.0v 419.745n 1.0v 419.755n 1.0v 424.745n 1.0v 424.755n 1.0v 429.745n 1.0v 429.755n 0.0v 434.745n 0.0v 434.755n 0.0v 439.745n 0.0v 439.755n 0.0v 444.745n 0.0v 444.755n 0.0v 449.745n 0.0v 449.755n 0.0v 454.745n 0.0v 454.755n 0.0v 459.745n 0.0v 459.755n 0.0v 464.745n 0.0v 464.755n 0.0v 469.745n 0.0v 469.755n 0.0v 474.745n 0.0v 474.755n 0.0v 479.745n 0.0v 479.755n 0.0v 484.745n 0.0v 484.755n 0.0v 489.745n 0.0v 489.755n 0.0v 494.745n 0.0v 494.755n 0.0v 499.745n 0.0v 499.755n 0.0v 504.745n 0.0v 504.755n 1.0v 509.745n 1.0v 509.755n 1.0v 514.745n 1.0v 514.755n 1.0v 519.745n 1.0v 519.755n 1.0v 524.745n 1.0v 524.755n 1.0v 529.745n 1.0v 529.755n 1.0v 534.745n 1.0v 534.755n 0.0v 539.745n 0.0v 539.755n 0.0v 544.745n 0.0v 544.755n 0.0v 549.745n 0.0v 549.755n 0.0v 554.745n 0.0v 554.755n 0.0v 559.745n 0.0v 559.755n 1.0v 564.745n 1.0v 564.755n 1.0v 569.745n 1.0v 569.755n 1.0v 574.745n 1.0v 574.755n 1.0v 579.745n 1.0v 579.755n 1.0v 584.745n 1.0v 584.755n 1.0v 589.745n 1.0v 589.755n 1.0v 594.745n 1.0v 594.755n 1.0v 599.745n 1.0v 599.755n 0.0v 604.745n 0.0v 604.755n 1.0v 609.745n 1.0v 609.755n 1.0v 614.745n 1.0v 614.755n 1.0v 619.745n 1.0v 619.755n 0.0v 624.745n 0.0v 624.755n 0.0v 629.745n 0.0v 629.755n 0.0v 634.745n 0.0v 634.755n 0.0v 639.745n 0.0v 639.755n 0.0v 644.745n 0.0v 644.755n 0.0v 649.745n 0.0v 649.755n 1.0v 654.745n 1.0v 654.755n 0.0v 659.745n 0.0v 659.755n 0.0v 664.745n 0.0v 664.755n 0.0v 669.745n 0.0v 669.755n 0.0v 674.745n 0.0v 674.755n 0.0v 679.745n 0.0v 679.755n 0.0v 684.745n 0.0v 684.755n 1.0v 689.745n 1.0v 689.755n 0.0v 694.745n 0.0v 694.755n 0.0v 699.745n 0.0v 699.755n 0.0v 704.745n 0.0v 704.755n 0.0v 709.745n 0.0v 709.755n 0.0v 714.745n 0.0v 714.755n 1.0v 719.745n 1.0v 719.755n 0.0v 724.745n 0.0v 724.755n 1.0v 729.745n 1.0v 729.755n 0.0v 734.745n 0.0v 734.755n 1.0v 739.745n 1.0v 739.755n 1.0v 744.745n 1.0v 744.755n 0.0v 749.745n 0.0v 749.755n 1.0v 754.745n 1.0v 754.755n 0.0v 759.745n 0.0v 759.755n 1.0v 764.745n 1.0v 764.755n 0.0v 769.745n 0.0v 769.755n 0.0v 774.745n 0.0v 774.755n 0.0v 779.745n 0.0v 779.755n 0.0v 784.745n 0.0v 784.755n 0.0v 789.745n 0.0v 789.755n 1.0v 794.745n 1.0v 794.755n 1.0v 799.745n 1.0v 799.755n 1.0v 804.745n 1.0v 804.755n 0.0v 809.745n 0.0v 809.755n 0.0v 814.745n 0.0v 814.755n 0.0v 819.745n 0.0v 819.755n 0.0v 824.745n 0.0v 824.755n 0.0v 829.745n 0.0v 829.755n 0.0v 834.745n 0.0v 834.755n 0.0v 839.745n 0.0v 839.755n 0.0v 844.745n 0.0v 844.755n 0.0v 849.745n 0.0v 849.755n 0.0v 854.745n 0.0v 854.755n 0.0v 859.745n 0.0v 859.755n 0.0v 864.745n 0.0v 864.755n 0.0v 869.745n 0.0v 869.755n 0.0v 874.745n 0.0v 874.755n 0.0v 879.745n 0.0v 879.755n 1.0v 884.745n 1.0v 884.755n 1.0v 889.745n 1.0v 889.755n 1.0v 894.745n 1.0v 894.755n 0.0v 899.745n 0.0v 899.755n 0.0v 904.745n 0.0v 904.755n 0.0v 909.745n 0.0v 909.755n 0.0v 914.745n 0.0v 914.755n 1.0v 919.745n 1.0v 919.755n 0.0v 924.745n 0.0v 924.755n 0.0v 929.745n 0.0v 929.755n 1.0v 934.745n 1.0v 934.755n 1.0v 939.745n 1.0v 939.755n 0.0v 944.745n 0.0v 944.755n 0.0v 949.745n 0.0v 949.755n 0.0v 954.745n 0.0v 954.755n 0.0v 959.745n 0.0v 959.755n 0.0v 964.745n 0.0v 964.755n 0.0v 969.745n 0.0v 969.755n 0.0v 974.745n 0.0v 974.755n 0.0v 979.745n 0.0v 979.755n 0.0v 984.745n 0.0v 984.755n 0.0v 989.745n 0.0v 989.755n 0.0v 994.745n 0.0v 994.755n 0.0v 999.745n 0.0v 999.755n 1.0v 1004.745n 1.0v 1004.755n 1.0v 1009.745n 1.0v 1009.755n 0.0v 1014.745n 0.0v 1014.755n 1.0v 1019.745n 1.0v 1019.755n 1.0v 1024.745n 1.0v 1024.755n 1.0v )
* (time, data): [(0, 0), (5, 0), (10, 0), (15, 1), (20, 1), (25, 0), (30, 0), (35, 0), (40, 1), (45, 1), (50, 0), (55, 1), (60, 1), (65, 0), (70, 0), (75, 0), (80, 1), (85, 1), (90, 1), (95, 1), (100, 1), (105, 0), (110, 1), (115, 1), (120, 1), (125, 1), (130, 1), (135, 1), (140, 0), (145, 0), (150, 0), (155, 0), (160, 0), (165, 0), (170, 0), (175, 0), (180, 1), (185, 1), (190, 1), (195, 1), (200, 1), (205, 1), (210, 0), (215, 1), (220, 0), (225, 0), (230, 1), (235, 0), (240, 1), (245, 1), (250, 1), (255, 1), (260, 1), (265, 1), (270, 1), (275, 0), (280, 0), (285, 0), (290, 0), (295, 1), (300, 1), (305, 1), (310, 1), (315, 1), (320, 1), (325, 0), (330, 0), (335, 0), (340, 0), (345, 1), (350, 0), (355, 1), (360, 1), (365, 0), (370, 0), (375, 0), (380, 1), (385, 0), (390, 1), (395, 1), (400, 1), (405, 0), (410, 1), (415, 1), (420, 1), (425, 1), (430, 0), (435, 0), (440, 0), (445, 0), (450, 0), (455, 0), (460, 0), (465, 0), (470, 0), (475, 0), (480, 0), (485, 0), (490, 1), (495, 0), (500, 0), (505, 1), (510, 1), (515, 1), (520, 1), (525, 1), (530, 1), (535, 0), (540, 0), (545, 0), (550, 0), (555, 0), (560, 1), (565, 1), (570, 1), (575, 1), (580, 1), (585, 1), (590, 1), (595, 1), (600, 0), (605, 1), (610, 1), (615, 1), (620, 0), (625, 0), (630, 0), (635, 0), (640, 0), (645, 0), (650, 1), (655, 1), (660, 1), (665, 0), (670, 0), (675, 0), (680, 0), (685, 1), (690, 1), (695, 0), (700, 0), (705, 0), (710, 0), (715, 1), (720, 0), (725, 1), (730, 0), (735, 1), (740, 1), (745, 1), (750, 1), (755, 0), (760, 1), (765, 0), (770, 0), (775, 0), (780, 0), (785, 0), (790, 1), (795, 1), (800, 1), (805, 0), (810, 0), (815, 0), (820, 0), (825, 0), (830, 1), (835, 0), (840, 0), (845, 0), (850, 0), (855, 0), (860, 0), (865, 0), (870, 0), (875, 0), (880, 1), (885, 1), (890, 1), (895, 1), (900, 1), (905, 0), (910, 0), (915, 1), (920, 1), (925, 0), (930, 1), (935, 1), (940, 0), (945, 0), (950, 0), (955, 0), (960, 0), (965, 1), (970, 0), (975, 0), (980, 0), (985, 0), (990, 0), (995, 0), (1000, 1), (1005, 1), (1010, 0), (1015, 1), (1020, 1), (1025, 1)]
Va1_3  a1_3  0 PWL (0n 0.0v 4.745n 0.0v 4.755n 0.0v 9.745n 0.0v 9.755n 0.0v 14.745n 0.0v 14.755n 1.0v 19.745n 1.0v 19.755n 1.0v 24.745n 1.0v 24.755n 0.0v 29.745n 0.0v 29.755n 0.0v 34.745n 0.0v 34.755n 0.0v 39.745n 0.0v 39.755n 1.0v 44.745n 1.0v 44.755n 1.0v 49.745n 1.0v 49.755n 0.0v 54.745n 0.0v 54.755n 1.0v 59.745n 1.0v 59.755n 1.0v 64.745n 1.0v 64.755n 0.0v 69.745n 0.0v 69.755n 0.0v 74.745n 0.0v 74.755n 0.0v 79.745n 0.0v 79.755n 1.0v 84.745n 1.0v 84.755n 1.0v 89.745n 1.0v 89.755n 1.0v 94.745n 1.0v 94.755n 1.0v 99.745n 1.0v 99.755n 1.0v 104.745n 1.0v 104.755n 0.0v 109.745n 0.0v 109.755n 1.0v 114.745n 1.0v 114.755n 1.0v 119.745n 1.0v 119.755n 1.0v 124.745n 1.0v 124.755n 1.0v 129.745n 1.0v 129.755n 1.0v 134.745n 1.0v 134.755n 1.0v 139.745n 1.0v 139.755n 0.0v 144.745n 0.0v 144.755n 0.0v 149.745n 0.0v 149.755n 0.0v 154.745n 0.0v 154.755n 0.0v 159.745n 0.0v 159.755n 0.0v 164.745n 0.0v 164.755n 0.0v 169.745n 0.0v 169.755n 0.0v 174.745n 0.0v 174.755n 0.0v 179.745n 0.0v 179.755n 1.0v 184.745n 1.0v 184.755n 1.0v 189.745n 1.0v 189.755n 1.0v 194.745n 1.0v 194.755n 1.0v 199.745n 1.0v 199.755n 1.0v 204.745n 1.0v 204.755n 1.0v 209.745n 1.0v 209.755n 0.0v 214.745n 0.0v 214.755n 1.0v 219.745n 1.0v 219.755n 0.0v 224.745n 0.0v 224.755n 0.0v 229.745n 0.0v 229.755n 1.0v 234.745n 1.0v 234.755n 0.0v 239.745n 0.0v 239.755n 1.0v 244.745n 1.0v 244.755n 1.0v 249.745n 1.0v 249.755n 1.0v 254.745n 1.0v 254.755n 1.0v 259.745n 1.0v 259.755n 1.0v 264.745n 1.0v 264.755n 1.0v 269.745n 1.0v 269.755n 1.0v 274.745n 1.0v 274.755n 0.0v 279.745n 0.0v 279.755n 0.0v 284.745n 0.0v 284.755n 0.0v 289.745n 0.0v 289.755n 0.0v 294.745n 0.0v 294.755n 1.0v 299.745n 1.0v 299.755n 1.0v 304.745n 1.0v 304.755n 1.0v 309.745n 1.0v 309.755n 1.0v 314.745n 1.0v 314.755n 1.0v 319.745n 1.0v 319.755n 1.0v 324.745n 1.0v 324.755n 0.0v 329.745n 0.0v 329.755n 0.0v 334.745n 0.0v 334.755n 0.0v 339.745n 0.0v 339.755n 0.0v 344.745n 0.0v 344.755n 1.0v 349.745n 1.0v 349.755n 0.0v 354.745n 0.0v 354.755n 1.0v 359.745n 1.0v 359.755n 1.0v 364.745n 1.0v 364.755n 0.0v 369.745n 0.0v 369.755n 0.0v 374.745n 0.0v 374.755n 0.0v 379.745n 0.0v 379.755n 1.0v 384.745n 1.0v 384.755n 0.0v 389.745n 0.0v 389.755n 1.0v 394.745n 1.0v 394.755n 1.0v 399.745n 1.0v 399.755n 1.0v 404.745n 1.0v 404.755n 0.0v 409.745n 0.0v 409.755n 1.0v 414.745n 1.0v 414.755n 1.0v 419.745n 1.0v 419.755n 1.0v 424.745n 1.0v 424.755n 1.0v 429.745n 1.0v 429.755n 0.0v 434.745n 0.0v 434.755n 0.0v 439.745n 0.0v 439.755n 0.0v 444.745n 0.0v 444.755n 0.0v 449.745n 0.0v 449.755n 0.0v 454.745n 0.0v 454.755n 0.0v 459.745n 0.0v 459.755n 0.0v 464.745n 0.0v 464.755n 0.0v 469.745n 0.0v 469.755n 0.0v 474.745n 0.0v 474.755n 0.0v 479.745n 0.0v 479.755n 0.0v 484.745n 0.0v 484.755n 0.0v 489.745n 0.0v 489.755n 1.0v 494.745n 1.0v 494.755n 0.0v 499.745n 0.0v 499.755n 0.0v 504.745n 0.0v 504.755n 1.0v 509.745n 1.0v 509.755n 1.0v 514.745n 1.0v 514.755n 1.0v 519.745n 1.0v 519.755n 1.0v 524.745n 1.0v 524.755n 1.0v 529.745n 1.0v 529.755n 1.0v 534.745n 1.0v 534.755n 0.0v 539.745n 0.0v 539.755n 0.0v 544.745n 0.0v 544.755n 0.0v 549.745n 0.0v 549.755n 0.0v 554.745n 0.0v 554.755n 0.0v 559.745n 0.0v 559.755n 1.0v 564.745n 1.0v 564.755n 1.0v 569.745n 1.0v 569.755n 1.0v 574.745n 1.0v 574.755n 1.0v 579.745n 1.0v 579.755n 1.0v 584.745n 1.0v 584.755n 1.0v 589.745n 1.0v 589.755n 1.0v 594.745n 1.0v 594.755n 1.0v 599.745n 1.0v 599.755n 0.0v 604.745n 0.0v 604.755n 1.0v 609.745n 1.0v 609.755n 1.0v 614.745n 1.0v 614.755n 1.0v 619.745n 1.0v 619.755n 0.0v 624.745n 0.0v 624.755n 0.0v 629.745n 0.0v 629.755n 0.0v 634.745n 0.0v 634.755n 0.0v 639.745n 0.0v 639.755n 0.0v 644.745n 0.0v 644.755n 0.0v 649.745n 0.0v 649.755n 1.0v 654.745n 1.0v 654.755n 1.0v 659.745n 1.0v 659.755n 1.0v 664.745n 1.0v 664.755n 0.0v 669.745n 0.0v 669.755n 0.0v 674.745n 0.0v 674.755n 0.0v 679.745n 0.0v 679.755n 0.0v 684.745n 0.0v 684.755n 1.0v 689.745n 1.0v 689.755n 1.0v 694.745n 1.0v 694.755n 0.0v 699.745n 0.0v 699.755n 0.0v 704.745n 0.0v 704.755n 0.0v 709.745n 0.0v 709.755n 0.0v 714.745n 0.0v 714.755n 1.0v 719.745n 1.0v 719.755n 0.0v 724.745n 0.0v 724.755n 1.0v 729.745n 1.0v 729.755n 0.0v 734.745n 0.0v 734.755n 1.0v 739.745n 1.0v 739.755n 1.0v 744.745n 1.0v 744.755n 1.0v 749.745n 1.0v 749.755n 1.0v 754.745n 1.0v 754.755n 0.0v 759.745n 0.0v 759.755n 1.0v 764.745n 1.0v 764.755n 0.0v 769.745n 0.0v 769.755n 0.0v 774.745n 0.0v 774.755n 0.0v 779.745n 0.0v 779.755n 0.0v 784.745n 0.0v 784.755n 0.0v 789.745n 0.0v 789.755n 1.0v 794.745n 1.0v 794.755n 1.0v 799.745n 1.0v 799.755n 1.0v 804.745n 1.0v 804.755n 0.0v 809.745n 0.0v 809.755n 0.0v 814.745n 0.0v 814.755n 0.0v 819.745n 0.0v 819.755n 0.0v 824.745n 0.0v 824.755n 0.0v 829.745n 0.0v 829.755n 1.0v 834.745n 1.0v 834.755n 0.0v 839.745n 0.0v 839.755n 0.0v 844.745n 0.0v 844.755n 0.0v 849.745n 0.0v 849.755n 0.0v 854.745n 0.0v 854.755n 0.0v 859.745n 0.0v 859.755n 0.0v 864.745n 0.0v 864.755n 0.0v 869.745n 0.0v 869.755n 0.0v 874.745n 0.0v 874.755n 0.0v 879.745n 0.0v 879.755n 1.0v 884.745n 1.0v 884.755n 1.0v 889.745n 1.0v 889.755n 1.0v 894.745n 1.0v 894.755n 1.0v 899.745n 1.0v 899.755n 1.0v 904.745n 1.0v 904.755n 0.0v 909.745n 0.0v 909.755n 0.0v 914.745n 0.0v 914.755n 1.0v 919.745n 1.0v 919.755n 1.0v 924.745n 1.0v 924.755n 0.0v 929.745n 0.0v 929.755n 1.0v 934.745n 1.0v 934.755n 1.0v 939.745n 1.0v 939.755n 0.0v 944.745n 0.0v 944.755n 0.0v 949.745n 0.0v 949.755n 0.0v 954.745n 0.0v 954.755n 0.0v 959.745n 0.0v 959.755n 0.0v 964.745n 0.0v 964.755n 1.0v 969.745n 1.0v 969.755n 0.0v 974.745n 0.0v 974.755n 0.0v 979.745n 0.0v 979.755n 0.0v 984.745n 0.0v 984.755n 0.0v 989.745n 0.0v 989.755n 0.0v 994.745n 0.0v 994.755n 0.0v 999.745n 0.0v 999.755n 1.0v 1004.745n 1.0v 1004.755n 1.0v 1009.745n 1.0v 1009.755n 0.0v 1014.745n 0.0v 1014.755n 1.0v 1019.745n 1.0v 1019.755n 1.0v 1024.745n 1.0v 1024.755n 1.0v )
* (time, data): [(0, 0), (5, 0), (10, 0), (15, 1), (20, 1), (25, 0), (30, 0), (35, 0), (40, 1), (45, 1), (50, 0), (55, 1), (60, 1), (65, 0), (70, 0), (75, 0), (80, 1), (85, 1), (90, 1), (95, 1), (100, 1), (105, 0), (110, 1), (115, 1), (120, 1), (125, 1), (130, 1), (135, 1), (140, 0), (145, 0), (150, 0), (155, 0), (160, 0), (165, 0), (170, 0), (175, 0), (180, 1), (185, 1), (190, 1), (195, 1), (200, 1), (205, 1), (210, 0), (215, 1), (220, 0), (225, 0), (230, 1), (235, 0), (240, 1), (245, 1), (250, 1), (255, 1), (260, 1), (265, 1), (270, 1), (275, 0), (280, 0), (285, 0), (290, 0), (295, 1), (300, 1), (305, 1), (310, 1), (315, 1), (320, 1), (325, 0), (330, 0), (335, 0), (340, 0), (345, 1), (350, 0), (355, 1), (360, 1), (365, 0), (370, 0), (375, 0), (380, 1), (385, 0), (390, 1), (395, 1), (400, 1), (405, 0), (410, 1), (415, 1), (420, 1), (425, 1), (430, 0), (435, 0), (440, 0), (445, 0), (450, 0), (455, 0), (460, 0), (465, 0), (470, 0), (475, 0), (480, 0), (485, 0), (490, 1), (495, 0), (500, 0), (505, 1), (510, 1), (515, 1), (520, 1), (525, 1), (530, 1), (535, 0), (540, 0), (545, 0), (550, 0), (555, 0), (560, 1), (565, 1), (570, 1), (575, 1), (580, 1), (585, 1), (590, 1), (595, 1), (600, 0), (605, 1), (610, 1), (615, 1), (620, 0), (625, 0), (630, 0), (635, 0), (640, 0), (645, 0), (650, 1), (655, 1), (660, 1), (665, 0), (670, 0), (675, 0), (680, 0), (685, 1), (690, 1), (695, 0), (700, 0), (705, 0), (710, 0), (715, 1), (720, 0), (725, 1), (730, 0), (735, 1), (740, 1), (745, 1), (750, 1), (755, 0), (760, 1), (765, 0), (770, 0), (775, 0), (780, 0), (785, 0), (790, 1), (795, 1), (800, 1), (805, 0), (810, 0), (815, 0), (820, 0), (825, 0), (830, 1), (835, 0), (840, 0), (845, 0), (850, 0), (855, 0), (860, 0), (865, 0), (870, 0), (875, 0), (880, 1), (885, 1), (890, 1), (895, 1), (900, 1), (905, 0), (910, 0), (915, 1), (920, 1), (925, 0), (930, 1), (935, 1), (940, 0), (945, 0), (950, 0), (955, 0), (960, 0), (965, 1), (970, 0), (975, 0), (980, 0), (985, 0), (990, 0), (995, 0), (1000, 1), (1005, 1), (1010, 0), (1015, 1), (1020, 1), (1025, 1)]
Va1_4  a1_4  0 PWL (0n 0.0v 4.745n 0.0v 4.755n 0.0v 9.745n 0.0v 9.755n 0.0v 14.745n 0.0v 14.755n 1.0v 19.745n 1.0v 19.755n 1.0v 24.745n 1.0v 24.755n 0.0v 29.745n 0.0v 29.755n 0.0v 34.745n 0.0v 34.755n 0.0v 39.745n 0.0v 39.755n 1.0v 44.745n 1.0v 44.755n 1.0v 49.745n 1.0v 49.755n 0.0v 54.745n 0.0v 54.755n 1.0v 59.745n 1.0v 59.755n 1.0v 64.745n 1.0v 64.755n 0.0v 69.745n 0.0v 69.755n 0.0v 74.745n 0.0v 74.755n 0.0v 79.745n 0.0v 79.755n 1.0v 84.745n 1.0v 84.755n 1.0v 89.745n 1.0v 89.755n 1.0v 94.745n 1.0v 94.755n 1.0v 99.745n 1.0v 99.755n 1.0v 104.745n 1.0v 104.755n 0.0v 109.745n 0.0v 109.755n 1.0v 114.745n 1.0v 114.755n 1.0v 119.745n 1.0v 119.755n 1.0v 124.745n 1.0v 124.755n 1.0v 129.745n 1.0v 129.755n 1.0v 134.745n 1.0v 134.755n 1.0v 139.745n 1.0v 139.755n 0.0v 144.745n 0.0v 144.755n 0.0v 149.745n 0.0v 149.755n 0.0v 154.745n 0.0v 154.755n 0.0v 159.745n 0.0v 159.755n 0.0v 164.745n 0.0v 164.755n 0.0v 169.745n 0.0v 169.755n 0.0v 174.745n 0.0v 174.755n 0.0v 179.745n 0.0v 179.755n 1.0v 184.745n 1.0v 184.755n 1.0v 189.745n 1.0v 189.755n 1.0v 194.745n 1.0v 194.755n 1.0v 199.745n 1.0v 199.755n 1.0v 204.745n 1.0v 204.755n 1.0v 209.745n 1.0v 209.755n 0.0v 214.745n 0.0v 214.755n 1.0v 219.745n 1.0v 219.755n 0.0v 224.745n 0.0v 224.755n 0.0v 229.745n 0.0v 229.755n 1.0v 234.745n 1.0v 234.755n 0.0v 239.745n 0.0v 239.755n 1.0v 244.745n 1.0v 244.755n 1.0v 249.745n 1.0v 249.755n 1.0v 254.745n 1.0v 254.755n 1.0v 259.745n 1.0v 259.755n 1.0v 264.745n 1.0v 264.755n 1.0v 269.745n 1.0v 269.755n 1.0v 274.745n 1.0v 274.755n 0.0v 279.745n 0.0v 279.755n 0.0v 284.745n 0.0v 284.755n 0.0v 289.745n 0.0v 289.755n 0.0v 294.745n 0.0v 294.755n 1.0v 299.745n 1.0v 299.755n 1.0v 304.745n 1.0v 304.755n 1.0v 309.745n 1.0v 309.755n 1.0v 314.745n 1.0v 314.755n 1.0v 319.745n 1.0v 319.755n 1.0v 324.745n 1.0v 324.755n 0.0v 329.745n 0.0v 329.755n 0.0v 334.745n 0.0v 334.755n 0.0v 339.745n 0.0v 339.755n 0.0v 344.745n 0.0v 344.755n 1.0v 349.745n 1.0v 349.755n 0.0v 354.745n 0.0v 354.755n 1.0v 359.745n 1.0v 359.755n 1.0v 364.745n 1.0v 364.755n 0.0v 369.745n 0.0v 369.755n 0.0v 374.745n 0.0v 374.755n 0.0v 379.745n 0.0v 379.755n 1.0v 384.745n 1.0v 384.755n 0.0v 389.745n 0.0v 389.755n 1.0v 394.745n 1.0v 394.755n 1.0v 399.745n 1.0v 399.755n 1.0v 404.745n 1.0v 404.755n 0.0v 409.745n 0.0v 409.755n 1.0v 414.745n 1.0v 414.755n 1.0v 419.745n 1.0v 419.755n 1.0v 424.745n 1.0v 424.755n 1.0v 429.745n 1.0v 429.755n 0.0v 434.745n 0.0v 434.755n 0.0v 439.745n 0.0v 439.755n 0.0v 444.745n 0.0v 444.755n 0.0v 449.745n 0.0v 449.755n 0.0v 454.745n 0.0v 454.755n 0.0v 459.745n 0.0v 459.755n 0.0v 464.745n 0.0v 464.755n 0.0v 469.745n 0.0v 469.755n 0.0v 474.745n 0.0v 474.755n 0.0v 479.745n 0.0v 479.755n 0.0v 484.745n 0.0v 484.755n 0.0v 489.745n 0.0v 489.755n 1.0v 494.745n 1.0v 494.755n 0.0v 499.745n 0.0v 499.755n 0.0v 504.745n 0.0v 504.755n 1.0v 509.745n 1.0v 509.755n 1.0v 514.745n 1.0v 514.755n 1.0v 519.745n 1.0v 519.755n 1.0v 524.745n 1.0v 524.755n 1.0v 529.745n 1.0v 529.755n 1.0v 534.745n 1.0v 534.755n 0.0v 539.745n 0.0v 539.755n 0.0v 544.745n 0.0v 544.755n 0.0v 549.745n 0.0v 549.755n 0.0v 554.745n 0.0v 554.755n 0.0v 559.745n 0.0v 559.755n 1.0v 564.745n 1.0v 564.755n 1.0v 569.745n 1.0v 569.755n 1.0v 574.745n 1.0v 574.755n 1.0v 579.745n 1.0v 579.755n 1.0v 584.745n 1.0v 584.755n 1.0v 589.745n 1.0v 589.755n 1.0v 594.745n 1.0v 594.755n 1.0v 599.745n 1.0v 599.755n 0.0v 604.745n 0.0v 604.755n 1.0v 609.745n 1.0v 609.755n 1.0v 614.745n 1.0v 614.755n 1.0v 619.745n 1.0v 619.755n 0.0v 624.745n 0.0v 624.755n 0.0v 629.745n 0.0v 629.755n 0.0v 634.745n 0.0v 634.755n 0.0v 639.745n 0.0v 639.755n 0.0v 644.745n 0.0v 644.755n 0.0v 649.745n 0.0v 649.755n 1.0v 654.745n 1.0v 654.755n 1.0v 659.745n 1.0v 659.755n 1.0v 664.745n 1.0v 664.755n 0.0v 669.745n 0.0v 669.755n 0.0v 674.745n 0.0v 674.755n 0.0v 679.745n 0.0v 679.755n 0.0v 684.745n 0.0v 684.755n 1.0v 689.745n 1.0v 689.755n 1.0v 694.745n 1.0v 694.755n 0.0v 699.745n 0.0v 699.755n 0.0v 704.745n 0.0v 704.755n 0.0v 709.745n 0.0v 709.755n 0.0v 714.745n 0.0v 714.755n 1.0v 719.745n 1.0v 719.755n 0.0v 724.745n 0.0v 724.755n 1.0v 729.745n 1.0v 729.755n 0.0v 734.745n 0.0v 734.755n 1.0v 739.745n 1.0v 739.755n 1.0v 744.745n 1.0v 744.755n 1.0v 749.745n 1.0v 749.755n 1.0v 754.745n 1.0v 754.755n 0.0v 759.745n 0.0v 759.755n 1.0v 764.745n 1.0v 764.755n 0.0v 769.745n 0.0v 769.755n 0.0v 774.745n 0.0v 774.755n 0.0v 779.745n 0.0v 779.755n 0.0v 784.745n 0.0v 784.755n 0.0v 789.745n 0.0v 789.755n 1.0v 794.745n 1.0v 794.755n 1.0v 799.745n 1.0v 799.755n 1.0v 804.745n 1.0v 804.755n 0.0v 809.745n 0.0v 809.755n 0.0v 814.745n 0.0v 814.755n 0.0v 819.745n 0.0v 819.755n 0.0v 824.745n 0.0v 824.755n 0.0v 829.745n 0.0v 829.755n 1.0v 834.745n 1.0v 834.755n 0.0v 839.745n 0.0v 839.755n 0.0v 844.745n 0.0v 844.755n 0.0v 849.745n 0.0v 849.755n 0.0v 854.745n 0.0v 854.755n 0.0v 859.745n 0.0v 859.755n 0.0v 864.745n 0.0v 864.755n 0.0v 869.745n 0.0v 869.755n 0.0v 874.745n 0.0v 874.755n 0.0v 879.745n 0.0v 879.755n 1.0v 884.745n 1.0v 884.755n 1.0v 889.745n 1.0v 889.755n 1.0v 894.745n 1.0v 894.755n 1.0v 899.745n 1.0v 899.755n 1.0v 904.745n 1.0v 904.755n 0.0v 909.745n 0.0v 909.755n 0.0v 914.745n 0.0v 914.755n 1.0v 919.745n 1.0v 919.755n 1.0v 924.745n 1.0v 924.755n 0.0v 929.745n 0.0v 929.755n 1.0v 934.745n 1.0v 934.755n 1.0v 939.745n 1.0v 939.755n 0.0v 944.745n 0.0v 944.755n 0.0v 949.745n 0.0v 949.755n 0.0v 954.745n 0.0v 954.755n 0.0v 959.745n 0.0v 959.755n 0.0v 964.745n 0.0v 964.755n 1.0v 969.745n 1.0v 969.755n 0.0v 974.745n 0.0v 974.755n 0.0v 979.745n 0.0v 979.755n 0.0v 984.745n 0.0v 984.755n 0.0v 989.745n 0.0v 989.755n 0.0v 994.745n 0.0v 994.755n 0.0v 999.745n 0.0v 999.755n 1.0v 1004.745n 1.0v 1004.755n 1.0v 1009.745n 1.0v 1009.755n 0.0v 1014.745n 0.0v 1014.755n 1.0v 1019.745n 1.0v 1019.755n 1.0v 1024.745n 1.0v 1024.755n 1.0v )
* (time, data): [(0, 0), (5, 0), (10, 0), (15, 1), (20, 1), (25, 0), (30, 0), (35, 0), (40, 1), (45, 1), (50, 0), (55, 1), (60, 1), (65, 0), (70, 0), (75, 0), (80, 1), (85, 1), (90, 1), (95, 1), (100, 1), (105, 0), (110, 1), (115, 1), (120, 1), (125, 1), (130, 1), (135, 1), (140, 0), (145, 0), (150, 0), (155, 0), (160, 0), (165, 0), (170, 0), (175, 0), (180, 1), (185, 1), (190, 1), (195, 1), (200, 1), (205, 1), (210, 0), (215, 1), (220, 0), (225, 0), (230, 1), (235, 0), (240, 1), (245, 1), (250, 1), (255, 1), (260, 1), (265, 1), (270, 1), (275, 0), (280, 0), (285, 0), (290, 0), (295, 1), (300, 1), (305, 1), (310, 1), (315, 1), (320, 1), (325, 0), (330, 0), (335, 0), (340, 0), (345, 1), (350, 0), (355, 1), (360, 1), (365, 0), (370, 0), (375, 0), (380, 1), (385, 0), (390, 1), (395, 1), (400, 1), (405, 0), (410, 1), (415, 1), (420, 1), (425, 1), (430, 0), (435, 0), (440, 0), (445, 0), (450, 0), (455, 0), (460, 0), (465, 0), (470, 0), (475, 0), (480, 0), (485, 0), (490, 1), (495, 0), (500, 0), (505, 1), (510, 1), (515, 1), (520, 1), (525, 1), (530, 1), (535, 0), (540, 0), (545, 0), (550, 0), (555, 0), (560, 1), (565, 1), (570, 1), (575, 1), (580, 1), (585, 1), (590, 1), (595, 1), (600, 0), (605, 1), (610, 1), (615, 1), (620, 0), (625, 0), (630, 0), (635, 0), (640, 0), (645, 0), (650, 1), (655, 1), (660, 1), (665, 0), (670, 0), (675, 0), (680, 0), (685, 1), (690, 1), (695, 0), (700, 0), (705, 0), (710, 0), (715, 1), (720, 0), (725, 1), (730, 0), (735, 1), (740, 1), (745, 1), (750, 1), (755, 0), (760, 1), (765, 0), (770, 0), (775, 0), (780, 0), (785, 0), (790, 1), (795, 1), (800, 1), (805, 0), (810, 0), (815, 0), (820, 0), (825, 0), (830, 1), (835, 0), (840, 0), (845, 0), (850, 0), (855, 0), (860, 0), (865, 0), (870, 0), (875, 0), (880, 1), (885, 1), (890, 1), (895, 1), (900, 1), (905, 0), (910, 0), (915, 1), (920, 1), (925, 0), (930, 1), (935, 1), (940, 0), (945, 0), (950, 0), (955, 0), (960, 0), (965, 1), (970, 0), (975, 0), (980, 0), (985, 0), (990, 0), (995, 0), (1000, 1), (1005, 1), (1010, 0), (1015, 1), (1020, 1), (1025, 1)]
Va1_5  a1_5  0 PWL (0n 0.0v 4.745n 0.0v 4.755n 0.0v 9.745n 0.0v 9.755n 0.0v 14.745n 0.0v 14.755n 1.0v 19.745n 1.0v 19.755n 1.0v 24.745n 1.0v 24.755n 0.0v 29.745n 0.0v 29.755n 0.0v 34.745n 0.0v 34.755n 0.0v 39.745n 0.0v 39.755n 1.0v 44.745n 1.0v 44.755n 1.0v 49.745n 1.0v 49.755n 0.0v 54.745n 0.0v 54.755n 1.0v 59.745n 1.0v 59.755n 1.0v 64.745n 1.0v 64.755n 0.0v 69.745n 0.0v 69.755n 0.0v 74.745n 0.0v 74.755n 0.0v 79.745n 0.0v 79.755n 1.0v 84.745n 1.0v 84.755n 1.0v 89.745n 1.0v 89.755n 1.0v 94.745n 1.0v 94.755n 1.0v 99.745n 1.0v 99.755n 1.0v 104.745n 1.0v 104.755n 0.0v 109.745n 0.0v 109.755n 1.0v 114.745n 1.0v 114.755n 1.0v 119.745n 1.0v 119.755n 1.0v 124.745n 1.0v 124.755n 1.0v 129.745n 1.0v 129.755n 1.0v 134.745n 1.0v 134.755n 1.0v 139.745n 1.0v 139.755n 0.0v 144.745n 0.0v 144.755n 0.0v 149.745n 0.0v 149.755n 0.0v 154.745n 0.0v 154.755n 0.0v 159.745n 0.0v 159.755n 0.0v 164.745n 0.0v 164.755n 0.0v 169.745n 0.0v 169.755n 0.0v 174.745n 0.0v 174.755n 0.0v 179.745n 0.0v 179.755n 1.0v 184.745n 1.0v 184.755n 1.0v 189.745n 1.0v 189.755n 1.0v 194.745n 1.0v 194.755n 1.0v 199.745n 1.0v 199.755n 1.0v 204.745n 1.0v 204.755n 1.0v 209.745n 1.0v 209.755n 0.0v 214.745n 0.0v 214.755n 1.0v 219.745n 1.0v 219.755n 0.0v 224.745n 0.0v 224.755n 0.0v 229.745n 0.0v 229.755n 1.0v 234.745n 1.0v 234.755n 0.0v 239.745n 0.0v 239.755n 1.0v 244.745n 1.0v 244.755n 1.0v 249.745n 1.0v 249.755n 1.0v 254.745n 1.0v 254.755n 1.0v 259.745n 1.0v 259.755n 1.0v 264.745n 1.0v 264.755n 1.0v 269.745n 1.0v 269.755n 1.0v 274.745n 1.0v 274.755n 0.0v 279.745n 0.0v 279.755n 0.0v 284.745n 0.0v 284.755n 0.0v 289.745n 0.0v 289.755n 0.0v 294.745n 0.0v 294.755n 1.0v 299.745n 1.0v 299.755n 1.0v 304.745n 1.0v 304.755n 1.0v 309.745n 1.0v 309.755n 1.0v 314.745n 1.0v 314.755n 1.0v 319.745n 1.0v 319.755n 1.0v 324.745n 1.0v 324.755n 0.0v 329.745n 0.0v 329.755n 0.0v 334.745n 0.0v 334.755n 0.0v 339.745n 0.0v 339.755n 0.0v 344.745n 0.0v 344.755n 1.0v 349.745n 1.0v 349.755n 0.0v 354.745n 0.0v 354.755n 1.0v 359.745n 1.0v 359.755n 1.0v 364.745n 1.0v 364.755n 0.0v 369.745n 0.0v 369.755n 0.0v 374.745n 0.0v 374.755n 0.0v 379.745n 0.0v 379.755n 1.0v 384.745n 1.0v 384.755n 0.0v 389.745n 0.0v 389.755n 1.0v 394.745n 1.0v 394.755n 1.0v 399.745n 1.0v 399.755n 1.0v 404.745n 1.0v 404.755n 0.0v 409.745n 0.0v 409.755n 1.0v 414.745n 1.0v 414.755n 1.0v 419.745n 1.0v 419.755n 1.0v 424.745n 1.0v 424.755n 1.0v 429.745n 1.0v 429.755n 0.0v 434.745n 0.0v 434.755n 0.0v 439.745n 0.0v 439.755n 0.0v 444.745n 0.0v 444.755n 0.0v 449.745n 0.0v 449.755n 0.0v 454.745n 0.0v 454.755n 0.0v 459.745n 0.0v 459.755n 0.0v 464.745n 0.0v 464.755n 0.0v 469.745n 0.0v 469.755n 0.0v 474.745n 0.0v 474.755n 0.0v 479.745n 0.0v 479.755n 0.0v 484.745n 0.0v 484.755n 0.0v 489.745n 0.0v 489.755n 1.0v 494.745n 1.0v 494.755n 0.0v 499.745n 0.0v 499.755n 0.0v 504.745n 0.0v 504.755n 1.0v 509.745n 1.0v 509.755n 1.0v 514.745n 1.0v 514.755n 1.0v 519.745n 1.0v 519.755n 1.0v 524.745n 1.0v 524.755n 1.0v 529.745n 1.0v 529.755n 1.0v 534.745n 1.0v 534.755n 0.0v 539.745n 0.0v 539.755n 0.0v 544.745n 0.0v 544.755n 0.0v 549.745n 0.0v 549.755n 0.0v 554.745n 0.0v 554.755n 0.0v 559.745n 0.0v 559.755n 1.0v 564.745n 1.0v 564.755n 1.0v 569.745n 1.0v 569.755n 1.0v 574.745n 1.0v 574.755n 1.0v 579.745n 1.0v 579.755n 1.0v 584.745n 1.0v 584.755n 1.0v 589.745n 1.0v 589.755n 1.0v 594.745n 1.0v 594.755n 1.0v 599.745n 1.0v 599.755n 0.0v 604.745n 0.0v 604.755n 1.0v 609.745n 1.0v 609.755n 1.0v 614.745n 1.0v 614.755n 1.0v 619.745n 1.0v 619.755n 0.0v 624.745n 0.0v 624.755n 0.0v 629.745n 0.0v 629.755n 0.0v 634.745n 0.0v 634.755n 0.0v 639.745n 0.0v 639.755n 0.0v 644.745n 0.0v 644.755n 0.0v 649.745n 0.0v 649.755n 1.0v 654.745n 1.0v 654.755n 1.0v 659.745n 1.0v 659.755n 1.0v 664.745n 1.0v 664.755n 0.0v 669.745n 0.0v 669.755n 0.0v 674.745n 0.0v 674.755n 0.0v 679.745n 0.0v 679.755n 0.0v 684.745n 0.0v 684.755n 1.0v 689.745n 1.0v 689.755n 1.0v 694.745n 1.0v 694.755n 0.0v 699.745n 0.0v 699.755n 0.0v 704.745n 0.0v 704.755n 0.0v 709.745n 0.0v 709.755n 0.0v 714.745n 0.0v 714.755n 1.0v 719.745n 1.0v 719.755n 0.0v 724.745n 0.0v 724.755n 1.0v 729.745n 1.0v 729.755n 0.0v 734.745n 0.0v 734.755n 1.0v 739.745n 1.0v 739.755n 1.0v 744.745n 1.0v 744.755n 1.0v 749.745n 1.0v 749.755n 1.0v 754.745n 1.0v 754.755n 0.0v 759.745n 0.0v 759.755n 1.0v 764.745n 1.0v 764.755n 0.0v 769.745n 0.0v 769.755n 0.0v 774.745n 0.0v 774.755n 0.0v 779.745n 0.0v 779.755n 0.0v 784.745n 0.0v 784.755n 0.0v 789.745n 0.0v 789.755n 1.0v 794.745n 1.0v 794.755n 1.0v 799.745n 1.0v 799.755n 1.0v 804.745n 1.0v 804.755n 0.0v 809.745n 0.0v 809.755n 0.0v 814.745n 0.0v 814.755n 0.0v 819.745n 0.0v 819.755n 0.0v 824.745n 0.0v 824.755n 0.0v 829.745n 0.0v 829.755n 1.0v 834.745n 1.0v 834.755n 0.0v 839.745n 0.0v 839.755n 0.0v 844.745n 0.0v 844.755n 0.0v 849.745n 0.0v 849.755n 0.0v 854.745n 0.0v 854.755n 0.0v 859.745n 0.0v 859.755n 0.0v 864.745n 0.0v 864.755n 0.0v 869.745n 0.0v 869.755n 0.0v 874.745n 0.0v 874.755n 0.0v 879.745n 0.0v 879.755n 1.0v 884.745n 1.0v 884.755n 1.0v 889.745n 1.0v 889.755n 1.0v 894.745n 1.0v 894.755n 1.0v 899.745n 1.0v 899.755n 1.0v 904.745n 1.0v 904.755n 0.0v 909.745n 0.0v 909.755n 0.0v 914.745n 0.0v 914.755n 1.0v 919.745n 1.0v 919.755n 1.0v 924.745n 1.0v 924.755n 0.0v 929.745n 0.0v 929.755n 1.0v 934.745n 1.0v 934.755n 1.0v 939.745n 1.0v 939.755n 0.0v 944.745n 0.0v 944.755n 0.0v 949.745n 0.0v 949.755n 0.0v 954.745n 0.0v 954.755n 0.0v 959.745n 0.0v 959.755n 0.0v 964.745n 0.0v 964.755n 1.0v 969.745n 1.0v 969.755n 0.0v 974.745n 0.0v 974.755n 0.0v 979.745n 0.0v 979.755n 0.0v 984.745n 0.0v 984.755n 0.0v 989.745n 0.0v 989.755n 0.0v 994.745n 0.0v 994.755n 0.0v 999.745n 0.0v 999.755n 1.0v 1004.745n 1.0v 1004.755n 1.0v 1009.745n 1.0v 1009.755n 0.0v 1014.745n 0.0v 1014.755n 1.0v 1019.745n 1.0v 1019.755n 1.0v 1024.745n 1.0v 1024.755n 1.0v )
* (time, data): [(0, 0), (5, 0), (10, 0), (15, 1), (20, 1), (25, 0), (30, 0), (35, 0), (40, 1), (45, 1), (50, 0), (55, 1), (60, 1), (65, 0), (70, 0), (75, 0), (80, 1), (85, 1), (90, 1), (95, 1), (100, 1), (105, 0), (110, 1), (115, 1), (120, 1), (125, 1), (130, 1), (135, 1), (140, 0), (145, 0), (150, 0), (155, 0), (160, 0), (165, 0), (170, 0), (175, 0), (180, 1), (185, 1), (190, 1), (195, 1), (200, 1), (205, 1), (210, 0), (215, 1), (220, 0), (225, 0), (230, 1), (235, 0), (240, 1), (245, 1), (250, 1), (255, 1), (260, 1), (265, 1), (270, 1), (275, 0), (280, 0), (285, 0), (290, 0), (295, 1), (300, 1), (305, 1), (310, 1), (315, 1), (320, 1), (325, 0), (330, 0), (335, 0), (340, 0), (345, 1), (350, 0), (355, 1), (360, 1), (365, 0), (370, 0), (375, 0), (380, 1), (385, 0), (390, 1), (395, 1), (400, 1), (405, 0), (410, 1), (415, 1), (420, 1), (425, 1), (430, 0), (435, 0), (440, 0), (445, 0), (450, 0), (455, 0), (460, 0), (465, 0), (470, 0), (475, 0), (480, 0), (485, 0), (490, 1), (495, 0), (500, 0), (505, 1), (510, 1), (515, 1), (520, 1), (525, 1), (530, 1), (535, 0), (540, 0), (545, 0), (550, 0), (555, 0), (560, 1), (565, 1), (570, 1), (575, 1), (580, 1), (585, 1), (590, 1), (595, 1), (600, 0), (605, 1), (610, 1), (615, 1), (620, 0), (625, 0), (630, 0), (635, 0), (640, 0), (645, 0), (650, 1), (655, 1), (660, 1), (665, 0), (670, 0), (675, 0), (680, 0), (685, 1), (690, 1), (695, 0), (700, 0), (705, 0), (710, 0), (715, 1), (720, 0), (725, 1), (730, 0), (735, 1), (740, 1), (745, 1), (750, 1), (755, 0), (760, 1), (765, 0), (770, 0), (775, 0), (780, 0), (785, 0), (790, 1), (795, 1), (800, 1), (805, 0), (810, 0), (815, 0), (820, 0), (825, 0), (830, 1), (835, 0), (840, 0), (845, 0), (850, 0), (855, 0), (860, 0), (865, 0), (870, 0), (875, 0), (880, 1), (885, 1), (890, 1), (895, 1), (900, 1), (905, 0), (910, 0), (915, 1), (920, 1), (925, 0), (930, 1), (935, 1), (940, 0), (945, 0), (950, 0), (955, 0), (960, 0), (965, 1), (970, 0), (975, 0), (980, 0), (985, 0), (990, 0), (995, 0), (1000, 1), (1005, 1), (1010, 0), (1015, 1), (1020, 1), (1025, 1)]
Va1_6  a1_6  0 PWL (0n 0.0v 4.745n 0.0v 4.755n 0.0v 9.745n 0.0v 9.755n 0.0v 14.745n 0.0v 14.755n 1.0v 19.745n 1.0v 19.755n 1.0v 24.745n 1.0v 24.755n 0.0v 29.745n 0.0v 29.755n 0.0v 34.745n 0.0v 34.755n 0.0v 39.745n 0.0v 39.755n 1.0v 44.745n 1.0v 44.755n 1.0v 49.745n 1.0v 49.755n 0.0v 54.745n 0.0v 54.755n 1.0v 59.745n 1.0v 59.755n 1.0v 64.745n 1.0v 64.755n 0.0v 69.745n 0.0v 69.755n 0.0v 74.745n 0.0v 74.755n 0.0v 79.745n 0.0v 79.755n 1.0v 84.745n 1.0v 84.755n 1.0v 89.745n 1.0v 89.755n 1.0v 94.745n 1.0v 94.755n 1.0v 99.745n 1.0v 99.755n 1.0v 104.745n 1.0v 104.755n 0.0v 109.745n 0.0v 109.755n 1.0v 114.745n 1.0v 114.755n 1.0v 119.745n 1.0v 119.755n 1.0v 124.745n 1.0v 124.755n 1.0v 129.745n 1.0v 129.755n 1.0v 134.745n 1.0v 134.755n 1.0v 139.745n 1.0v 139.755n 0.0v 144.745n 0.0v 144.755n 0.0v 149.745n 0.0v 149.755n 0.0v 154.745n 0.0v 154.755n 0.0v 159.745n 0.0v 159.755n 0.0v 164.745n 0.0v 164.755n 0.0v 169.745n 0.0v 169.755n 0.0v 174.745n 0.0v 174.755n 0.0v 179.745n 0.0v 179.755n 1.0v 184.745n 1.0v 184.755n 1.0v 189.745n 1.0v 189.755n 1.0v 194.745n 1.0v 194.755n 1.0v 199.745n 1.0v 199.755n 1.0v 204.745n 1.0v 204.755n 1.0v 209.745n 1.0v 209.755n 0.0v 214.745n 0.0v 214.755n 1.0v 219.745n 1.0v 219.755n 0.0v 224.745n 0.0v 224.755n 0.0v 229.745n 0.0v 229.755n 1.0v 234.745n 1.0v 234.755n 0.0v 239.745n 0.0v 239.755n 1.0v 244.745n 1.0v 244.755n 1.0v 249.745n 1.0v 249.755n 1.0v 254.745n 1.0v 254.755n 1.0v 259.745n 1.0v 259.755n 1.0v 264.745n 1.0v 264.755n 1.0v 269.745n 1.0v 269.755n 1.0v 274.745n 1.0v 274.755n 0.0v 279.745n 0.0v 279.755n 0.0v 284.745n 0.0v 284.755n 0.0v 289.745n 0.0v 289.755n 0.0v 294.745n 0.0v 294.755n 1.0v 299.745n 1.0v 299.755n 1.0v 304.745n 1.0v 304.755n 1.0v 309.745n 1.0v 309.755n 1.0v 314.745n 1.0v 314.755n 1.0v 319.745n 1.0v 319.755n 1.0v 324.745n 1.0v 324.755n 0.0v 329.745n 0.0v 329.755n 0.0v 334.745n 0.0v 334.755n 0.0v 339.745n 0.0v 339.755n 0.0v 344.745n 0.0v 344.755n 1.0v 349.745n 1.0v 349.755n 0.0v 354.745n 0.0v 354.755n 1.0v 359.745n 1.0v 359.755n 1.0v 364.745n 1.0v 364.755n 0.0v 369.745n 0.0v 369.755n 0.0v 374.745n 0.0v 374.755n 0.0v 379.745n 0.0v 379.755n 1.0v 384.745n 1.0v 384.755n 0.0v 389.745n 0.0v 389.755n 1.0v 394.745n 1.0v 394.755n 1.0v 399.745n 1.0v 399.755n 1.0v 404.745n 1.0v 404.755n 0.0v 409.745n 0.0v 409.755n 1.0v 414.745n 1.0v 414.755n 1.0v 419.745n 1.0v 419.755n 1.0v 424.745n 1.0v 424.755n 1.0v 429.745n 1.0v 429.755n 0.0v 434.745n 0.0v 434.755n 0.0v 439.745n 0.0v 439.755n 0.0v 444.745n 0.0v 444.755n 0.0v 449.745n 0.0v 449.755n 0.0v 454.745n 0.0v 454.755n 0.0v 459.745n 0.0v 459.755n 0.0v 464.745n 0.0v 464.755n 0.0v 469.745n 0.0v 469.755n 0.0v 474.745n 0.0v 474.755n 0.0v 479.745n 0.0v 479.755n 0.0v 484.745n 0.0v 484.755n 0.0v 489.745n 0.0v 489.755n 1.0v 494.745n 1.0v 494.755n 0.0v 499.745n 0.0v 499.755n 0.0v 504.745n 0.0v 504.755n 1.0v 509.745n 1.0v 509.755n 1.0v 514.745n 1.0v 514.755n 1.0v 519.745n 1.0v 519.755n 1.0v 524.745n 1.0v 524.755n 1.0v 529.745n 1.0v 529.755n 1.0v 534.745n 1.0v 534.755n 0.0v 539.745n 0.0v 539.755n 0.0v 544.745n 0.0v 544.755n 0.0v 549.745n 0.0v 549.755n 0.0v 554.745n 0.0v 554.755n 0.0v 559.745n 0.0v 559.755n 1.0v 564.745n 1.0v 564.755n 1.0v 569.745n 1.0v 569.755n 1.0v 574.745n 1.0v 574.755n 1.0v 579.745n 1.0v 579.755n 1.0v 584.745n 1.0v 584.755n 1.0v 589.745n 1.0v 589.755n 1.0v 594.745n 1.0v 594.755n 1.0v 599.745n 1.0v 599.755n 0.0v 604.745n 0.0v 604.755n 1.0v 609.745n 1.0v 609.755n 1.0v 614.745n 1.0v 614.755n 1.0v 619.745n 1.0v 619.755n 0.0v 624.745n 0.0v 624.755n 0.0v 629.745n 0.0v 629.755n 0.0v 634.745n 0.0v 634.755n 0.0v 639.745n 0.0v 639.755n 0.0v 644.745n 0.0v 644.755n 0.0v 649.745n 0.0v 649.755n 1.0v 654.745n 1.0v 654.755n 1.0v 659.745n 1.0v 659.755n 1.0v 664.745n 1.0v 664.755n 0.0v 669.745n 0.0v 669.755n 0.0v 674.745n 0.0v 674.755n 0.0v 679.745n 0.0v 679.755n 0.0v 684.745n 0.0v 684.755n 1.0v 689.745n 1.0v 689.755n 1.0v 694.745n 1.0v 694.755n 0.0v 699.745n 0.0v 699.755n 0.0v 704.745n 0.0v 704.755n 0.0v 709.745n 0.0v 709.755n 0.0v 714.745n 0.0v 714.755n 1.0v 719.745n 1.0v 719.755n 0.0v 724.745n 0.0v 724.755n 1.0v 729.745n 1.0v 729.755n 0.0v 734.745n 0.0v 734.755n 1.0v 739.745n 1.0v 739.755n 1.0v 744.745n 1.0v 744.755n 1.0v 749.745n 1.0v 749.755n 1.0v 754.745n 1.0v 754.755n 0.0v 759.745n 0.0v 759.755n 1.0v 764.745n 1.0v 764.755n 0.0v 769.745n 0.0v 769.755n 0.0v 774.745n 0.0v 774.755n 0.0v 779.745n 0.0v 779.755n 0.0v 784.745n 0.0v 784.755n 0.0v 789.745n 0.0v 789.755n 1.0v 794.745n 1.0v 794.755n 1.0v 799.745n 1.0v 799.755n 1.0v 804.745n 1.0v 804.755n 0.0v 809.745n 0.0v 809.755n 0.0v 814.745n 0.0v 814.755n 0.0v 819.745n 0.0v 819.755n 0.0v 824.745n 0.0v 824.755n 0.0v 829.745n 0.0v 829.755n 1.0v 834.745n 1.0v 834.755n 0.0v 839.745n 0.0v 839.755n 0.0v 844.745n 0.0v 844.755n 0.0v 849.745n 0.0v 849.755n 0.0v 854.745n 0.0v 854.755n 0.0v 859.745n 0.0v 859.755n 0.0v 864.745n 0.0v 864.755n 0.0v 869.745n 0.0v 869.755n 0.0v 874.745n 0.0v 874.755n 0.0v 879.745n 0.0v 879.755n 1.0v 884.745n 1.0v 884.755n 1.0v 889.745n 1.0v 889.755n 1.0v 894.745n 1.0v 894.755n 1.0v 899.745n 1.0v 899.755n 1.0v 904.745n 1.0v 904.755n 0.0v 909.745n 0.0v 909.755n 0.0v 914.745n 0.0v 914.755n 1.0v 919.745n 1.0v 919.755n 1.0v 924.745n 1.0v 924.755n 0.0v 929.745n 0.0v 929.755n 1.0v 934.745n 1.0v 934.755n 1.0v 939.745n 1.0v 939.755n 0.0v 944.745n 0.0v 944.755n 0.0v 949.745n 0.0v 949.755n 0.0v 954.745n 0.0v 954.755n 0.0v 959.745n 0.0v 959.755n 0.0v 964.745n 0.0v 964.755n 1.0v 969.745n 1.0v 969.755n 0.0v 974.745n 0.0v 974.755n 0.0v 979.745n 0.0v 979.755n 0.0v 984.745n 0.0v 984.755n 0.0v 989.745n 0.0v 989.755n 0.0v 994.745n 0.0v 994.755n 0.0v 999.745n 0.0v 999.755n 1.0v 1004.745n 1.0v 1004.755n 1.0v 1009.745n 1.0v 1009.755n 0.0v 1014.745n 0.0v 1014.755n 1.0v 1019.745n 1.0v 1019.755n 1.0v 1024.745n 1.0v 1024.755n 1.0v )
* (time, data): [(0, 0), (5, 0), (10, 0), (15, 1), (20, 1), (25, 0), (30, 0), (35, 0), (40, 1), (45, 1), (50, 0), (55, 1), (60, 1), (65, 0), (70, 0), (75, 0), (80, 1), (85, 1), (90, 1), (95, 1), (100, 1), (105, 0), (110, 1), (115, 1), (120, 1), (125, 1), (130, 1), (135, 1), (140, 0), (145, 0), (150, 0), (155, 0), (160, 0), (165, 0), (170, 0), (175, 0), (180, 1), (185, 1), (190, 1), (195, 1), (200, 1), (205, 1), (210, 0), (215, 1), (220, 0), (225, 0), (230, 1), (235, 0), (240, 1), (245, 1), (250, 1), (255, 1), (260, 1), (265, 1), (270, 1), (275, 0), (280, 0), (285, 0), (290, 0), (295, 1), (300, 1), (305, 1), (310, 1), (315, 1), (320, 1), (325, 0), (330, 0), (335, 0), (340, 0), (345, 1), (350, 0), (355, 1), (360, 1), (365, 0), (370, 0), (375, 0), (380, 1), (385, 0), (390, 1), (395, 1), (400, 1), (405, 0), (410, 1), (415, 1), (420, 1), (425, 1), (430, 0), (435, 0), (440, 0), (445, 0), (450, 0), (455, 0), (460, 0), (465, 0), (470, 0), (475, 0), (480, 0), (485, 0), (490, 1), (495, 0), (500, 0), (505, 1), (510, 1), (515, 1), (520, 1), (525, 1), (530, 1), (535, 0), (540, 0), (545, 0), (550, 0), (555, 0), (560, 1), (565, 1), (570, 1), (575, 1), (580, 1), (585, 1), (590, 1), (595, 1), (600, 0), (605, 1), (610, 1), (615, 1), (620, 0), (625, 0), (630, 0), (635, 0), (640, 0), (645, 0), (650, 1), (655, 1), (660, 1), (665, 0), (670, 0), (675, 0), (680, 0), (685, 1), (690, 1), (695, 0), (700, 0), (705, 0), (710, 0), (715, 1), (720, 0), (725, 1), (730, 0), (735, 1), (740, 1), (745, 1), (750, 1), (755, 0), (760, 1), (765, 0), (770, 0), (775, 0), (780, 0), (785, 0), (790, 1), (795, 1), (800, 1), (805, 0), (810, 0), (815, 0), (820, 0), (825, 0), (830, 1), (835, 0), (840, 0), (845, 0), (850, 0), (855, 0), (860, 0), (865, 0), (870, 0), (875, 0), (880, 1), (885, 1), (890, 1), (895, 1), (900, 1), (905, 0), (910, 0), (915, 1), (920, 1), (925, 0), (930, 1), (935, 1), (940, 0), (945, 0), (950, 0), (955, 0), (960, 0), (965, 1), (970, 0), (975, 0), (980, 0), (985, 0), (990, 0), (995, 0), (1000, 1), (1005, 1), (1010, 0), (1015, 1), (1020, 1), (1025, 1)]
Va1_7  a1_7  0 PWL (0n 0.0v 4.745n 0.0v 4.755n 0.0v 9.745n 0.0v 9.755n 0.0v 14.745n 0.0v 14.755n 1.0v 19.745n 1.0v 19.755n 1.0v 24.745n 1.0v 24.755n 0.0v 29.745n 0.0v 29.755n 0.0v 34.745n 0.0v 34.755n 0.0v 39.745n 0.0v 39.755n 1.0v 44.745n 1.0v 44.755n 1.0v 49.745n 1.0v 49.755n 0.0v 54.745n 0.0v 54.755n 1.0v 59.745n 1.0v 59.755n 1.0v 64.745n 1.0v 64.755n 0.0v 69.745n 0.0v 69.755n 0.0v 74.745n 0.0v 74.755n 0.0v 79.745n 0.0v 79.755n 1.0v 84.745n 1.0v 84.755n 1.0v 89.745n 1.0v 89.755n 1.0v 94.745n 1.0v 94.755n 1.0v 99.745n 1.0v 99.755n 1.0v 104.745n 1.0v 104.755n 0.0v 109.745n 0.0v 109.755n 1.0v 114.745n 1.0v 114.755n 1.0v 119.745n 1.0v 119.755n 1.0v 124.745n 1.0v 124.755n 1.0v 129.745n 1.0v 129.755n 1.0v 134.745n 1.0v 134.755n 1.0v 139.745n 1.0v 139.755n 0.0v 144.745n 0.0v 144.755n 0.0v 149.745n 0.0v 149.755n 0.0v 154.745n 0.0v 154.755n 0.0v 159.745n 0.0v 159.755n 0.0v 164.745n 0.0v 164.755n 0.0v 169.745n 0.0v 169.755n 0.0v 174.745n 0.0v 174.755n 0.0v 179.745n 0.0v 179.755n 1.0v 184.745n 1.0v 184.755n 1.0v 189.745n 1.0v 189.755n 1.0v 194.745n 1.0v 194.755n 1.0v 199.745n 1.0v 199.755n 1.0v 204.745n 1.0v 204.755n 1.0v 209.745n 1.0v 209.755n 0.0v 214.745n 0.0v 214.755n 1.0v 219.745n 1.0v 219.755n 0.0v 224.745n 0.0v 224.755n 0.0v 229.745n 0.0v 229.755n 1.0v 234.745n 1.0v 234.755n 0.0v 239.745n 0.0v 239.755n 1.0v 244.745n 1.0v 244.755n 1.0v 249.745n 1.0v 249.755n 1.0v 254.745n 1.0v 254.755n 1.0v 259.745n 1.0v 259.755n 1.0v 264.745n 1.0v 264.755n 1.0v 269.745n 1.0v 269.755n 1.0v 274.745n 1.0v 274.755n 0.0v 279.745n 0.0v 279.755n 0.0v 284.745n 0.0v 284.755n 0.0v 289.745n 0.0v 289.755n 0.0v 294.745n 0.0v 294.755n 1.0v 299.745n 1.0v 299.755n 1.0v 304.745n 1.0v 304.755n 1.0v 309.745n 1.0v 309.755n 1.0v 314.745n 1.0v 314.755n 1.0v 319.745n 1.0v 319.755n 1.0v 324.745n 1.0v 324.755n 0.0v 329.745n 0.0v 329.755n 0.0v 334.745n 0.0v 334.755n 0.0v 339.745n 0.0v 339.755n 0.0v 344.745n 0.0v 344.755n 1.0v 349.745n 1.0v 349.755n 0.0v 354.745n 0.0v 354.755n 1.0v 359.745n 1.0v 359.755n 1.0v 364.745n 1.0v 364.755n 0.0v 369.745n 0.0v 369.755n 0.0v 374.745n 0.0v 374.755n 0.0v 379.745n 0.0v 379.755n 1.0v 384.745n 1.0v 384.755n 0.0v 389.745n 0.0v 389.755n 1.0v 394.745n 1.0v 394.755n 1.0v 399.745n 1.0v 399.755n 1.0v 404.745n 1.0v 404.755n 0.0v 409.745n 0.0v 409.755n 1.0v 414.745n 1.0v 414.755n 1.0v 419.745n 1.0v 419.755n 1.0v 424.745n 1.0v 424.755n 1.0v 429.745n 1.0v 429.755n 0.0v 434.745n 0.0v 434.755n 0.0v 439.745n 0.0v 439.755n 0.0v 444.745n 0.0v 444.755n 0.0v 449.745n 0.0v 449.755n 0.0v 454.745n 0.0v 454.755n 0.0v 459.745n 0.0v 459.755n 0.0v 464.745n 0.0v 464.755n 0.0v 469.745n 0.0v 469.755n 0.0v 474.745n 0.0v 474.755n 0.0v 479.745n 0.0v 479.755n 0.0v 484.745n 0.0v 484.755n 0.0v 489.745n 0.0v 489.755n 1.0v 494.745n 1.0v 494.755n 0.0v 499.745n 0.0v 499.755n 0.0v 504.745n 0.0v 504.755n 1.0v 509.745n 1.0v 509.755n 1.0v 514.745n 1.0v 514.755n 1.0v 519.745n 1.0v 519.755n 1.0v 524.745n 1.0v 524.755n 1.0v 529.745n 1.0v 529.755n 1.0v 534.745n 1.0v 534.755n 0.0v 539.745n 0.0v 539.755n 0.0v 544.745n 0.0v 544.755n 0.0v 549.745n 0.0v 549.755n 0.0v 554.745n 0.0v 554.755n 0.0v 559.745n 0.0v 559.755n 1.0v 564.745n 1.0v 564.755n 1.0v 569.745n 1.0v 569.755n 1.0v 574.745n 1.0v 574.755n 1.0v 579.745n 1.0v 579.755n 1.0v 584.745n 1.0v 584.755n 1.0v 589.745n 1.0v 589.755n 1.0v 594.745n 1.0v 594.755n 1.0v 599.745n 1.0v 599.755n 0.0v 604.745n 0.0v 604.755n 1.0v 609.745n 1.0v 609.755n 1.0v 614.745n 1.0v 614.755n 1.0v 619.745n 1.0v 619.755n 0.0v 624.745n 0.0v 624.755n 0.0v 629.745n 0.0v 629.755n 0.0v 634.745n 0.0v 634.755n 0.0v 639.745n 0.0v 639.755n 0.0v 644.745n 0.0v 644.755n 0.0v 649.745n 0.0v 649.755n 1.0v 654.745n 1.0v 654.755n 1.0v 659.745n 1.0v 659.755n 1.0v 664.745n 1.0v 664.755n 0.0v 669.745n 0.0v 669.755n 0.0v 674.745n 0.0v 674.755n 0.0v 679.745n 0.0v 679.755n 0.0v 684.745n 0.0v 684.755n 1.0v 689.745n 1.0v 689.755n 1.0v 694.745n 1.0v 694.755n 0.0v 699.745n 0.0v 699.755n 0.0v 704.745n 0.0v 704.755n 0.0v 709.745n 0.0v 709.755n 0.0v 714.745n 0.0v 714.755n 1.0v 719.745n 1.0v 719.755n 0.0v 724.745n 0.0v 724.755n 1.0v 729.745n 1.0v 729.755n 0.0v 734.745n 0.0v 734.755n 1.0v 739.745n 1.0v 739.755n 1.0v 744.745n 1.0v 744.755n 1.0v 749.745n 1.0v 749.755n 1.0v 754.745n 1.0v 754.755n 0.0v 759.745n 0.0v 759.755n 1.0v 764.745n 1.0v 764.755n 0.0v 769.745n 0.0v 769.755n 0.0v 774.745n 0.0v 774.755n 0.0v 779.745n 0.0v 779.755n 0.0v 784.745n 0.0v 784.755n 0.0v 789.745n 0.0v 789.755n 1.0v 794.745n 1.0v 794.755n 1.0v 799.745n 1.0v 799.755n 1.0v 804.745n 1.0v 804.755n 0.0v 809.745n 0.0v 809.755n 0.0v 814.745n 0.0v 814.755n 0.0v 819.745n 0.0v 819.755n 0.0v 824.745n 0.0v 824.755n 0.0v 829.745n 0.0v 829.755n 1.0v 834.745n 1.0v 834.755n 0.0v 839.745n 0.0v 839.755n 0.0v 844.745n 0.0v 844.755n 0.0v 849.745n 0.0v 849.755n 0.0v 854.745n 0.0v 854.755n 0.0v 859.745n 0.0v 859.755n 0.0v 864.745n 0.0v 864.755n 0.0v 869.745n 0.0v 869.755n 0.0v 874.745n 0.0v 874.755n 0.0v 879.745n 0.0v 879.755n 1.0v 884.745n 1.0v 884.755n 1.0v 889.745n 1.0v 889.755n 1.0v 894.745n 1.0v 894.755n 1.0v 899.745n 1.0v 899.755n 1.0v 904.745n 1.0v 904.755n 0.0v 909.745n 0.0v 909.755n 0.0v 914.745n 0.0v 914.755n 1.0v 919.745n 1.0v 919.755n 1.0v 924.745n 1.0v 924.755n 0.0v 929.745n 0.0v 929.755n 1.0v 934.745n 1.0v 934.755n 1.0v 939.745n 1.0v 939.755n 0.0v 944.745n 0.0v 944.755n 0.0v 949.745n 0.0v 949.755n 0.0v 954.745n 0.0v 954.755n 0.0v 959.745n 0.0v 959.755n 0.0v 964.745n 0.0v 964.755n 1.0v 969.745n 1.0v 969.755n 0.0v 974.745n 0.0v 974.755n 0.0v 979.745n 0.0v 979.755n 0.0v 984.745n 0.0v 984.755n 0.0v 989.745n 0.0v 989.755n 0.0v 994.745n 0.0v 994.755n 0.0v 999.745n 0.0v 999.755n 1.0v 1004.745n 1.0v 1004.755n 1.0v 1009.745n 1.0v 1009.755n 0.0v 1014.745n 0.0v 1014.755n 1.0v 1019.745n 1.0v 1019.755n 1.0v 1024.745n 1.0v 1024.755n 1.0v )
* (time, data): [(0, 0), (5, 0), (10, 0), (15, 1), (20, 1), (25, 0), (30, 0), (35, 0), (40, 1), (45, 1), (50, 0), (55, 1), (60, 1), (65, 0), (70, 0), (75, 0), (80, 1), (85, 1), (90, 1), (95, 1), (100, 1), (105, 0), (110, 1), (115, 1), (120, 1), (125, 1), (130, 1), (135, 1), (140, 0), (145, 0), (150, 0), (155, 0), (160, 0), (165, 0), (170, 0), (175, 0), (180, 1), (185, 1), (190, 1), (195, 1), (200, 1), (205, 1), (210, 0), (215, 1), (220, 0), (225, 0), (230, 1), (235, 0), (240, 1), (245, 1), (250, 1), (255, 1), (260, 1), (265, 1), (270, 1), (275, 0), (280, 0), (285, 0), (290, 0), (295, 1), (300, 1), (305, 1), (310, 1), (315, 1), (320, 1), (325, 0), (330, 0), (335, 0), (340, 0), (345, 1), (350, 0), (355, 1), (360, 1), (365, 0), (370, 0), (375, 0), (380, 1), (385, 0), (390, 1), (395, 1), (400, 1), (405, 0), (410, 1), (415, 1), (420, 1), (425, 1), (430, 0), (435, 0), (440, 0), (445, 0), (450, 0), (455, 0), (460, 0), (465, 0), (470, 0), (475, 0), (480, 0), (485, 0), (490, 1), (495, 0), (500, 0), (505, 1), (510, 1), (515, 1), (520, 1), (525, 1), (530, 1), (535, 0), (540, 0), (545, 0), (550, 0), (555, 0), (560, 1), (565, 1), (570, 1), (575, 1), (580, 1), (585, 1), (590, 1), (595, 1), (600, 0), (605, 1), (610, 1), (615, 1), (620, 0), (625, 0), (630, 0), (635, 0), (640, 0), (645, 0), (650, 1), (655, 1), (660, 1), (665, 0), (670, 0), (675, 0), (680, 0), (685, 1), (690, 1), (695, 0), (700, 0), (705, 0), (710, 0), (715, 1), (720, 0), (725, 1), (730, 0), (735, 1), (740, 1), (745, 1), (750, 1), (755, 0), (760, 1), (765, 0), (770, 0), (775, 0), (780, 0), (785, 0), (790, 1), (795, 1), (800, 1), (805, 0), (810, 0), (815, 0), (820, 0), (825, 0), (830, 1), (835, 0), (840, 0), (845, 0), (850, 0), (855, 0), (860, 0), (865, 0), (870, 0), (875, 0), (880, 1), (885, 1), (890, 1), (895, 1), (900, 1), (905, 0), (910, 0), (915, 1), (920, 1), (925, 0), (930, 1), (935, 1), (940, 0), (945, 0), (950, 0), (955, 0), (960, 0), (965, 1), (970, 0), (975, 0), (980, 0), (985, 0), (990, 0), (995, 0), (1000, 1), (1005, 1), (1010, 0), (1015, 1), (1020, 1), (1025, 1)]
Va1_8  a1_8  0 PWL (0n 0.0v 4.745n 0.0v 4.755n 0.0v 9.745n 0.0v 9.755n 0.0v 14.745n 0.0v 14.755n 1.0v 19.745n 1.0v 19.755n 1.0v 24.745n 1.0v 24.755n 0.0v 29.745n 0.0v 29.755n 0.0v 34.745n 0.0v 34.755n 0.0v 39.745n 0.0v 39.755n 1.0v 44.745n 1.0v 44.755n 1.0v 49.745n 1.0v 49.755n 0.0v 54.745n 0.0v 54.755n 1.0v 59.745n 1.0v 59.755n 1.0v 64.745n 1.0v 64.755n 0.0v 69.745n 0.0v 69.755n 0.0v 74.745n 0.0v 74.755n 0.0v 79.745n 0.0v 79.755n 1.0v 84.745n 1.0v 84.755n 1.0v 89.745n 1.0v 89.755n 1.0v 94.745n 1.0v 94.755n 1.0v 99.745n 1.0v 99.755n 1.0v 104.745n 1.0v 104.755n 0.0v 109.745n 0.0v 109.755n 1.0v 114.745n 1.0v 114.755n 1.0v 119.745n 1.0v 119.755n 1.0v 124.745n 1.0v 124.755n 1.0v 129.745n 1.0v 129.755n 1.0v 134.745n 1.0v 134.755n 1.0v 139.745n 1.0v 139.755n 0.0v 144.745n 0.0v 144.755n 0.0v 149.745n 0.0v 149.755n 0.0v 154.745n 0.0v 154.755n 0.0v 159.745n 0.0v 159.755n 0.0v 164.745n 0.0v 164.755n 0.0v 169.745n 0.0v 169.755n 0.0v 174.745n 0.0v 174.755n 0.0v 179.745n 0.0v 179.755n 1.0v 184.745n 1.0v 184.755n 1.0v 189.745n 1.0v 189.755n 1.0v 194.745n 1.0v 194.755n 1.0v 199.745n 1.0v 199.755n 1.0v 204.745n 1.0v 204.755n 1.0v 209.745n 1.0v 209.755n 0.0v 214.745n 0.0v 214.755n 1.0v 219.745n 1.0v 219.755n 0.0v 224.745n 0.0v 224.755n 0.0v 229.745n 0.0v 229.755n 1.0v 234.745n 1.0v 234.755n 0.0v 239.745n 0.0v 239.755n 1.0v 244.745n 1.0v 244.755n 1.0v 249.745n 1.0v 249.755n 1.0v 254.745n 1.0v 254.755n 1.0v 259.745n 1.0v 259.755n 1.0v 264.745n 1.0v 264.755n 1.0v 269.745n 1.0v 269.755n 1.0v 274.745n 1.0v 274.755n 0.0v 279.745n 0.0v 279.755n 0.0v 284.745n 0.0v 284.755n 0.0v 289.745n 0.0v 289.755n 0.0v 294.745n 0.0v 294.755n 1.0v 299.745n 1.0v 299.755n 1.0v 304.745n 1.0v 304.755n 1.0v 309.745n 1.0v 309.755n 1.0v 314.745n 1.0v 314.755n 1.0v 319.745n 1.0v 319.755n 1.0v 324.745n 1.0v 324.755n 0.0v 329.745n 0.0v 329.755n 0.0v 334.745n 0.0v 334.755n 0.0v 339.745n 0.0v 339.755n 0.0v 344.745n 0.0v 344.755n 1.0v 349.745n 1.0v 349.755n 0.0v 354.745n 0.0v 354.755n 1.0v 359.745n 1.0v 359.755n 1.0v 364.745n 1.0v 364.755n 0.0v 369.745n 0.0v 369.755n 0.0v 374.745n 0.0v 374.755n 0.0v 379.745n 0.0v 379.755n 1.0v 384.745n 1.0v 384.755n 0.0v 389.745n 0.0v 389.755n 1.0v 394.745n 1.0v 394.755n 1.0v 399.745n 1.0v 399.755n 1.0v 404.745n 1.0v 404.755n 0.0v 409.745n 0.0v 409.755n 1.0v 414.745n 1.0v 414.755n 1.0v 419.745n 1.0v 419.755n 1.0v 424.745n 1.0v 424.755n 1.0v 429.745n 1.0v 429.755n 0.0v 434.745n 0.0v 434.755n 0.0v 439.745n 0.0v 439.755n 0.0v 444.745n 0.0v 444.755n 0.0v 449.745n 0.0v 449.755n 0.0v 454.745n 0.0v 454.755n 0.0v 459.745n 0.0v 459.755n 0.0v 464.745n 0.0v 464.755n 0.0v 469.745n 0.0v 469.755n 0.0v 474.745n 0.0v 474.755n 0.0v 479.745n 0.0v 479.755n 0.0v 484.745n 0.0v 484.755n 0.0v 489.745n 0.0v 489.755n 1.0v 494.745n 1.0v 494.755n 0.0v 499.745n 0.0v 499.755n 0.0v 504.745n 0.0v 504.755n 1.0v 509.745n 1.0v 509.755n 1.0v 514.745n 1.0v 514.755n 1.0v 519.745n 1.0v 519.755n 1.0v 524.745n 1.0v 524.755n 1.0v 529.745n 1.0v 529.755n 1.0v 534.745n 1.0v 534.755n 0.0v 539.745n 0.0v 539.755n 0.0v 544.745n 0.0v 544.755n 0.0v 549.745n 0.0v 549.755n 0.0v 554.745n 0.0v 554.755n 0.0v 559.745n 0.0v 559.755n 1.0v 564.745n 1.0v 564.755n 1.0v 569.745n 1.0v 569.755n 1.0v 574.745n 1.0v 574.755n 1.0v 579.745n 1.0v 579.755n 1.0v 584.745n 1.0v 584.755n 1.0v 589.745n 1.0v 589.755n 1.0v 594.745n 1.0v 594.755n 1.0v 599.745n 1.0v 599.755n 0.0v 604.745n 0.0v 604.755n 1.0v 609.745n 1.0v 609.755n 1.0v 614.745n 1.0v 614.755n 1.0v 619.745n 1.0v 619.755n 0.0v 624.745n 0.0v 624.755n 0.0v 629.745n 0.0v 629.755n 0.0v 634.745n 0.0v 634.755n 0.0v 639.745n 0.0v 639.755n 0.0v 644.745n 0.0v 644.755n 0.0v 649.745n 0.0v 649.755n 1.0v 654.745n 1.0v 654.755n 1.0v 659.745n 1.0v 659.755n 1.0v 664.745n 1.0v 664.755n 0.0v 669.745n 0.0v 669.755n 0.0v 674.745n 0.0v 674.755n 0.0v 679.745n 0.0v 679.755n 0.0v 684.745n 0.0v 684.755n 1.0v 689.745n 1.0v 689.755n 1.0v 694.745n 1.0v 694.755n 0.0v 699.745n 0.0v 699.755n 0.0v 704.745n 0.0v 704.755n 0.0v 709.745n 0.0v 709.755n 0.0v 714.745n 0.0v 714.755n 1.0v 719.745n 1.0v 719.755n 0.0v 724.745n 0.0v 724.755n 1.0v 729.745n 1.0v 729.755n 0.0v 734.745n 0.0v 734.755n 1.0v 739.745n 1.0v 739.755n 1.0v 744.745n 1.0v 744.755n 1.0v 749.745n 1.0v 749.755n 1.0v 754.745n 1.0v 754.755n 0.0v 759.745n 0.0v 759.755n 1.0v 764.745n 1.0v 764.755n 0.0v 769.745n 0.0v 769.755n 0.0v 774.745n 0.0v 774.755n 0.0v 779.745n 0.0v 779.755n 0.0v 784.745n 0.0v 784.755n 0.0v 789.745n 0.0v 789.755n 1.0v 794.745n 1.0v 794.755n 1.0v 799.745n 1.0v 799.755n 1.0v 804.745n 1.0v 804.755n 0.0v 809.745n 0.0v 809.755n 0.0v 814.745n 0.0v 814.755n 0.0v 819.745n 0.0v 819.755n 0.0v 824.745n 0.0v 824.755n 0.0v 829.745n 0.0v 829.755n 1.0v 834.745n 1.0v 834.755n 0.0v 839.745n 0.0v 839.755n 0.0v 844.745n 0.0v 844.755n 0.0v 849.745n 0.0v 849.755n 0.0v 854.745n 0.0v 854.755n 0.0v 859.745n 0.0v 859.755n 0.0v 864.745n 0.0v 864.755n 0.0v 869.745n 0.0v 869.755n 0.0v 874.745n 0.0v 874.755n 0.0v 879.745n 0.0v 879.755n 1.0v 884.745n 1.0v 884.755n 1.0v 889.745n 1.0v 889.755n 1.0v 894.745n 1.0v 894.755n 1.0v 899.745n 1.0v 899.755n 1.0v 904.745n 1.0v 904.755n 0.0v 909.745n 0.0v 909.755n 0.0v 914.745n 0.0v 914.755n 1.0v 919.745n 1.0v 919.755n 1.0v 924.745n 1.0v 924.755n 0.0v 929.745n 0.0v 929.755n 1.0v 934.745n 1.0v 934.755n 1.0v 939.745n 1.0v 939.755n 0.0v 944.745n 0.0v 944.755n 0.0v 949.745n 0.0v 949.755n 0.0v 954.745n 0.0v 954.755n 0.0v 959.745n 0.0v 959.755n 0.0v 964.745n 0.0v 964.755n 1.0v 969.745n 1.0v 969.755n 0.0v 974.745n 0.0v 974.755n 0.0v 979.745n 0.0v 979.755n 0.0v 984.745n 0.0v 984.755n 0.0v 989.745n 0.0v 989.755n 0.0v 994.745n 0.0v 994.755n 0.0v 999.745n 0.0v 999.755n 1.0v 1004.745n 1.0v 1004.755n 1.0v 1009.745n 1.0v 1009.755n 0.0v 1014.745n 0.0v 1014.755n 1.0v 1019.745n 1.0v 1019.755n 1.0v 1024.745n 1.0v 1024.755n 1.0v )

 * Generation of control signals
* (time, data): [(0, 1), (5, 0), (10, 0), (15, 0), (20, 0), (25, 0), (30, 0), (35, 0), (40, 0), (45, 1), (50, 0), (55, 0), (60, 0), (65, 0), (70, 0), (75, 0), (80, 0), (85, 0), (90, 0), (95, 0), (100, 0), (105, 0), (110, 1), (115, 0), (120, 0), (125, 1), (130, 0), (135, 0), (140, 0), (145, 0), (150, 1), (155, 0), (160, 1), (165, 1), (170, 0), (175, 0), (180, 1), (185, 0), (190, 0), (195, 0), (200, 0), (205, 0), (210, 0), (215, 0), (220, 0), (225, 1), (230, 0), (235, 0), (240, 0), (245, 0), (250, 0), (255, 1), (260, 1), (265, 0), (270, 1), (275, 0), (280, 0), (285, 0), (290, 0), (295, 0), (300, 0), (305, 1), (310, 0), (315, 1), (320, 1), (325, 1), (330, 1), (335, 0), (340, 0), (345, 0), (350, 0), (355, 1), (360, 1), (365, 0), (370, 0), (375, 1), (380, 0), (385, 1), (390, 0), (395, 0), (400, 1), (405, 0), (410, 0), (415, 0), (420, 0), (425, 1), (430, 0), (435, 0), (440, 1), (445, 0), (450, 0), (455, 0), (460, 0), (465, 0), (470, 0), (475, 0), (480, 0), (485, 0), (490, 0), (495, 0), (500, 0), (505, 0), (510, 1), (515, 0), (520, 0), (525, 0), (530, 1), (535, 0), (540, 0), (545, 0), (550, 0), (555, 0), (560, 0), (565, 0), (570, 0), (575, 0), (580, 1), (585, 1), (590, 1), (595, 0), (600, 0), (605, 0), (610, 0), (615, 0), (620, 0), (625, 0), (630, 0), (635, 0), (640, 1), (645, 0), (650, 0), (655, 0), (660, 1), (665, 0), (670, 0), (675, 0), (680, 0), (685, 0), (690, 0), (695, 0), (700, 0), (705, 0), (710, 0), (715, 0), (720, 0), (725, 0), (730, 0), (735, 0), (740, 0), (745, 0), (750, 0), (755, 1), (760, 0), (765, 0), (770, 0), (775, 0), (780, 0), (785, 0), (790, 0), (795, 0), (800, 1), (805, 0), (810, 0), (815, 0), (820, 0), (825, 0), (830, 0), (835, 0), (840, 0), (845, 1), (850, 0), (855, 0), (860, 0), (865, 0), (870, 0), (875, 0), (880, 0), (885, 0), (890, 0), (895, 0), (900, 0), (905, 0), (910, 0), (915, 0), (920, 1), (925, 0), (930, 0), (935, 1), (940, 0), (945, 0), (950, 1), (955, 0), (960, 1), (965, 0), (970, 0), (975, 0), (980, 0), (985, 0), (990, 1), (995, 1), (1000, 0), (1005, 0), (1010, 1), (1015, 0), (1020, 0), (1025, 1)]
VCSB0 CSB0 0 PWL (0n 1.0v 4.745n 1.0v 4.755n 0.0v 9.745n 0.0v 9.755n 0.0v 14.745n 0.0v 14.755n 0.0v 19.745n 0.0v 19.755n 0.0v 24.745n 0.0v 24.755n 0.0v 29.745n 0.0v 29.755n 0.0v 34.745n 0.0v 34.755n 0.0v 39.745n 0.0v 39.755n 0.0v 44.745n 0.0v 44.755n 1.0v 49.745n 1.0v 49.755n 0.0v 54.745n 0.0v 54.755n 0.0v 59.745n 0.0v 59.755n 0.0v 64.745n 0.0v 64.755n 0.0v 69.745n 0.0v 69.755n 0.0v 74.745n 0.0v 74.755n 0.0v 79.745n 0.0v 79.755n 0.0v 84.745n 0.0v 84.755n 0.0v 89.745n 0.0v 89.755n 0.0v 94.745n 0.0v 94.755n 0.0v 99.745n 0.0v 99.755n 0.0v 104.745n 0.0v 104.755n 0.0v 109.745n 0.0v 109.755n 1.0v 114.745n 1.0v 114.755n 0.0v 119.745n 0.0v 119.755n 0.0v 124.745n 0.0v 124.755n 1.0v 129.745n 1.0v 129.755n 0.0v 134.745n 0.0v 134.755n 0.0v 139.745n 0.0v 139.755n 0.0v 144.745n 0.0v 144.755n 0.0v 149.745n 0.0v 149.755n 1.0v 154.745n 1.0v 154.755n 0.0v 159.745n 0.0v 159.755n 1.0v 164.745n 1.0v 164.755n 1.0v 169.745n 1.0v 169.755n 0.0v 174.745n 0.0v 174.755n 0.0v 179.745n 0.0v 179.755n 1.0v 184.745n 1.0v 184.755n 0.0v 189.745n 0.0v 189.755n 0.0v 194.745n 0.0v 194.755n 0.0v 199.745n 0.0v 199.755n 0.0v 204.745n 0.0v 204.755n 0.0v 209.745n 0.0v 209.755n 0.0v 214.745n 0.0v 214.755n 0.0v 219.745n 0.0v 219.755n 0.0v 224.745n 0.0v 224.755n 1.0v 229.745n 1.0v 229.755n 0.0v 234.745n 0.0v 234.755n 0.0v 239.745n 0.0v 239.755n 0.0v 244.745n 0.0v 244.755n 0.0v 249.745n 0.0v 249.755n 0.0v 254.745n 0.0v 254.755n 1.0v 259.745n 1.0v 259.755n 1.0v 264.745n 1.0v 264.755n 0.0v 269.745n 0.0v 269.755n 1.0v 274.745n 1.0v 274.755n 0.0v 279.745n 0.0v 279.755n 0.0v 284.745n 0.0v 284.755n 0.0v 289.745n 0.0v 289.755n 0.0v 294.745n 0.0v 294.755n 0.0v 299.745n 0.0v 299.755n 0.0v 304.745n 0.0v 304.755n 1.0v 309.745n 1.0v 309.755n 0.0v 314.745n 0.0v 314.755n 1.0v 319.745n 1.0v 319.755n 1.0v 324.745n 1.0v 324.755n 1.0v 329.745n 1.0v 329.755n 1.0v 334.745n 1.0v 334.755n 0.0v 339.745n 0.0v 339.755n 0.0v 344.745n 0.0v 344.755n 0.0v 349.745n 0.0v 349.755n 0.0v 354.745n 0.0v 354.755n 1.0v 359.745n 1.0v 359.755n 1.0v 364.745n 1.0v 364.755n 0.0v 369.745n 0.0v 369.755n 0.0v 374.745n 0.0v 374.755n 1.0v 379.745n 1.0v 379.755n 0.0v 384.745n 0.0v 384.755n 1.0v 389.745n 1.0v 389.755n 0.0v 394.745n 0.0v 394.755n 0.0v 399.745n 0.0v 399.755n 1.0v 404.745n 1.0v 404.755n 0.0v 409.745n 0.0v 409.755n 0.0v 414.745n 0.0v 414.755n 0.0v 419.745n 0.0v 419.755n 0.0v 424.745n 0.0v 424.755n 1.0v 429.745n 1.0v 429.755n 0.0v 434.745n 0.0v 434.755n 0.0v 439.745n 0.0v 439.755n 1.0v 444.745n 1.0v 444.755n 0.0v 449.745n 0.0v 449.755n 0.0v 454.745n 0.0v 454.755n 0.0v 459.745n 0.0v 459.755n 0.0v 464.745n 0.0v 464.755n 0.0v 469.745n 0.0v 469.755n 0.0v 474.745n 0.0v 474.755n 0.0v 479.745n 0.0v 479.755n 0.0v 484.745n 0.0v 484.755n 0.0v 489.745n 0.0v 489.755n 0.0v 494.745n 0.0v 494.755n 0.0v 499.745n 0.0v 499.755n 0.0v 504.745n 0.0v 504.755n 0.0v 509.745n 0.0v 509.755n 1.0v 514.745n 1.0v 514.755n 0.0v 519.745n 0.0v 519.755n 0.0v 524.745n 0.0v 524.755n 0.0v 529.745n 0.0v 529.755n 1.0v 534.745n 1.0v 534.755n 0.0v 539.745n 0.0v 539.755n 0.0v 544.745n 0.0v 544.755n 0.0v 549.745n 0.0v 549.755n 0.0v 554.745n 0.0v 554.755n 0.0v 559.745n 0.0v 559.755n 0.0v 564.745n 0.0v 564.755n 0.0v 569.745n 0.0v 569.755n 0.0v 574.745n 0.0v 574.755n 0.0v 579.745n 0.0v 579.755n 1.0v 584.745n 1.0v 584.755n 1.0v 589.745n 1.0v 589.755n 1.0v 594.745n 1.0v 594.755n 0.0v 599.745n 0.0v 599.755n 0.0v 604.745n 0.0v 604.755n 0.0v 609.745n 0.0v 609.755n 0.0v 614.745n 0.0v 614.755n 0.0v 619.745n 0.0v 619.755n 0.0v 624.745n 0.0v 624.755n 0.0v 629.745n 0.0v 629.755n 0.0v 634.745n 0.0v 634.755n 0.0v 639.745n 0.0v 639.755n 1.0v 644.745n 1.0v 644.755n 0.0v 649.745n 0.0v 649.755n 0.0v 654.745n 0.0v 654.755n 0.0v 659.745n 0.0v 659.755n 1.0v 664.745n 1.0v 664.755n 0.0v 669.745n 0.0v 669.755n 0.0v 674.745n 0.0v 674.755n 0.0v 679.745n 0.0v 679.755n 0.0v 684.745n 0.0v 684.755n 0.0v 689.745n 0.0v 689.755n 0.0v 694.745n 0.0v 694.755n 0.0v 699.745n 0.0v 699.755n 0.0v 704.745n 0.0v 704.755n 0.0v 709.745n 0.0v 709.755n 0.0v 714.745n 0.0v 714.755n 0.0v 719.745n 0.0v 719.755n 0.0v 724.745n 0.0v 724.755n 0.0v 729.745n 0.0v 729.755n 0.0v 734.745n 0.0v 734.755n 0.0v 739.745n 0.0v 739.755n 0.0v 744.745n 0.0v 744.755n 0.0v 749.745n 0.0v 749.755n 0.0v 754.745n 0.0v 754.755n 1.0v 759.745n 1.0v 759.755n 0.0v 764.745n 0.0v 764.755n 0.0v 769.745n 0.0v 769.755n 0.0v 774.745n 0.0v 774.755n 0.0v 779.745n 0.0v 779.755n 0.0v 784.745n 0.0v 784.755n 0.0v 789.745n 0.0v 789.755n 0.0v 794.745n 0.0v 794.755n 0.0v 799.745n 0.0v 799.755n 1.0v 804.745n 1.0v 804.755n 0.0v 809.745n 0.0v 809.755n 0.0v 814.745n 0.0v 814.755n 0.0v 819.745n 0.0v 819.755n 0.0v 824.745n 0.0v 824.755n 0.0v 829.745n 0.0v 829.755n 0.0v 834.745n 0.0v 834.755n 0.0v 839.745n 0.0v 839.755n 0.0v 844.745n 0.0v 844.755n 1.0v 849.745n 1.0v 849.755n 0.0v 854.745n 0.0v 854.755n 0.0v 859.745n 0.0v 859.755n 0.0v 864.745n 0.0v 864.755n 0.0v 869.745n 0.0v 869.755n 0.0v 874.745n 0.0v 874.755n 0.0v 879.745n 0.0v 879.755n 0.0v 884.745n 0.0v 884.755n 0.0v 889.745n 0.0v 889.755n 0.0v 894.745n 0.0v 894.755n 0.0v 899.745n 0.0v 899.755n 0.0v 904.745n 0.0v 904.755n 0.0v 909.745n 0.0v 909.755n 0.0v 914.745n 0.0v 914.755n 0.0v 919.745n 0.0v 919.755n 1.0v 924.745n 1.0v 924.755n 0.0v 929.745n 0.0v 929.755n 0.0v 934.745n 0.0v 934.755n 1.0v 939.745n 1.0v 939.755n 0.0v 944.745n 0.0v 944.755n 0.0v 949.745n 0.0v 949.755n 1.0v 954.745n 1.0v 954.755n 0.0v 959.745n 0.0v 959.755n 1.0v 964.745n 1.0v 964.755n 0.0v 969.745n 0.0v 969.755n 0.0v 974.745n 0.0v 974.755n 0.0v 979.745n 0.0v 979.755n 0.0v 984.745n 0.0v 984.755n 0.0v 989.745n 0.0v 989.755n 1.0v 994.745n 1.0v 994.755n 1.0v 999.745n 1.0v 999.755n 0.0v 1004.745n 0.0v 1004.755n 0.0v 1009.745n 0.0v 1009.755n 1.0v 1014.745n 1.0v 1014.755n 0.0v 1019.745n 0.0v 1019.755n 0.0v 1024.745n 0.0v 1024.755n 1.0v )
* (time, data): [(0, 1), (5, 0), (10, 0), (15, 0), (20, 0), (25, 0), (30, 1), (35, 1), (40, 0), (45, 1), (50, 0), (55, 0), (60, 0), (65, 0), (70, 0), (75, 0), (80, 0), (85, 0), (90, 0), (95, 1), (100, 1), (105, 0), (110, 0), (115, 1), (120, 1), (125, 1), (130, 0), (135, 0), (140, 0), (145, 0), (150, 1), (155, 1), (160, 0), (165, 0), (170, 1), (175, 0), (180, 0), (185, 1), (190, 1), (195, 1), (200, 1), (205, 0), (210, 0), (215, 0), (220, 0), (225, 1), (230, 0), (235, 0), (240, 0), (245, 0), (250, 0), (255, 0), (260, 1), (265, 0), (270, 1), (275, 0), (280, 0), (285, 0), (290, 1), (295, 0), (300, 0), (305, 1), (310, 0), (315, 1), (320, 0), (325, 0), (330, 1), (335, 1), (340, 0), (345, 0), (350, 0), (355, 0), (360, 0), (365, 0), (370, 1), (375, 0), (380, 0), (385, 0), (390, 0), (395, 0), (400, 0), (405, 0), (410, 0), (415, 0), (420, 0), (425, 1), (430, 0), (435, 1), (440, 0), (445, 1), (450, 1), (455, 0), (460, 0), (465, 0), (470, 0), (475, 0), (480, 1), (485, 0), (490, 0), (495, 0), (500, 0), (505, 0), (510, 0), (515, 0), (520, 0), (525, 1), (530, 1), (535, 0), (540, 1), (545, 1), (550, 1), (555, 0), (560, 0), (565, 0), (570, 0), (575, 1), (580, 0), (585, 0), (590, 0), (595, 0), (600, 0), (605, 0), (610, 0), (615, 0), (620, 0), (625, 1), (630, 1), (635, 1), (640, 0), (645, 1), (650, 0), (655, 0), (660, 1), (665, 0), (670, 1), (675, 0), (680, 0), (685, 0), (690, 0), (695, 0), (700, 0), (705, 0), (710, 1), (715, 0), (720, 0), (725, 0), (730, 0), (735, 0), (740, 1), (745, 0), (750, 0), (755, 0), (760, 0), (765, 0), (770, 0), (775, 0), (780, 1), (785, 1), (790, 0), (795, 1), (800, 0), (805, 0), (810, 0), (815, 1), (820, 0), (825, 1), (830, 0), (835, 0), (840, 0), (845, 0), (850, 0), (855, 0), (860, 0), (865, 1), (870, 0), (875, 0), (880, 0), (885, 1), (890, 0), (895, 0), (900, 0), (905, 0), (910, 1), (915, 0), (920, 0), (925, 0), (930, 0), (935, 1), (940, 0), (945, 0), (950, 0), (955, 1), (960, 0), (965, 0), (970, 0), (975, 1), (980, 1), (985, 0), (990, 0), (995, 0), (1000, 0), (1005, 1), (1010, 0), (1015, 0), (1020, 0), (1025, 1)]
VCSB1 CSB1 0 PWL (0n 1.0v 4.745n 1.0v 4.755n 0.0v 9.745n 0.0v 9.755n 0.0v 14.745n 0.0v 14.755n 0.0v 19.745n 0.0v 19.755n 0.0v 24.745n 0.0v 24.755n 0.0v 29.745n 0.0v 29.755n 1.0v 34.745n 1.0v 34.755n 1.0v 39.745n 1.0v 39.755n 0.0v 44.745n 0.0v 44.755n 1.0v 49.745n 1.0v 49.755n 0.0v 54.745n 0.0v 54.755n 0.0v 59.745n 0.0v 59.755n 0.0v 64.745n 0.0v 64.755n 0.0v 69.745n 0.0v 69.755n 0.0v 74.745n 0.0v 74.755n 0.0v 79.745n 0.0v 79.755n 0.0v 84.745n 0.0v 84.755n 0.0v 89.745n 0.0v 89.755n 0.0v 94.745n 0.0v 94.755n 1.0v 99.745n 1.0v 99.755n 1.0v 104.745n 1.0v 104.755n 0.0v 109.745n 0.0v 109.755n 0.0v 114.745n 0.0v 114.755n 1.0v 119.745n 1.0v 119.755n 1.0v 124.745n 1.0v 124.755n 1.0v 129.745n 1.0v 129.755n 0.0v 134.745n 0.0v 134.755n 0.0v 139.745n 0.0v 139.755n 0.0v 144.745n 0.0v 144.755n 0.0v 149.745n 0.0v 149.755n 1.0v 154.745n 1.0v 154.755n 1.0v 159.745n 1.0v 159.755n 0.0v 164.745n 0.0v 164.755n 0.0v 169.745n 0.0v 169.755n 1.0v 174.745n 1.0v 174.755n 0.0v 179.745n 0.0v 179.755n 0.0v 184.745n 0.0v 184.755n 1.0v 189.745n 1.0v 189.755n 1.0v 194.745n 1.0v 194.755n 1.0v 199.745n 1.0v 199.755n 1.0v 204.745n 1.0v 204.755n 0.0v 209.745n 0.0v 209.755n 0.0v 214.745n 0.0v 214.755n 0.0v 219.745n 0.0v 219.755n 0.0v 224.745n 0.0v 224.755n 1.0v 229.745n 1.0v 229.755n 0.0v 234.745n 0.0v 234.755n 0.0v 239.745n 0.0v 239.755n 0.0v 244.745n 0.0v 244.755n 0.0v 249.745n 0.0v 249.755n 0.0v 254.745n 0.0v 254.755n 0.0v 259.745n 0.0v 259.755n 1.0v 264.745n 1.0v 264.755n 0.0v 269.745n 0.0v 269.755n 1.0v 274.745n 1.0v 274.755n 0.0v 279.745n 0.0v 279.755n 0.0v 284.745n 0.0v 284.755n 0.0v 289.745n 0.0v 289.755n 1.0v 294.745n 1.0v 294.755n 0.0v 299.745n 0.0v 299.755n 0.0v 304.745n 0.0v 304.755n 1.0v 309.745n 1.0v 309.755n 0.0v 314.745n 0.0v 314.755n 1.0v 319.745n 1.0v 319.755n 0.0v 324.745n 0.0v 324.755n 0.0v 329.745n 0.0v 329.755n 1.0v 334.745n 1.0v 334.755n 1.0v 339.745n 1.0v 339.755n 0.0v 344.745n 0.0v 344.755n 0.0v 349.745n 0.0v 349.755n 0.0v 354.745n 0.0v 354.755n 0.0v 359.745n 0.0v 359.755n 0.0v 364.745n 0.0v 364.755n 0.0v 369.745n 0.0v 369.755n 1.0v 374.745n 1.0v 374.755n 0.0v 379.745n 0.0v 379.755n 0.0v 384.745n 0.0v 384.755n 0.0v 389.745n 0.0v 389.755n 0.0v 394.745n 0.0v 394.755n 0.0v 399.745n 0.0v 399.755n 0.0v 404.745n 0.0v 404.755n 0.0v 409.745n 0.0v 409.755n 0.0v 414.745n 0.0v 414.755n 0.0v 419.745n 0.0v 419.755n 0.0v 424.745n 0.0v 424.755n 1.0v 429.745n 1.0v 429.755n 0.0v 434.745n 0.0v 434.755n 1.0v 439.745n 1.0v 439.755n 0.0v 444.745n 0.0v 444.755n 1.0v 449.745n 1.0v 449.755n 1.0v 454.745n 1.0v 454.755n 0.0v 459.745n 0.0v 459.755n 0.0v 464.745n 0.0v 464.755n 0.0v 469.745n 0.0v 469.755n 0.0v 474.745n 0.0v 474.755n 0.0v 479.745n 0.0v 479.755n 1.0v 484.745n 1.0v 484.755n 0.0v 489.745n 0.0v 489.755n 0.0v 494.745n 0.0v 494.755n 0.0v 499.745n 0.0v 499.755n 0.0v 504.745n 0.0v 504.755n 0.0v 509.745n 0.0v 509.755n 0.0v 514.745n 0.0v 514.755n 0.0v 519.745n 0.0v 519.755n 0.0v 524.745n 0.0v 524.755n 1.0v 529.745n 1.0v 529.755n 1.0v 534.745n 1.0v 534.755n 0.0v 539.745n 0.0v 539.755n 1.0v 544.745n 1.0v 544.755n 1.0v 549.745n 1.0v 549.755n 1.0v 554.745n 1.0v 554.755n 0.0v 559.745n 0.0v 559.755n 0.0v 564.745n 0.0v 564.755n 0.0v 569.745n 0.0v 569.755n 0.0v 574.745n 0.0v 574.755n 1.0v 579.745n 1.0v 579.755n 0.0v 584.745n 0.0v 584.755n 0.0v 589.745n 0.0v 589.755n 0.0v 594.745n 0.0v 594.755n 0.0v 599.745n 0.0v 599.755n 0.0v 604.745n 0.0v 604.755n 0.0v 609.745n 0.0v 609.755n 0.0v 614.745n 0.0v 614.755n 0.0v 619.745n 0.0v 619.755n 0.0v 624.745n 0.0v 624.755n 1.0v 629.745n 1.0v 629.755n 1.0v 634.745n 1.0v 634.755n 1.0v 639.745n 1.0v 639.755n 0.0v 644.745n 0.0v 644.755n 1.0v 649.745n 1.0v 649.755n 0.0v 654.745n 0.0v 654.755n 0.0v 659.745n 0.0v 659.755n 1.0v 664.745n 1.0v 664.755n 0.0v 669.745n 0.0v 669.755n 1.0v 674.745n 1.0v 674.755n 0.0v 679.745n 0.0v 679.755n 0.0v 684.745n 0.0v 684.755n 0.0v 689.745n 0.0v 689.755n 0.0v 694.745n 0.0v 694.755n 0.0v 699.745n 0.0v 699.755n 0.0v 704.745n 0.0v 704.755n 0.0v 709.745n 0.0v 709.755n 1.0v 714.745n 1.0v 714.755n 0.0v 719.745n 0.0v 719.755n 0.0v 724.745n 0.0v 724.755n 0.0v 729.745n 0.0v 729.755n 0.0v 734.745n 0.0v 734.755n 0.0v 739.745n 0.0v 739.755n 1.0v 744.745n 1.0v 744.755n 0.0v 749.745n 0.0v 749.755n 0.0v 754.745n 0.0v 754.755n 0.0v 759.745n 0.0v 759.755n 0.0v 764.745n 0.0v 764.755n 0.0v 769.745n 0.0v 769.755n 0.0v 774.745n 0.0v 774.755n 0.0v 779.745n 0.0v 779.755n 1.0v 784.745n 1.0v 784.755n 1.0v 789.745n 1.0v 789.755n 0.0v 794.745n 0.0v 794.755n 1.0v 799.745n 1.0v 799.755n 0.0v 804.745n 0.0v 804.755n 0.0v 809.745n 0.0v 809.755n 0.0v 814.745n 0.0v 814.755n 1.0v 819.745n 1.0v 819.755n 0.0v 824.745n 0.0v 824.755n 1.0v 829.745n 1.0v 829.755n 0.0v 834.745n 0.0v 834.755n 0.0v 839.745n 0.0v 839.755n 0.0v 844.745n 0.0v 844.755n 0.0v 849.745n 0.0v 849.755n 0.0v 854.745n 0.0v 854.755n 0.0v 859.745n 0.0v 859.755n 0.0v 864.745n 0.0v 864.755n 1.0v 869.745n 1.0v 869.755n 0.0v 874.745n 0.0v 874.755n 0.0v 879.745n 0.0v 879.755n 0.0v 884.745n 0.0v 884.755n 1.0v 889.745n 1.0v 889.755n 0.0v 894.745n 0.0v 894.755n 0.0v 899.745n 0.0v 899.755n 0.0v 904.745n 0.0v 904.755n 0.0v 909.745n 0.0v 909.755n 1.0v 914.745n 1.0v 914.755n 0.0v 919.745n 0.0v 919.755n 0.0v 924.745n 0.0v 924.755n 0.0v 929.745n 0.0v 929.755n 0.0v 934.745n 0.0v 934.755n 1.0v 939.745n 1.0v 939.755n 0.0v 944.745n 0.0v 944.755n 0.0v 949.745n 0.0v 949.755n 0.0v 954.745n 0.0v 954.755n 1.0v 959.745n 1.0v 959.755n 0.0v 964.745n 0.0v 964.755n 0.0v 969.745n 0.0v 969.755n 0.0v 974.745n 0.0v 974.755n 1.0v 979.745n 1.0v 979.755n 1.0v 984.745n 1.0v 984.755n 0.0v 989.745n 0.0v 989.755n 0.0v 994.745n 0.0v 994.755n 0.0v 999.745n 0.0v 999.755n 0.0v 1004.745n 0.0v 1004.755n 1.0v 1009.745n 1.0v 1009.755n 0.0v 1014.745n 0.0v 1014.755n 0.0v 1019.745n 0.0v 1019.755n 0.0v 1024.745n 0.0v 1024.755n 1.0v )
* (time, data): [(0, 1), (5, 0), (10, 0), (15, 0), (20, 1), (25, 1), (30, 0), (35, 1), (40, 0), (45, 1), (50, 0), (55, 1), (60, 1), (65, 0), (70, 1), (75, 1), (80, 1), (85, 0), (90, 1), (95, 1), (100, 0), (105, 0), (110, 1), (115, 0), (120, 1), (125, 1), (130, 1), (135, 1), (140, 1), (145, 1), (150, 1), (155, 0), (160, 1), (165, 1), (170, 1), (175, 0), (180, 1), (185, 1), (190, 0), (195, 0), (200, 1), (205, 1), (210, 1), (215, 1), (220, 1), (225, 1), (230, 1), (235, 1), (240, 1), (245, 0), (250, 1), (255, 1), (260, 1), (265, 1), (270, 1), (275, 1), (280, 1), (285, 1), (290, 0), (295, 1), (300, 1), (305, 1), (310, 1), (315, 1), (320, 1), (325, 1), (330, 1), (335, 0), (340, 1), (345, 1), (350, 0), (355, 1), (360, 1), (365, 1), (370, 1), (375, 1), (380, 1), (385, 1), (390, 1), (395, 1), (400, 1), (405, 1), (410, 0), (415, 1), (420, 1), (425, 1), (430, 1), (435, 0), (440, 1), (445, 0), (450, 1), (455, 1), (460, 1), (465, 1), (470, 1), (475, 1), (480, 1), (485, 0), (490, 0), (495, 1), (500, 0), (505, 1), (510, 1), (515, 0), (520, 1), (525, 1), (530, 1), (535, 0), (540, 0), (545, 0), (550, 0), (555, 1), (560, 0), (565, 1), (570, 1), (575, 1), (580, 1), (585, 1), (590, 1), (595, 1), (600, 0), (605, 1), (610, 0), (615, 1), (620, 0), (625, 1), (630, 1), (635, 0), (640, 1), (645, 0), (650, 0), (655, 0), (660, 1), (665, 1), (670, 0), (675, 1), (680, 1), (685, 1), (690, 1), (695, 1), (700, 1), (705, 1), (710, 1), (715, 1), (720, 0), (725, 1), (730, 1), (735, 1), (740, 0), (745, 1), (750, 1), (755, 1), (760, 1), (765, 1), (770, 0), (775, 1), (780, 0), (785, 1), (790, 1), (795, 1), (800, 1), (805, 0), (810, 0), (815, 1), (820, 1), (825, 1), (830, 1), (835, 1), (840, 0), (845, 1), (850, 0), (855, 0), (860, 1), (865, 0), (870, 0), (875, 1), (880, 1), (885, 1), (890, 1), (895, 1), (900, 1), (905, 1), (910, 0), (915, 0), (920, 1), (925, 1), (930, 0), (935, 1), (940, 1), (945, 1), (950, 1), (955, 1), (960, 1), (965, 0), (970, 1), (975, 1), (980, 1), (985, 1), (990, 1), (995, 1), (1000, 1), (1005, 1), (1010, 1), (1015, 1), (1020, 0), (1025, 1)]
VWEB0 WEB0 0 PWL (0n 1.0v 4.745n 1.0v 4.755n 0.0v 9.745n 0.0v 9.755n 0.0v 14.745n 0.0v 14.755n 0.0v 19.745n 0.0v 19.755n 1.0v 24.745n 1.0v 24.755n 1.0v 29.745n 1.0v 29.755n 0.0v 34.745n 0.0v 34.755n 1.0v 39.745n 1.0v 39.755n 0.0v 44.745n 0.0v 44.755n 1.0v 49.745n 1.0v 49.755n 0.0v 54.745n 0.0v 54.755n 1.0v 59.745n 1.0v 59.755n 1.0v 64.745n 1.0v 64.755n 0.0v 69.745n 0.0v 69.755n 1.0v 74.745n 1.0v 74.755n 1.0v 79.745n 1.0v 79.755n 1.0v 84.745n 1.0v 84.755n 0.0v 89.745n 0.0v 89.755n 1.0v 94.745n 1.0v 94.755n 1.0v 99.745n 1.0v 99.755n 0.0v 104.745n 0.0v 104.755n 0.0v 109.745n 0.0v 109.755n 1.0v 114.745n 1.0v 114.755n 0.0v 119.745n 0.0v 119.755n 1.0v 124.745n 1.0v 124.755n 1.0v 129.745n 1.0v 129.755n 1.0v 134.745n 1.0v 134.755n 1.0v 139.745n 1.0v 139.755n 1.0v 144.745n 1.0v 144.755n 1.0v 149.745n 1.0v 149.755n 1.0v 154.745n 1.0v 154.755n 0.0v 159.745n 0.0v 159.755n 1.0v 164.745n 1.0v 164.755n 1.0v 169.745n 1.0v 169.755n 1.0v 174.745n 1.0v 174.755n 0.0v 179.745n 0.0v 179.755n 1.0v 184.745n 1.0v 184.755n 1.0v 189.745n 1.0v 189.755n 0.0v 194.745n 0.0v 194.755n 0.0v 199.745n 0.0v 199.755n 1.0v 204.745n 1.0v 204.755n 1.0v 209.745n 1.0v 209.755n 1.0v 214.745n 1.0v 214.755n 1.0v 219.745n 1.0v 219.755n 1.0v 224.745n 1.0v 224.755n 1.0v 229.745n 1.0v 229.755n 1.0v 234.745n 1.0v 234.755n 1.0v 239.745n 1.0v 239.755n 1.0v 244.745n 1.0v 244.755n 0.0v 249.745n 0.0v 249.755n 1.0v 254.745n 1.0v 254.755n 1.0v 259.745n 1.0v 259.755n 1.0v 264.745n 1.0v 264.755n 1.0v 269.745n 1.0v 269.755n 1.0v 274.745n 1.0v 274.755n 1.0v 279.745n 1.0v 279.755n 1.0v 284.745n 1.0v 284.755n 1.0v 289.745n 1.0v 289.755n 0.0v 294.745n 0.0v 294.755n 1.0v 299.745n 1.0v 299.755n 1.0v 304.745n 1.0v 304.755n 1.0v 309.745n 1.0v 309.755n 1.0v 314.745n 1.0v 314.755n 1.0v 319.745n 1.0v 319.755n 1.0v 324.745n 1.0v 324.755n 1.0v 329.745n 1.0v 329.755n 1.0v 334.745n 1.0v 334.755n 0.0v 339.745n 0.0v 339.755n 1.0v 344.745n 1.0v 344.755n 1.0v 349.745n 1.0v 349.755n 0.0v 354.745n 0.0v 354.755n 1.0v 359.745n 1.0v 359.755n 1.0v 364.745n 1.0v 364.755n 1.0v 369.745n 1.0v 369.755n 1.0v 374.745n 1.0v 374.755n 1.0v 379.745n 1.0v 379.755n 1.0v 384.745n 1.0v 384.755n 1.0v 389.745n 1.0v 389.755n 1.0v 394.745n 1.0v 394.755n 1.0v 399.745n 1.0v 399.755n 1.0v 404.745n 1.0v 404.755n 1.0v 409.745n 1.0v 409.755n 0.0v 414.745n 0.0v 414.755n 1.0v 419.745n 1.0v 419.755n 1.0v 424.745n 1.0v 424.755n 1.0v 429.745n 1.0v 429.755n 1.0v 434.745n 1.0v 434.755n 0.0v 439.745n 0.0v 439.755n 1.0v 444.745n 1.0v 444.755n 0.0v 449.745n 0.0v 449.755n 1.0v 454.745n 1.0v 454.755n 1.0v 459.745n 1.0v 459.755n 1.0v 464.745n 1.0v 464.755n 1.0v 469.745n 1.0v 469.755n 1.0v 474.745n 1.0v 474.755n 1.0v 479.745n 1.0v 479.755n 1.0v 484.745n 1.0v 484.755n 0.0v 489.745n 0.0v 489.755n 0.0v 494.745n 0.0v 494.755n 1.0v 499.745n 1.0v 499.755n 0.0v 504.745n 0.0v 504.755n 1.0v 509.745n 1.0v 509.755n 1.0v 514.745n 1.0v 514.755n 0.0v 519.745n 0.0v 519.755n 1.0v 524.745n 1.0v 524.755n 1.0v 529.745n 1.0v 529.755n 1.0v 534.745n 1.0v 534.755n 0.0v 539.745n 0.0v 539.755n 0.0v 544.745n 0.0v 544.755n 0.0v 549.745n 0.0v 549.755n 0.0v 554.745n 0.0v 554.755n 1.0v 559.745n 1.0v 559.755n 0.0v 564.745n 0.0v 564.755n 1.0v 569.745n 1.0v 569.755n 1.0v 574.745n 1.0v 574.755n 1.0v 579.745n 1.0v 579.755n 1.0v 584.745n 1.0v 584.755n 1.0v 589.745n 1.0v 589.755n 1.0v 594.745n 1.0v 594.755n 1.0v 599.745n 1.0v 599.755n 0.0v 604.745n 0.0v 604.755n 1.0v 609.745n 1.0v 609.755n 0.0v 614.745n 0.0v 614.755n 1.0v 619.745n 1.0v 619.755n 0.0v 624.745n 0.0v 624.755n 1.0v 629.745n 1.0v 629.755n 1.0v 634.745n 1.0v 634.755n 0.0v 639.745n 0.0v 639.755n 1.0v 644.745n 1.0v 644.755n 0.0v 649.745n 0.0v 649.755n 0.0v 654.745n 0.0v 654.755n 0.0v 659.745n 0.0v 659.755n 1.0v 664.745n 1.0v 664.755n 1.0v 669.745n 1.0v 669.755n 0.0v 674.745n 0.0v 674.755n 1.0v 679.745n 1.0v 679.755n 1.0v 684.745n 1.0v 684.755n 1.0v 689.745n 1.0v 689.755n 1.0v 694.745n 1.0v 694.755n 1.0v 699.745n 1.0v 699.755n 1.0v 704.745n 1.0v 704.755n 1.0v 709.745n 1.0v 709.755n 1.0v 714.745n 1.0v 714.755n 1.0v 719.745n 1.0v 719.755n 0.0v 724.745n 0.0v 724.755n 1.0v 729.745n 1.0v 729.755n 1.0v 734.745n 1.0v 734.755n 1.0v 739.745n 1.0v 739.755n 0.0v 744.745n 0.0v 744.755n 1.0v 749.745n 1.0v 749.755n 1.0v 754.745n 1.0v 754.755n 1.0v 759.745n 1.0v 759.755n 1.0v 764.745n 1.0v 764.755n 1.0v 769.745n 1.0v 769.755n 0.0v 774.745n 0.0v 774.755n 1.0v 779.745n 1.0v 779.755n 0.0v 784.745n 0.0v 784.755n 1.0v 789.745n 1.0v 789.755n 1.0v 794.745n 1.0v 794.755n 1.0v 799.745n 1.0v 799.755n 1.0v 804.745n 1.0v 804.755n 0.0v 809.745n 0.0v 809.755n 0.0v 814.745n 0.0v 814.755n 1.0v 819.745n 1.0v 819.755n 1.0v 824.745n 1.0v 824.755n 1.0v 829.745n 1.0v 829.755n 1.0v 834.745n 1.0v 834.755n 1.0v 839.745n 1.0v 839.755n 0.0v 844.745n 0.0v 844.755n 1.0v 849.745n 1.0v 849.755n 0.0v 854.745n 0.0v 854.755n 0.0v 859.745n 0.0v 859.755n 1.0v 864.745n 1.0v 864.755n 0.0v 869.745n 0.0v 869.755n 0.0v 874.745n 0.0v 874.755n 1.0v 879.745n 1.0v 879.755n 1.0v 884.745n 1.0v 884.755n 1.0v 889.745n 1.0v 889.755n 1.0v 894.745n 1.0v 894.755n 1.0v 899.745n 1.0v 899.755n 1.0v 904.745n 1.0v 904.755n 1.0v 909.745n 1.0v 909.755n 0.0v 914.745n 0.0v 914.755n 0.0v 919.745n 0.0v 919.755n 1.0v 924.745n 1.0v 924.755n 1.0v 929.745n 1.0v 929.755n 0.0v 934.745n 0.0v 934.755n 1.0v 939.745n 1.0v 939.755n 1.0v 944.745n 1.0v 944.755n 1.0v 949.745n 1.0v 949.755n 1.0v 954.745n 1.0v 954.755n 1.0v 959.745n 1.0v 959.755n 1.0v 964.745n 1.0v 964.755n 0.0v 969.745n 0.0v 969.755n 1.0v 974.745n 1.0v 974.755n 1.0v 979.745n 1.0v 979.755n 1.0v 984.745n 1.0v 984.755n 1.0v 989.745n 1.0v 989.755n 1.0v 994.745n 1.0v 994.755n 1.0v 999.745n 1.0v 999.755n 1.0v 1004.745n 1.0v 1004.755n 1.0v 1009.745n 1.0v 1009.755n 1.0v 1014.745n 1.0v 1014.755n 1.0v 1019.745n 1.0v 1019.755n 0.0v 1024.745n 0.0v 1024.755n 1.0v )
* (time, data): [(0, 1), (5, 0), (10, 0), (15, 0), (20, 1), (25, 1), (30, 1), (35, 1), (40, 1), (45, 1), (50, 1), (55, 1), (60, 0), (65, 1), (70, 1), (75, 1), (80, 0), (85, 1), (90, 0), (95, 1), (100, 1), (105, 1), (110, 1), (115, 1), (120, 1), (125, 1), (130, 0), (135, 1), (140, 1), (145, 0), (150, 1), (155, 1), (160, 1), (165, 1), (170, 1), (175, 0), (180, 0), (185, 1), (190, 1), (195, 1), (200, 1), (205, 1), (210, 1), (215, 1), (220, 1), (225, 1), (230, 1), (235, 1), (240, 1), (245, 0), (250, 0), (255, 1), (260, 1), (265, 1), (270, 1), (275, 1), (280, 1), (285, 0), (290, 1), (295, 1), (300, 0), (305, 1), (310, 1), (315, 1), (320, 1), (325, 1), (330, 1), (335, 1), (340, 1), (345, 1), (350, 1), (355, 1), (360, 1), (365, 0), (370, 1), (375, 1), (380, 0), (385, 1), (390, 0), (395, 0), (400, 0), (405, 1), (410, 1), (415, 1), (420, 0), (425, 1), (430, 1), (435, 1), (440, 1), (445, 1), (450, 1), (455, 1), (460, 1), (465, 0), (470, 1), (475, 1), (480, 1), (485, 0), (490, 1), (495, 1), (500, 1), (505, 0), (510, 1), (515, 1), (520, 0), (525, 1), (530, 1), (535, 1), (540, 1), (545, 1), (550, 1), (555, 1), (560, 1), (565, 1), (570, 1), (575, 1), (580, 0), (585, 0), (590, 1), (595, 1), (600, 1), (605, 0), (610, 1), (615, 0), (620, 1), (625, 1), (630, 1), (635, 1), (640, 1), (645, 1), (650, 1), (655, 1), (660, 1), (665, 1), (670, 1), (675, 1), (680, 1), (685, 1), (690, 0), (695, 1), (700, 1), (705, 1), (710, 1), (715, 1), (720, 1), (725, 1), (730, 0), (735, 0), (740, 1), (745, 1), (750, 1), (755, 1), (760, 0), (765, 0), (770, 0), (775, 1), (780, 1), (785, 1), (790, 0), (795, 1), (800, 1), (805, 1), (810, 0), (815, 1), (820, 1), (825, 1), (830, 0), (835, 1), (840, 1), (845, 1), (850, 1), (855, 1), (860, 0), (865, 1), (870, 1), (875, 1), (880, 0), (885, 1), (890, 1), (895, 1), (900, 0), (905, 0), (910, 1), (915, 1), (920, 1), (925, 0), (930, 0), (935, 1), (940, 1), (945, 0), (950, 1), (955, 1), (960, 1), (965, 1), (970, 1), (975, 1), (980, 1), (985, 1), (990, 1), (995, 1), (1000, 0), (1005, 1), (1010, 0), (1015, 1), (1020, 0), (1025, 1)]
VWEB1 WEB1 0 PWL (0n 1.0v 4.745n 1.0v 4.755n 0.0v 9.745n 0.0v 9.755n 0.0v 14.745n 0.0v 14.755n 0.0v 19.745n 0.0v 19.755n 1.0v 24.745n 1.0v 24.755n 1.0v 29.745n 1.0v 29.755n 1.0v 34.745n 1.0v 34.755n 1.0v 39.745n 1.0v 39.755n 1.0v 44.745n 1.0v 44.755n 1.0v 49.745n 1.0v 49.755n 1.0v 54.745n 1.0v 54.755n 1.0v 59.745n 1.0v 59.755n 0.0v 64.745n 0.0v 64.755n 1.0v 69.745n 1.0v 69.755n 1.0v 74.745n 1.0v 74.755n 1.0v 79.745n 1.0v 79.755n 0.0v 84.745n 0.0v 84.755n 1.0v 89.745n 1.0v 89.755n 0.0v 94.745n 0.0v 94.755n 1.0v 99.745n 1.0v 99.755n 1.0v 104.745n 1.0v 104.755n 1.0v 109.745n 1.0v 109.755n 1.0v 114.745n 1.0v 114.755n 1.0v 119.745n 1.0v 119.755n 1.0v 124.745n 1.0v 124.755n 1.0v 129.745n 1.0v 129.755n 0.0v 134.745n 0.0v 134.755n 1.0v 139.745n 1.0v 139.755n 1.0v 144.745n 1.0v 144.755n 0.0v 149.745n 0.0v 149.755n 1.0v 154.745n 1.0v 154.755n 1.0v 159.745n 1.0v 159.755n 1.0v 164.745n 1.0v 164.755n 1.0v 169.745n 1.0v 169.755n 1.0v 174.745n 1.0v 174.755n 0.0v 179.745n 0.0v 179.755n 0.0v 184.745n 0.0v 184.755n 1.0v 189.745n 1.0v 189.755n 1.0v 194.745n 1.0v 194.755n 1.0v 199.745n 1.0v 199.755n 1.0v 204.745n 1.0v 204.755n 1.0v 209.745n 1.0v 209.755n 1.0v 214.745n 1.0v 214.755n 1.0v 219.745n 1.0v 219.755n 1.0v 224.745n 1.0v 224.755n 1.0v 229.745n 1.0v 229.755n 1.0v 234.745n 1.0v 234.755n 1.0v 239.745n 1.0v 239.755n 1.0v 244.745n 1.0v 244.755n 0.0v 249.745n 0.0v 249.755n 0.0v 254.745n 0.0v 254.755n 1.0v 259.745n 1.0v 259.755n 1.0v 264.745n 1.0v 264.755n 1.0v 269.745n 1.0v 269.755n 1.0v 274.745n 1.0v 274.755n 1.0v 279.745n 1.0v 279.755n 1.0v 284.745n 1.0v 284.755n 0.0v 289.745n 0.0v 289.755n 1.0v 294.745n 1.0v 294.755n 1.0v 299.745n 1.0v 299.755n 0.0v 304.745n 0.0v 304.755n 1.0v 309.745n 1.0v 309.755n 1.0v 314.745n 1.0v 314.755n 1.0v 319.745n 1.0v 319.755n 1.0v 324.745n 1.0v 324.755n 1.0v 329.745n 1.0v 329.755n 1.0v 334.745n 1.0v 334.755n 1.0v 339.745n 1.0v 339.755n 1.0v 344.745n 1.0v 344.755n 1.0v 349.745n 1.0v 349.755n 1.0v 354.745n 1.0v 354.755n 1.0v 359.745n 1.0v 359.755n 1.0v 364.745n 1.0v 364.755n 0.0v 369.745n 0.0v 369.755n 1.0v 374.745n 1.0v 374.755n 1.0v 379.745n 1.0v 379.755n 0.0v 384.745n 0.0v 384.755n 1.0v 389.745n 1.0v 389.755n 0.0v 394.745n 0.0v 394.755n 0.0v 399.745n 0.0v 399.755n 0.0v 404.745n 0.0v 404.755n 1.0v 409.745n 1.0v 409.755n 1.0v 414.745n 1.0v 414.755n 1.0v 419.745n 1.0v 419.755n 0.0v 424.745n 0.0v 424.755n 1.0v 429.745n 1.0v 429.755n 1.0v 434.745n 1.0v 434.755n 1.0v 439.745n 1.0v 439.755n 1.0v 444.745n 1.0v 444.755n 1.0v 449.745n 1.0v 449.755n 1.0v 454.745n 1.0v 454.755n 1.0v 459.745n 1.0v 459.755n 1.0v 464.745n 1.0v 464.755n 0.0v 469.745n 0.0v 469.755n 1.0v 474.745n 1.0v 474.755n 1.0v 479.745n 1.0v 479.755n 1.0v 484.745n 1.0v 484.755n 0.0v 489.745n 0.0v 489.755n 1.0v 494.745n 1.0v 494.755n 1.0v 499.745n 1.0v 499.755n 1.0v 504.745n 1.0v 504.755n 0.0v 509.745n 0.0v 509.755n 1.0v 514.745n 1.0v 514.755n 1.0v 519.745n 1.0v 519.755n 0.0v 524.745n 0.0v 524.755n 1.0v 529.745n 1.0v 529.755n 1.0v 534.745n 1.0v 534.755n 1.0v 539.745n 1.0v 539.755n 1.0v 544.745n 1.0v 544.755n 1.0v 549.745n 1.0v 549.755n 1.0v 554.745n 1.0v 554.755n 1.0v 559.745n 1.0v 559.755n 1.0v 564.745n 1.0v 564.755n 1.0v 569.745n 1.0v 569.755n 1.0v 574.745n 1.0v 574.755n 1.0v 579.745n 1.0v 579.755n 0.0v 584.745n 0.0v 584.755n 0.0v 589.745n 0.0v 589.755n 1.0v 594.745n 1.0v 594.755n 1.0v 599.745n 1.0v 599.755n 1.0v 604.745n 1.0v 604.755n 0.0v 609.745n 0.0v 609.755n 1.0v 614.745n 1.0v 614.755n 0.0v 619.745n 0.0v 619.755n 1.0v 624.745n 1.0v 624.755n 1.0v 629.745n 1.0v 629.755n 1.0v 634.745n 1.0v 634.755n 1.0v 639.745n 1.0v 639.755n 1.0v 644.745n 1.0v 644.755n 1.0v 649.745n 1.0v 649.755n 1.0v 654.745n 1.0v 654.755n 1.0v 659.745n 1.0v 659.755n 1.0v 664.745n 1.0v 664.755n 1.0v 669.745n 1.0v 669.755n 1.0v 674.745n 1.0v 674.755n 1.0v 679.745n 1.0v 679.755n 1.0v 684.745n 1.0v 684.755n 1.0v 689.745n 1.0v 689.755n 0.0v 694.745n 0.0v 694.755n 1.0v 699.745n 1.0v 699.755n 1.0v 704.745n 1.0v 704.755n 1.0v 709.745n 1.0v 709.755n 1.0v 714.745n 1.0v 714.755n 1.0v 719.745n 1.0v 719.755n 1.0v 724.745n 1.0v 724.755n 1.0v 729.745n 1.0v 729.755n 0.0v 734.745n 0.0v 734.755n 0.0v 739.745n 0.0v 739.755n 1.0v 744.745n 1.0v 744.755n 1.0v 749.745n 1.0v 749.755n 1.0v 754.745n 1.0v 754.755n 1.0v 759.745n 1.0v 759.755n 0.0v 764.745n 0.0v 764.755n 0.0v 769.745n 0.0v 769.755n 0.0v 774.745n 0.0v 774.755n 1.0v 779.745n 1.0v 779.755n 1.0v 784.745n 1.0v 784.755n 1.0v 789.745n 1.0v 789.755n 0.0v 794.745n 0.0v 794.755n 1.0v 799.745n 1.0v 799.755n 1.0v 804.745n 1.0v 804.755n 1.0v 809.745n 1.0v 809.755n 0.0v 814.745n 0.0v 814.755n 1.0v 819.745n 1.0v 819.755n 1.0v 824.745n 1.0v 824.755n 1.0v 829.745n 1.0v 829.755n 0.0v 834.745n 0.0v 834.755n 1.0v 839.745n 1.0v 839.755n 1.0v 844.745n 1.0v 844.755n 1.0v 849.745n 1.0v 849.755n 1.0v 854.745n 1.0v 854.755n 1.0v 859.745n 1.0v 859.755n 0.0v 864.745n 0.0v 864.755n 1.0v 869.745n 1.0v 869.755n 1.0v 874.745n 1.0v 874.755n 1.0v 879.745n 1.0v 879.755n 0.0v 884.745n 0.0v 884.755n 1.0v 889.745n 1.0v 889.755n 1.0v 894.745n 1.0v 894.755n 1.0v 899.745n 1.0v 899.755n 0.0v 904.745n 0.0v 904.755n 0.0v 909.745n 0.0v 909.755n 1.0v 914.745n 1.0v 914.755n 1.0v 919.745n 1.0v 919.755n 1.0v 924.745n 1.0v 924.755n 0.0v 929.745n 0.0v 929.755n 0.0v 934.745n 0.0v 934.755n 1.0v 939.745n 1.0v 939.755n 1.0v 944.745n 1.0v 944.755n 0.0v 949.745n 0.0v 949.755n 1.0v 954.745n 1.0v 954.755n 1.0v 959.745n 1.0v 959.755n 1.0v 964.745n 1.0v 964.755n 1.0v 969.745n 1.0v 969.755n 1.0v 974.745n 1.0v 974.755n 1.0v 979.745n 1.0v 979.755n 1.0v 984.745n 1.0v 984.755n 1.0v 989.745n 1.0v 989.755n 1.0v 994.745n 1.0v 994.755n 1.0v 999.745n 1.0v 999.755n 0.0v 1004.745n 0.0v 1004.755n 1.0v 1009.745n 1.0v 1009.755n 0.0v 1014.745n 0.0v 1014.755n 1.0v 1019.745n 1.0v 1019.755n 0.0v 1024.745n 0.0v 1024.755n 1.0v )
* PULSE: period=5
Vclk0 clk0 0 PULSE (0 1.0 4.995n 0.01n 0.01n 2.49n 5n)
* PULSE: period=5
Vclk1 clk1 0 PULSE (0 1.0 4.995n 0.01n 0.01n 2.49n 5n)

 * Generation of dout measurements
* CHECK dout0_0 vdout0_0ck4 = 0 time = 25
* CHECK dout0_1 vdout0_1ck4 = 0 time = 25
* CHECK dout0_2 vdout0_2ck4 = 1.0 time = 25
* CHECK dout0_3 vdout0_3ck4 = 1.0 time = 25
* CHECK dout0_4 vdout0_4ck4 = 0 time = 25
* CHECK dout0_5 vdout0_5ck4 = 1.0 time = 25
* CHECK dout0_6 vdout0_6ck4 = 0 time = 25
* CHECK dout0_7 vdout0_7ck4 = 0 time = 25
* CHECK dout0_8 vdout0_8ck4 = 0 time = 25
* CHECK dout0_9 vdout0_9ck4 = 1.0 time = 25
* CHECK dout0_10 vdout0_10ck4 = 0 time = 25
* CHECK dout0_11 vdout0_11ck4 = 1.0 time = 25
* CHECK dout0_12 vdout0_12ck4 = 1.0 time = 25
* CHECK dout0_13 vdout0_13ck4 = 0 time = 25
* CHECK dout0_14 vdout0_14ck4 = 1.0 time = 25
* CHECK dout0_15 vdout0_15ck4 = 1.0 time = 25
* CHECK dout0_16 vdout0_16ck4 = 1.0 time = 25
* CHECK dout0_17 vdout0_17ck4 = 1.0 time = 25
* CHECK dout0_18 vdout0_18ck4 = 1.0 time = 25
* CHECK dout0_19 vdout0_19ck4 = 0 time = 25
* CHECK dout0_20 vdout0_20ck4 = 1.0 time = 25
* CHECK dout0_21 vdout0_21ck4 = 0 time = 25
* CHECK dout0_22 vdout0_22ck4 = 0 time = 25
* CHECK dout0_23 vdout0_23ck4 = 1.0 time = 25
* CHECK dout0_24 vdout0_24ck4 = 1.0 time = 25
* CHECK dout0_25 vdout0_25ck4 = 0 time = 25
* CHECK dout0_26 vdout0_26ck4 = 0 time = 25
* CHECK dout0_27 vdout0_27ck4 = 1.0 time = 25
* CHECK dout0_28 vdout0_28ck4 = 1.0 time = 25
* CHECK dout0_29 vdout0_29ck4 = 1.0 time = 25
* CHECK dout0_30 vdout0_30ck4 = 1.0 time = 25
* CHECK dout0_31 vdout0_31ck4 = 1.0 time = 25
* CHECK dout0_32 vdout0_32ck4 = 1.0 time = 25
* CHECK dout0_33 vdout0_33ck4 = 1.0 time = 25
* CHECK dout0_34 vdout0_34ck4 = 1.0 time = 25
* CHECK dout0_35 vdout0_35ck4 = 0 time = 25
* CHECK dout0_36 vdout0_36ck4 = 0 time = 25
* CHECK dout0_37 vdout0_37ck4 = 1.0 time = 25
* CHECK dout0_38 vdout0_38ck4 = 0 time = 25
* CHECK dout0_39 vdout0_39ck4 = 0 time = 25
* CHECK dout0_40 vdout0_40ck4 = 0 time = 25
* CHECK dout0_41 vdout0_41ck4 = 0 time = 25
* CHECK dout0_42 vdout0_42ck4 = 1.0 time = 25
* CHECK dout0_43 vdout0_43ck4 = 1.0 time = 25
* CHECK dout0_44 vdout0_44ck4 = 0 time = 25
* CHECK dout0_45 vdout0_45ck4 = 1.0 time = 25
* CHECK dout0_46 vdout0_46ck4 = 1.0 time = 25
* CHECK dout0_47 vdout0_47ck4 = 1.0 time = 25
* CHECK dout0_48 vdout0_48ck4 = 1.0 time = 25
* CHECK dout0_49 vdout0_49ck4 = 0 time = 25
* CHECK dout0_50 vdout0_50ck4 = 1.0 time = 25
* CHECK dout0_51 vdout0_51ck4 = 1.0 time = 25
* CHECK dout0_52 vdout0_52ck4 = 0 time = 25
* CHECK dout0_53 vdout0_53ck4 = 1.0 time = 25
* CHECK dout0_54 vdout0_54ck4 = 0 time = 25
* CHECK dout0_55 vdout0_55ck4 = 0 time = 25
* CHECK dout0_56 vdout0_56ck4 = 1.0 time = 25
* CHECK dout0_57 vdout0_57ck4 = 0 time = 25
* CHECK dout0_58 vdout0_58ck4 = 0 time = 25
* CHECK dout0_59 vdout0_59ck4 = 0 time = 25
* CHECK dout0_60 vdout0_60ck4 = 1.0 time = 25
* CHECK dout0_61 vdout0_61ck4 = 0 time = 25
* CHECK dout0_62 vdout0_62ck4 = 1.0 time = 25
* CHECK dout0_63 vdout0_63ck4 = 1.0 time = 25
* CHECK dout1_0 vdout1_0ck4 = 0 time = 25
* CHECK dout1_1 vdout1_1ck4 = 0 time = 25
* CHECK dout1_2 vdout1_2ck4 = 0 time = 25
* CHECK dout1_3 vdout1_3ck4 = 0 time = 25
* CHECK dout1_4 vdout1_4ck4 = 1.0 time = 25
* CHECK dout1_5 vdout1_5ck4 = 0 time = 25
* CHECK dout1_6 vdout1_6ck4 = 0 time = 25
* CHECK dout1_7 vdout1_7ck4 = 1.0 time = 25
* CHECK dout1_8 vdout1_8ck4 = 0 time = 25
* CHECK dout1_9 vdout1_9ck4 = 1.0 time = 25
* CHECK dout1_10 vdout1_10ck4 = 0 time = 25
* CHECK dout1_11 vdout1_11ck4 = 0 time = 25
* CHECK dout1_12 vdout1_12ck4 = 0 time = 25
* CHECK dout1_13 vdout1_13ck4 = 0 time = 25
* CHECK dout1_14 vdout1_14ck4 = 1.0 time = 25
* CHECK dout1_15 vdout1_15ck4 = 1.0 time = 25
* CHECK dout1_16 vdout1_16ck4 = 0 time = 25
* CHECK dout1_17 vdout1_17ck4 = 0 time = 25
* CHECK dout1_18 vdout1_18ck4 = 1.0 time = 25
* CHECK dout1_19 vdout1_19ck4 = 1.0 time = 25
* CHECK dout1_20 vdout1_20ck4 = 1.0 time = 25
* CHECK dout1_21 vdout1_21ck4 = 0 time = 25
* CHECK dout1_22 vdout1_22ck4 = 1.0 time = 25
* CHECK dout1_23 vdout1_23ck4 = 0 time = 25
* CHECK dout1_24 vdout1_24ck4 = 1.0 time = 25
* CHECK dout1_25 vdout1_25ck4 = 1.0 time = 25
* CHECK dout1_26 vdout1_26ck4 = 1.0 time = 25
* CHECK dout1_27 vdout1_27ck4 = 0 time = 25
* CHECK dout1_28 vdout1_28ck4 = 1.0 time = 25
* CHECK dout1_29 vdout1_29ck4 = 1.0 time = 25
* CHECK dout1_30 vdout1_30ck4 = 1.0 time = 25
* CHECK dout1_31 vdout1_31ck4 = 1.0 time = 25
* CHECK dout1_32 vdout1_32ck4 = 1.0 time = 25
* CHECK dout1_33 vdout1_33ck4 = 1.0 time = 25
* CHECK dout1_34 vdout1_34ck4 = 0 time = 25
* CHECK dout1_35 vdout1_35ck4 = 1.0 time = 25
* CHECK dout1_36 vdout1_36ck4 = 1.0 time = 25
* CHECK dout1_37 vdout1_37ck4 = 0 time = 25
* CHECK dout1_38 vdout1_38ck4 = 1.0 time = 25
* CHECK dout1_39 vdout1_39ck4 = 0 time = 25
* CHECK dout1_40 vdout1_40ck4 = 0 time = 25
* CHECK dout1_41 vdout1_41ck4 = 1.0 time = 25
* CHECK dout1_42 vdout1_42ck4 = 0 time = 25
* CHECK dout1_43 vdout1_43ck4 = 0 time = 25
* CHECK dout1_44 vdout1_44ck4 = 1.0 time = 25
* CHECK dout1_45 vdout1_45ck4 = 0 time = 25
* CHECK dout1_46 vdout1_46ck4 = 0 time = 25
* CHECK dout1_47 vdout1_47ck4 = 1.0 time = 25
* CHECK dout1_48 vdout1_48ck4 = 1.0 time = 25
* CHECK dout1_49 vdout1_49ck4 = 1.0 time = 25
* CHECK dout1_50 vdout1_50ck4 = 1.0 time = 25
* CHECK dout1_51 vdout1_51ck4 = 0 time = 25
* CHECK dout1_52 vdout1_52ck4 = 1.0 time = 25
* CHECK dout1_53 vdout1_53ck4 = 0 time = 25
* CHECK dout1_54 vdout1_54ck4 = 1.0 time = 25
* CHECK dout1_55 vdout1_55ck4 = 0 time = 25
* CHECK dout1_56 vdout1_56ck4 = 0 time = 25
* CHECK dout1_57 vdout1_57ck4 = 1.0 time = 25
* CHECK dout1_58 vdout1_58ck4 = 1.0 time = 25
* CHECK dout1_59 vdout1_59ck4 = 0 time = 25
* CHECK dout1_60 vdout1_60ck4 = 1.0 time = 25
* CHECK dout1_61 vdout1_61ck4 = 1.0 time = 25
* CHECK dout1_62 vdout1_62ck4 = 1.0 time = 25
* CHECK dout1_63 vdout1_63ck4 = 1.0 time = 25
* CHECK dout0_0 vdout0_0ck5 = 1.0 time = 30
* CHECK dout0_1 vdout0_1ck5 = 0 time = 30
* CHECK dout0_2 vdout0_2ck5 = 0 time = 30
* CHECK dout0_3 vdout0_3ck5 = 0 time = 30
* CHECK dout0_4 vdout0_4ck5 = 1.0 time = 30
* CHECK dout0_5 vdout0_5ck5 = 0 time = 30
* CHECK dout0_6 vdout0_6ck5 = 1.0 time = 30
* CHECK dout0_7 vdout0_7ck5 = 0 time = 30
* CHECK dout0_8 vdout0_8ck5 = 0 time = 30
* CHECK dout0_9 vdout0_9ck5 = 1.0 time = 30
* CHECK dout0_10 vdout0_10ck5 = 1.0 time = 30
* CHECK dout0_11 vdout0_11ck5 = 0 time = 30
* CHECK dout0_12 vdout0_12ck5 = 0 time = 30
* CHECK dout0_13 vdout0_13ck5 = 0 time = 30
* CHECK dout0_14 vdout0_14ck5 = 1.0 time = 30
* CHECK dout0_15 vdout0_15ck5 = 0 time = 30
* CHECK dout0_16 vdout0_16ck5 = 0 time = 30
* CHECK dout0_17 vdout0_17ck5 = 0 time = 30
* CHECK dout0_18 vdout0_18ck5 = 0 time = 30
* CHECK dout0_19 vdout0_19ck5 = 1.0 time = 30
* CHECK dout0_20 vdout0_20ck5 = 0 time = 30
* CHECK dout0_21 vdout0_21ck5 = 0 time = 30
* CHECK dout0_22 vdout0_22ck5 = 0 time = 30
* CHECK dout0_23 vdout0_23ck5 = 0 time = 30
* CHECK dout0_24 vdout0_24ck5 = 1.0 time = 30
* CHECK dout0_25 vdout0_25ck5 = 0 time = 30
* CHECK dout0_26 vdout0_26ck5 = 0 time = 30
* CHECK dout0_27 vdout0_27ck5 = 1.0 time = 30
* CHECK dout0_28 vdout0_28ck5 = 1.0 time = 30
* CHECK dout0_29 vdout0_29ck5 = 1.0 time = 30
* CHECK dout0_30 vdout0_30ck5 = 1.0 time = 30
* CHECK dout0_31 vdout0_31ck5 = 1.0 time = 30
* CHECK dout0_32 vdout0_32ck5 = 0 time = 30
* CHECK dout0_33 vdout0_33ck5 = 0 time = 30
* CHECK dout0_34 vdout0_34ck5 = 1.0 time = 30
* CHECK dout0_35 vdout0_35ck5 = 0 time = 30
* CHECK dout0_36 vdout0_36ck5 = 1.0 time = 30
* CHECK dout0_37 vdout0_37ck5 = 1.0 time = 30
* CHECK dout0_38 vdout0_38ck5 = 1.0 time = 30
* CHECK dout0_39 vdout0_39ck5 = 1.0 time = 30
* CHECK dout0_40 vdout0_40ck5 = 1.0 time = 30
* CHECK dout0_41 vdout0_41ck5 = 1.0 time = 30
* CHECK dout0_42 vdout0_42ck5 = 1.0 time = 30
* CHECK dout0_43 vdout0_43ck5 = 0 time = 30
* CHECK dout0_44 vdout0_44ck5 = 0 time = 30
* CHECK dout0_45 vdout0_45ck5 = 0 time = 30
* CHECK dout0_46 vdout0_46ck5 = 1.0 time = 30
* CHECK dout0_47 vdout0_47ck5 = 0 time = 30
* CHECK dout0_48 vdout0_48ck5 = 1.0 time = 30
* CHECK dout0_49 vdout0_49ck5 = 0 time = 30
* CHECK dout0_50 vdout0_50ck5 = 0 time = 30
* CHECK dout0_51 vdout0_51ck5 = 0 time = 30
* CHECK dout0_52 vdout0_52ck5 = 1.0 time = 30
* CHECK dout0_53 vdout0_53ck5 = 1.0 time = 30
* CHECK dout0_54 vdout0_54ck5 = 1.0 time = 30
* CHECK dout0_55 vdout0_55ck5 = 0 time = 30
* CHECK dout0_56 vdout0_56ck5 = 0 time = 30
* CHECK dout0_57 vdout0_57ck5 = 1.0 time = 30
* CHECK dout0_58 vdout0_58ck5 = 0 time = 30
* CHECK dout0_59 vdout0_59ck5 = 1.0 time = 30
* CHECK dout0_60 vdout0_60ck5 = 1.0 time = 30
* CHECK dout0_61 vdout0_61ck5 = 1.0 time = 30
* CHECK dout0_62 vdout0_62ck5 = 0 time = 30
* CHECK dout0_63 vdout0_63ck5 = 1.0 time = 30
* CHECK dout1_0 vdout1_0ck5 = 0 time = 30
* CHECK dout1_1 vdout1_1ck5 = 1.0 time = 30
* CHECK dout1_2 vdout1_2ck5 = 0 time = 30
* CHECK dout1_3 vdout1_3ck5 = 1.0 time = 30
* CHECK dout1_4 vdout1_4ck5 = 0 time = 30
* CHECK dout1_5 vdout1_5ck5 = 1.0 time = 30
* CHECK dout1_6 vdout1_6ck5 = 1.0 time = 30
* CHECK dout1_7 vdout1_7ck5 = 0 time = 30
* CHECK dout1_8 vdout1_8ck5 = 1.0 time = 30
* CHECK dout1_9 vdout1_9ck5 = 0 time = 30
* CHECK dout1_10 vdout1_10ck5 = 1.0 time = 30
* CHECK dout1_11 vdout1_11ck5 = 1.0 time = 30
* CHECK dout1_12 vdout1_12ck5 = 1.0 time = 30
* CHECK dout1_13 vdout1_13ck5 = 0 time = 30
* CHECK dout1_14 vdout1_14ck5 = 1.0 time = 30
* CHECK dout1_15 vdout1_15ck5 = 1.0 time = 30
* CHECK dout1_16 vdout1_16ck5 = 1.0 time = 30
* CHECK dout1_17 vdout1_17ck5 = 0 time = 30
* CHECK dout1_18 vdout1_18ck5 = 1.0 time = 30
* CHECK dout1_19 vdout1_19ck5 = 1.0 time = 30
* CHECK dout1_20 vdout1_20ck5 = 1.0 time = 30
* CHECK dout1_21 vdout1_21ck5 = 1.0 time = 30
* CHECK dout1_22 vdout1_22ck5 = 0 time = 30
* CHECK dout1_23 vdout1_23ck5 = 1.0 time = 30
* CHECK dout1_24 vdout1_24ck5 = 1.0 time = 30
* CHECK dout1_25 vdout1_25ck5 = 0 time = 30
* CHECK dout1_26 vdout1_26ck5 = 1.0 time = 30
* CHECK dout1_27 vdout1_27ck5 = 1.0 time = 30
* CHECK dout1_28 vdout1_28ck5 = 1.0 time = 30
* CHECK dout1_29 vdout1_29ck5 = 0 time = 30
* CHECK dout1_30 vdout1_30ck5 = 1.0 time = 30
* CHECK dout1_31 vdout1_31ck5 = 1.0 time = 30
* CHECK dout1_32 vdout1_32ck5 = 0 time = 30
* CHECK dout1_33 vdout1_33ck5 = 1.0 time = 30
* CHECK dout1_34 vdout1_34ck5 = 0 time = 30
* CHECK dout1_35 vdout1_35ck5 = 1.0 time = 30
* CHECK dout1_36 vdout1_36ck5 = 0 time = 30
* CHECK dout1_37 vdout1_37ck5 = 1.0 time = 30
* CHECK dout1_38 vdout1_38ck5 = 0 time = 30
* CHECK dout1_39 vdout1_39ck5 = 1.0 time = 30
* CHECK dout1_40 vdout1_40ck5 = 0 time = 30
* CHECK dout1_41 vdout1_41ck5 = 1.0 time = 30
* CHECK dout1_42 vdout1_42ck5 = 1.0 time = 30
* CHECK dout1_43 vdout1_43ck5 = 1.0 time = 30
* CHECK dout1_44 vdout1_44ck5 = 1.0 time = 30
* CHECK dout1_45 vdout1_45ck5 = 1.0 time = 30
* CHECK dout1_46 vdout1_46ck5 = 0 time = 30
* CHECK dout1_47 vdout1_47ck5 = 1.0 time = 30
* CHECK dout1_48 vdout1_48ck5 = 1.0 time = 30
* CHECK dout1_49 vdout1_49ck5 = 0 time = 30
* CHECK dout1_50 vdout1_50ck5 = 1.0 time = 30
* CHECK dout1_51 vdout1_51ck5 = 0 time = 30
* CHECK dout1_52 vdout1_52ck5 = 1.0 time = 30
* CHECK dout1_53 vdout1_53ck5 = 0 time = 30
* CHECK dout1_54 vdout1_54ck5 = 1.0 time = 30
* CHECK dout1_55 vdout1_55ck5 = 1.0 time = 30
* CHECK dout1_56 vdout1_56ck5 = 1.0 time = 30
* CHECK dout1_57 vdout1_57ck5 = 1.0 time = 30
* CHECK dout1_58 vdout1_58ck5 = 1.0 time = 30
* CHECK dout1_59 vdout1_59ck5 = 1.0 time = 30
* CHECK dout1_60 vdout1_60ck5 = 1.0 time = 30
* CHECK dout1_61 vdout1_61ck5 = 1.0 time = 30
* CHECK dout1_62 vdout1_62ck5 = 1.0 time = 30
* CHECK dout1_63 vdout1_63ck5 = 0 time = 30
* CHECK dout0_0 vdout0_0ck7 = 0 time = 40
* CHECK dout0_1 vdout0_1ck7 = 0 time = 40
* CHECK dout0_2 vdout0_2ck7 = 1.0 time = 40
* CHECK dout0_3 vdout0_3ck7 = 1.0 time = 40
* CHECK dout0_4 vdout0_4ck7 = 0 time = 40
* CHECK dout0_5 vdout0_5ck7 = 1.0 time = 40
* CHECK dout0_6 vdout0_6ck7 = 0 time = 40
* CHECK dout0_7 vdout0_7ck7 = 0 time = 40
* CHECK dout0_8 vdout0_8ck7 = 0 time = 40
* CHECK dout0_9 vdout0_9ck7 = 1.0 time = 40
* CHECK dout0_10 vdout0_10ck7 = 0 time = 40
* CHECK dout0_11 vdout0_11ck7 = 1.0 time = 40
* CHECK dout0_12 vdout0_12ck7 = 1.0 time = 40
* CHECK dout0_13 vdout0_13ck7 = 0 time = 40
* CHECK dout0_14 vdout0_14ck7 = 1.0 time = 40
* CHECK dout0_15 vdout0_15ck7 = 1.0 time = 40
* CHECK dout0_16 vdout0_16ck7 = 1.0 time = 40
* CHECK dout0_17 vdout0_17ck7 = 1.0 time = 40
* CHECK dout0_18 vdout0_18ck7 = 1.0 time = 40
* CHECK dout0_19 vdout0_19ck7 = 0 time = 40
* CHECK dout0_20 vdout0_20ck7 = 1.0 time = 40
* CHECK dout0_21 vdout0_21ck7 = 0 time = 40
* CHECK dout0_22 vdout0_22ck7 = 0 time = 40
* CHECK dout0_23 vdout0_23ck7 = 1.0 time = 40
* CHECK dout0_24 vdout0_24ck7 = 1.0 time = 40
* CHECK dout0_25 vdout0_25ck7 = 0 time = 40
* CHECK dout0_26 vdout0_26ck7 = 0 time = 40
* CHECK dout0_27 vdout0_27ck7 = 1.0 time = 40
* CHECK dout0_28 vdout0_28ck7 = 1.0 time = 40
* CHECK dout0_29 vdout0_29ck7 = 1.0 time = 40
* CHECK dout0_30 vdout0_30ck7 = 1.0 time = 40
* CHECK dout0_31 vdout0_31ck7 = 1.0 time = 40
* CHECK dout0_32 vdout0_32ck7 = 1.0 time = 40
* CHECK dout0_33 vdout0_33ck7 = 1.0 time = 40
* CHECK dout0_34 vdout0_34ck7 = 1.0 time = 40
* CHECK dout0_35 vdout0_35ck7 = 0 time = 40
* CHECK dout0_36 vdout0_36ck7 = 0 time = 40
* CHECK dout0_37 vdout0_37ck7 = 1.0 time = 40
* CHECK dout0_38 vdout0_38ck7 = 0 time = 40
* CHECK dout0_39 vdout0_39ck7 = 0 time = 40
* CHECK dout0_40 vdout0_40ck7 = 0 time = 40
* CHECK dout0_41 vdout0_41ck7 = 0 time = 40
* CHECK dout0_42 vdout0_42ck7 = 1.0 time = 40
* CHECK dout0_43 vdout0_43ck7 = 1.0 time = 40
* CHECK dout0_44 vdout0_44ck7 = 0 time = 40
* CHECK dout0_45 vdout0_45ck7 = 1.0 time = 40
* CHECK dout0_46 vdout0_46ck7 = 1.0 time = 40
* CHECK dout0_47 vdout0_47ck7 = 1.0 time = 40
* CHECK dout0_48 vdout0_48ck7 = 1.0 time = 40
* CHECK dout0_49 vdout0_49ck7 = 0 time = 40
* CHECK dout0_50 vdout0_50ck7 = 1.0 time = 40
* CHECK dout0_51 vdout0_51ck7 = 1.0 time = 40
* CHECK dout0_52 vdout0_52ck7 = 0 time = 40
* CHECK dout0_53 vdout0_53ck7 = 1.0 time = 40
* CHECK dout0_54 vdout0_54ck7 = 0 time = 40
* CHECK dout0_55 vdout0_55ck7 = 0 time = 40
* CHECK dout0_56 vdout0_56ck7 = 1.0 time = 40
* CHECK dout0_57 vdout0_57ck7 = 0 time = 40
* CHECK dout0_58 vdout0_58ck7 = 0 time = 40
* CHECK dout0_59 vdout0_59ck7 = 0 time = 40
* CHECK dout0_60 vdout0_60ck7 = 1.0 time = 40
* CHECK dout0_61 vdout0_61ck7 = 0 time = 40
* CHECK dout0_62 vdout0_62ck7 = 1.0 time = 40
* CHECK dout0_63 vdout0_63ck7 = 1.0 time = 40
* CHECK dout1_0 vdout1_0ck8 = 0 time = 45
* CHECK dout1_1 vdout1_1ck8 = 0 time = 45
* CHECK dout1_2 vdout1_2ck8 = 0 time = 45
* CHECK dout1_3 vdout1_3ck8 = 0 time = 45
* CHECK dout1_4 vdout1_4ck8 = 1.0 time = 45
* CHECK dout1_5 vdout1_5ck8 = 0 time = 45
* CHECK dout1_6 vdout1_6ck8 = 0 time = 45
* CHECK dout1_7 vdout1_7ck8 = 1.0 time = 45
* CHECK dout1_8 vdout1_8ck8 = 0 time = 45
* CHECK dout1_9 vdout1_9ck8 = 1.0 time = 45
* CHECK dout1_10 vdout1_10ck8 = 0 time = 45
* CHECK dout1_11 vdout1_11ck8 = 0 time = 45
* CHECK dout1_12 vdout1_12ck8 = 0 time = 45
* CHECK dout1_13 vdout1_13ck8 = 0 time = 45
* CHECK dout1_14 vdout1_14ck8 = 1.0 time = 45
* CHECK dout1_15 vdout1_15ck8 = 1.0 time = 45
* CHECK dout1_16 vdout1_16ck8 = 0 time = 45
* CHECK dout1_17 vdout1_17ck8 = 0 time = 45
* CHECK dout1_18 vdout1_18ck8 = 1.0 time = 45
* CHECK dout1_19 vdout1_19ck8 = 1.0 time = 45
* CHECK dout1_20 vdout1_20ck8 = 1.0 time = 45
* CHECK dout1_21 vdout1_21ck8 = 0 time = 45
* CHECK dout1_22 vdout1_22ck8 = 1.0 time = 45
* CHECK dout1_23 vdout1_23ck8 = 0 time = 45
* CHECK dout1_24 vdout1_24ck8 = 1.0 time = 45
* CHECK dout1_25 vdout1_25ck8 = 1.0 time = 45
* CHECK dout1_26 vdout1_26ck8 = 1.0 time = 45
* CHECK dout1_27 vdout1_27ck8 = 0 time = 45
* CHECK dout1_28 vdout1_28ck8 = 1.0 time = 45
* CHECK dout1_29 vdout1_29ck8 = 1.0 time = 45
* CHECK dout1_30 vdout1_30ck8 = 1.0 time = 45
* CHECK dout1_31 vdout1_31ck8 = 1.0 time = 45
* CHECK dout1_32 vdout1_32ck8 = 1.0 time = 45
* CHECK dout1_33 vdout1_33ck8 = 1.0 time = 45
* CHECK dout1_34 vdout1_34ck8 = 0 time = 45
* CHECK dout1_35 vdout1_35ck8 = 1.0 time = 45
* CHECK dout1_36 vdout1_36ck8 = 1.0 time = 45
* CHECK dout1_37 vdout1_37ck8 = 0 time = 45
* CHECK dout1_38 vdout1_38ck8 = 1.0 time = 45
* CHECK dout1_39 vdout1_39ck8 = 0 time = 45
* CHECK dout1_40 vdout1_40ck8 = 0 time = 45
* CHECK dout1_41 vdout1_41ck8 = 1.0 time = 45
* CHECK dout1_42 vdout1_42ck8 = 0 time = 45
* CHECK dout1_43 vdout1_43ck8 = 0 time = 45
* CHECK dout1_44 vdout1_44ck8 = 1.0 time = 45
* CHECK dout1_45 vdout1_45ck8 = 0 time = 45
* CHECK dout1_46 vdout1_46ck8 = 0 time = 45
* CHECK dout1_47 vdout1_47ck8 = 1.0 time = 45
* CHECK dout1_48 vdout1_48ck8 = 1.0 time = 45
* CHECK dout1_49 vdout1_49ck8 = 1.0 time = 45
* CHECK dout1_50 vdout1_50ck8 = 1.0 time = 45
* CHECK dout1_51 vdout1_51ck8 = 0 time = 45
* CHECK dout1_52 vdout1_52ck8 = 1.0 time = 45
* CHECK dout1_53 vdout1_53ck8 = 0 time = 45
* CHECK dout1_54 vdout1_54ck8 = 1.0 time = 45
* CHECK dout1_55 vdout1_55ck8 = 0 time = 45
* CHECK dout1_56 vdout1_56ck8 = 0 time = 45
* CHECK dout1_57 vdout1_57ck8 = 1.0 time = 45
* CHECK dout1_58 vdout1_58ck8 = 1.0 time = 45
* CHECK dout1_59 vdout1_59ck8 = 0 time = 45
* CHECK dout1_60 vdout1_60ck8 = 1.0 time = 45
* CHECK dout1_61 vdout1_61ck8 = 1.0 time = 45
* CHECK dout1_62 vdout1_62ck8 = 1.0 time = 45
* CHECK dout1_63 vdout1_63ck8 = 1.0 time = 45
* CHECK dout1_0 vdout1_0ck10 = 0 time = 55
* CHECK dout1_1 vdout1_1ck10 = 0 time = 55
* CHECK dout1_2 vdout1_2ck10 = 1.0 time = 55
* CHECK dout1_3 vdout1_3ck10 = 1.0 time = 55
* CHECK dout1_4 vdout1_4ck10 = 0 time = 55
* CHECK dout1_5 vdout1_5ck10 = 1.0 time = 55
* CHECK dout1_6 vdout1_6ck10 = 0 time = 55
* CHECK dout1_7 vdout1_7ck10 = 0 time = 55
* CHECK dout1_8 vdout1_8ck10 = 0 time = 55
* CHECK dout1_9 vdout1_9ck10 = 1.0 time = 55
* CHECK dout1_10 vdout1_10ck10 = 0 time = 55
* CHECK dout1_11 vdout1_11ck10 = 1.0 time = 55
* CHECK dout1_12 vdout1_12ck10 = 1.0 time = 55
* CHECK dout1_13 vdout1_13ck10 = 0 time = 55
* CHECK dout1_14 vdout1_14ck10 = 1.0 time = 55
* CHECK dout1_15 vdout1_15ck10 = 1.0 time = 55
* CHECK dout1_16 vdout1_16ck10 = 1.0 time = 55
* CHECK dout1_17 vdout1_17ck10 = 1.0 time = 55
* CHECK dout1_18 vdout1_18ck10 = 1.0 time = 55
* CHECK dout1_19 vdout1_19ck10 = 0 time = 55
* CHECK dout1_20 vdout1_20ck10 = 1.0 time = 55
* CHECK dout1_21 vdout1_21ck10 = 0 time = 55
* CHECK dout1_22 vdout1_22ck10 = 0 time = 55
* CHECK dout1_23 vdout1_23ck10 = 1.0 time = 55
* CHECK dout1_24 vdout1_24ck10 = 1.0 time = 55
* CHECK dout1_25 vdout1_25ck10 = 0 time = 55
* CHECK dout1_26 vdout1_26ck10 = 0 time = 55
* CHECK dout1_27 vdout1_27ck10 = 1.0 time = 55
* CHECK dout1_28 vdout1_28ck10 = 1.0 time = 55
* CHECK dout1_29 vdout1_29ck10 = 1.0 time = 55
* CHECK dout1_30 vdout1_30ck10 = 1.0 time = 55
* CHECK dout1_31 vdout1_31ck10 = 1.0 time = 55
* CHECK dout1_32 vdout1_32ck10 = 1.0 time = 55
* CHECK dout1_33 vdout1_33ck10 = 1.0 time = 55
* CHECK dout1_34 vdout1_34ck10 = 1.0 time = 55
* CHECK dout1_35 vdout1_35ck10 = 0 time = 55
* CHECK dout1_36 vdout1_36ck10 = 0 time = 55
* CHECK dout1_37 vdout1_37ck10 = 1.0 time = 55
* CHECK dout1_38 vdout1_38ck10 = 0 time = 55
* CHECK dout1_39 vdout1_39ck10 = 0 time = 55
* CHECK dout1_40 vdout1_40ck10 = 0 time = 55
* CHECK dout1_41 vdout1_41ck10 = 0 time = 55
* CHECK dout1_42 vdout1_42ck10 = 1.0 time = 55
* CHECK dout1_43 vdout1_43ck10 = 1.0 time = 55
* CHECK dout1_44 vdout1_44ck10 = 0 time = 55
* CHECK dout1_45 vdout1_45ck10 = 1.0 time = 55
* CHECK dout1_46 vdout1_46ck10 = 1.0 time = 55
* CHECK dout1_47 vdout1_47ck10 = 1.0 time = 55
* CHECK dout1_48 vdout1_48ck10 = 1.0 time = 55
* CHECK dout1_49 vdout1_49ck10 = 0 time = 55
* CHECK dout1_50 vdout1_50ck10 = 1.0 time = 55
* CHECK dout1_51 vdout1_51ck10 = 1.0 time = 55
* CHECK dout1_52 vdout1_52ck10 = 0 time = 55
* CHECK dout1_53 vdout1_53ck10 = 1.0 time = 55
* CHECK dout1_54 vdout1_54ck10 = 0 time = 55
* CHECK dout1_55 vdout1_55ck10 = 0 time = 55
* CHECK dout1_56 vdout1_56ck10 = 1.0 time = 55
* CHECK dout1_57 vdout1_57ck10 = 0 time = 55
* CHECK dout1_58 vdout1_58ck10 = 0 time = 55
* CHECK dout1_59 vdout1_59ck10 = 0 time = 55
* CHECK dout1_60 vdout1_60ck10 = 1.0 time = 55
* CHECK dout1_61 vdout1_61ck10 = 0 time = 55
* CHECK dout1_62 vdout1_62ck10 = 1.0 time = 55
* CHECK dout1_63 vdout1_63ck10 = 1.0 time = 55
* CHECK dout0_0 vdout0_0ck11 = 0 time = 60
* CHECK dout0_1 vdout0_1ck11 = 0 time = 60
* CHECK dout0_2 vdout0_2ck11 = 0 time = 60
* CHECK dout0_3 vdout0_3ck11 = 0 time = 60
* CHECK dout0_4 vdout0_4ck11 = 1.0 time = 60
* CHECK dout0_5 vdout0_5ck11 = 0 time = 60
* CHECK dout0_6 vdout0_6ck11 = 0 time = 60
* CHECK dout0_7 vdout0_7ck11 = 1.0 time = 60
* CHECK dout0_8 vdout0_8ck11 = 0 time = 60
* CHECK dout0_9 vdout0_9ck11 = 1.0 time = 60
* CHECK dout0_10 vdout0_10ck11 = 0 time = 60
* CHECK dout0_11 vdout0_11ck11 = 0 time = 60
* CHECK dout0_12 vdout0_12ck11 = 0 time = 60
* CHECK dout0_13 vdout0_13ck11 = 0 time = 60
* CHECK dout0_14 vdout0_14ck11 = 1.0 time = 60
* CHECK dout0_15 vdout0_15ck11 = 1.0 time = 60
* CHECK dout0_16 vdout0_16ck11 = 0 time = 60
* CHECK dout0_17 vdout0_17ck11 = 0 time = 60
* CHECK dout0_18 vdout0_18ck11 = 1.0 time = 60
* CHECK dout0_19 vdout0_19ck11 = 1.0 time = 60
* CHECK dout0_20 vdout0_20ck11 = 1.0 time = 60
* CHECK dout0_21 vdout0_21ck11 = 0 time = 60
* CHECK dout0_22 vdout0_22ck11 = 1.0 time = 60
* CHECK dout0_23 vdout0_23ck11 = 0 time = 60
* CHECK dout0_24 vdout0_24ck11 = 1.0 time = 60
* CHECK dout0_25 vdout0_25ck11 = 1.0 time = 60
* CHECK dout0_26 vdout0_26ck11 = 1.0 time = 60
* CHECK dout0_27 vdout0_27ck11 = 0 time = 60
* CHECK dout0_28 vdout0_28ck11 = 1.0 time = 60
* CHECK dout0_29 vdout0_29ck11 = 1.0 time = 60
* CHECK dout0_30 vdout0_30ck11 = 1.0 time = 60
* CHECK dout0_31 vdout0_31ck11 = 1.0 time = 60
* CHECK dout0_32 vdout0_32ck11 = 1.0 time = 60
* CHECK dout0_33 vdout0_33ck11 = 1.0 time = 60
* CHECK dout0_34 vdout0_34ck11 = 0 time = 60
* CHECK dout0_35 vdout0_35ck11 = 1.0 time = 60
* CHECK dout0_36 vdout0_36ck11 = 1.0 time = 60
* CHECK dout0_37 vdout0_37ck11 = 0 time = 60
* CHECK dout0_38 vdout0_38ck11 = 1.0 time = 60
* CHECK dout0_39 vdout0_39ck11 = 0 time = 60
* CHECK dout0_40 vdout0_40ck11 = 0 time = 60
* CHECK dout0_41 vdout0_41ck11 = 1.0 time = 60
* CHECK dout0_42 vdout0_42ck11 = 0 time = 60
* CHECK dout0_43 vdout0_43ck11 = 0 time = 60
* CHECK dout0_44 vdout0_44ck11 = 1.0 time = 60
* CHECK dout0_45 vdout0_45ck11 = 0 time = 60
* CHECK dout0_46 vdout0_46ck11 = 0 time = 60
* CHECK dout0_47 vdout0_47ck11 = 1.0 time = 60
* CHECK dout0_48 vdout0_48ck11 = 1.0 time = 60
* CHECK dout0_49 vdout0_49ck11 = 1.0 time = 60
* CHECK dout0_50 vdout0_50ck11 = 1.0 time = 60
* CHECK dout0_51 vdout0_51ck11 = 0 time = 60
* CHECK dout0_52 vdout0_52ck11 = 1.0 time = 60
* CHECK dout0_53 vdout0_53ck11 = 0 time = 60
* CHECK dout0_54 vdout0_54ck11 = 1.0 time = 60
* CHECK dout0_55 vdout0_55ck11 = 0 time = 60
* CHECK dout0_56 vdout0_56ck11 = 0 time = 60
* CHECK dout0_57 vdout0_57ck11 = 1.0 time = 60
* CHECK dout0_58 vdout0_58ck11 = 1.0 time = 60
* CHECK dout0_59 vdout0_59ck11 = 0 time = 60
* CHECK dout0_60 vdout0_60ck11 = 1.0 time = 60
* CHECK dout0_61 vdout0_61ck11 = 1.0 time = 60
* CHECK dout0_62 vdout0_62ck11 = 1.0 time = 60
* CHECK dout0_63 vdout0_63ck11 = 1.0 time = 60
* CHECK dout1_0 vdout1_0ck11 = 0 time = 60
* CHECK dout1_1 vdout1_1ck11 = 0 time = 60
* CHECK dout1_2 vdout1_2ck11 = 0 time = 60
* CHECK dout1_3 vdout1_3ck11 = 0 time = 60
* CHECK dout1_4 vdout1_4ck11 = 1.0 time = 60
* CHECK dout1_5 vdout1_5ck11 = 0 time = 60
* CHECK dout1_6 vdout1_6ck11 = 0 time = 60
* CHECK dout1_7 vdout1_7ck11 = 1.0 time = 60
* CHECK dout1_8 vdout1_8ck11 = 0 time = 60
* CHECK dout1_9 vdout1_9ck11 = 1.0 time = 60
* CHECK dout1_10 vdout1_10ck11 = 0 time = 60
* CHECK dout1_11 vdout1_11ck11 = 0 time = 60
* CHECK dout1_12 vdout1_12ck11 = 0 time = 60
* CHECK dout1_13 vdout1_13ck11 = 0 time = 60
* CHECK dout1_14 vdout1_14ck11 = 1.0 time = 60
* CHECK dout1_15 vdout1_15ck11 = 1.0 time = 60
* CHECK dout1_16 vdout1_16ck11 = 0 time = 60
* CHECK dout1_17 vdout1_17ck11 = 0 time = 60
* CHECK dout1_18 vdout1_18ck11 = 1.0 time = 60
* CHECK dout1_19 vdout1_19ck11 = 1.0 time = 60
* CHECK dout1_20 vdout1_20ck11 = 1.0 time = 60
* CHECK dout1_21 vdout1_21ck11 = 0 time = 60
* CHECK dout1_22 vdout1_22ck11 = 1.0 time = 60
* CHECK dout1_23 vdout1_23ck11 = 0 time = 60
* CHECK dout1_24 vdout1_24ck11 = 1.0 time = 60
* CHECK dout1_25 vdout1_25ck11 = 1.0 time = 60
* CHECK dout1_26 vdout1_26ck11 = 1.0 time = 60
* CHECK dout1_27 vdout1_27ck11 = 0 time = 60
* CHECK dout1_28 vdout1_28ck11 = 1.0 time = 60
* CHECK dout1_29 vdout1_29ck11 = 1.0 time = 60
* CHECK dout1_30 vdout1_30ck11 = 1.0 time = 60
* CHECK dout1_31 vdout1_31ck11 = 1.0 time = 60
* CHECK dout1_32 vdout1_32ck11 = 1.0 time = 60
* CHECK dout1_33 vdout1_33ck11 = 1.0 time = 60
* CHECK dout1_34 vdout1_34ck11 = 0 time = 60
* CHECK dout1_35 vdout1_35ck11 = 1.0 time = 60
* CHECK dout1_36 vdout1_36ck11 = 1.0 time = 60
* CHECK dout1_37 vdout1_37ck11 = 0 time = 60
* CHECK dout1_38 vdout1_38ck11 = 1.0 time = 60
* CHECK dout1_39 vdout1_39ck11 = 0 time = 60
* CHECK dout1_40 vdout1_40ck11 = 0 time = 60
* CHECK dout1_41 vdout1_41ck11 = 1.0 time = 60
* CHECK dout1_42 vdout1_42ck11 = 0 time = 60
* CHECK dout1_43 vdout1_43ck11 = 0 time = 60
* CHECK dout1_44 vdout1_44ck11 = 1.0 time = 60
* CHECK dout1_45 vdout1_45ck11 = 0 time = 60
* CHECK dout1_46 vdout1_46ck11 = 0 time = 60
* CHECK dout1_47 vdout1_47ck11 = 1.0 time = 60
* CHECK dout1_48 vdout1_48ck11 = 1.0 time = 60
* CHECK dout1_49 vdout1_49ck11 = 1.0 time = 60
* CHECK dout1_50 vdout1_50ck11 = 1.0 time = 60
* CHECK dout1_51 vdout1_51ck11 = 0 time = 60
* CHECK dout1_52 vdout1_52ck11 = 1.0 time = 60
* CHECK dout1_53 vdout1_53ck11 = 0 time = 60
* CHECK dout1_54 vdout1_54ck11 = 1.0 time = 60
* CHECK dout1_55 vdout1_55ck11 = 0 time = 60
* CHECK dout1_56 vdout1_56ck11 = 0 time = 60
* CHECK dout1_57 vdout1_57ck11 = 1.0 time = 60
* CHECK dout1_58 vdout1_58ck11 = 1.0 time = 60
* CHECK dout1_59 vdout1_59ck11 = 0 time = 60
* CHECK dout1_60 vdout1_60ck11 = 1.0 time = 60
* CHECK dout1_61 vdout1_61ck11 = 1.0 time = 60
* CHECK dout1_62 vdout1_62ck11 = 1.0 time = 60
* CHECK dout1_63 vdout1_63ck11 = 1.0 time = 60
* CHECK dout0_0 vdout0_0ck12 = 0 time = 65
* CHECK dout0_1 vdout0_1ck12 = 1.0 time = 65
* CHECK dout0_2 vdout0_2ck12 = 0 time = 65
* CHECK dout0_3 vdout0_3ck12 = 1.0 time = 65
* CHECK dout0_4 vdout0_4ck12 = 0 time = 65
* CHECK dout0_5 vdout0_5ck12 = 1.0 time = 65
* CHECK dout0_6 vdout0_6ck12 = 1.0 time = 65
* CHECK dout0_7 vdout0_7ck12 = 0 time = 65
* CHECK dout0_8 vdout0_8ck12 = 1.0 time = 65
* CHECK dout0_9 vdout0_9ck12 = 0 time = 65
* CHECK dout0_10 vdout0_10ck12 = 1.0 time = 65
* CHECK dout0_11 vdout0_11ck12 = 1.0 time = 65
* CHECK dout0_12 vdout0_12ck12 = 1.0 time = 65
* CHECK dout0_13 vdout0_13ck12 = 0 time = 65
* CHECK dout0_14 vdout0_14ck12 = 1.0 time = 65
* CHECK dout0_15 vdout0_15ck12 = 1.0 time = 65
* CHECK dout0_16 vdout0_16ck12 = 1.0 time = 65
* CHECK dout0_17 vdout0_17ck12 = 0 time = 65
* CHECK dout0_18 vdout0_18ck12 = 1.0 time = 65
* CHECK dout0_19 vdout0_19ck12 = 1.0 time = 65
* CHECK dout0_20 vdout0_20ck12 = 1.0 time = 65
* CHECK dout0_21 vdout0_21ck12 = 1.0 time = 65
* CHECK dout0_22 vdout0_22ck12 = 0 time = 65
* CHECK dout0_23 vdout0_23ck12 = 1.0 time = 65
* CHECK dout0_24 vdout0_24ck12 = 1.0 time = 65
* CHECK dout0_25 vdout0_25ck12 = 0 time = 65
* CHECK dout0_26 vdout0_26ck12 = 1.0 time = 65
* CHECK dout0_27 vdout0_27ck12 = 1.0 time = 65
* CHECK dout0_28 vdout0_28ck12 = 1.0 time = 65
* CHECK dout0_29 vdout0_29ck12 = 0 time = 65
* CHECK dout0_30 vdout0_30ck12 = 1.0 time = 65
* CHECK dout0_31 vdout0_31ck12 = 1.0 time = 65
* CHECK dout0_32 vdout0_32ck12 = 0 time = 65
* CHECK dout0_33 vdout0_33ck12 = 1.0 time = 65
* CHECK dout0_34 vdout0_34ck12 = 0 time = 65
* CHECK dout0_35 vdout0_35ck12 = 1.0 time = 65
* CHECK dout0_36 vdout0_36ck12 = 0 time = 65
* CHECK dout0_37 vdout0_37ck12 = 1.0 time = 65
* CHECK dout0_38 vdout0_38ck12 = 0 time = 65
* CHECK dout0_39 vdout0_39ck12 = 1.0 time = 65
* CHECK dout0_40 vdout0_40ck12 = 0 time = 65
* CHECK dout0_41 vdout0_41ck12 = 1.0 time = 65
* CHECK dout0_42 vdout0_42ck12 = 1.0 time = 65
* CHECK dout0_43 vdout0_43ck12 = 1.0 time = 65
* CHECK dout0_44 vdout0_44ck12 = 1.0 time = 65
* CHECK dout0_45 vdout0_45ck12 = 1.0 time = 65
* CHECK dout0_46 vdout0_46ck12 = 0 time = 65
* CHECK dout0_47 vdout0_47ck12 = 1.0 time = 65
* CHECK dout0_48 vdout0_48ck12 = 1.0 time = 65
* CHECK dout0_49 vdout0_49ck12 = 0 time = 65
* CHECK dout0_50 vdout0_50ck12 = 1.0 time = 65
* CHECK dout0_51 vdout0_51ck12 = 0 time = 65
* CHECK dout0_52 vdout0_52ck12 = 1.0 time = 65
* CHECK dout0_53 vdout0_53ck12 = 0 time = 65
* CHECK dout0_54 vdout0_54ck12 = 1.0 time = 65
* CHECK dout0_55 vdout0_55ck12 = 1.0 time = 65
* CHECK dout0_56 vdout0_56ck12 = 1.0 time = 65
* CHECK dout0_57 vdout0_57ck12 = 1.0 time = 65
* CHECK dout0_58 vdout0_58ck12 = 1.0 time = 65
* CHECK dout0_59 vdout0_59ck12 = 1.0 time = 65
* CHECK dout0_60 vdout0_60ck12 = 1.0 time = 65
* CHECK dout0_61 vdout0_61ck12 = 1.0 time = 65
* CHECK dout0_62 vdout0_62ck12 = 1.0 time = 65
* CHECK dout0_63 vdout0_63ck12 = 0 time = 65
* CHECK dout1_0 vdout1_0ck13 = 0 time = 70
* CHECK dout1_1 vdout1_1ck13 = 0 time = 70
* CHECK dout1_2 vdout1_2ck13 = 1.0 time = 70
* CHECK dout1_3 vdout1_3ck13 = 1.0 time = 70
* CHECK dout1_4 vdout1_4ck13 = 0 time = 70
* CHECK dout1_5 vdout1_5ck13 = 1.0 time = 70
* CHECK dout1_6 vdout1_6ck13 = 0 time = 70
* CHECK dout1_7 vdout1_7ck13 = 0 time = 70
* CHECK dout1_8 vdout1_8ck13 = 0 time = 70
* CHECK dout1_9 vdout1_9ck13 = 1.0 time = 70
* CHECK dout1_10 vdout1_10ck13 = 0 time = 70
* CHECK dout1_11 vdout1_11ck13 = 1.0 time = 70
* CHECK dout1_12 vdout1_12ck13 = 1.0 time = 70
* CHECK dout1_13 vdout1_13ck13 = 0 time = 70
* CHECK dout1_14 vdout1_14ck13 = 1.0 time = 70
* CHECK dout1_15 vdout1_15ck13 = 1.0 time = 70
* CHECK dout1_16 vdout1_16ck13 = 1.0 time = 70
* CHECK dout1_17 vdout1_17ck13 = 1.0 time = 70
* CHECK dout1_18 vdout1_18ck13 = 1.0 time = 70
* CHECK dout1_19 vdout1_19ck13 = 0 time = 70
* CHECK dout1_20 vdout1_20ck13 = 1.0 time = 70
* CHECK dout1_21 vdout1_21ck13 = 0 time = 70
* CHECK dout1_22 vdout1_22ck13 = 0 time = 70
* CHECK dout1_23 vdout1_23ck13 = 1.0 time = 70
* CHECK dout1_24 vdout1_24ck13 = 1.0 time = 70
* CHECK dout1_25 vdout1_25ck13 = 0 time = 70
* CHECK dout1_26 vdout1_26ck13 = 0 time = 70
* CHECK dout1_27 vdout1_27ck13 = 1.0 time = 70
* CHECK dout1_28 vdout1_28ck13 = 1.0 time = 70
* CHECK dout1_29 vdout1_29ck13 = 1.0 time = 70
* CHECK dout1_30 vdout1_30ck13 = 1.0 time = 70
* CHECK dout1_31 vdout1_31ck13 = 1.0 time = 70
* CHECK dout1_32 vdout1_32ck13 = 1.0 time = 70
* CHECK dout1_33 vdout1_33ck13 = 1.0 time = 70
* CHECK dout1_34 vdout1_34ck13 = 1.0 time = 70
* CHECK dout1_35 vdout1_35ck13 = 0 time = 70
* CHECK dout1_36 vdout1_36ck13 = 0 time = 70
* CHECK dout1_37 vdout1_37ck13 = 1.0 time = 70
* CHECK dout1_38 vdout1_38ck13 = 0 time = 70
* CHECK dout1_39 vdout1_39ck13 = 0 time = 70
* CHECK dout1_40 vdout1_40ck13 = 0 time = 70
* CHECK dout1_41 vdout1_41ck13 = 0 time = 70
* CHECK dout1_42 vdout1_42ck13 = 1.0 time = 70
* CHECK dout1_43 vdout1_43ck13 = 1.0 time = 70
* CHECK dout1_44 vdout1_44ck13 = 0 time = 70
* CHECK dout1_45 vdout1_45ck13 = 1.0 time = 70
* CHECK dout1_46 vdout1_46ck13 = 1.0 time = 70
* CHECK dout1_47 vdout1_47ck13 = 1.0 time = 70
* CHECK dout1_48 vdout1_48ck13 = 1.0 time = 70
* CHECK dout1_49 vdout1_49ck13 = 0 time = 70
* CHECK dout1_50 vdout1_50ck13 = 1.0 time = 70
* CHECK dout1_51 vdout1_51ck13 = 1.0 time = 70
* CHECK dout1_52 vdout1_52ck13 = 0 time = 70
* CHECK dout1_53 vdout1_53ck13 = 1.0 time = 70
* CHECK dout1_54 vdout1_54ck13 = 0 time = 70
* CHECK dout1_55 vdout1_55ck13 = 0 time = 70
* CHECK dout1_56 vdout1_56ck13 = 1.0 time = 70
* CHECK dout1_57 vdout1_57ck13 = 0 time = 70
* CHECK dout1_58 vdout1_58ck13 = 0 time = 70
* CHECK dout1_59 vdout1_59ck13 = 0 time = 70
* CHECK dout1_60 vdout1_60ck13 = 1.0 time = 70
* CHECK dout1_61 vdout1_61ck13 = 0 time = 70
* CHECK dout1_62 vdout1_62ck13 = 1.0 time = 70
* CHECK dout1_63 vdout1_63ck13 = 1.0 time = 70
* CHECK dout0_0 vdout0_0ck14 = 0 time = 75
* CHECK dout0_1 vdout0_1ck14 = 0 time = 75
* CHECK dout0_2 vdout0_2ck14 = 1.0 time = 75
* CHECK dout0_3 vdout0_3ck14 = 1.0 time = 75
* CHECK dout0_4 vdout0_4ck14 = 0 time = 75
* CHECK dout0_5 vdout0_5ck14 = 1.0 time = 75
* CHECK dout0_6 vdout0_6ck14 = 0 time = 75
* CHECK dout0_7 vdout0_7ck14 = 0 time = 75
* CHECK dout0_8 vdout0_8ck14 = 0 time = 75
* CHECK dout0_9 vdout0_9ck14 = 1.0 time = 75
* CHECK dout0_10 vdout0_10ck14 = 0 time = 75
* CHECK dout0_11 vdout0_11ck14 = 1.0 time = 75
* CHECK dout0_12 vdout0_12ck14 = 1.0 time = 75
* CHECK dout0_13 vdout0_13ck14 = 0 time = 75
* CHECK dout0_14 vdout0_14ck14 = 1.0 time = 75
* CHECK dout0_15 vdout0_15ck14 = 1.0 time = 75
* CHECK dout0_16 vdout0_16ck14 = 1.0 time = 75
* CHECK dout0_17 vdout0_17ck14 = 1.0 time = 75
* CHECK dout0_18 vdout0_18ck14 = 1.0 time = 75
* CHECK dout0_19 vdout0_19ck14 = 0 time = 75
* CHECK dout0_20 vdout0_20ck14 = 1.0 time = 75
* CHECK dout0_21 vdout0_21ck14 = 0 time = 75
* CHECK dout0_22 vdout0_22ck14 = 0 time = 75
* CHECK dout0_23 vdout0_23ck14 = 1.0 time = 75
* CHECK dout0_24 vdout0_24ck14 = 1.0 time = 75
* CHECK dout0_25 vdout0_25ck14 = 0 time = 75
* CHECK dout0_26 vdout0_26ck14 = 0 time = 75
* CHECK dout0_27 vdout0_27ck14 = 1.0 time = 75
* CHECK dout0_28 vdout0_28ck14 = 1.0 time = 75
* CHECK dout0_29 vdout0_29ck14 = 1.0 time = 75
* CHECK dout0_30 vdout0_30ck14 = 1.0 time = 75
* CHECK dout0_31 vdout0_31ck14 = 1.0 time = 75
* CHECK dout0_32 vdout0_32ck14 = 1.0 time = 75
* CHECK dout0_33 vdout0_33ck14 = 1.0 time = 75
* CHECK dout0_34 vdout0_34ck14 = 1.0 time = 75
* CHECK dout0_35 vdout0_35ck14 = 0 time = 75
* CHECK dout0_36 vdout0_36ck14 = 0 time = 75
* CHECK dout0_37 vdout0_37ck14 = 1.0 time = 75
* CHECK dout0_38 vdout0_38ck14 = 0 time = 75
* CHECK dout0_39 vdout0_39ck14 = 0 time = 75
* CHECK dout0_40 vdout0_40ck14 = 0 time = 75
* CHECK dout0_41 vdout0_41ck14 = 0 time = 75
* CHECK dout0_42 vdout0_42ck14 = 1.0 time = 75
* CHECK dout0_43 vdout0_43ck14 = 1.0 time = 75
* CHECK dout0_44 vdout0_44ck14 = 0 time = 75
* CHECK dout0_45 vdout0_45ck14 = 1.0 time = 75
* CHECK dout0_46 vdout0_46ck14 = 1.0 time = 75
* CHECK dout0_47 vdout0_47ck14 = 1.0 time = 75
* CHECK dout0_48 vdout0_48ck14 = 1.0 time = 75
* CHECK dout0_49 vdout0_49ck14 = 0 time = 75
* CHECK dout0_50 vdout0_50ck14 = 1.0 time = 75
* CHECK dout0_51 vdout0_51ck14 = 1.0 time = 75
* CHECK dout0_52 vdout0_52ck14 = 0 time = 75
* CHECK dout0_53 vdout0_53ck14 = 1.0 time = 75
* CHECK dout0_54 vdout0_54ck14 = 0 time = 75
* CHECK dout0_55 vdout0_55ck14 = 0 time = 75
* CHECK dout0_56 vdout0_56ck14 = 1.0 time = 75
* CHECK dout0_57 vdout0_57ck14 = 0 time = 75
* CHECK dout0_58 vdout0_58ck14 = 0 time = 75
* CHECK dout0_59 vdout0_59ck14 = 0 time = 75
* CHECK dout0_60 vdout0_60ck14 = 1.0 time = 75
* CHECK dout0_61 vdout0_61ck14 = 0 time = 75
* CHECK dout0_62 vdout0_62ck14 = 1.0 time = 75
* CHECK dout0_63 vdout0_63ck14 = 1.0 time = 75
* CHECK dout1_0 vdout1_0ck14 = 0 time = 75
* CHECK dout1_1 vdout1_1ck14 = 0 time = 75
* CHECK dout1_2 vdout1_2ck14 = 1.0 time = 75
* CHECK dout1_3 vdout1_3ck14 = 1.0 time = 75
* CHECK dout1_4 vdout1_4ck14 = 0 time = 75
* CHECK dout1_5 vdout1_5ck14 = 1.0 time = 75
* CHECK dout1_6 vdout1_6ck14 = 0 time = 75
* CHECK dout1_7 vdout1_7ck14 = 0 time = 75
* CHECK dout1_8 vdout1_8ck14 = 0 time = 75
* CHECK dout1_9 vdout1_9ck14 = 1.0 time = 75
* CHECK dout1_10 vdout1_10ck14 = 0 time = 75
* CHECK dout1_11 vdout1_11ck14 = 1.0 time = 75
* CHECK dout1_12 vdout1_12ck14 = 1.0 time = 75
* CHECK dout1_13 vdout1_13ck14 = 0 time = 75
* CHECK dout1_14 vdout1_14ck14 = 1.0 time = 75
* CHECK dout1_15 vdout1_15ck14 = 1.0 time = 75
* CHECK dout1_16 vdout1_16ck14 = 1.0 time = 75
* CHECK dout1_17 vdout1_17ck14 = 1.0 time = 75
* CHECK dout1_18 vdout1_18ck14 = 1.0 time = 75
* CHECK dout1_19 vdout1_19ck14 = 0 time = 75
* CHECK dout1_20 vdout1_20ck14 = 1.0 time = 75
* CHECK dout1_21 vdout1_21ck14 = 0 time = 75
* CHECK dout1_22 vdout1_22ck14 = 0 time = 75
* CHECK dout1_23 vdout1_23ck14 = 1.0 time = 75
* CHECK dout1_24 vdout1_24ck14 = 1.0 time = 75
* CHECK dout1_25 vdout1_25ck14 = 0 time = 75
* CHECK dout1_26 vdout1_26ck14 = 0 time = 75
* CHECK dout1_27 vdout1_27ck14 = 1.0 time = 75
* CHECK dout1_28 vdout1_28ck14 = 1.0 time = 75
* CHECK dout1_29 vdout1_29ck14 = 1.0 time = 75
* CHECK dout1_30 vdout1_30ck14 = 1.0 time = 75
* CHECK dout1_31 vdout1_31ck14 = 1.0 time = 75
* CHECK dout1_32 vdout1_32ck14 = 1.0 time = 75
* CHECK dout1_33 vdout1_33ck14 = 1.0 time = 75
* CHECK dout1_34 vdout1_34ck14 = 1.0 time = 75
* CHECK dout1_35 vdout1_35ck14 = 0 time = 75
* CHECK dout1_36 vdout1_36ck14 = 0 time = 75
* CHECK dout1_37 vdout1_37ck14 = 1.0 time = 75
* CHECK dout1_38 vdout1_38ck14 = 0 time = 75
* CHECK dout1_39 vdout1_39ck14 = 0 time = 75
* CHECK dout1_40 vdout1_40ck14 = 0 time = 75
* CHECK dout1_41 vdout1_41ck14 = 0 time = 75
* CHECK dout1_42 vdout1_42ck14 = 1.0 time = 75
* CHECK dout1_43 vdout1_43ck14 = 1.0 time = 75
* CHECK dout1_44 vdout1_44ck14 = 0 time = 75
* CHECK dout1_45 vdout1_45ck14 = 1.0 time = 75
* CHECK dout1_46 vdout1_46ck14 = 1.0 time = 75
* CHECK dout1_47 vdout1_47ck14 = 1.0 time = 75
* CHECK dout1_48 vdout1_48ck14 = 1.0 time = 75
* CHECK dout1_49 vdout1_49ck14 = 0 time = 75
* CHECK dout1_50 vdout1_50ck14 = 1.0 time = 75
* CHECK dout1_51 vdout1_51ck14 = 1.0 time = 75
* CHECK dout1_52 vdout1_52ck14 = 0 time = 75
* CHECK dout1_53 vdout1_53ck14 = 1.0 time = 75
* CHECK dout1_54 vdout1_54ck14 = 0 time = 75
* CHECK dout1_55 vdout1_55ck14 = 0 time = 75
* CHECK dout1_56 vdout1_56ck14 = 1.0 time = 75
* CHECK dout1_57 vdout1_57ck14 = 0 time = 75
* CHECK dout1_58 vdout1_58ck14 = 0 time = 75
* CHECK dout1_59 vdout1_59ck14 = 0 time = 75
* CHECK dout1_60 vdout1_60ck14 = 1.0 time = 75
* CHECK dout1_61 vdout1_61ck14 = 0 time = 75
* CHECK dout1_62 vdout1_62ck14 = 1.0 time = 75
* CHECK dout1_63 vdout1_63ck14 = 1.0 time = 75
* CHECK dout0_0 vdout0_0ck15 = 0 time = 80
* CHECK dout0_1 vdout0_1ck15 = 1.0 time = 80
* CHECK dout0_2 vdout0_2ck15 = 1.0 time = 80
* CHECK dout0_3 vdout0_3ck15 = 0 time = 80
* CHECK dout0_4 vdout0_4ck15 = 1.0 time = 80
* CHECK dout0_5 vdout0_5ck15 = 0 time = 80
* CHECK dout0_6 vdout0_6ck15 = 0 time = 80
* CHECK dout0_7 vdout0_7ck15 = 1.0 time = 80
* CHECK dout0_8 vdout0_8ck15 = 0 time = 80
* CHECK dout0_9 vdout0_9ck15 = 0 time = 80
* CHECK dout0_10 vdout0_10ck15 = 1.0 time = 80
* CHECK dout0_11 vdout0_11ck15 = 1.0 time = 80
* CHECK dout0_12 vdout0_12ck15 = 1.0 time = 80
* CHECK dout0_13 vdout0_13ck15 = 1.0 time = 80
* CHECK dout0_14 vdout0_14ck15 = 0 time = 80
* CHECK dout0_15 vdout0_15ck15 = 0 time = 80
* CHECK dout0_16 vdout0_16ck15 = 1.0 time = 80
* CHECK dout0_17 vdout0_17ck15 = 1.0 time = 80
* CHECK dout0_18 vdout0_18ck15 = 0 time = 80
* CHECK dout0_19 vdout0_19ck15 = 0 time = 80
* CHECK dout0_20 vdout0_20ck15 = 0 time = 80
* CHECK dout0_21 vdout0_21ck15 = 0 time = 80
* CHECK dout0_22 vdout0_22ck15 = 1.0 time = 80
* CHECK dout0_23 vdout0_23ck15 = 0 time = 80
* CHECK dout0_24 vdout0_24ck15 = 0 time = 80
* CHECK dout0_25 vdout0_25ck15 = 1.0 time = 80
* CHECK dout0_26 vdout0_26ck15 = 0 time = 80
* CHECK dout0_27 vdout0_27ck15 = 1.0 time = 80
* CHECK dout0_28 vdout0_28ck15 = 0 time = 80
* CHECK dout0_29 vdout0_29ck15 = 1.0 time = 80
* CHECK dout0_30 vdout0_30ck15 = 1.0 time = 80
* CHECK dout0_31 vdout0_31ck15 = 0 time = 80
* CHECK dout0_32 vdout0_32ck15 = 0 time = 80
* CHECK dout0_33 vdout0_33ck15 = 0 time = 80
* CHECK dout0_34 vdout0_34ck15 = 1.0 time = 80
* CHECK dout0_35 vdout0_35ck15 = 0 time = 80
* CHECK dout0_36 vdout0_36ck15 = 1.0 time = 80
* CHECK dout0_37 vdout0_37ck15 = 0 time = 80
* CHECK dout0_38 vdout0_38ck15 = 0 time = 80
* CHECK dout0_39 vdout0_39ck15 = 1.0 time = 80
* CHECK dout0_40 vdout0_40ck15 = 0 time = 80
* CHECK dout0_41 vdout0_41ck15 = 0 time = 80
* CHECK dout0_42 vdout0_42ck15 = 1.0 time = 80
* CHECK dout0_43 vdout0_43ck15 = 1.0 time = 80
* CHECK dout0_44 vdout0_44ck15 = 1.0 time = 80
* CHECK dout0_45 vdout0_45ck15 = 1.0 time = 80
* CHECK dout0_46 vdout0_46ck15 = 0 time = 80
* CHECK dout0_47 vdout0_47ck15 = 1.0 time = 80
* CHECK dout0_48 vdout0_48ck15 = 1.0 time = 80
* CHECK dout0_49 vdout0_49ck15 = 0 time = 80
* CHECK dout0_50 vdout0_50ck15 = 1.0 time = 80
* CHECK dout0_51 vdout0_51ck15 = 1.0 time = 80
* CHECK dout0_52 vdout0_52ck15 = 1.0 time = 80
* CHECK dout0_53 vdout0_53ck15 = 0 time = 80
* CHECK dout0_54 vdout0_54ck15 = 0 time = 80
* CHECK dout0_55 vdout0_55ck15 = 0 time = 80
* CHECK dout0_56 vdout0_56ck15 = 1.0 time = 80
* CHECK dout0_57 vdout0_57ck15 = 0 time = 80
* CHECK dout0_58 vdout0_58ck15 = 1.0 time = 80
* CHECK dout0_59 vdout0_59ck15 = 1.0 time = 80
* CHECK dout0_60 vdout0_60ck15 = 0 time = 80
* CHECK dout0_61 vdout0_61ck15 = 0 time = 80
* CHECK dout0_62 vdout0_62ck15 = 0 time = 80
* CHECK dout0_63 vdout0_63ck15 = 0 time = 80
* CHECK dout1_0 vdout1_0ck15 = 0 time = 80
* CHECK dout1_1 vdout1_1ck15 = 1.0 time = 80
* CHECK dout1_2 vdout1_2ck15 = 1.0 time = 80
* CHECK dout1_3 vdout1_3ck15 = 0 time = 80
* CHECK dout1_4 vdout1_4ck15 = 1.0 time = 80
* CHECK dout1_5 vdout1_5ck15 = 0 time = 80
* CHECK dout1_6 vdout1_6ck15 = 0 time = 80
* CHECK dout1_7 vdout1_7ck15 = 1.0 time = 80
* CHECK dout1_8 vdout1_8ck15 = 0 time = 80
* CHECK dout1_9 vdout1_9ck15 = 1.0 time = 80
* CHECK dout1_10 vdout1_10ck15 = 1.0 time = 80
* CHECK dout1_11 vdout1_11ck15 = 1.0 time = 80
* CHECK dout1_12 vdout1_12ck15 = 1.0 time = 80
* CHECK dout1_13 vdout1_13ck15 = 1.0 time = 80
* CHECK dout1_14 vdout1_14ck15 = 1.0 time = 80
* CHECK dout1_15 vdout1_15ck15 = 0 time = 80
* CHECK dout1_16 vdout1_16ck15 = 0 time = 80
* CHECK dout1_17 vdout1_17ck15 = 1.0 time = 80
* CHECK dout1_18 vdout1_18ck15 = 1.0 time = 80
* CHECK dout1_19 vdout1_19ck15 = 0 time = 80
* CHECK dout1_20 vdout1_20ck15 = 0 time = 80
* CHECK dout1_21 vdout1_21ck15 = 0 time = 80
* CHECK dout1_22 vdout1_22ck15 = 0 time = 80
* CHECK dout1_23 vdout1_23ck15 = 1.0 time = 80
* CHECK dout1_24 vdout1_24ck15 = 0 time = 80
* CHECK dout1_25 vdout1_25ck15 = 1.0 time = 80
* CHECK dout1_26 vdout1_26ck15 = 1.0 time = 80
* CHECK dout1_27 vdout1_27ck15 = 1.0 time = 80
* CHECK dout1_28 vdout1_28ck15 = 0 time = 80
* CHECK dout1_29 vdout1_29ck15 = 0 time = 80
* CHECK dout1_30 vdout1_30ck15 = 1.0 time = 80
* CHECK dout1_31 vdout1_31ck15 = 1.0 time = 80
* CHECK dout1_32 vdout1_32ck15 = 1.0 time = 80
* CHECK dout1_33 vdout1_33ck15 = 0 time = 80
* CHECK dout1_34 vdout1_34ck15 = 1.0 time = 80
* CHECK dout1_35 vdout1_35ck15 = 0 time = 80
* CHECK dout1_36 vdout1_36ck15 = 0 time = 80
* CHECK dout1_37 vdout1_37ck15 = 0 time = 80
* CHECK dout1_38 vdout1_38ck15 = 1.0 time = 80
* CHECK dout1_39 vdout1_39ck15 = 1.0 time = 80
* CHECK dout1_40 vdout1_40ck15 = 1.0 time = 80
* CHECK dout1_41 vdout1_41ck15 = 0 time = 80
* CHECK dout1_42 vdout1_42ck15 = 1.0 time = 80
* CHECK dout1_43 vdout1_43ck15 = 1.0 time = 80
* CHECK dout1_44 vdout1_44ck15 = 1.0 time = 80
* CHECK dout1_45 vdout1_45ck15 = 0 time = 80
* CHECK dout1_46 vdout1_46ck15 = 0 time = 80
* CHECK dout1_47 vdout1_47ck15 = 0 time = 80
* CHECK dout1_48 vdout1_48ck15 = 1.0 time = 80
* CHECK dout1_49 vdout1_49ck15 = 1.0 time = 80
* CHECK dout1_50 vdout1_50ck15 = 0 time = 80
* CHECK dout1_51 vdout1_51ck15 = 1.0 time = 80
* CHECK dout1_52 vdout1_52ck15 = 1.0 time = 80
* CHECK dout1_53 vdout1_53ck15 = 0 time = 80
* CHECK dout1_54 vdout1_54ck15 = 0 time = 80
* CHECK dout1_55 vdout1_55ck15 = 0 time = 80
* CHECK dout1_56 vdout1_56ck15 = 0 time = 80
* CHECK dout1_57 vdout1_57ck15 = 0 time = 80
* CHECK dout1_58 vdout1_58ck15 = 1.0 time = 80
* CHECK dout1_59 vdout1_59ck15 = 0 time = 80
* CHECK dout1_60 vdout1_60ck15 = 1.0 time = 80
* CHECK dout1_61 vdout1_61ck15 = 0 time = 80
* CHECK dout1_62 vdout1_62ck15 = 0 time = 80
* CHECK dout1_63 vdout1_63ck15 = 0 time = 80
* CHECK dout0_0 vdout0_0ck16 = 0 time = 85
* CHECK dout0_1 vdout0_1ck16 = 0 time = 85
* CHECK dout0_2 vdout0_2ck16 = 1.0 time = 85
* CHECK dout0_3 vdout0_3ck16 = 1.0 time = 85
* CHECK dout0_4 vdout0_4ck16 = 0 time = 85
* CHECK dout0_5 vdout0_5ck16 = 1.0 time = 85
* CHECK dout0_6 vdout0_6ck16 = 0 time = 85
* CHECK dout0_7 vdout0_7ck16 = 0 time = 85
* CHECK dout0_8 vdout0_8ck16 = 0 time = 85
* CHECK dout0_9 vdout0_9ck16 = 1.0 time = 85
* CHECK dout0_10 vdout0_10ck16 = 0 time = 85
* CHECK dout0_11 vdout0_11ck16 = 1.0 time = 85
* CHECK dout0_12 vdout0_12ck16 = 1.0 time = 85
* CHECK dout0_13 vdout0_13ck16 = 0 time = 85
* CHECK dout0_14 vdout0_14ck16 = 1.0 time = 85
* CHECK dout0_15 vdout0_15ck16 = 1.0 time = 85
* CHECK dout0_16 vdout0_16ck16 = 1.0 time = 85
* CHECK dout0_17 vdout0_17ck16 = 1.0 time = 85
* CHECK dout0_18 vdout0_18ck16 = 1.0 time = 85
* CHECK dout0_19 vdout0_19ck16 = 0 time = 85
* CHECK dout0_20 vdout0_20ck16 = 1.0 time = 85
* CHECK dout0_21 vdout0_21ck16 = 0 time = 85
* CHECK dout0_22 vdout0_22ck16 = 0 time = 85
* CHECK dout0_23 vdout0_23ck16 = 1.0 time = 85
* CHECK dout0_24 vdout0_24ck16 = 1.0 time = 85
* CHECK dout0_25 vdout0_25ck16 = 0 time = 85
* CHECK dout0_26 vdout0_26ck16 = 0 time = 85
* CHECK dout0_27 vdout0_27ck16 = 1.0 time = 85
* CHECK dout0_28 vdout0_28ck16 = 1.0 time = 85
* CHECK dout0_29 vdout0_29ck16 = 1.0 time = 85
* CHECK dout0_30 vdout0_30ck16 = 1.0 time = 85
* CHECK dout0_31 vdout0_31ck16 = 1.0 time = 85
* CHECK dout0_32 vdout0_32ck16 = 1.0 time = 85
* CHECK dout0_33 vdout0_33ck16 = 1.0 time = 85
* CHECK dout0_34 vdout0_34ck16 = 1.0 time = 85
* CHECK dout0_35 vdout0_35ck16 = 0 time = 85
* CHECK dout0_36 vdout0_36ck16 = 0 time = 85
* CHECK dout0_37 vdout0_37ck16 = 1.0 time = 85
* CHECK dout0_38 vdout0_38ck16 = 0 time = 85
* CHECK dout0_39 vdout0_39ck16 = 0 time = 85
* CHECK dout0_40 vdout0_40ck16 = 0 time = 85
* CHECK dout0_41 vdout0_41ck16 = 0 time = 85
* CHECK dout0_42 vdout0_42ck16 = 1.0 time = 85
* CHECK dout0_43 vdout0_43ck16 = 1.0 time = 85
* CHECK dout0_44 vdout0_44ck16 = 0 time = 85
* CHECK dout0_45 vdout0_45ck16 = 1.0 time = 85
* CHECK dout0_46 vdout0_46ck16 = 1.0 time = 85
* CHECK dout0_47 vdout0_47ck16 = 1.0 time = 85
* CHECK dout0_48 vdout0_48ck16 = 1.0 time = 85
* CHECK dout0_49 vdout0_49ck16 = 0 time = 85
* CHECK dout0_50 vdout0_50ck16 = 1.0 time = 85
* CHECK dout0_51 vdout0_51ck16 = 1.0 time = 85
* CHECK dout0_52 vdout0_52ck16 = 0 time = 85
* CHECK dout0_53 vdout0_53ck16 = 1.0 time = 85
* CHECK dout0_54 vdout0_54ck16 = 0 time = 85
* CHECK dout0_55 vdout0_55ck16 = 0 time = 85
* CHECK dout0_56 vdout0_56ck16 = 1.0 time = 85
* CHECK dout0_57 vdout0_57ck16 = 0 time = 85
* CHECK dout0_58 vdout0_58ck16 = 0 time = 85
* CHECK dout0_59 vdout0_59ck16 = 0 time = 85
* CHECK dout0_60 vdout0_60ck16 = 1.0 time = 85
* CHECK dout0_61 vdout0_61ck16 = 0 time = 85
* CHECK dout0_62 vdout0_62ck16 = 1.0 time = 85
* CHECK dout0_63 vdout0_63ck16 = 1.0 time = 85
* CHECK dout1_0 vdout1_0ck17 = 1.0 time = 90
* CHECK dout1_1 vdout1_1ck17 = 0 time = 90
* CHECK dout1_2 vdout1_2ck17 = 1.0 time = 90
* CHECK dout1_3 vdout1_3ck17 = 0 time = 90
* CHECK dout1_4 vdout1_4ck17 = 0 time = 90
* CHECK dout1_5 vdout1_5ck17 = 0 time = 90
* CHECK dout1_6 vdout1_6ck17 = 1.0 time = 90
* CHECK dout1_7 vdout1_7ck17 = 0 time = 90
* CHECK dout1_8 vdout1_8ck17 = 0 time = 90
* CHECK dout1_9 vdout1_9ck17 = 0 time = 90
* CHECK dout1_10 vdout1_10ck17 = 1.0 time = 90
* CHECK dout1_11 vdout1_11ck17 = 1.0 time = 90
* CHECK dout1_12 vdout1_12ck17 = 0 time = 90
* CHECK dout1_13 vdout1_13ck17 = 0 time = 90
* CHECK dout1_14 vdout1_14ck17 = 1.0 time = 90
* CHECK dout1_15 vdout1_15ck17 = 0 time = 90
* CHECK dout1_16 vdout1_16ck17 = 1.0 time = 90
* CHECK dout1_17 vdout1_17ck17 = 1.0 time = 90
* CHECK dout1_18 vdout1_18ck17 = 1.0 time = 90
* CHECK dout1_19 vdout1_19ck17 = 1.0 time = 90
* CHECK dout1_20 vdout1_20ck17 = 0 time = 90
* CHECK dout1_21 vdout1_21ck17 = 1.0 time = 90
* CHECK dout1_22 vdout1_22ck17 = 1.0 time = 90
* CHECK dout1_23 vdout1_23ck17 = 0 time = 90
* CHECK dout1_24 vdout1_24ck17 = 1.0 time = 90
* CHECK dout1_25 vdout1_25ck17 = 1.0 time = 90
* CHECK dout1_26 vdout1_26ck17 = 1.0 time = 90
* CHECK dout1_27 vdout1_27ck17 = 0 time = 90
* CHECK dout1_28 vdout1_28ck17 = 1.0 time = 90
* CHECK dout1_29 vdout1_29ck17 = 0 time = 90
* CHECK dout1_30 vdout1_30ck17 = 0 time = 90
* CHECK dout1_31 vdout1_31ck17 = 1.0 time = 90
* CHECK dout1_32 vdout1_32ck17 = 1.0 time = 90
* CHECK dout1_33 vdout1_33ck17 = 1.0 time = 90
* CHECK dout1_34 vdout1_34ck17 = 1.0 time = 90
* CHECK dout1_35 vdout1_35ck17 = 0 time = 90
* CHECK dout1_36 vdout1_36ck17 = 1.0 time = 90
* CHECK dout1_37 vdout1_37ck17 = 1.0 time = 90
* CHECK dout1_38 vdout1_38ck17 = 0 time = 90
* CHECK dout1_39 vdout1_39ck17 = 0 time = 90
* CHECK dout1_40 vdout1_40ck17 = 0 time = 90
* CHECK dout1_41 vdout1_41ck17 = 1.0 time = 90
* CHECK dout1_42 vdout1_42ck17 = 1.0 time = 90
* CHECK dout1_43 vdout1_43ck17 = 1.0 time = 90
* CHECK dout1_44 vdout1_44ck17 = 0 time = 90
* CHECK dout1_45 vdout1_45ck17 = 1.0 time = 90
* CHECK dout1_46 vdout1_46ck17 = 0 time = 90
* CHECK dout1_47 vdout1_47ck17 = 1.0 time = 90
* CHECK dout1_48 vdout1_48ck17 = 1.0 time = 90
* CHECK dout1_49 vdout1_49ck17 = 1.0 time = 90
* CHECK dout1_50 vdout1_50ck17 = 0 time = 90
* CHECK dout1_51 vdout1_51ck17 = 1.0 time = 90
* CHECK dout1_52 vdout1_52ck17 = 1.0 time = 90
* CHECK dout1_53 vdout1_53ck17 = 0 time = 90
* CHECK dout1_54 vdout1_54ck17 = 0 time = 90
* CHECK dout1_55 vdout1_55ck17 = 0 time = 90
* CHECK dout1_56 vdout1_56ck17 = 1.0 time = 90
* CHECK dout1_57 vdout1_57ck17 = 1.0 time = 90
* CHECK dout1_58 vdout1_58ck17 = 0 time = 90
* CHECK dout1_59 vdout1_59ck17 = 0 time = 90
* CHECK dout1_60 vdout1_60ck17 = 1.0 time = 90
* CHECK dout1_61 vdout1_61ck17 = 0 time = 90
* CHECK dout1_62 vdout1_62ck17 = 1.0 time = 90
* CHECK dout1_63 vdout1_63ck17 = 0 time = 90
* CHECK dout0_0 vdout0_0ck18 = 1.0 time = 95
* CHECK dout0_1 vdout0_1ck18 = 0 time = 95
* CHECK dout0_2 vdout0_2ck18 = 1.0 time = 95
* CHECK dout0_3 vdout0_3ck18 = 0 time = 95
* CHECK dout0_4 vdout0_4ck18 = 1.0 time = 95
* CHECK dout0_5 vdout0_5ck18 = 1.0 time = 95
* CHECK dout0_6 vdout0_6ck18 = 0 time = 95
* CHECK dout0_7 vdout0_7ck18 = 1.0 time = 95
* CHECK dout0_8 vdout0_8ck18 = 0 time = 95
* CHECK dout0_9 vdout0_9ck18 = 1.0 time = 95
* CHECK dout0_10 vdout0_10ck18 = 1.0 time = 95
* CHECK dout0_11 vdout0_11ck18 = 1.0 time = 95
* CHECK dout0_12 vdout0_12ck18 = 0 time = 95
* CHECK dout0_13 vdout0_13ck18 = 1.0 time = 95
* CHECK dout0_14 vdout0_14ck18 = 0 time = 95
* CHECK dout0_15 vdout0_15ck18 = 1.0 time = 95
* CHECK dout0_16 vdout0_16ck18 = 1.0 time = 95
* CHECK dout0_17 vdout0_17ck18 = 1.0 time = 95
* CHECK dout0_18 vdout0_18ck18 = 1.0 time = 95
* CHECK dout0_19 vdout0_19ck18 = 1.0 time = 95
* CHECK dout0_20 vdout0_20ck18 = 1.0 time = 95
* CHECK dout0_21 vdout0_21ck18 = 0 time = 95
* CHECK dout0_22 vdout0_22ck18 = 0 time = 95
* CHECK dout0_23 vdout0_23ck18 = 0 time = 95
* CHECK dout0_24 vdout0_24ck18 = 1.0 time = 95
* CHECK dout0_25 vdout0_25ck18 = 1.0 time = 95
* CHECK dout0_26 vdout0_26ck18 = 0 time = 95
* CHECK dout0_27 vdout0_27ck18 = 1.0 time = 95
* CHECK dout0_28 vdout0_28ck18 = 0 time = 95
* CHECK dout0_29 vdout0_29ck18 = 1.0 time = 95
* CHECK dout0_30 vdout0_30ck18 = 1.0 time = 95
* CHECK dout0_31 vdout0_31ck18 = 0 time = 95
* CHECK dout0_32 vdout0_32ck18 = 0 time = 95
* CHECK dout0_33 vdout0_33ck18 = 0 time = 95
* CHECK dout0_34 vdout0_34ck18 = 1.0 time = 95
* CHECK dout0_35 vdout0_35ck18 = 0 time = 95
* CHECK dout0_36 vdout0_36ck18 = 0 time = 95
* CHECK dout0_37 vdout0_37ck18 = 1.0 time = 95
* CHECK dout0_38 vdout0_38ck18 = 1.0 time = 95
* CHECK dout0_39 vdout0_39ck18 = 0 time = 95
* CHECK dout0_40 vdout0_40ck18 = 0 time = 95
* CHECK dout0_41 vdout0_41ck18 = 1.0 time = 95
* CHECK dout0_42 vdout0_42ck18 = 1.0 time = 95
* CHECK dout0_43 vdout0_43ck18 = 1.0 time = 95
* CHECK dout0_44 vdout0_44ck18 = 1.0 time = 95
* CHECK dout0_45 vdout0_45ck18 = 0 time = 95
* CHECK dout0_46 vdout0_46ck18 = 0 time = 95
* CHECK dout0_47 vdout0_47ck18 = 1.0 time = 95
* CHECK dout0_48 vdout0_48ck18 = 0 time = 95
* CHECK dout0_49 vdout0_49ck18 = 1.0 time = 95
* CHECK dout0_50 vdout0_50ck18 = 1.0 time = 95
* CHECK dout0_51 vdout0_51ck18 = 1.0 time = 95
* CHECK dout0_52 vdout0_52ck18 = 0 time = 95
* CHECK dout0_53 vdout0_53ck18 = 0 time = 95
* CHECK dout0_54 vdout0_54ck18 = 0 time = 95
* CHECK dout0_55 vdout0_55ck18 = 0 time = 95
* CHECK dout0_56 vdout0_56ck18 = 1.0 time = 95
* CHECK dout0_57 vdout0_57ck18 = 0 time = 95
* CHECK dout0_58 vdout0_58ck18 = 1.0 time = 95
* CHECK dout0_59 vdout0_59ck18 = 1.0 time = 95
* CHECK dout0_60 vdout0_60ck18 = 1.0 time = 95
* CHECK dout0_61 vdout0_61ck18 = 0 time = 95
* CHECK dout0_62 vdout0_62ck18 = 1.0 time = 95
* CHECK dout0_63 vdout0_63ck18 = 0 time = 95
* CHECK dout0_0 vdout0_0ck19 = 1.0 time = 100
* CHECK dout0_1 vdout0_1ck19 = 1.0 time = 100
* CHECK dout0_2 vdout0_2ck19 = 0 time = 100
* CHECK dout0_3 vdout0_3ck19 = 1.0 time = 100
* CHECK dout0_4 vdout0_4ck19 = 0 time = 100
* CHECK dout0_5 vdout0_5ck19 = 1.0 time = 100
* CHECK dout0_6 vdout0_6ck19 = 0 time = 100
* CHECK dout0_7 vdout0_7ck19 = 0 time = 100
* CHECK dout0_8 vdout0_8ck19 = 0 time = 100
* CHECK dout0_9 vdout0_9ck19 = 0 time = 100
* CHECK dout0_10 vdout0_10ck19 = 0 time = 100
* CHECK dout0_11 vdout0_11ck19 = 1.0 time = 100
* CHECK dout0_12 vdout0_12ck19 = 1.0 time = 100
* CHECK dout0_13 vdout0_13ck19 = 0 time = 100
* CHECK dout0_14 vdout0_14ck19 = 0 time = 100
* CHECK dout0_15 vdout0_15ck19 = 1.0 time = 100
* CHECK dout0_16 vdout0_16ck19 = 0 time = 100
* CHECK dout0_17 vdout0_17ck19 = 0 time = 100
* CHECK dout0_18 vdout0_18ck19 = 0 time = 100
* CHECK dout0_19 vdout0_19ck19 = 0 time = 100
* CHECK dout0_20 vdout0_20ck19 = 1.0 time = 100
* CHECK dout0_21 vdout0_21ck19 = 0 time = 100
* CHECK dout0_22 vdout0_22ck19 = 0 time = 100
* CHECK dout0_23 vdout0_23ck19 = 1.0 time = 100
* CHECK dout0_24 vdout0_24ck19 = 0 time = 100
* CHECK dout0_25 vdout0_25ck19 = 0 time = 100
* CHECK dout0_26 vdout0_26ck19 = 0 time = 100
* CHECK dout0_27 vdout0_27ck19 = 1.0 time = 100
* CHECK dout0_28 vdout0_28ck19 = 0 time = 100
* CHECK dout0_29 vdout0_29ck19 = 1.0 time = 100
* CHECK dout0_30 vdout0_30ck19 = 1.0 time = 100
* CHECK dout0_31 vdout0_31ck19 = 0 time = 100
* CHECK dout0_32 vdout0_32ck19 = 1.0 time = 100
* CHECK dout0_33 vdout0_33ck19 = 1.0 time = 100
* CHECK dout0_34 vdout0_34ck19 = 1.0 time = 100
* CHECK dout0_35 vdout0_35ck19 = 0 time = 100
* CHECK dout0_36 vdout0_36ck19 = 0 time = 100
* CHECK dout0_37 vdout0_37ck19 = 0 time = 100
* CHECK dout0_38 vdout0_38ck19 = 0 time = 100
* CHECK dout0_39 vdout0_39ck19 = 1.0 time = 100
* CHECK dout0_40 vdout0_40ck19 = 1.0 time = 100
* CHECK dout0_41 vdout0_41ck19 = 1.0 time = 100
* CHECK dout0_42 vdout0_42ck19 = 1.0 time = 100
* CHECK dout0_43 vdout0_43ck19 = 1.0 time = 100
* CHECK dout0_44 vdout0_44ck19 = 1.0 time = 100
* CHECK dout0_45 vdout0_45ck19 = 0 time = 100
* CHECK dout0_46 vdout0_46ck19 = 1.0 time = 100
* CHECK dout0_47 vdout0_47ck19 = 1.0 time = 100
* CHECK dout0_48 vdout0_48ck19 = 0 time = 100
* CHECK dout0_49 vdout0_49ck19 = 0 time = 100
* CHECK dout0_50 vdout0_50ck19 = 1.0 time = 100
* CHECK dout0_51 vdout0_51ck19 = 0 time = 100
* CHECK dout0_52 vdout0_52ck19 = 0 time = 100
* CHECK dout0_53 vdout0_53ck19 = 1.0 time = 100
* CHECK dout0_54 vdout0_54ck19 = 0 time = 100
* CHECK dout0_55 vdout0_55ck19 = 1.0 time = 100
* CHECK dout0_56 vdout0_56ck19 = 1.0 time = 100
* CHECK dout0_57 vdout0_57ck19 = 1.0 time = 100
* CHECK dout0_58 vdout0_58ck19 = 1.0 time = 100
* CHECK dout0_59 vdout0_59ck19 = 0 time = 100
* CHECK dout0_60 vdout0_60ck19 = 0 time = 100
* CHECK dout0_61 vdout0_61ck19 = 0 time = 100
* CHECK dout0_62 vdout0_62ck19 = 1.0 time = 100
* CHECK dout0_63 vdout0_63ck19 = 1.0 time = 100
* CHECK dout1_0 vdout1_0ck21 = 0 time = 110
* CHECK dout1_1 vdout1_1ck21 = 1.0 time = 110
* CHECK dout1_2 vdout1_2ck21 = 1.0 time = 110
* CHECK dout1_3 vdout1_3ck21 = 0 time = 110
* CHECK dout1_4 vdout1_4ck21 = 1.0 time = 110
* CHECK dout1_5 vdout1_5ck21 = 0 time = 110
* CHECK dout1_6 vdout1_6ck21 = 0 time = 110
* CHECK dout1_7 vdout1_7ck21 = 1.0 time = 110
* CHECK dout1_8 vdout1_8ck21 = 0 time = 110
* CHECK dout1_9 vdout1_9ck21 = 0 time = 110
* CHECK dout1_10 vdout1_10ck21 = 1.0 time = 110
* CHECK dout1_11 vdout1_11ck21 = 1.0 time = 110
* CHECK dout1_12 vdout1_12ck21 = 1.0 time = 110
* CHECK dout1_13 vdout1_13ck21 = 1.0 time = 110
* CHECK dout1_14 vdout1_14ck21 = 0 time = 110
* CHECK dout1_15 vdout1_15ck21 = 0 time = 110
* CHECK dout1_16 vdout1_16ck21 = 1.0 time = 110
* CHECK dout1_17 vdout1_17ck21 = 1.0 time = 110
* CHECK dout1_18 vdout1_18ck21 = 0 time = 110
* CHECK dout1_19 vdout1_19ck21 = 0 time = 110
* CHECK dout1_20 vdout1_20ck21 = 0 time = 110
* CHECK dout1_21 vdout1_21ck21 = 0 time = 110
* CHECK dout1_22 vdout1_22ck21 = 1.0 time = 110
* CHECK dout1_23 vdout1_23ck21 = 0 time = 110
* CHECK dout1_24 vdout1_24ck21 = 0 time = 110
* CHECK dout1_25 vdout1_25ck21 = 1.0 time = 110
* CHECK dout1_26 vdout1_26ck21 = 0 time = 110
* CHECK dout1_27 vdout1_27ck21 = 1.0 time = 110
* CHECK dout1_28 vdout1_28ck21 = 0 time = 110
* CHECK dout1_29 vdout1_29ck21 = 1.0 time = 110
* CHECK dout1_30 vdout1_30ck21 = 1.0 time = 110
* CHECK dout1_31 vdout1_31ck21 = 0 time = 110
* CHECK dout1_32 vdout1_32ck21 = 0 time = 110
* CHECK dout1_33 vdout1_33ck21 = 0 time = 110
* CHECK dout1_34 vdout1_34ck21 = 1.0 time = 110
* CHECK dout1_35 vdout1_35ck21 = 0 time = 110
* CHECK dout1_36 vdout1_36ck21 = 1.0 time = 110
* CHECK dout1_37 vdout1_37ck21 = 0 time = 110
* CHECK dout1_38 vdout1_38ck21 = 0 time = 110
* CHECK dout1_39 vdout1_39ck21 = 1.0 time = 110
* CHECK dout1_40 vdout1_40ck21 = 0 time = 110
* CHECK dout1_41 vdout1_41ck21 = 0 time = 110
* CHECK dout1_42 vdout1_42ck21 = 1.0 time = 110
* CHECK dout1_43 vdout1_43ck21 = 1.0 time = 110
* CHECK dout1_44 vdout1_44ck21 = 1.0 time = 110
* CHECK dout1_45 vdout1_45ck21 = 1.0 time = 110
* CHECK dout1_46 vdout1_46ck21 = 0 time = 110
* CHECK dout1_47 vdout1_47ck21 = 1.0 time = 110
* CHECK dout1_48 vdout1_48ck21 = 1.0 time = 110
* CHECK dout1_49 vdout1_49ck21 = 0 time = 110
* CHECK dout1_50 vdout1_50ck21 = 1.0 time = 110
* CHECK dout1_51 vdout1_51ck21 = 1.0 time = 110
* CHECK dout1_52 vdout1_52ck21 = 1.0 time = 110
* CHECK dout1_53 vdout1_53ck21 = 0 time = 110
* CHECK dout1_54 vdout1_54ck21 = 0 time = 110
* CHECK dout1_55 vdout1_55ck21 = 0 time = 110
* CHECK dout1_56 vdout1_56ck21 = 1.0 time = 110
* CHECK dout1_57 vdout1_57ck21 = 0 time = 110
* CHECK dout1_58 vdout1_58ck21 = 1.0 time = 110
* CHECK dout1_59 vdout1_59ck21 = 1.0 time = 110
* CHECK dout1_60 vdout1_60ck21 = 0 time = 110
* CHECK dout1_61 vdout1_61ck21 = 0 time = 110
* CHECK dout1_62 vdout1_62ck21 = 0 time = 110
* CHECK dout1_63 vdout1_63ck21 = 0 time = 110
* CHECK dout1_0 vdout1_0ck22 = 0 time = 115
* CHECK dout1_1 vdout1_1ck22 = 1.0 time = 115
* CHECK dout1_2 vdout1_2ck22 = 0 time = 115
* CHECK dout1_3 vdout1_3ck22 = 1.0 time = 115
* CHECK dout1_4 vdout1_4ck22 = 0 time = 115
* CHECK dout1_5 vdout1_5ck22 = 0 time = 115
* CHECK dout1_6 vdout1_6ck22 = 0 time = 115
* CHECK dout1_7 vdout1_7ck22 = 1.0 time = 115
* CHECK dout1_8 vdout1_8ck22 = 1.0 time = 115
* CHECK dout1_9 vdout1_9ck22 = 0 time = 115
* CHECK dout1_10 vdout1_10ck22 = 1.0 time = 115
* CHECK dout1_11 vdout1_11ck22 = 0 time = 115
* CHECK dout1_12 vdout1_12ck22 = 1.0 time = 115
* CHECK dout1_13 vdout1_13ck22 = 0 time = 115
* CHECK dout1_14 vdout1_14ck22 = 1.0 time = 115
* CHECK dout1_15 vdout1_15ck22 = 0 time = 115
* CHECK dout1_16 vdout1_16ck22 = 1.0 time = 115
* CHECK dout1_17 vdout1_17ck22 = 1.0 time = 115
* CHECK dout1_18 vdout1_18ck22 = 1.0 time = 115
* CHECK dout1_19 vdout1_19ck22 = 1.0 time = 115
* CHECK dout1_20 vdout1_20ck22 = 0 time = 115
* CHECK dout1_21 vdout1_21ck22 = 0 time = 115
* CHECK dout1_22 vdout1_22ck22 = 0 time = 115
* CHECK dout1_23 vdout1_23ck22 = 1.0 time = 115
* CHECK dout1_24 vdout1_24ck22 = 1.0 time = 115
* CHECK dout1_25 vdout1_25ck22 = 1.0 time = 115
* CHECK dout1_26 vdout1_26ck22 = 1.0 time = 115
* CHECK dout1_27 vdout1_27ck22 = 0 time = 115
* CHECK dout1_28 vdout1_28ck22 = 1.0 time = 115
* CHECK dout1_29 vdout1_29ck22 = 1.0 time = 115
* CHECK dout1_30 vdout1_30ck22 = 1.0 time = 115
* CHECK dout1_31 vdout1_31ck22 = 1.0 time = 115
* CHECK dout1_32 vdout1_32ck22 = 0 time = 115
* CHECK dout1_33 vdout1_33ck22 = 1.0 time = 115
* CHECK dout1_34 vdout1_34ck22 = 1.0 time = 115
* CHECK dout1_35 vdout1_35ck22 = 1.0 time = 115
* CHECK dout1_36 vdout1_36ck22 = 1.0 time = 115
* CHECK dout1_37 vdout1_37ck22 = 0 time = 115
* CHECK dout1_38 vdout1_38ck22 = 0 time = 115
* CHECK dout1_39 vdout1_39ck22 = 1.0 time = 115
* CHECK dout1_40 vdout1_40ck22 = 1.0 time = 115
* CHECK dout1_41 vdout1_41ck22 = 0 time = 115
* CHECK dout1_42 vdout1_42ck22 = 1.0 time = 115
* CHECK dout1_43 vdout1_43ck22 = 0 time = 115
* CHECK dout1_44 vdout1_44ck22 = 1.0 time = 115
* CHECK dout1_45 vdout1_45ck22 = 1.0 time = 115
* CHECK dout1_46 vdout1_46ck22 = 0 time = 115
* CHECK dout1_47 vdout1_47ck22 = 0 time = 115
* CHECK dout1_48 vdout1_48ck22 = 0 time = 115
* CHECK dout1_49 vdout1_49ck22 = 0 time = 115
* CHECK dout1_50 vdout1_50ck22 = 1.0 time = 115
* CHECK dout1_51 vdout1_51ck22 = 0 time = 115
* CHECK dout1_52 vdout1_52ck22 = 0 time = 115
* CHECK dout1_53 vdout1_53ck22 = 1.0 time = 115
* CHECK dout1_54 vdout1_54ck22 = 1.0 time = 115
* CHECK dout1_55 vdout1_55ck22 = 1.0 time = 115
* CHECK dout1_56 vdout1_56ck22 = 0 time = 115
* CHECK dout1_57 vdout1_57ck22 = 1.0 time = 115
* CHECK dout1_58 vdout1_58ck22 = 0 time = 115
* CHECK dout1_59 vdout1_59ck22 = 0 time = 115
* CHECK dout1_60 vdout1_60ck22 = 0 time = 115
* CHECK dout1_61 vdout1_61ck22 = 1.0 time = 115
* CHECK dout1_62 vdout1_62ck22 = 1.0 time = 115
* CHECK dout1_63 vdout1_63ck22 = 0 time = 115
* CHECK dout0_0 vdout0_0ck24 = 0 time = 125
* CHECK dout0_1 vdout0_1ck24 = 0 time = 125
* CHECK dout0_2 vdout0_2ck24 = 1.0 time = 125
* CHECK dout0_3 vdout0_3ck24 = 1.0 time = 125
* CHECK dout0_4 vdout0_4ck24 = 0 time = 125
* CHECK dout0_5 vdout0_5ck24 = 1.0 time = 125
* CHECK dout0_6 vdout0_6ck24 = 0 time = 125
* CHECK dout0_7 vdout0_7ck24 = 0 time = 125
* CHECK dout0_8 vdout0_8ck24 = 0 time = 125
* CHECK dout0_9 vdout0_9ck24 = 1.0 time = 125
* CHECK dout0_10 vdout0_10ck24 = 0 time = 125
* CHECK dout0_11 vdout0_11ck24 = 1.0 time = 125
* CHECK dout0_12 vdout0_12ck24 = 1.0 time = 125
* CHECK dout0_13 vdout0_13ck24 = 0 time = 125
* CHECK dout0_14 vdout0_14ck24 = 1.0 time = 125
* CHECK dout0_15 vdout0_15ck24 = 1.0 time = 125
* CHECK dout0_16 vdout0_16ck24 = 1.0 time = 125
* CHECK dout0_17 vdout0_17ck24 = 1.0 time = 125
* CHECK dout0_18 vdout0_18ck24 = 1.0 time = 125
* CHECK dout0_19 vdout0_19ck24 = 0 time = 125
* CHECK dout0_20 vdout0_20ck24 = 1.0 time = 125
* CHECK dout0_21 vdout0_21ck24 = 0 time = 125
* CHECK dout0_22 vdout0_22ck24 = 0 time = 125
* CHECK dout0_23 vdout0_23ck24 = 1.0 time = 125
* CHECK dout0_24 vdout0_24ck24 = 1.0 time = 125
* CHECK dout0_25 vdout0_25ck24 = 0 time = 125
* CHECK dout0_26 vdout0_26ck24 = 0 time = 125
* CHECK dout0_27 vdout0_27ck24 = 1.0 time = 125
* CHECK dout0_28 vdout0_28ck24 = 1.0 time = 125
* CHECK dout0_29 vdout0_29ck24 = 1.0 time = 125
* CHECK dout0_30 vdout0_30ck24 = 1.0 time = 125
* CHECK dout0_31 vdout0_31ck24 = 1.0 time = 125
* CHECK dout0_32 vdout0_32ck24 = 1.0 time = 125
* CHECK dout0_33 vdout0_33ck24 = 1.0 time = 125
* CHECK dout0_34 vdout0_34ck24 = 1.0 time = 125
* CHECK dout0_35 vdout0_35ck24 = 0 time = 125
* CHECK dout0_36 vdout0_36ck24 = 0 time = 125
* CHECK dout0_37 vdout0_37ck24 = 1.0 time = 125
* CHECK dout0_38 vdout0_38ck24 = 0 time = 125
* CHECK dout0_39 vdout0_39ck24 = 0 time = 125
* CHECK dout0_40 vdout0_40ck24 = 0 time = 125
* CHECK dout0_41 vdout0_41ck24 = 0 time = 125
* CHECK dout0_42 vdout0_42ck24 = 1.0 time = 125
* CHECK dout0_43 vdout0_43ck24 = 1.0 time = 125
* CHECK dout0_44 vdout0_44ck24 = 0 time = 125
* CHECK dout0_45 vdout0_45ck24 = 1.0 time = 125
* CHECK dout0_46 vdout0_46ck24 = 1.0 time = 125
* CHECK dout0_47 vdout0_47ck24 = 1.0 time = 125
* CHECK dout0_48 vdout0_48ck24 = 1.0 time = 125
* CHECK dout0_49 vdout0_49ck24 = 0 time = 125
* CHECK dout0_50 vdout0_50ck24 = 1.0 time = 125
* CHECK dout0_51 vdout0_51ck24 = 1.0 time = 125
* CHECK dout0_52 vdout0_52ck24 = 0 time = 125
* CHECK dout0_53 vdout0_53ck24 = 1.0 time = 125
* CHECK dout0_54 vdout0_54ck24 = 0 time = 125
* CHECK dout0_55 vdout0_55ck24 = 0 time = 125
* CHECK dout0_56 vdout0_56ck24 = 1.0 time = 125
* CHECK dout0_57 vdout0_57ck24 = 0 time = 125
* CHECK dout0_58 vdout0_58ck24 = 0 time = 125
* CHECK dout0_59 vdout0_59ck24 = 0 time = 125
* CHECK dout0_60 vdout0_60ck24 = 1.0 time = 125
* CHECK dout0_61 vdout0_61ck24 = 0 time = 125
* CHECK dout0_62 vdout0_62ck24 = 1.0 time = 125
* CHECK dout0_63 vdout0_63ck24 = 1.0 time = 125
* CHECK dout0_0 vdout0_0ck26 = 1.0 time = 135
* CHECK dout0_1 vdout0_1ck26 = 1.0 time = 135
* CHECK dout0_2 vdout0_2ck26 = 0 time = 135
* CHECK dout0_3 vdout0_3ck26 = 0 time = 135
* CHECK dout0_4 vdout0_4ck26 = 0 time = 135
* CHECK dout0_5 vdout0_5ck26 = 0 time = 135
* CHECK dout0_6 vdout0_6ck26 = 1.0 time = 135
* CHECK dout0_7 vdout0_7ck26 = 0 time = 135
* CHECK dout0_8 vdout0_8ck26 = 1.0 time = 135
* CHECK dout0_9 vdout0_9ck26 = 1.0 time = 135
* CHECK dout0_10 vdout0_10ck26 = 1.0 time = 135
* CHECK dout0_11 vdout0_11ck26 = 1.0 time = 135
* CHECK dout0_12 vdout0_12ck26 = 0 time = 135
* CHECK dout0_13 vdout0_13ck26 = 0 time = 135
* CHECK dout0_14 vdout0_14ck26 = 1.0 time = 135
* CHECK dout0_15 vdout0_15ck26 = 0 time = 135
* CHECK dout0_16 vdout0_16ck26 = 0 time = 135
* CHECK dout0_17 vdout0_17ck26 = 0 time = 135
* CHECK dout0_18 vdout0_18ck26 = 1.0 time = 135
* CHECK dout0_19 vdout0_19ck26 = 0 time = 135
* CHECK dout0_20 vdout0_20ck26 = 1.0 time = 135
* CHECK dout0_21 vdout0_21ck26 = 1.0 time = 135
* CHECK dout0_22 vdout0_22ck26 = 0 time = 135
* CHECK dout0_23 vdout0_23ck26 = 1.0 time = 135
* CHECK dout0_24 vdout0_24ck26 = 1.0 time = 135
* CHECK dout0_25 vdout0_25ck26 = 0 time = 135
* CHECK dout0_26 vdout0_26ck26 = 0 time = 135
* CHECK dout0_27 vdout0_27ck26 = 0 time = 135
* CHECK dout0_28 vdout0_28ck26 = 1.0 time = 135
* CHECK dout0_29 vdout0_29ck26 = 1.0 time = 135
* CHECK dout0_30 vdout0_30ck26 = 1.0 time = 135
* CHECK dout0_31 vdout0_31ck26 = 0 time = 135
* CHECK dout0_32 vdout0_32ck26 = 1.0 time = 135
* CHECK dout0_33 vdout0_33ck26 = 1.0 time = 135
* CHECK dout0_34 vdout0_34ck26 = 1.0 time = 135
* CHECK dout0_35 vdout0_35ck26 = 1.0 time = 135
* CHECK dout0_36 vdout0_36ck26 = 0 time = 135
* CHECK dout0_37 vdout0_37ck26 = 1.0 time = 135
* CHECK dout0_38 vdout0_38ck26 = 0 time = 135
* CHECK dout0_39 vdout0_39ck26 = 0 time = 135
* CHECK dout0_40 vdout0_40ck26 = 1.0 time = 135
* CHECK dout0_41 vdout0_41ck26 = 0 time = 135
* CHECK dout0_42 vdout0_42ck26 = 0 time = 135
* CHECK dout0_43 vdout0_43ck26 = 0 time = 135
* CHECK dout0_44 vdout0_44ck26 = 0 time = 135
* CHECK dout0_45 vdout0_45ck26 = 1.0 time = 135
* CHECK dout0_46 vdout0_46ck26 = 0 time = 135
* CHECK dout0_47 vdout0_47ck26 = 0 time = 135
* CHECK dout0_48 vdout0_48ck26 = 1.0 time = 135
* CHECK dout0_49 vdout0_49ck26 = 1.0 time = 135
* CHECK dout0_50 vdout0_50ck26 = 0 time = 135
* CHECK dout0_51 vdout0_51ck26 = 0 time = 135
* CHECK dout0_52 vdout0_52ck26 = 0 time = 135
* CHECK dout0_53 vdout0_53ck26 = 1.0 time = 135
* CHECK dout0_54 vdout0_54ck26 = 1.0 time = 135
* CHECK dout0_55 vdout0_55ck26 = 1.0 time = 135
* CHECK dout0_56 vdout0_56ck26 = 0 time = 135
* CHECK dout0_57 vdout0_57ck26 = 0 time = 135
* CHECK dout0_58 vdout0_58ck26 = 1.0 time = 135
* CHECK dout0_59 vdout0_59ck26 = 0 time = 135
* CHECK dout0_60 vdout0_60ck26 = 0 time = 135
* CHECK dout0_61 vdout0_61ck26 = 1.0 time = 135
* CHECK dout0_62 vdout0_62ck26 = 0 time = 135
* CHECK dout0_63 vdout0_63ck26 = 0 time = 135
* CHECK dout0_0 vdout0_0ck27 = 0 time = 140
* CHECK dout0_1 vdout0_1ck27 = 1.0 time = 140
* CHECK dout0_2 vdout0_2ck27 = 1.0 time = 140
* CHECK dout0_3 vdout0_3ck27 = 0 time = 140
* CHECK dout0_4 vdout0_4ck27 = 1.0 time = 140
* CHECK dout0_5 vdout0_5ck27 = 0 time = 140
* CHECK dout0_6 vdout0_6ck27 = 0 time = 140
* CHECK dout0_7 vdout0_7ck27 = 1.0 time = 140
* CHECK dout0_8 vdout0_8ck27 = 0 time = 140
* CHECK dout0_9 vdout0_9ck27 = 1.0 time = 140
* CHECK dout0_10 vdout0_10ck27 = 1.0 time = 140
* CHECK dout0_11 vdout0_11ck27 = 1.0 time = 140
* CHECK dout0_12 vdout0_12ck27 = 1.0 time = 140
* CHECK dout0_13 vdout0_13ck27 = 1.0 time = 140
* CHECK dout0_14 vdout0_14ck27 = 1.0 time = 140
* CHECK dout0_15 vdout0_15ck27 = 0 time = 140
* CHECK dout0_16 vdout0_16ck27 = 0 time = 140
* CHECK dout0_17 vdout0_17ck27 = 1.0 time = 140
* CHECK dout0_18 vdout0_18ck27 = 1.0 time = 140
* CHECK dout0_19 vdout0_19ck27 = 0 time = 140
* CHECK dout0_20 vdout0_20ck27 = 0 time = 140
* CHECK dout0_21 vdout0_21ck27 = 0 time = 140
* CHECK dout0_22 vdout0_22ck27 = 0 time = 140
* CHECK dout0_23 vdout0_23ck27 = 1.0 time = 140
* CHECK dout0_24 vdout0_24ck27 = 0 time = 140
* CHECK dout0_25 vdout0_25ck27 = 1.0 time = 140
* CHECK dout0_26 vdout0_26ck27 = 1.0 time = 140
* CHECK dout0_27 vdout0_27ck27 = 1.0 time = 140
* CHECK dout0_28 vdout0_28ck27 = 0 time = 140
* CHECK dout0_29 vdout0_29ck27 = 0 time = 140
* CHECK dout0_30 vdout0_30ck27 = 1.0 time = 140
* CHECK dout0_31 vdout0_31ck27 = 1.0 time = 140
* CHECK dout0_32 vdout0_32ck27 = 1.0 time = 140
* CHECK dout0_33 vdout0_33ck27 = 0 time = 140
* CHECK dout0_34 vdout0_34ck27 = 1.0 time = 140
* CHECK dout0_35 vdout0_35ck27 = 0 time = 140
* CHECK dout0_36 vdout0_36ck27 = 0 time = 140
* CHECK dout0_37 vdout0_37ck27 = 0 time = 140
* CHECK dout0_38 vdout0_38ck27 = 1.0 time = 140
* CHECK dout0_39 vdout0_39ck27 = 1.0 time = 140
* CHECK dout0_40 vdout0_40ck27 = 1.0 time = 140
* CHECK dout0_41 vdout0_41ck27 = 0 time = 140
* CHECK dout0_42 vdout0_42ck27 = 1.0 time = 140
* CHECK dout0_43 vdout0_43ck27 = 1.0 time = 140
* CHECK dout0_44 vdout0_44ck27 = 1.0 time = 140
* CHECK dout0_45 vdout0_45ck27 = 0 time = 140
* CHECK dout0_46 vdout0_46ck27 = 0 time = 140
* CHECK dout0_47 vdout0_47ck27 = 0 time = 140
* CHECK dout0_48 vdout0_48ck27 = 1.0 time = 140
* CHECK dout0_49 vdout0_49ck27 = 1.0 time = 140
* CHECK dout0_50 vdout0_50ck27 = 0 time = 140
* CHECK dout0_51 vdout0_51ck27 = 1.0 time = 140
* CHECK dout0_52 vdout0_52ck27 = 1.0 time = 140
* CHECK dout0_53 vdout0_53ck27 = 0 time = 140
* CHECK dout0_54 vdout0_54ck27 = 0 time = 140
* CHECK dout0_55 vdout0_55ck27 = 0 time = 140
* CHECK dout0_56 vdout0_56ck27 = 0 time = 140
* CHECK dout0_57 vdout0_57ck27 = 0 time = 140
* CHECK dout0_58 vdout0_58ck27 = 1.0 time = 140
* CHECK dout0_59 vdout0_59ck27 = 0 time = 140
* CHECK dout0_60 vdout0_60ck27 = 1.0 time = 140
* CHECK dout0_61 vdout0_61ck27 = 0 time = 140
* CHECK dout0_62 vdout0_62ck27 = 0 time = 140
* CHECK dout0_63 vdout0_63ck27 = 0 time = 140
* CHECK dout1_0 vdout1_0ck27 = 0 time = 140
* CHECK dout1_1 vdout1_1ck27 = 1.0 time = 140
* CHECK dout1_2 vdout1_2ck27 = 0 time = 140
* CHECK dout1_3 vdout1_3ck27 = 1.0 time = 140
* CHECK dout1_4 vdout1_4ck27 = 0 time = 140
* CHECK dout1_5 vdout1_5ck27 = 0 time = 140
* CHECK dout1_6 vdout1_6ck27 = 0 time = 140
* CHECK dout1_7 vdout1_7ck27 = 1.0 time = 140
* CHECK dout1_8 vdout1_8ck27 = 1.0 time = 140
* CHECK dout1_9 vdout1_9ck27 = 0 time = 140
* CHECK dout1_10 vdout1_10ck27 = 1.0 time = 140
* CHECK dout1_11 vdout1_11ck27 = 0 time = 140
* CHECK dout1_12 vdout1_12ck27 = 1.0 time = 140
* CHECK dout1_13 vdout1_13ck27 = 0 time = 140
* CHECK dout1_14 vdout1_14ck27 = 1.0 time = 140
* CHECK dout1_15 vdout1_15ck27 = 0 time = 140
* CHECK dout1_16 vdout1_16ck27 = 1.0 time = 140
* CHECK dout1_17 vdout1_17ck27 = 1.0 time = 140
* CHECK dout1_18 vdout1_18ck27 = 1.0 time = 140
* CHECK dout1_19 vdout1_19ck27 = 1.0 time = 140
* CHECK dout1_20 vdout1_20ck27 = 0 time = 140
* CHECK dout1_21 vdout1_21ck27 = 0 time = 140
* CHECK dout1_22 vdout1_22ck27 = 0 time = 140
* CHECK dout1_23 vdout1_23ck27 = 1.0 time = 140
* CHECK dout1_24 vdout1_24ck27 = 1.0 time = 140
* CHECK dout1_25 vdout1_25ck27 = 1.0 time = 140
* CHECK dout1_26 vdout1_26ck27 = 1.0 time = 140
* CHECK dout1_27 vdout1_27ck27 = 0 time = 140
* CHECK dout1_28 vdout1_28ck27 = 1.0 time = 140
* CHECK dout1_29 vdout1_29ck27 = 1.0 time = 140
* CHECK dout1_30 vdout1_30ck27 = 1.0 time = 140
* CHECK dout1_31 vdout1_31ck27 = 1.0 time = 140
* CHECK dout1_32 vdout1_32ck27 = 0 time = 140
* CHECK dout1_33 vdout1_33ck27 = 1.0 time = 140
* CHECK dout1_34 vdout1_34ck27 = 1.0 time = 140
* CHECK dout1_35 vdout1_35ck27 = 1.0 time = 140
* CHECK dout1_36 vdout1_36ck27 = 1.0 time = 140
* CHECK dout1_37 vdout1_37ck27 = 0 time = 140
* CHECK dout1_38 vdout1_38ck27 = 0 time = 140
* CHECK dout1_39 vdout1_39ck27 = 1.0 time = 140
* CHECK dout1_40 vdout1_40ck27 = 1.0 time = 140
* CHECK dout1_41 vdout1_41ck27 = 0 time = 140
* CHECK dout1_42 vdout1_42ck27 = 1.0 time = 140
* CHECK dout1_43 vdout1_43ck27 = 0 time = 140
* CHECK dout1_44 vdout1_44ck27 = 1.0 time = 140
* CHECK dout1_45 vdout1_45ck27 = 1.0 time = 140
* CHECK dout1_46 vdout1_46ck27 = 0 time = 140
* CHECK dout1_47 vdout1_47ck27 = 0 time = 140
* CHECK dout1_48 vdout1_48ck27 = 0 time = 140
* CHECK dout1_49 vdout1_49ck27 = 0 time = 140
* CHECK dout1_50 vdout1_50ck27 = 1.0 time = 140
* CHECK dout1_51 vdout1_51ck27 = 0 time = 140
* CHECK dout1_52 vdout1_52ck27 = 0 time = 140
* CHECK dout1_53 vdout1_53ck27 = 1.0 time = 140
* CHECK dout1_54 vdout1_54ck27 = 1.0 time = 140
* CHECK dout1_55 vdout1_55ck27 = 1.0 time = 140
* CHECK dout1_56 vdout1_56ck27 = 0 time = 140
* CHECK dout1_57 vdout1_57ck27 = 1.0 time = 140
* CHECK dout1_58 vdout1_58ck27 = 0 time = 140
* CHECK dout1_59 vdout1_59ck27 = 0 time = 140
* CHECK dout1_60 vdout1_60ck27 = 0 time = 140
* CHECK dout1_61 vdout1_61ck27 = 1.0 time = 140
* CHECK dout1_62 vdout1_62ck27 = 1.0 time = 140
* CHECK dout1_63 vdout1_63ck27 = 0 time = 140
* CHECK dout0_0 vdout0_0ck28 = 0 time = 145
* CHECK dout0_1 vdout0_1ck28 = 1.0 time = 145
* CHECK dout0_2 vdout0_2ck28 = 0 time = 145
* CHECK dout0_3 vdout0_3ck28 = 1.0 time = 145
* CHECK dout0_4 vdout0_4ck28 = 0 time = 145
* CHECK dout0_5 vdout0_5ck28 = 1.0 time = 145
* CHECK dout0_6 vdout0_6ck28 = 1.0 time = 145
* CHECK dout0_7 vdout0_7ck28 = 0 time = 145
* CHECK dout0_8 vdout0_8ck28 = 1.0 time = 145
* CHECK dout0_9 vdout0_9ck28 = 1.0 time = 145
* CHECK dout0_10 vdout0_10ck28 = 0 time = 145
* CHECK dout0_11 vdout0_11ck28 = 1.0 time = 145
* CHECK dout0_12 vdout0_12ck28 = 1.0 time = 145
* CHECK dout0_13 vdout0_13ck28 = 0 time = 145
* CHECK dout0_14 vdout0_14ck28 = 0 time = 145
* CHECK dout0_15 vdout0_15ck28 = 0 time = 145
* CHECK dout0_16 vdout0_16ck28 = 0 time = 145
* CHECK dout0_17 vdout0_17ck28 = 0 time = 145
* CHECK dout0_18 vdout0_18ck28 = 1.0 time = 145
* CHECK dout0_19 vdout0_19ck28 = 1.0 time = 145
* CHECK dout0_20 vdout0_20ck28 = 0 time = 145
* CHECK dout0_21 vdout0_21ck28 = 1.0 time = 145
* CHECK dout0_22 vdout0_22ck28 = 0 time = 145
* CHECK dout0_23 vdout0_23ck28 = 0 time = 145
* CHECK dout0_24 vdout0_24ck28 = 1.0 time = 145
* CHECK dout0_25 vdout0_25ck28 = 1.0 time = 145
* CHECK dout0_26 vdout0_26ck28 = 1.0 time = 145
* CHECK dout0_27 vdout0_27ck28 = 1.0 time = 145
* CHECK dout0_28 vdout0_28ck28 = 0 time = 145
* CHECK dout0_29 vdout0_29ck28 = 0 time = 145
* CHECK dout0_30 vdout0_30ck28 = 1.0 time = 145
* CHECK dout0_31 vdout0_31ck28 = 0 time = 145
* CHECK dout0_32 vdout0_32ck28 = 0 time = 145
* CHECK dout0_33 vdout0_33ck28 = 0 time = 145
* CHECK dout0_34 vdout0_34ck28 = 1.0 time = 145
* CHECK dout0_35 vdout0_35ck28 = 0 time = 145
* CHECK dout0_36 vdout0_36ck28 = 0 time = 145
* CHECK dout0_37 vdout0_37ck28 = 1.0 time = 145
* CHECK dout0_38 vdout0_38ck28 = 1.0 time = 145
* CHECK dout0_39 vdout0_39ck28 = 0 time = 145
* CHECK dout0_40 vdout0_40ck28 = 0 time = 145
* CHECK dout0_41 vdout0_41ck28 = 0 time = 145
* CHECK dout0_42 vdout0_42ck28 = 0 time = 145
* CHECK dout0_43 vdout0_43ck28 = 1.0 time = 145
* CHECK dout0_44 vdout0_44ck28 = 0 time = 145
* CHECK dout0_45 vdout0_45ck28 = 1.0 time = 145
* CHECK dout0_46 vdout0_46ck28 = 0 time = 145
* CHECK dout0_47 vdout0_47ck28 = 0 time = 145
* CHECK dout0_48 vdout0_48ck28 = 1.0 time = 145
* CHECK dout0_49 vdout0_49ck28 = 1.0 time = 145
* CHECK dout0_50 vdout0_50ck28 = 0 time = 145
* CHECK dout0_51 vdout0_51ck28 = 0 time = 145
* CHECK dout0_52 vdout0_52ck28 = 0 time = 145
* CHECK dout0_53 vdout0_53ck28 = 1.0 time = 145
* CHECK dout0_54 vdout0_54ck28 = 0 time = 145
* CHECK dout0_55 vdout0_55ck28 = 0 time = 145
* CHECK dout0_56 vdout0_56ck28 = 1.0 time = 145
* CHECK dout0_57 vdout0_57ck28 = 0 time = 145
* CHECK dout0_58 vdout0_58ck28 = 1.0 time = 145
* CHECK dout0_59 vdout0_59ck28 = 0 time = 145
* CHECK dout0_60 vdout0_60ck28 = 1.0 time = 145
* CHECK dout0_61 vdout0_61ck28 = 1.0 time = 145
* CHECK dout0_62 vdout0_62ck28 = 0 time = 145
* CHECK dout0_63 vdout0_63ck28 = 0 time = 145
* CHECK dout1_0 vdout1_0ck28 = 0 time = 145
* CHECK dout1_1 vdout1_1ck28 = 1.0 time = 145
* CHECK dout1_2 vdout1_2ck28 = 1.0 time = 145
* CHECK dout1_3 vdout1_3ck28 = 0 time = 145
* CHECK dout1_4 vdout1_4ck28 = 1.0 time = 145
* CHECK dout1_5 vdout1_5ck28 = 0 time = 145
* CHECK dout1_6 vdout1_6ck28 = 0 time = 145
* CHECK dout1_7 vdout1_7ck28 = 1.0 time = 145
* CHECK dout1_8 vdout1_8ck28 = 0 time = 145
* CHECK dout1_9 vdout1_9ck28 = 0 time = 145
* CHECK dout1_10 vdout1_10ck28 = 1.0 time = 145
* CHECK dout1_11 vdout1_11ck28 = 1.0 time = 145
* CHECK dout1_12 vdout1_12ck28 = 1.0 time = 145
* CHECK dout1_13 vdout1_13ck28 = 1.0 time = 145
* CHECK dout1_14 vdout1_14ck28 = 0 time = 145
* CHECK dout1_15 vdout1_15ck28 = 0 time = 145
* CHECK dout1_16 vdout1_16ck28 = 1.0 time = 145
* CHECK dout1_17 vdout1_17ck28 = 1.0 time = 145
* CHECK dout1_18 vdout1_18ck28 = 0 time = 145
* CHECK dout1_19 vdout1_19ck28 = 0 time = 145
* CHECK dout1_20 vdout1_20ck28 = 0 time = 145
* CHECK dout1_21 vdout1_21ck28 = 0 time = 145
* CHECK dout1_22 vdout1_22ck28 = 1.0 time = 145
* CHECK dout1_23 vdout1_23ck28 = 0 time = 145
* CHECK dout1_24 vdout1_24ck28 = 0 time = 145
* CHECK dout1_25 vdout1_25ck28 = 1.0 time = 145
* CHECK dout1_26 vdout1_26ck28 = 0 time = 145
* CHECK dout1_27 vdout1_27ck28 = 1.0 time = 145
* CHECK dout1_28 vdout1_28ck28 = 0 time = 145
* CHECK dout1_29 vdout1_29ck28 = 1.0 time = 145
* CHECK dout1_30 vdout1_30ck28 = 1.0 time = 145
* CHECK dout1_31 vdout1_31ck28 = 0 time = 145
* CHECK dout1_32 vdout1_32ck28 = 0 time = 145
* CHECK dout1_33 vdout1_33ck28 = 0 time = 145
* CHECK dout1_34 vdout1_34ck28 = 1.0 time = 145
* CHECK dout1_35 vdout1_35ck28 = 0 time = 145
* CHECK dout1_36 vdout1_36ck28 = 1.0 time = 145
* CHECK dout1_37 vdout1_37ck28 = 0 time = 145
* CHECK dout1_38 vdout1_38ck28 = 0 time = 145
* CHECK dout1_39 vdout1_39ck28 = 1.0 time = 145
* CHECK dout1_40 vdout1_40ck28 = 0 time = 145
* CHECK dout1_41 vdout1_41ck28 = 0 time = 145
* CHECK dout1_42 vdout1_42ck28 = 1.0 time = 145
* CHECK dout1_43 vdout1_43ck28 = 1.0 time = 145
* CHECK dout1_44 vdout1_44ck28 = 1.0 time = 145
* CHECK dout1_45 vdout1_45ck28 = 1.0 time = 145
* CHECK dout1_46 vdout1_46ck28 = 0 time = 145
* CHECK dout1_47 vdout1_47ck28 = 1.0 time = 145
* CHECK dout1_48 vdout1_48ck28 = 1.0 time = 145
* CHECK dout1_49 vdout1_49ck28 = 0 time = 145
* CHECK dout1_50 vdout1_50ck28 = 1.0 time = 145
* CHECK dout1_51 vdout1_51ck28 = 1.0 time = 145
* CHECK dout1_52 vdout1_52ck28 = 1.0 time = 145
* CHECK dout1_53 vdout1_53ck28 = 0 time = 145
* CHECK dout1_54 vdout1_54ck28 = 0 time = 145
* CHECK dout1_55 vdout1_55ck28 = 0 time = 145
* CHECK dout1_56 vdout1_56ck28 = 1.0 time = 145
* CHECK dout1_57 vdout1_57ck28 = 0 time = 145
* CHECK dout1_58 vdout1_58ck28 = 1.0 time = 145
* CHECK dout1_59 vdout1_59ck28 = 1.0 time = 145
* CHECK dout1_60 vdout1_60ck28 = 0 time = 145
* CHECK dout1_61 vdout1_61ck28 = 0 time = 145
* CHECK dout1_62 vdout1_62ck28 = 0 time = 145
* CHECK dout1_63 vdout1_63ck28 = 0 time = 145
* CHECK dout0_0 vdout0_0ck29 = 1.0 time = 150
* CHECK dout0_1 vdout0_1ck29 = 1.0 time = 150
* CHECK dout0_2 vdout0_2ck29 = 0 time = 150
* CHECK dout0_3 vdout0_3ck29 = 0 time = 150
* CHECK dout0_4 vdout0_4ck29 = 0 time = 150
* CHECK dout0_5 vdout0_5ck29 = 0 time = 150
* CHECK dout0_6 vdout0_6ck29 = 1.0 time = 150
* CHECK dout0_7 vdout0_7ck29 = 0 time = 150
* CHECK dout0_8 vdout0_8ck29 = 1.0 time = 150
* CHECK dout0_9 vdout0_9ck29 = 1.0 time = 150
* CHECK dout0_10 vdout0_10ck29 = 1.0 time = 150
* CHECK dout0_11 vdout0_11ck29 = 1.0 time = 150
* CHECK dout0_12 vdout0_12ck29 = 0 time = 150
* CHECK dout0_13 vdout0_13ck29 = 0 time = 150
* CHECK dout0_14 vdout0_14ck29 = 1.0 time = 150
* CHECK dout0_15 vdout0_15ck29 = 0 time = 150
* CHECK dout0_16 vdout0_16ck29 = 0 time = 150
* CHECK dout0_17 vdout0_17ck29 = 0 time = 150
* CHECK dout0_18 vdout0_18ck29 = 1.0 time = 150
* CHECK dout0_19 vdout0_19ck29 = 0 time = 150
* CHECK dout0_20 vdout0_20ck29 = 1.0 time = 150
* CHECK dout0_21 vdout0_21ck29 = 1.0 time = 150
* CHECK dout0_22 vdout0_22ck29 = 0 time = 150
* CHECK dout0_23 vdout0_23ck29 = 1.0 time = 150
* CHECK dout0_24 vdout0_24ck29 = 1.0 time = 150
* CHECK dout0_25 vdout0_25ck29 = 0 time = 150
* CHECK dout0_26 vdout0_26ck29 = 0 time = 150
* CHECK dout0_27 vdout0_27ck29 = 0 time = 150
* CHECK dout0_28 vdout0_28ck29 = 1.0 time = 150
* CHECK dout0_29 vdout0_29ck29 = 1.0 time = 150
* CHECK dout0_30 vdout0_30ck29 = 1.0 time = 150
* CHECK dout0_31 vdout0_31ck29 = 0 time = 150
* CHECK dout0_32 vdout0_32ck29 = 1.0 time = 150
* CHECK dout0_33 vdout0_33ck29 = 1.0 time = 150
* CHECK dout0_34 vdout0_34ck29 = 1.0 time = 150
* CHECK dout0_35 vdout0_35ck29 = 1.0 time = 150
* CHECK dout0_36 vdout0_36ck29 = 0 time = 150
* CHECK dout0_37 vdout0_37ck29 = 1.0 time = 150
* CHECK dout0_38 vdout0_38ck29 = 0 time = 150
* CHECK dout0_39 vdout0_39ck29 = 0 time = 150
* CHECK dout0_40 vdout0_40ck29 = 1.0 time = 150
* CHECK dout0_41 vdout0_41ck29 = 0 time = 150
* CHECK dout0_42 vdout0_42ck29 = 0 time = 150
* CHECK dout0_43 vdout0_43ck29 = 0 time = 150
* CHECK dout0_44 vdout0_44ck29 = 0 time = 150
* CHECK dout0_45 vdout0_45ck29 = 1.0 time = 150
* CHECK dout0_46 vdout0_46ck29 = 0 time = 150
* CHECK dout0_47 vdout0_47ck29 = 0 time = 150
* CHECK dout0_48 vdout0_48ck29 = 1.0 time = 150
* CHECK dout0_49 vdout0_49ck29 = 1.0 time = 150
* CHECK dout0_50 vdout0_50ck29 = 0 time = 150
* CHECK dout0_51 vdout0_51ck29 = 0 time = 150
* CHECK dout0_52 vdout0_52ck29 = 0 time = 150
* CHECK dout0_53 vdout0_53ck29 = 1.0 time = 150
* CHECK dout0_54 vdout0_54ck29 = 1.0 time = 150
* CHECK dout0_55 vdout0_55ck29 = 1.0 time = 150
* CHECK dout0_56 vdout0_56ck29 = 0 time = 150
* CHECK dout0_57 vdout0_57ck29 = 0 time = 150
* CHECK dout0_58 vdout0_58ck29 = 1.0 time = 150
* CHECK dout0_59 vdout0_59ck29 = 0 time = 150
* CHECK dout0_60 vdout0_60ck29 = 0 time = 150
* CHECK dout0_61 vdout0_61ck29 = 1.0 time = 150
* CHECK dout0_62 vdout0_62ck29 = 0 time = 150
* CHECK dout0_63 vdout0_63ck29 = 0 time = 150
* CHECK dout1_0 vdout1_0ck32 = 0 time = 165
* CHECK dout1_1 vdout1_1ck32 = 1.0 time = 165
* CHECK dout1_2 vdout1_2ck32 = 1.0 time = 165
* CHECK dout1_3 vdout1_3ck32 = 1.0 time = 165
* CHECK dout1_4 vdout1_4ck32 = 1.0 time = 165
* CHECK dout1_5 vdout1_5ck32 = 1.0 time = 165
* CHECK dout1_6 vdout1_6ck32 = 1.0 time = 165
* CHECK dout1_7 vdout1_7ck32 = 0 time = 165
* CHECK dout1_8 vdout1_8ck32 = 1.0 time = 165
* CHECK dout1_9 vdout1_9ck32 = 0 time = 165
* CHECK dout1_10 vdout1_10ck32 = 1.0 time = 165
* CHECK dout1_11 vdout1_11ck32 = 1.0 time = 165
* CHECK dout1_12 vdout1_12ck32 = 1.0 time = 165
* CHECK dout1_13 vdout1_13ck32 = 1.0 time = 165
* CHECK dout1_14 vdout1_14ck32 = 0 time = 165
* CHECK dout1_15 vdout1_15ck32 = 0 time = 165
* CHECK dout1_16 vdout1_16ck32 = 1.0 time = 165
* CHECK dout1_17 vdout1_17ck32 = 1.0 time = 165
* CHECK dout1_18 vdout1_18ck32 = 1.0 time = 165
* CHECK dout1_19 vdout1_19ck32 = 1.0 time = 165
* CHECK dout1_20 vdout1_20ck32 = 0 time = 165
* CHECK dout1_21 vdout1_21ck32 = 0 time = 165
* CHECK dout1_22 vdout1_22ck32 = 1.0 time = 165
* CHECK dout1_23 vdout1_23ck32 = 1.0 time = 165
* CHECK dout1_24 vdout1_24ck32 = 0 time = 165
* CHECK dout1_25 vdout1_25ck32 = 1.0 time = 165
* CHECK dout1_26 vdout1_26ck32 = 0 time = 165
* CHECK dout1_27 vdout1_27ck32 = 0 time = 165
* CHECK dout1_28 vdout1_28ck32 = 0 time = 165
* CHECK dout1_29 vdout1_29ck32 = 1.0 time = 165
* CHECK dout1_30 vdout1_30ck32 = 0 time = 165
* CHECK dout1_31 vdout1_31ck32 = 1.0 time = 165
* CHECK dout1_32 vdout1_32ck32 = 1.0 time = 165
* CHECK dout1_33 vdout1_33ck32 = 1.0 time = 165
* CHECK dout1_34 vdout1_34ck32 = 0 time = 165
* CHECK dout1_35 vdout1_35ck32 = 1.0 time = 165
* CHECK dout1_36 vdout1_36ck32 = 1.0 time = 165
* CHECK dout1_37 vdout1_37ck32 = 0 time = 165
* CHECK dout1_38 vdout1_38ck32 = 0 time = 165
* CHECK dout1_39 vdout1_39ck32 = 1.0 time = 165
* CHECK dout1_40 vdout1_40ck32 = 0 time = 165
* CHECK dout1_41 vdout1_41ck32 = 1.0 time = 165
* CHECK dout1_42 vdout1_42ck32 = 0 time = 165
* CHECK dout1_43 vdout1_43ck32 = 1.0 time = 165
* CHECK dout1_44 vdout1_44ck32 = 1.0 time = 165
* CHECK dout1_45 vdout1_45ck32 = 1.0 time = 165
* CHECK dout1_46 vdout1_46ck32 = 1.0 time = 165
* CHECK dout1_47 vdout1_47ck32 = 0 time = 165
* CHECK dout1_48 vdout1_48ck32 = 0 time = 165
* CHECK dout1_49 vdout1_49ck32 = 1.0 time = 165
* CHECK dout1_50 vdout1_50ck32 = 0 time = 165
* CHECK dout1_51 vdout1_51ck32 = 1.0 time = 165
* CHECK dout1_52 vdout1_52ck32 = 1.0 time = 165
* CHECK dout1_53 vdout1_53ck32 = 1.0 time = 165
* CHECK dout1_54 vdout1_54ck32 = 1.0 time = 165
* CHECK dout1_55 vdout1_55ck32 = 0 time = 165
* CHECK dout1_56 vdout1_56ck32 = 1.0 time = 165
* CHECK dout1_57 vdout1_57ck32 = 0 time = 165
* CHECK dout1_58 vdout1_58ck32 = 0 time = 165
* CHECK dout1_59 vdout1_59ck32 = 0 time = 165
* CHECK dout1_60 vdout1_60ck32 = 1.0 time = 165
* CHECK dout1_61 vdout1_61ck32 = 1.0 time = 165
* CHECK dout1_62 vdout1_62ck32 = 0 time = 165
* CHECK dout1_63 vdout1_63ck32 = 0 time = 165
* CHECK dout1_0 vdout1_0ck33 = 0 time = 170
* CHECK dout1_1 vdout1_1ck33 = 1.0 time = 170
* CHECK dout1_2 vdout1_2ck33 = 1.0 time = 170
* CHECK dout1_3 vdout1_3ck33 = 0 time = 170
* CHECK dout1_4 vdout1_4ck33 = 1.0 time = 170
* CHECK dout1_5 vdout1_5ck33 = 0 time = 170
* CHECK dout1_6 vdout1_6ck33 = 0 time = 170
* CHECK dout1_7 vdout1_7ck33 = 1.0 time = 170
* CHECK dout1_8 vdout1_8ck33 = 0 time = 170
* CHECK dout1_9 vdout1_9ck33 = 0 time = 170
* CHECK dout1_10 vdout1_10ck33 = 1.0 time = 170
* CHECK dout1_11 vdout1_11ck33 = 1.0 time = 170
* CHECK dout1_12 vdout1_12ck33 = 1.0 time = 170
* CHECK dout1_13 vdout1_13ck33 = 1.0 time = 170
* CHECK dout1_14 vdout1_14ck33 = 0 time = 170
* CHECK dout1_15 vdout1_15ck33 = 0 time = 170
* CHECK dout1_16 vdout1_16ck33 = 1.0 time = 170
* CHECK dout1_17 vdout1_17ck33 = 1.0 time = 170
* CHECK dout1_18 vdout1_18ck33 = 0 time = 170
* CHECK dout1_19 vdout1_19ck33 = 0 time = 170
* CHECK dout1_20 vdout1_20ck33 = 0 time = 170
* CHECK dout1_21 vdout1_21ck33 = 0 time = 170
* CHECK dout1_22 vdout1_22ck33 = 1.0 time = 170
* CHECK dout1_23 vdout1_23ck33 = 0 time = 170
* CHECK dout1_24 vdout1_24ck33 = 0 time = 170
* CHECK dout1_25 vdout1_25ck33 = 1.0 time = 170
* CHECK dout1_26 vdout1_26ck33 = 0 time = 170
* CHECK dout1_27 vdout1_27ck33 = 1.0 time = 170
* CHECK dout1_28 vdout1_28ck33 = 0 time = 170
* CHECK dout1_29 vdout1_29ck33 = 1.0 time = 170
* CHECK dout1_30 vdout1_30ck33 = 1.0 time = 170
* CHECK dout1_31 vdout1_31ck33 = 0 time = 170
* CHECK dout1_32 vdout1_32ck33 = 0 time = 170
* CHECK dout1_33 vdout1_33ck33 = 0 time = 170
* CHECK dout1_34 vdout1_34ck33 = 1.0 time = 170
* CHECK dout1_35 vdout1_35ck33 = 0 time = 170
* CHECK dout1_36 vdout1_36ck33 = 1.0 time = 170
* CHECK dout1_37 vdout1_37ck33 = 0 time = 170
* CHECK dout1_38 vdout1_38ck33 = 0 time = 170
* CHECK dout1_39 vdout1_39ck33 = 1.0 time = 170
* CHECK dout1_40 vdout1_40ck33 = 0 time = 170
* CHECK dout1_41 vdout1_41ck33 = 0 time = 170
* CHECK dout1_42 vdout1_42ck33 = 1.0 time = 170
* CHECK dout1_43 vdout1_43ck33 = 1.0 time = 170
* CHECK dout1_44 vdout1_44ck33 = 1.0 time = 170
* CHECK dout1_45 vdout1_45ck33 = 1.0 time = 170
* CHECK dout1_46 vdout1_46ck33 = 0 time = 170
* CHECK dout1_47 vdout1_47ck33 = 1.0 time = 170
* CHECK dout1_48 vdout1_48ck33 = 1.0 time = 170
* CHECK dout1_49 vdout1_49ck33 = 0 time = 170
* CHECK dout1_50 vdout1_50ck33 = 1.0 time = 170
* CHECK dout1_51 vdout1_51ck33 = 1.0 time = 170
* CHECK dout1_52 vdout1_52ck33 = 1.0 time = 170
* CHECK dout1_53 vdout1_53ck33 = 0 time = 170
* CHECK dout1_54 vdout1_54ck33 = 0 time = 170
* CHECK dout1_55 vdout1_55ck33 = 0 time = 170
* CHECK dout1_56 vdout1_56ck33 = 1.0 time = 170
* CHECK dout1_57 vdout1_57ck33 = 0 time = 170
* CHECK dout1_58 vdout1_58ck33 = 1.0 time = 170
* CHECK dout1_59 vdout1_59ck33 = 1.0 time = 170
* CHECK dout1_60 vdout1_60ck33 = 0 time = 170
* CHECK dout1_61 vdout1_61ck33 = 0 time = 170
* CHECK dout1_62 vdout1_62ck33 = 0 time = 170
* CHECK dout1_63 vdout1_63ck33 = 0 time = 170
* CHECK dout0_0 vdout0_0ck34 = 0 time = 175
* CHECK dout0_1 vdout0_1ck34 = 1.0 time = 175
* CHECK dout0_2 vdout0_2ck34 = 0 time = 175
* CHECK dout0_3 vdout0_3ck34 = 1.0 time = 175
* CHECK dout0_4 vdout0_4ck34 = 0 time = 175
* CHECK dout0_5 vdout0_5ck34 = 0 time = 175
* CHECK dout0_6 vdout0_6ck34 = 0 time = 175
* CHECK dout0_7 vdout0_7ck34 = 1.0 time = 175
* CHECK dout0_8 vdout0_8ck34 = 1.0 time = 175
* CHECK dout0_9 vdout0_9ck34 = 0 time = 175
* CHECK dout0_10 vdout0_10ck34 = 1.0 time = 175
* CHECK dout0_11 vdout0_11ck34 = 0 time = 175
* CHECK dout0_12 vdout0_12ck34 = 1.0 time = 175
* CHECK dout0_13 vdout0_13ck34 = 0 time = 175
* CHECK dout0_14 vdout0_14ck34 = 1.0 time = 175
* CHECK dout0_15 vdout0_15ck34 = 0 time = 175
* CHECK dout0_16 vdout0_16ck34 = 1.0 time = 175
* CHECK dout0_17 vdout0_17ck34 = 1.0 time = 175
* CHECK dout0_18 vdout0_18ck34 = 1.0 time = 175
* CHECK dout0_19 vdout0_19ck34 = 1.0 time = 175
* CHECK dout0_20 vdout0_20ck34 = 0 time = 175
* CHECK dout0_21 vdout0_21ck34 = 0 time = 175
* CHECK dout0_22 vdout0_22ck34 = 0 time = 175
* CHECK dout0_23 vdout0_23ck34 = 1.0 time = 175
* CHECK dout0_24 vdout0_24ck34 = 1.0 time = 175
* CHECK dout0_25 vdout0_25ck34 = 1.0 time = 175
* CHECK dout0_26 vdout0_26ck34 = 1.0 time = 175
* CHECK dout0_27 vdout0_27ck34 = 0 time = 175
* CHECK dout0_28 vdout0_28ck34 = 1.0 time = 175
* CHECK dout0_29 vdout0_29ck34 = 1.0 time = 175
* CHECK dout0_30 vdout0_30ck34 = 1.0 time = 175
* CHECK dout0_31 vdout0_31ck34 = 1.0 time = 175
* CHECK dout0_32 vdout0_32ck34 = 0 time = 175
* CHECK dout0_33 vdout0_33ck34 = 1.0 time = 175
* CHECK dout0_34 vdout0_34ck34 = 1.0 time = 175
* CHECK dout0_35 vdout0_35ck34 = 1.0 time = 175
* CHECK dout0_36 vdout0_36ck34 = 1.0 time = 175
* CHECK dout0_37 vdout0_37ck34 = 0 time = 175
* CHECK dout0_38 vdout0_38ck34 = 0 time = 175
* CHECK dout0_39 vdout0_39ck34 = 1.0 time = 175
* CHECK dout0_40 vdout0_40ck34 = 1.0 time = 175
* CHECK dout0_41 vdout0_41ck34 = 0 time = 175
* CHECK dout0_42 vdout0_42ck34 = 1.0 time = 175
* CHECK dout0_43 vdout0_43ck34 = 0 time = 175
* CHECK dout0_44 vdout0_44ck34 = 1.0 time = 175
* CHECK dout0_45 vdout0_45ck34 = 1.0 time = 175
* CHECK dout0_46 vdout0_46ck34 = 0 time = 175
* CHECK dout0_47 vdout0_47ck34 = 0 time = 175
* CHECK dout0_48 vdout0_48ck34 = 0 time = 175
* CHECK dout0_49 vdout0_49ck34 = 0 time = 175
* CHECK dout0_50 vdout0_50ck34 = 1.0 time = 175
* CHECK dout0_51 vdout0_51ck34 = 0 time = 175
* CHECK dout0_52 vdout0_52ck34 = 0 time = 175
* CHECK dout0_53 vdout0_53ck34 = 1.0 time = 175
* CHECK dout0_54 vdout0_54ck34 = 1.0 time = 175
* CHECK dout0_55 vdout0_55ck34 = 1.0 time = 175
* CHECK dout0_56 vdout0_56ck34 = 0 time = 175
* CHECK dout0_57 vdout0_57ck34 = 1.0 time = 175
* CHECK dout0_58 vdout0_58ck34 = 0 time = 175
* CHECK dout0_59 vdout0_59ck34 = 0 time = 175
* CHECK dout0_60 vdout0_60ck34 = 0 time = 175
* CHECK dout0_61 vdout0_61ck34 = 1.0 time = 175
* CHECK dout0_62 vdout0_62ck34 = 1.0 time = 175
* CHECK dout0_63 vdout0_63ck34 = 0 time = 175
* CHECK dout0_0 vdout0_0ck37 = 0 time = 190
* CHECK dout0_1 vdout0_1ck37 = 0 time = 190
* CHECK dout0_2 vdout0_2ck37 = 1.0 time = 190
* CHECK dout0_3 vdout0_3ck37 = 0 time = 190
* CHECK dout0_4 vdout0_4ck37 = 0 time = 190
* CHECK dout0_5 vdout0_5ck37 = 0 time = 190
* CHECK dout0_6 vdout0_6ck37 = 1.0 time = 190
* CHECK dout0_7 vdout0_7ck37 = 0 time = 190
* CHECK dout0_8 vdout0_8ck37 = 0 time = 190
* CHECK dout0_9 vdout0_9ck37 = 1.0 time = 190
* CHECK dout0_10 vdout0_10ck37 = 1.0 time = 190
* CHECK dout0_11 vdout0_11ck37 = 1.0 time = 190
* CHECK dout0_12 vdout0_12ck37 = 0 time = 190
* CHECK dout0_13 vdout0_13ck37 = 1.0 time = 190
* CHECK dout0_14 vdout0_14ck37 = 0 time = 190
* CHECK dout0_15 vdout0_15ck37 = 0 time = 190
* CHECK dout0_16 vdout0_16ck37 = 1.0 time = 190
* CHECK dout0_17 vdout0_17ck37 = 1.0 time = 190
* CHECK dout0_18 vdout0_18ck37 = 1.0 time = 190
* CHECK dout0_19 vdout0_19ck37 = 1.0 time = 190
* CHECK dout0_20 vdout0_20ck37 = 1.0 time = 190
* CHECK dout0_21 vdout0_21ck37 = 1.0 time = 190
* CHECK dout0_22 vdout0_22ck37 = 0 time = 190
* CHECK dout0_23 vdout0_23ck37 = 0 time = 190
* CHECK dout0_24 vdout0_24ck37 = 1.0 time = 190
* CHECK dout0_25 vdout0_25ck37 = 0 time = 190
* CHECK dout0_26 vdout0_26ck37 = 0 time = 190
* CHECK dout0_27 vdout0_27ck37 = 1.0 time = 190
* CHECK dout0_28 vdout0_28ck37 = 0 time = 190
* CHECK dout0_29 vdout0_29ck37 = 1.0 time = 190
* CHECK dout0_30 vdout0_30ck37 = 0 time = 190
* CHECK dout0_31 vdout0_31ck37 = 1.0 time = 190
* CHECK dout0_32 vdout0_32ck37 = 0 time = 190
* CHECK dout0_33 vdout0_33ck37 = 1.0 time = 190
* CHECK dout0_34 vdout0_34ck37 = 1.0 time = 190
* CHECK dout0_35 vdout0_35ck37 = 1.0 time = 190
* CHECK dout0_36 vdout0_36ck37 = 1.0 time = 190
* CHECK dout0_37 vdout0_37ck37 = 1.0 time = 190
* CHECK dout0_38 vdout0_38ck37 = 0 time = 190
* CHECK dout0_39 vdout0_39ck37 = 0 time = 190
* CHECK dout0_40 vdout0_40ck37 = 1.0 time = 190
* CHECK dout0_41 vdout0_41ck37 = 0 time = 190
* CHECK dout0_42 vdout0_42ck37 = 1.0 time = 190
* CHECK dout0_43 vdout0_43ck37 = 1.0 time = 190
* CHECK dout0_44 vdout0_44ck37 = 1.0 time = 190
* CHECK dout0_45 vdout0_45ck37 = 1.0 time = 190
* CHECK dout0_46 vdout0_46ck37 = 1.0 time = 190
* CHECK dout0_47 vdout0_47ck37 = 1.0 time = 190
* CHECK dout0_48 vdout0_48ck37 = 1.0 time = 190
* CHECK dout0_49 vdout0_49ck37 = 0 time = 190
* CHECK dout0_50 vdout0_50ck37 = 0 time = 190
* CHECK dout0_51 vdout0_51ck37 = 0 time = 190
* CHECK dout0_52 vdout0_52ck37 = 1.0 time = 190
* CHECK dout0_53 vdout0_53ck37 = 0 time = 190
* CHECK dout0_54 vdout0_54ck37 = 0 time = 190
* CHECK dout0_55 vdout0_55ck37 = 1.0 time = 190
* CHECK dout0_56 vdout0_56ck37 = 1.0 time = 190
* CHECK dout0_57 vdout0_57ck37 = 1.0 time = 190
* CHECK dout0_58 vdout0_58ck37 = 0 time = 190
* CHECK dout0_59 vdout0_59ck37 = 0 time = 190
* CHECK dout0_60 vdout0_60ck37 = 1.0 time = 190
* CHECK dout0_61 vdout0_61ck37 = 0 time = 190
* CHECK dout0_62 vdout0_62ck37 = 1.0 time = 190
* CHECK dout0_63 vdout0_63ck37 = 1.0 time = 190
* CHECK dout0_0 vdout0_0ck40 = 1.0 time = 205
* CHECK dout0_1 vdout0_1ck40 = 0 time = 205
* CHECK dout0_2 vdout0_2ck40 = 0 time = 205
* CHECK dout0_3 vdout0_3ck40 = 0 time = 205
* CHECK dout0_4 vdout0_4ck40 = 0 time = 205
* CHECK dout0_5 vdout0_5ck40 = 1.0 time = 205
* CHECK dout0_6 vdout0_6ck40 = 0 time = 205
* CHECK dout0_7 vdout0_7ck40 = 0 time = 205
* CHECK dout0_8 vdout0_8ck40 = 0 time = 205
* CHECK dout0_9 vdout0_9ck40 = 0 time = 205
* CHECK dout0_10 vdout0_10ck40 = 1.0 time = 205
* CHECK dout0_11 vdout0_11ck40 = 0 time = 205
* CHECK dout0_12 vdout0_12ck40 = 1.0 time = 205
* CHECK dout0_13 vdout0_13ck40 = 0 time = 205
* CHECK dout0_14 vdout0_14ck40 = 1.0 time = 205
* CHECK dout0_15 vdout0_15ck40 = 0 time = 205
* CHECK dout0_16 vdout0_16ck40 = 0 time = 205
* CHECK dout0_17 vdout0_17ck40 = 0 time = 205
* CHECK dout0_18 vdout0_18ck40 = 1.0 time = 205
* CHECK dout0_19 vdout0_19ck40 = 1.0 time = 205
* CHECK dout0_20 vdout0_20ck40 = 0 time = 205
* CHECK dout0_21 vdout0_21ck40 = 1.0 time = 205
* CHECK dout0_22 vdout0_22ck40 = 0 time = 205
* CHECK dout0_23 vdout0_23ck40 = 1.0 time = 205
* CHECK dout0_24 vdout0_24ck40 = 0 time = 205
* CHECK dout0_25 vdout0_25ck40 = 0 time = 205
* CHECK dout0_26 vdout0_26ck40 = 1.0 time = 205
* CHECK dout0_27 vdout0_27ck40 = 1.0 time = 205
* CHECK dout0_28 vdout0_28ck40 = 0 time = 205
* CHECK dout0_29 vdout0_29ck40 = 1.0 time = 205
* CHECK dout0_30 vdout0_30ck40 = 1.0 time = 205
* CHECK dout0_31 vdout0_31ck40 = 0 time = 205
* CHECK dout0_32 vdout0_32ck40 = 0 time = 205
* CHECK dout0_33 vdout0_33ck40 = 1.0 time = 205
* CHECK dout0_34 vdout0_34ck40 = 0 time = 205
* CHECK dout0_35 vdout0_35ck40 = 0 time = 205
* CHECK dout0_36 vdout0_36ck40 = 0 time = 205
* CHECK dout0_37 vdout0_37ck40 = 0 time = 205
* CHECK dout0_38 vdout0_38ck40 = 0 time = 205
* CHECK dout0_39 vdout0_39ck40 = 0 time = 205
* CHECK dout0_40 vdout0_40ck40 = 1.0 time = 205
* CHECK dout0_41 vdout0_41ck40 = 1.0 time = 205
* CHECK dout0_42 vdout0_42ck40 = 1.0 time = 205
* CHECK dout0_43 vdout0_43ck40 = 1.0 time = 205
* CHECK dout0_44 vdout0_44ck40 = 0 time = 205
* CHECK dout0_45 vdout0_45ck40 = 1.0 time = 205
* CHECK dout0_46 vdout0_46ck40 = 0 time = 205
* CHECK dout0_47 vdout0_47ck40 = 0 time = 205
* CHECK dout0_48 vdout0_48ck40 = 1.0 time = 205
* CHECK dout0_49 vdout0_49ck40 = 0 time = 205
* CHECK dout0_50 vdout0_50ck40 = 0 time = 205
* CHECK dout0_51 vdout0_51ck40 = 0 time = 205
* CHECK dout0_52 vdout0_52ck40 = 0 time = 205
* CHECK dout0_53 vdout0_53ck40 = 0 time = 205
* CHECK dout0_54 vdout0_54ck40 = 1.0 time = 205
* CHECK dout0_55 vdout0_55ck40 = 0 time = 205
* CHECK dout0_56 vdout0_56ck40 = 1.0 time = 205
* CHECK dout0_57 vdout0_57ck40 = 0 time = 205
* CHECK dout0_58 vdout0_58ck40 = 1.0 time = 205
* CHECK dout0_59 vdout0_59ck40 = 1.0 time = 205
* CHECK dout0_60 vdout0_60ck40 = 1.0 time = 205
* CHECK dout0_61 vdout0_61ck40 = 1.0 time = 205
* CHECK dout0_62 vdout0_62ck40 = 0 time = 205
* CHECK dout0_63 vdout0_63ck40 = 0 time = 205
* CHECK dout0_0 vdout0_0ck41 = 0 time = 210
* CHECK dout0_1 vdout0_1ck41 = 1.0 time = 210
* CHECK dout0_2 vdout0_2ck41 = 0 time = 210
* CHECK dout0_3 vdout0_3ck41 = 1.0 time = 210
* CHECK dout0_4 vdout0_4ck41 = 0 time = 210
* CHECK dout0_5 vdout0_5ck41 = 1.0 time = 210
* CHECK dout0_6 vdout0_6ck41 = 1.0 time = 210
* CHECK dout0_7 vdout0_7ck41 = 0 time = 210
* CHECK dout0_8 vdout0_8ck41 = 1.0 time = 210
* CHECK dout0_9 vdout0_9ck41 = 1.0 time = 210
* CHECK dout0_10 vdout0_10ck41 = 0 time = 210
* CHECK dout0_11 vdout0_11ck41 = 1.0 time = 210
* CHECK dout0_12 vdout0_12ck41 = 1.0 time = 210
* CHECK dout0_13 vdout0_13ck41 = 0 time = 210
* CHECK dout0_14 vdout0_14ck41 = 0 time = 210
* CHECK dout0_15 vdout0_15ck41 = 0 time = 210
* CHECK dout0_16 vdout0_16ck41 = 0 time = 210
* CHECK dout0_17 vdout0_17ck41 = 0 time = 210
* CHECK dout0_18 vdout0_18ck41 = 1.0 time = 210
* CHECK dout0_19 vdout0_19ck41 = 1.0 time = 210
* CHECK dout0_20 vdout0_20ck41 = 0 time = 210
* CHECK dout0_21 vdout0_21ck41 = 1.0 time = 210
* CHECK dout0_22 vdout0_22ck41 = 0 time = 210
* CHECK dout0_23 vdout0_23ck41 = 0 time = 210
* CHECK dout0_24 vdout0_24ck41 = 1.0 time = 210
* CHECK dout0_25 vdout0_25ck41 = 1.0 time = 210
* CHECK dout0_26 vdout0_26ck41 = 1.0 time = 210
* CHECK dout0_27 vdout0_27ck41 = 1.0 time = 210
* CHECK dout0_28 vdout0_28ck41 = 0 time = 210
* CHECK dout0_29 vdout0_29ck41 = 0 time = 210
* CHECK dout0_30 vdout0_30ck41 = 1.0 time = 210
* CHECK dout0_31 vdout0_31ck41 = 0 time = 210
* CHECK dout0_32 vdout0_32ck41 = 0 time = 210
* CHECK dout0_33 vdout0_33ck41 = 0 time = 210
* CHECK dout0_34 vdout0_34ck41 = 1.0 time = 210
* CHECK dout0_35 vdout0_35ck41 = 0 time = 210
* CHECK dout0_36 vdout0_36ck41 = 0 time = 210
* CHECK dout0_37 vdout0_37ck41 = 1.0 time = 210
* CHECK dout0_38 vdout0_38ck41 = 1.0 time = 210
* CHECK dout0_39 vdout0_39ck41 = 0 time = 210
* CHECK dout0_40 vdout0_40ck41 = 0 time = 210
* CHECK dout0_41 vdout0_41ck41 = 0 time = 210
* CHECK dout0_42 vdout0_42ck41 = 0 time = 210
* CHECK dout0_43 vdout0_43ck41 = 1.0 time = 210
* CHECK dout0_44 vdout0_44ck41 = 0 time = 210
* CHECK dout0_45 vdout0_45ck41 = 1.0 time = 210
* CHECK dout0_46 vdout0_46ck41 = 0 time = 210
* CHECK dout0_47 vdout0_47ck41 = 0 time = 210
* CHECK dout0_48 vdout0_48ck41 = 1.0 time = 210
* CHECK dout0_49 vdout0_49ck41 = 1.0 time = 210
* CHECK dout0_50 vdout0_50ck41 = 0 time = 210
* CHECK dout0_51 vdout0_51ck41 = 0 time = 210
* CHECK dout0_52 vdout0_52ck41 = 0 time = 210
* CHECK dout0_53 vdout0_53ck41 = 1.0 time = 210
* CHECK dout0_54 vdout0_54ck41 = 0 time = 210
* CHECK dout0_55 vdout0_55ck41 = 0 time = 210
* CHECK dout0_56 vdout0_56ck41 = 1.0 time = 210
* CHECK dout0_57 vdout0_57ck41 = 0 time = 210
* CHECK dout0_58 vdout0_58ck41 = 1.0 time = 210
* CHECK dout0_59 vdout0_59ck41 = 0 time = 210
* CHECK dout0_60 vdout0_60ck41 = 1.0 time = 210
* CHECK dout0_61 vdout0_61ck41 = 1.0 time = 210
* CHECK dout0_62 vdout0_62ck41 = 0 time = 210
* CHECK dout0_63 vdout0_63ck41 = 0 time = 210
* CHECK dout1_0 vdout1_0ck41 = 0 time = 210
* CHECK dout1_1 vdout1_1ck41 = 1.0 time = 210
* CHECK dout1_2 vdout1_2ck41 = 0 time = 210
* CHECK dout1_3 vdout1_3ck41 = 1.0 time = 210
* CHECK dout1_4 vdout1_4ck41 = 0 time = 210
* CHECK dout1_5 vdout1_5ck41 = 0 time = 210
* CHECK dout1_6 vdout1_6ck41 = 0 time = 210
* CHECK dout1_7 vdout1_7ck41 = 1.0 time = 210
* CHECK dout1_8 vdout1_8ck41 = 1.0 time = 210
* CHECK dout1_9 vdout1_9ck41 = 0 time = 210
* CHECK dout1_10 vdout1_10ck41 = 1.0 time = 210
* CHECK dout1_11 vdout1_11ck41 = 0 time = 210
* CHECK dout1_12 vdout1_12ck41 = 1.0 time = 210
* CHECK dout1_13 vdout1_13ck41 = 0 time = 210
* CHECK dout1_14 vdout1_14ck41 = 1.0 time = 210
* CHECK dout1_15 vdout1_15ck41 = 0 time = 210
* CHECK dout1_16 vdout1_16ck41 = 1.0 time = 210
* CHECK dout1_17 vdout1_17ck41 = 1.0 time = 210
* CHECK dout1_18 vdout1_18ck41 = 1.0 time = 210
* CHECK dout1_19 vdout1_19ck41 = 1.0 time = 210
* CHECK dout1_20 vdout1_20ck41 = 0 time = 210
* CHECK dout1_21 vdout1_21ck41 = 0 time = 210
* CHECK dout1_22 vdout1_22ck41 = 0 time = 210
* CHECK dout1_23 vdout1_23ck41 = 1.0 time = 210
* CHECK dout1_24 vdout1_24ck41 = 1.0 time = 210
* CHECK dout1_25 vdout1_25ck41 = 1.0 time = 210
* CHECK dout1_26 vdout1_26ck41 = 1.0 time = 210
* CHECK dout1_27 vdout1_27ck41 = 0 time = 210
* CHECK dout1_28 vdout1_28ck41 = 1.0 time = 210
* CHECK dout1_29 vdout1_29ck41 = 1.0 time = 210
* CHECK dout1_30 vdout1_30ck41 = 1.0 time = 210
* CHECK dout1_31 vdout1_31ck41 = 1.0 time = 210
* CHECK dout1_32 vdout1_32ck41 = 0 time = 210
* CHECK dout1_33 vdout1_33ck41 = 1.0 time = 210
* CHECK dout1_34 vdout1_34ck41 = 1.0 time = 210
* CHECK dout1_35 vdout1_35ck41 = 1.0 time = 210
* CHECK dout1_36 vdout1_36ck41 = 1.0 time = 210
* CHECK dout1_37 vdout1_37ck41 = 0 time = 210
* CHECK dout1_38 vdout1_38ck41 = 0 time = 210
* CHECK dout1_39 vdout1_39ck41 = 1.0 time = 210
* CHECK dout1_40 vdout1_40ck41 = 1.0 time = 210
* CHECK dout1_41 vdout1_41ck41 = 0 time = 210
* CHECK dout1_42 vdout1_42ck41 = 1.0 time = 210
* CHECK dout1_43 vdout1_43ck41 = 0 time = 210
* CHECK dout1_44 vdout1_44ck41 = 1.0 time = 210
* CHECK dout1_45 vdout1_45ck41 = 1.0 time = 210
* CHECK dout1_46 vdout1_46ck41 = 0 time = 210
* CHECK dout1_47 vdout1_47ck41 = 0 time = 210
* CHECK dout1_48 vdout1_48ck41 = 0 time = 210
* CHECK dout1_49 vdout1_49ck41 = 0 time = 210
* CHECK dout1_50 vdout1_50ck41 = 1.0 time = 210
* CHECK dout1_51 vdout1_51ck41 = 0 time = 210
* CHECK dout1_52 vdout1_52ck41 = 0 time = 210
* CHECK dout1_53 vdout1_53ck41 = 1.0 time = 210
* CHECK dout1_54 vdout1_54ck41 = 1.0 time = 210
* CHECK dout1_55 vdout1_55ck41 = 1.0 time = 210
* CHECK dout1_56 vdout1_56ck41 = 0 time = 210
* CHECK dout1_57 vdout1_57ck41 = 1.0 time = 210
* CHECK dout1_58 vdout1_58ck41 = 0 time = 210
* CHECK dout1_59 vdout1_59ck41 = 0 time = 210
* CHECK dout1_60 vdout1_60ck41 = 0 time = 210
* CHECK dout1_61 vdout1_61ck41 = 1.0 time = 210
* CHECK dout1_62 vdout1_62ck41 = 1.0 time = 210
* CHECK dout1_63 vdout1_63ck41 = 0 time = 210
* CHECK dout0_0 vdout0_0ck42 = 1.0 time = 215
* CHECK dout0_1 vdout0_1ck42 = 0 time = 215
* CHECK dout0_2 vdout0_2ck42 = 0 time = 215
* CHECK dout0_3 vdout0_3ck42 = 1.0 time = 215
* CHECK dout0_4 vdout0_4ck42 = 1.0 time = 215
* CHECK dout0_5 vdout0_5ck42 = 0 time = 215
* CHECK dout0_6 vdout0_6ck42 = 1.0 time = 215
* CHECK dout0_7 vdout0_7ck42 = 1.0 time = 215
* CHECK dout0_8 vdout0_8ck42 = 0 time = 215
* CHECK dout0_9 vdout0_9ck42 = 1.0 time = 215
* CHECK dout0_10 vdout0_10ck42 = 0 time = 215
* CHECK dout0_11 vdout0_11ck42 = 1.0 time = 215
* CHECK dout0_12 vdout0_12ck42 = 0 time = 215
* CHECK dout0_13 vdout0_13ck42 = 1.0 time = 215
* CHECK dout0_14 vdout0_14ck42 = 1.0 time = 215
* CHECK dout0_15 vdout0_15ck42 = 1.0 time = 215
* CHECK dout0_16 vdout0_16ck42 = 1.0 time = 215
* CHECK dout0_17 vdout0_17ck42 = 1.0 time = 215
* CHECK dout0_18 vdout0_18ck42 = 1.0 time = 215
* CHECK dout0_19 vdout0_19ck42 = 1.0 time = 215
* CHECK dout0_20 vdout0_20ck42 = 0 time = 215
* CHECK dout0_21 vdout0_21ck42 = 0 time = 215
* CHECK dout0_22 vdout0_22ck42 = 1.0 time = 215
* CHECK dout0_23 vdout0_23ck42 = 0 time = 215
* CHECK dout0_24 vdout0_24ck42 = 1.0 time = 215
* CHECK dout0_25 vdout0_25ck42 = 1.0 time = 215
* CHECK dout0_26 vdout0_26ck42 = 1.0 time = 215
* CHECK dout0_27 vdout0_27ck42 = 0 time = 215
* CHECK dout0_28 vdout0_28ck42 = 0 time = 215
* CHECK dout0_29 vdout0_29ck42 = 1.0 time = 215
* CHECK dout0_30 vdout0_30ck42 = 1.0 time = 215
* CHECK dout0_31 vdout0_31ck42 = 1.0 time = 215
* CHECK dout0_32 vdout0_32ck42 = 1.0 time = 215
* CHECK dout0_33 vdout0_33ck42 = 0 time = 215
* CHECK dout0_34 vdout0_34ck42 = 1.0 time = 215
* CHECK dout0_35 vdout0_35ck42 = 0 time = 215
* CHECK dout0_36 vdout0_36ck42 = 1.0 time = 215
* CHECK dout0_37 vdout0_37ck42 = 0 time = 215
* CHECK dout0_38 vdout0_38ck42 = 0 time = 215
* CHECK dout0_39 vdout0_39ck42 = 0 time = 215
* CHECK dout0_40 vdout0_40ck42 = 1.0 time = 215
* CHECK dout0_41 vdout0_41ck42 = 0 time = 215
* CHECK dout0_42 vdout0_42ck42 = 1.0 time = 215
* CHECK dout0_43 vdout0_43ck42 = 1.0 time = 215
* CHECK dout0_44 vdout0_44ck42 = 1.0 time = 215
* CHECK dout0_45 vdout0_45ck42 = 0 time = 215
* CHECK dout0_46 vdout0_46ck42 = 0 time = 215
* CHECK dout0_47 vdout0_47ck42 = 1.0 time = 215
* CHECK dout0_48 vdout0_48ck42 = 1.0 time = 215
* CHECK dout0_49 vdout0_49ck42 = 0 time = 215
* CHECK dout0_50 vdout0_50ck42 = 1.0 time = 215
* CHECK dout0_51 vdout0_51ck42 = 1.0 time = 215
* CHECK dout0_52 vdout0_52ck42 = 1.0 time = 215
* CHECK dout0_53 vdout0_53ck42 = 1.0 time = 215
* CHECK dout0_54 vdout0_54ck42 = 1.0 time = 215
* CHECK dout0_55 vdout0_55ck42 = 1.0 time = 215
* CHECK dout0_56 vdout0_56ck42 = 0 time = 215
* CHECK dout0_57 vdout0_57ck42 = 0 time = 215
* CHECK dout0_58 vdout0_58ck42 = 0 time = 215
* CHECK dout0_59 vdout0_59ck42 = 0 time = 215
* CHECK dout0_60 vdout0_60ck42 = 0 time = 215
* CHECK dout0_61 vdout0_61ck42 = 1.0 time = 215
* CHECK dout0_62 vdout0_62ck42 = 0 time = 215
* CHECK dout0_63 vdout0_63ck42 = 1.0 time = 215
* CHECK dout1_0 vdout1_0ck42 = 0 time = 215
* CHECK dout1_1 vdout1_1ck42 = 1.0 time = 215
* CHECK dout1_2 vdout1_2ck42 = 0 time = 215
* CHECK dout1_3 vdout1_3ck42 = 1.0 time = 215
* CHECK dout1_4 vdout1_4ck42 = 0 time = 215
* CHECK dout1_5 vdout1_5ck42 = 1.0 time = 215
* CHECK dout1_6 vdout1_6ck42 = 1.0 time = 215
* CHECK dout1_7 vdout1_7ck42 = 0 time = 215
* CHECK dout1_8 vdout1_8ck42 = 1.0 time = 215
* CHECK dout1_9 vdout1_9ck42 = 1.0 time = 215
* CHECK dout1_10 vdout1_10ck42 = 0 time = 215
* CHECK dout1_11 vdout1_11ck42 = 1.0 time = 215
* CHECK dout1_12 vdout1_12ck42 = 1.0 time = 215
* CHECK dout1_13 vdout1_13ck42 = 0 time = 215
* CHECK dout1_14 vdout1_14ck42 = 0 time = 215
* CHECK dout1_15 vdout1_15ck42 = 0 time = 215
* CHECK dout1_16 vdout1_16ck42 = 0 time = 215
* CHECK dout1_17 vdout1_17ck42 = 0 time = 215
* CHECK dout1_18 vdout1_18ck42 = 1.0 time = 215
* CHECK dout1_19 vdout1_19ck42 = 1.0 time = 215
* CHECK dout1_20 vdout1_20ck42 = 0 time = 215
* CHECK dout1_21 vdout1_21ck42 = 1.0 time = 215
* CHECK dout1_22 vdout1_22ck42 = 0 time = 215
* CHECK dout1_23 vdout1_23ck42 = 0 time = 215
* CHECK dout1_24 vdout1_24ck42 = 1.0 time = 215
* CHECK dout1_25 vdout1_25ck42 = 1.0 time = 215
* CHECK dout1_26 vdout1_26ck42 = 1.0 time = 215
* CHECK dout1_27 vdout1_27ck42 = 1.0 time = 215
* CHECK dout1_28 vdout1_28ck42 = 0 time = 215
* CHECK dout1_29 vdout1_29ck42 = 0 time = 215
* CHECK dout1_30 vdout1_30ck42 = 1.0 time = 215
* CHECK dout1_31 vdout1_31ck42 = 0 time = 215
* CHECK dout1_32 vdout1_32ck42 = 0 time = 215
* CHECK dout1_33 vdout1_33ck42 = 0 time = 215
* CHECK dout1_34 vdout1_34ck42 = 1.0 time = 215
* CHECK dout1_35 vdout1_35ck42 = 0 time = 215
* CHECK dout1_36 vdout1_36ck42 = 0 time = 215
* CHECK dout1_37 vdout1_37ck42 = 1.0 time = 215
* CHECK dout1_38 vdout1_38ck42 = 1.0 time = 215
* CHECK dout1_39 vdout1_39ck42 = 0 time = 215
* CHECK dout1_40 vdout1_40ck42 = 0 time = 215
* CHECK dout1_41 vdout1_41ck42 = 0 time = 215
* CHECK dout1_42 vdout1_42ck42 = 0 time = 215
* CHECK dout1_43 vdout1_43ck42 = 1.0 time = 215
* CHECK dout1_44 vdout1_44ck42 = 0 time = 215
* CHECK dout1_45 vdout1_45ck42 = 1.0 time = 215
* CHECK dout1_46 vdout1_46ck42 = 0 time = 215
* CHECK dout1_47 vdout1_47ck42 = 0 time = 215
* CHECK dout1_48 vdout1_48ck42 = 1.0 time = 215
* CHECK dout1_49 vdout1_49ck42 = 1.0 time = 215
* CHECK dout1_50 vdout1_50ck42 = 0 time = 215
* CHECK dout1_51 vdout1_51ck42 = 0 time = 215
* CHECK dout1_52 vdout1_52ck42 = 0 time = 215
* CHECK dout1_53 vdout1_53ck42 = 1.0 time = 215
* CHECK dout1_54 vdout1_54ck42 = 0 time = 215
* CHECK dout1_55 vdout1_55ck42 = 0 time = 215
* CHECK dout1_56 vdout1_56ck42 = 1.0 time = 215
* CHECK dout1_57 vdout1_57ck42 = 0 time = 215
* CHECK dout1_58 vdout1_58ck42 = 1.0 time = 215
* CHECK dout1_59 vdout1_59ck42 = 0 time = 215
* CHECK dout1_60 vdout1_60ck42 = 1.0 time = 215
* CHECK dout1_61 vdout1_61ck42 = 1.0 time = 215
* CHECK dout1_62 vdout1_62ck42 = 0 time = 215
* CHECK dout1_63 vdout1_63ck42 = 0 time = 215
* CHECK dout0_0 vdout0_0ck43 = 0 time = 220
* CHECK dout0_1 vdout0_1ck43 = 1.0 time = 220
* CHECK dout0_2 vdout0_2ck43 = 1.0 time = 220
* CHECK dout0_3 vdout0_3ck43 = 0 time = 220
* CHECK dout0_4 vdout0_4ck43 = 1.0 time = 220
* CHECK dout0_5 vdout0_5ck43 = 0 time = 220
* CHECK dout0_6 vdout0_6ck43 = 0 time = 220
* CHECK dout0_7 vdout0_7ck43 = 1.0 time = 220
* CHECK dout0_8 vdout0_8ck43 = 0 time = 220
* CHECK dout0_9 vdout0_9ck43 = 0 time = 220
* CHECK dout0_10 vdout0_10ck43 = 1.0 time = 220
* CHECK dout0_11 vdout0_11ck43 = 1.0 time = 220
* CHECK dout0_12 vdout0_12ck43 = 1.0 time = 220
* CHECK dout0_13 vdout0_13ck43 = 1.0 time = 220
* CHECK dout0_14 vdout0_14ck43 = 0 time = 220
* CHECK dout0_15 vdout0_15ck43 = 0 time = 220
* CHECK dout0_16 vdout0_16ck43 = 1.0 time = 220
* CHECK dout0_17 vdout0_17ck43 = 1.0 time = 220
* CHECK dout0_18 vdout0_18ck43 = 0 time = 220
* CHECK dout0_19 vdout0_19ck43 = 0 time = 220
* CHECK dout0_20 vdout0_20ck43 = 0 time = 220
* CHECK dout0_21 vdout0_21ck43 = 0 time = 220
* CHECK dout0_22 vdout0_22ck43 = 1.0 time = 220
* CHECK dout0_23 vdout0_23ck43 = 0 time = 220
* CHECK dout0_24 vdout0_24ck43 = 0 time = 220
* CHECK dout0_25 vdout0_25ck43 = 1.0 time = 220
* CHECK dout0_26 vdout0_26ck43 = 0 time = 220
* CHECK dout0_27 vdout0_27ck43 = 1.0 time = 220
* CHECK dout0_28 vdout0_28ck43 = 0 time = 220
* CHECK dout0_29 vdout0_29ck43 = 1.0 time = 220
* CHECK dout0_30 vdout0_30ck43 = 1.0 time = 220
* CHECK dout0_31 vdout0_31ck43 = 0 time = 220
* CHECK dout0_32 vdout0_32ck43 = 0 time = 220
* CHECK dout0_33 vdout0_33ck43 = 0 time = 220
* CHECK dout0_34 vdout0_34ck43 = 1.0 time = 220
* CHECK dout0_35 vdout0_35ck43 = 0 time = 220
* CHECK dout0_36 vdout0_36ck43 = 1.0 time = 220
* CHECK dout0_37 vdout0_37ck43 = 0 time = 220
* CHECK dout0_38 vdout0_38ck43 = 0 time = 220
* CHECK dout0_39 vdout0_39ck43 = 1.0 time = 220
* CHECK dout0_40 vdout0_40ck43 = 0 time = 220
* CHECK dout0_41 vdout0_41ck43 = 0 time = 220
* CHECK dout0_42 vdout0_42ck43 = 1.0 time = 220
* CHECK dout0_43 vdout0_43ck43 = 1.0 time = 220
* CHECK dout0_44 vdout0_44ck43 = 1.0 time = 220
* CHECK dout0_45 vdout0_45ck43 = 1.0 time = 220
* CHECK dout0_46 vdout0_46ck43 = 0 time = 220
* CHECK dout0_47 vdout0_47ck43 = 1.0 time = 220
* CHECK dout0_48 vdout0_48ck43 = 1.0 time = 220
* CHECK dout0_49 vdout0_49ck43 = 0 time = 220
* CHECK dout0_50 vdout0_50ck43 = 1.0 time = 220
* CHECK dout0_51 vdout0_51ck43 = 1.0 time = 220
* CHECK dout0_52 vdout0_52ck43 = 1.0 time = 220
* CHECK dout0_53 vdout0_53ck43 = 0 time = 220
* CHECK dout0_54 vdout0_54ck43 = 0 time = 220
* CHECK dout0_55 vdout0_55ck43 = 0 time = 220
* CHECK dout0_56 vdout0_56ck43 = 1.0 time = 220
* CHECK dout0_57 vdout0_57ck43 = 0 time = 220
* CHECK dout0_58 vdout0_58ck43 = 1.0 time = 220
* CHECK dout0_59 vdout0_59ck43 = 1.0 time = 220
* CHECK dout0_60 vdout0_60ck43 = 0 time = 220
* CHECK dout0_61 vdout0_61ck43 = 0 time = 220
* CHECK dout0_62 vdout0_62ck43 = 0 time = 220
* CHECK dout0_63 vdout0_63ck43 = 0 time = 220
* CHECK dout1_0 vdout1_0ck43 = 0 time = 220
* CHECK dout1_1 vdout1_1ck43 = 1.0 time = 220
* CHECK dout1_2 vdout1_2ck43 = 0 time = 220
* CHECK dout1_3 vdout1_3ck43 = 1.0 time = 220
* CHECK dout1_4 vdout1_4ck43 = 0 time = 220
* CHECK dout1_5 vdout1_5ck43 = 0 time = 220
* CHECK dout1_6 vdout1_6ck43 = 0 time = 220
* CHECK dout1_7 vdout1_7ck43 = 1.0 time = 220
* CHECK dout1_8 vdout1_8ck43 = 1.0 time = 220
* CHECK dout1_9 vdout1_9ck43 = 0 time = 220
* CHECK dout1_10 vdout1_10ck43 = 1.0 time = 220
* CHECK dout1_11 vdout1_11ck43 = 0 time = 220
* CHECK dout1_12 vdout1_12ck43 = 1.0 time = 220
* CHECK dout1_13 vdout1_13ck43 = 0 time = 220
* CHECK dout1_14 vdout1_14ck43 = 1.0 time = 220
* CHECK dout1_15 vdout1_15ck43 = 0 time = 220
* CHECK dout1_16 vdout1_16ck43 = 1.0 time = 220
* CHECK dout1_17 vdout1_17ck43 = 1.0 time = 220
* CHECK dout1_18 vdout1_18ck43 = 1.0 time = 220
* CHECK dout1_19 vdout1_19ck43 = 1.0 time = 220
* CHECK dout1_20 vdout1_20ck43 = 0 time = 220
* CHECK dout1_21 vdout1_21ck43 = 0 time = 220
* CHECK dout1_22 vdout1_22ck43 = 0 time = 220
* CHECK dout1_23 vdout1_23ck43 = 1.0 time = 220
* CHECK dout1_24 vdout1_24ck43 = 1.0 time = 220
* CHECK dout1_25 vdout1_25ck43 = 1.0 time = 220
* CHECK dout1_26 vdout1_26ck43 = 1.0 time = 220
* CHECK dout1_27 vdout1_27ck43 = 0 time = 220
* CHECK dout1_28 vdout1_28ck43 = 1.0 time = 220
* CHECK dout1_29 vdout1_29ck43 = 1.0 time = 220
* CHECK dout1_30 vdout1_30ck43 = 1.0 time = 220
* CHECK dout1_31 vdout1_31ck43 = 1.0 time = 220
* CHECK dout1_32 vdout1_32ck43 = 0 time = 220
* CHECK dout1_33 vdout1_33ck43 = 1.0 time = 220
* CHECK dout1_34 vdout1_34ck43 = 1.0 time = 220
* CHECK dout1_35 vdout1_35ck43 = 1.0 time = 220
* CHECK dout1_36 vdout1_36ck43 = 1.0 time = 220
* CHECK dout1_37 vdout1_37ck43 = 0 time = 220
* CHECK dout1_38 vdout1_38ck43 = 0 time = 220
* CHECK dout1_39 vdout1_39ck43 = 1.0 time = 220
* CHECK dout1_40 vdout1_40ck43 = 1.0 time = 220
* CHECK dout1_41 vdout1_41ck43 = 0 time = 220
* CHECK dout1_42 vdout1_42ck43 = 1.0 time = 220
* CHECK dout1_43 vdout1_43ck43 = 0 time = 220
* CHECK dout1_44 vdout1_44ck43 = 1.0 time = 220
* CHECK dout1_45 vdout1_45ck43 = 1.0 time = 220
* CHECK dout1_46 vdout1_46ck43 = 0 time = 220
* CHECK dout1_47 vdout1_47ck43 = 0 time = 220
* CHECK dout1_48 vdout1_48ck43 = 0 time = 220
* CHECK dout1_49 vdout1_49ck43 = 0 time = 220
* CHECK dout1_50 vdout1_50ck43 = 1.0 time = 220
* CHECK dout1_51 vdout1_51ck43 = 0 time = 220
* CHECK dout1_52 vdout1_52ck43 = 0 time = 220
* CHECK dout1_53 vdout1_53ck43 = 1.0 time = 220
* CHECK dout1_54 vdout1_54ck43 = 1.0 time = 220
* CHECK dout1_55 vdout1_55ck43 = 1.0 time = 220
* CHECK dout1_56 vdout1_56ck43 = 0 time = 220
* CHECK dout1_57 vdout1_57ck43 = 1.0 time = 220
* CHECK dout1_58 vdout1_58ck43 = 0 time = 220
* CHECK dout1_59 vdout1_59ck43 = 0 time = 220
* CHECK dout1_60 vdout1_60ck43 = 0 time = 220
* CHECK dout1_61 vdout1_61ck43 = 1.0 time = 220
* CHECK dout1_62 vdout1_62ck43 = 1.0 time = 220
* CHECK dout1_63 vdout1_63ck43 = 0 time = 220
* CHECK dout0_0 vdout0_0ck44 = 1.0 time = 225
* CHECK dout0_1 vdout0_1ck44 = 0 time = 225
* CHECK dout0_2 vdout0_2ck44 = 1.0 time = 225
* CHECK dout0_3 vdout0_3ck44 = 0 time = 225
* CHECK dout0_4 vdout0_4ck44 = 0 time = 225
* CHECK dout0_5 vdout0_5ck44 = 1.0 time = 225
* CHECK dout0_6 vdout0_6ck44 = 1.0 time = 225
* CHECK dout0_7 vdout0_7ck44 = 0 time = 225
* CHECK dout0_8 vdout0_8ck44 = 0 time = 225
* CHECK dout0_9 vdout0_9ck44 = 1.0 time = 225
* CHECK dout0_10 vdout0_10ck44 = 0 time = 225
* CHECK dout0_11 vdout0_11ck44 = 1.0 time = 225
* CHECK dout0_12 vdout0_12ck44 = 0 time = 225
* CHECK dout0_13 vdout0_13ck44 = 0 time = 225
* CHECK dout0_14 vdout0_14ck44 = 1.0 time = 225
* CHECK dout0_15 vdout0_15ck44 = 1.0 time = 225
* CHECK dout0_16 vdout0_16ck44 = 1.0 time = 225
* CHECK dout0_17 vdout0_17ck44 = 0 time = 225
* CHECK dout0_18 vdout0_18ck44 = 0 time = 225
* CHECK dout0_19 vdout0_19ck44 = 0 time = 225
* CHECK dout0_20 vdout0_20ck44 = 0 time = 225
* CHECK dout0_21 vdout0_21ck44 = 0 time = 225
* CHECK dout0_22 vdout0_22ck44 = 1.0 time = 225
* CHECK dout0_23 vdout0_23ck44 = 1.0 time = 225
* CHECK dout0_24 vdout0_24ck44 = 1.0 time = 225
* CHECK dout0_25 vdout0_25ck44 = 0 time = 225
* CHECK dout0_26 vdout0_26ck44 = 0 time = 225
* CHECK dout0_27 vdout0_27ck44 = 1.0 time = 225
* CHECK dout0_28 vdout0_28ck44 = 0 time = 225
* CHECK dout0_29 vdout0_29ck44 = 1.0 time = 225
* CHECK dout0_30 vdout0_30ck44 = 1.0 time = 225
* CHECK dout0_31 vdout0_31ck44 = 0 time = 225
* CHECK dout0_32 vdout0_32ck44 = 0 time = 225
* CHECK dout0_33 vdout0_33ck44 = 1.0 time = 225
* CHECK dout0_34 vdout0_34ck44 = 0 time = 225
* CHECK dout0_35 vdout0_35ck44 = 1.0 time = 225
* CHECK dout0_36 vdout0_36ck44 = 0 time = 225
* CHECK dout0_37 vdout0_37ck44 = 0 time = 225
* CHECK dout0_38 vdout0_38ck44 = 0 time = 225
* CHECK dout0_39 vdout0_39ck44 = 1.0 time = 225
* CHECK dout0_40 vdout0_40ck44 = 1.0 time = 225
* CHECK dout0_41 vdout0_41ck44 = 0 time = 225
* CHECK dout0_42 vdout0_42ck44 = 0 time = 225
* CHECK dout0_43 vdout0_43ck44 = 0 time = 225
* CHECK dout0_44 vdout0_44ck44 = 1.0 time = 225
* CHECK dout0_45 vdout0_45ck44 = 0 time = 225
* CHECK dout0_46 vdout0_46ck44 = 1.0 time = 225
* CHECK dout0_47 vdout0_47ck44 = 0 time = 225
* CHECK dout0_48 vdout0_48ck44 = 0 time = 225
* CHECK dout0_49 vdout0_49ck44 = 0 time = 225
* CHECK dout0_50 vdout0_50ck44 = 0 time = 225
* CHECK dout0_51 vdout0_51ck44 = 1.0 time = 225
* CHECK dout0_52 vdout0_52ck44 = 0 time = 225
* CHECK dout0_53 vdout0_53ck44 = 0 time = 225
* CHECK dout0_54 vdout0_54ck44 = 0 time = 225
* CHECK dout0_55 vdout0_55ck44 = 1.0 time = 225
* CHECK dout0_56 vdout0_56ck44 = 1.0 time = 225
* CHECK dout0_57 vdout0_57ck44 = 0 time = 225
* CHECK dout0_58 vdout0_58ck44 = 1.0 time = 225
* CHECK dout0_59 vdout0_59ck44 = 0 time = 225
* CHECK dout0_60 vdout0_60ck44 = 0 time = 225
* CHECK dout0_61 vdout0_61ck44 = 0 time = 225
* CHECK dout0_62 vdout0_62ck44 = 1.0 time = 225
* CHECK dout0_63 vdout0_63ck44 = 1.0 time = 225
* CHECK dout1_0 vdout1_0ck44 = 1.0 time = 225
* CHECK dout1_1 vdout1_1ck44 = 0 time = 225
* CHECK dout1_2 vdout1_2ck44 = 1.0 time = 225
* CHECK dout1_3 vdout1_3ck44 = 0 time = 225
* CHECK dout1_4 vdout1_4ck44 = 0 time = 225
* CHECK dout1_5 vdout1_5ck44 = 1.0 time = 225
* CHECK dout1_6 vdout1_6ck44 = 1.0 time = 225
* CHECK dout1_7 vdout1_7ck44 = 0 time = 225
* CHECK dout1_8 vdout1_8ck44 = 0 time = 225
* CHECK dout1_9 vdout1_9ck44 = 1.0 time = 225
* CHECK dout1_10 vdout1_10ck44 = 0 time = 225
* CHECK dout1_11 vdout1_11ck44 = 1.0 time = 225
* CHECK dout1_12 vdout1_12ck44 = 0 time = 225
* CHECK dout1_13 vdout1_13ck44 = 0 time = 225
* CHECK dout1_14 vdout1_14ck44 = 1.0 time = 225
* CHECK dout1_15 vdout1_15ck44 = 1.0 time = 225
* CHECK dout1_16 vdout1_16ck44 = 1.0 time = 225
* CHECK dout1_17 vdout1_17ck44 = 0 time = 225
* CHECK dout1_18 vdout1_18ck44 = 0 time = 225
* CHECK dout1_19 vdout1_19ck44 = 0 time = 225
* CHECK dout1_20 vdout1_20ck44 = 0 time = 225
* CHECK dout1_21 vdout1_21ck44 = 0 time = 225
* CHECK dout1_22 vdout1_22ck44 = 1.0 time = 225
* CHECK dout1_23 vdout1_23ck44 = 1.0 time = 225
* CHECK dout1_24 vdout1_24ck44 = 1.0 time = 225
* CHECK dout1_25 vdout1_25ck44 = 0 time = 225
* CHECK dout1_26 vdout1_26ck44 = 0 time = 225
* CHECK dout1_27 vdout1_27ck44 = 1.0 time = 225
* CHECK dout1_28 vdout1_28ck44 = 0 time = 225
* CHECK dout1_29 vdout1_29ck44 = 1.0 time = 225
* CHECK dout1_30 vdout1_30ck44 = 1.0 time = 225
* CHECK dout1_31 vdout1_31ck44 = 0 time = 225
* CHECK dout1_32 vdout1_32ck44 = 0 time = 225
* CHECK dout1_33 vdout1_33ck44 = 1.0 time = 225
* CHECK dout1_34 vdout1_34ck44 = 0 time = 225
* CHECK dout1_35 vdout1_35ck44 = 1.0 time = 225
* CHECK dout1_36 vdout1_36ck44 = 0 time = 225
* CHECK dout1_37 vdout1_37ck44 = 0 time = 225
* CHECK dout1_38 vdout1_38ck44 = 0 time = 225
* CHECK dout1_39 vdout1_39ck44 = 1.0 time = 225
* CHECK dout1_40 vdout1_40ck44 = 1.0 time = 225
* CHECK dout1_41 vdout1_41ck44 = 0 time = 225
* CHECK dout1_42 vdout1_42ck44 = 0 time = 225
* CHECK dout1_43 vdout1_43ck44 = 0 time = 225
* CHECK dout1_44 vdout1_44ck44 = 1.0 time = 225
* CHECK dout1_45 vdout1_45ck44 = 0 time = 225
* CHECK dout1_46 vdout1_46ck44 = 1.0 time = 225
* CHECK dout1_47 vdout1_47ck44 = 0 time = 225
* CHECK dout1_48 vdout1_48ck44 = 0 time = 225
* CHECK dout1_49 vdout1_49ck44 = 0 time = 225
* CHECK dout1_50 vdout1_50ck44 = 0 time = 225
* CHECK dout1_51 vdout1_51ck44 = 1.0 time = 225
* CHECK dout1_52 vdout1_52ck44 = 0 time = 225
* CHECK dout1_53 vdout1_53ck44 = 0 time = 225
* CHECK dout1_54 vdout1_54ck44 = 0 time = 225
* CHECK dout1_55 vdout1_55ck44 = 1.0 time = 225
* CHECK dout1_56 vdout1_56ck44 = 1.0 time = 225
* CHECK dout1_57 vdout1_57ck44 = 0 time = 225
* CHECK dout1_58 vdout1_58ck44 = 1.0 time = 225
* CHECK dout1_59 vdout1_59ck44 = 0 time = 225
* CHECK dout1_60 vdout1_60ck44 = 0 time = 225
* CHECK dout1_61 vdout1_61ck44 = 0 time = 225
* CHECK dout1_62 vdout1_62ck44 = 1.0 time = 225
* CHECK dout1_63 vdout1_63ck44 = 1.0 time = 225
* CHECK dout0_0 vdout0_0ck46 = 0 time = 235
* CHECK dout0_1 vdout0_1ck46 = 1.0 time = 235
* CHECK dout0_2 vdout0_2ck46 = 0 time = 235
* CHECK dout0_3 vdout0_3ck46 = 1.0 time = 235
* CHECK dout0_4 vdout0_4ck46 = 0 time = 235
* CHECK dout0_5 vdout0_5ck46 = 0 time = 235
* CHECK dout0_6 vdout0_6ck46 = 0 time = 235
* CHECK dout0_7 vdout0_7ck46 = 1.0 time = 235
* CHECK dout0_8 vdout0_8ck46 = 1.0 time = 235
* CHECK dout0_9 vdout0_9ck46 = 0 time = 235
* CHECK dout0_10 vdout0_10ck46 = 1.0 time = 235
* CHECK dout0_11 vdout0_11ck46 = 0 time = 235
* CHECK dout0_12 vdout0_12ck46 = 1.0 time = 235
* CHECK dout0_13 vdout0_13ck46 = 0 time = 235
* CHECK dout0_14 vdout0_14ck46 = 1.0 time = 235
* CHECK dout0_15 vdout0_15ck46 = 0 time = 235
* CHECK dout0_16 vdout0_16ck46 = 1.0 time = 235
* CHECK dout0_17 vdout0_17ck46 = 1.0 time = 235
* CHECK dout0_18 vdout0_18ck46 = 1.0 time = 235
* CHECK dout0_19 vdout0_19ck46 = 1.0 time = 235
* CHECK dout0_20 vdout0_20ck46 = 0 time = 235
* CHECK dout0_21 vdout0_21ck46 = 0 time = 235
* CHECK dout0_22 vdout0_22ck46 = 0 time = 235
* CHECK dout0_23 vdout0_23ck46 = 1.0 time = 235
* CHECK dout0_24 vdout0_24ck46 = 1.0 time = 235
* CHECK dout0_25 vdout0_25ck46 = 1.0 time = 235
* CHECK dout0_26 vdout0_26ck46 = 1.0 time = 235
* CHECK dout0_27 vdout0_27ck46 = 0 time = 235
* CHECK dout0_28 vdout0_28ck46 = 1.0 time = 235
* CHECK dout0_29 vdout0_29ck46 = 1.0 time = 235
* CHECK dout0_30 vdout0_30ck46 = 1.0 time = 235
* CHECK dout0_31 vdout0_31ck46 = 1.0 time = 235
* CHECK dout0_32 vdout0_32ck46 = 0 time = 235
* CHECK dout0_33 vdout0_33ck46 = 1.0 time = 235
* CHECK dout0_34 vdout0_34ck46 = 1.0 time = 235
* CHECK dout0_35 vdout0_35ck46 = 1.0 time = 235
* CHECK dout0_36 vdout0_36ck46 = 1.0 time = 235
* CHECK dout0_37 vdout0_37ck46 = 0 time = 235
* CHECK dout0_38 vdout0_38ck46 = 0 time = 235
* CHECK dout0_39 vdout0_39ck46 = 1.0 time = 235
* CHECK dout0_40 vdout0_40ck46 = 1.0 time = 235
* CHECK dout0_41 vdout0_41ck46 = 0 time = 235
* CHECK dout0_42 vdout0_42ck46 = 1.0 time = 235
* CHECK dout0_43 vdout0_43ck46 = 0 time = 235
* CHECK dout0_44 vdout0_44ck46 = 1.0 time = 235
* CHECK dout0_45 vdout0_45ck46 = 1.0 time = 235
* CHECK dout0_46 vdout0_46ck46 = 0 time = 235
* CHECK dout0_47 vdout0_47ck46 = 0 time = 235
* CHECK dout0_48 vdout0_48ck46 = 0 time = 235
* CHECK dout0_49 vdout0_49ck46 = 0 time = 235
* CHECK dout0_50 vdout0_50ck46 = 1.0 time = 235
* CHECK dout0_51 vdout0_51ck46 = 0 time = 235
* CHECK dout0_52 vdout0_52ck46 = 0 time = 235
* CHECK dout0_53 vdout0_53ck46 = 1.0 time = 235
* CHECK dout0_54 vdout0_54ck46 = 1.0 time = 235
* CHECK dout0_55 vdout0_55ck46 = 1.0 time = 235
* CHECK dout0_56 vdout0_56ck46 = 0 time = 235
* CHECK dout0_57 vdout0_57ck46 = 1.0 time = 235
* CHECK dout0_58 vdout0_58ck46 = 0 time = 235
* CHECK dout0_59 vdout0_59ck46 = 0 time = 235
* CHECK dout0_60 vdout0_60ck46 = 0 time = 235
* CHECK dout0_61 vdout0_61ck46 = 1.0 time = 235
* CHECK dout0_62 vdout0_62ck46 = 1.0 time = 235
* CHECK dout0_63 vdout0_63ck46 = 0 time = 235
* CHECK dout1_0 vdout1_0ck46 = 1.0 time = 235
* CHECK dout1_1 vdout1_1ck46 = 1.0 time = 235
* CHECK dout1_2 vdout1_2ck46 = 0 time = 235
* CHECK dout1_3 vdout1_3ck46 = 1.0 time = 235
* CHECK dout1_4 vdout1_4ck46 = 0 time = 235
* CHECK dout1_5 vdout1_5ck46 = 1.0 time = 235
* CHECK dout1_6 vdout1_6ck46 = 0 time = 235
* CHECK dout1_7 vdout1_7ck46 = 0 time = 235
* CHECK dout1_8 vdout1_8ck46 = 0 time = 235
* CHECK dout1_9 vdout1_9ck46 = 1.0 time = 235
* CHECK dout1_10 vdout1_10ck46 = 0 time = 235
* CHECK dout1_11 vdout1_11ck46 = 0 time = 235
* CHECK dout1_12 vdout1_12ck46 = 1.0 time = 235
* CHECK dout1_13 vdout1_13ck46 = 1.0 time = 235
* CHECK dout1_14 vdout1_14ck46 = 1.0 time = 235
* CHECK dout1_15 vdout1_15ck46 = 0 time = 235
* CHECK dout1_16 vdout1_16ck46 = 1.0 time = 235
* CHECK dout1_17 vdout1_17ck46 = 0 time = 235
* CHECK dout1_18 vdout1_18ck46 = 0 time = 235
* CHECK dout1_19 vdout1_19ck46 = 1.0 time = 235
* CHECK dout1_20 vdout1_20ck46 = 0 time = 235
* CHECK dout1_21 vdout1_21ck46 = 0 time = 235
* CHECK dout1_22 vdout1_22ck46 = 0 time = 235
* CHECK dout1_23 vdout1_23ck46 = 1.0 time = 235
* CHECK dout1_24 vdout1_24ck46 = 0 time = 235
* CHECK dout1_25 vdout1_25ck46 = 1.0 time = 235
* CHECK dout1_26 vdout1_26ck46 = 0 time = 235
* CHECK dout1_27 vdout1_27ck46 = 1.0 time = 235
* CHECK dout1_28 vdout1_28ck46 = 0 time = 235
* CHECK dout1_29 vdout1_29ck46 = 0 time = 235
* CHECK dout1_30 vdout1_30ck46 = 1.0 time = 235
* CHECK dout1_31 vdout1_31ck46 = 0 time = 235
* CHECK dout1_32 vdout1_32ck46 = 1.0 time = 235
* CHECK dout1_33 vdout1_33ck46 = 1.0 time = 235
* CHECK dout1_34 vdout1_34ck46 = 1.0 time = 235
* CHECK dout1_35 vdout1_35ck46 = 1.0 time = 235
* CHECK dout1_36 vdout1_36ck46 = 1.0 time = 235
* CHECK dout1_37 vdout1_37ck46 = 1.0 time = 235
* CHECK dout1_38 vdout1_38ck46 = 0 time = 235
* CHECK dout1_39 vdout1_39ck46 = 1.0 time = 235
* CHECK dout1_40 vdout1_40ck46 = 0 time = 235
* CHECK dout1_41 vdout1_41ck46 = 0 time = 235
* CHECK dout1_42 vdout1_42ck46 = 1.0 time = 235
* CHECK dout1_43 vdout1_43ck46 = 1.0 time = 235
* CHECK dout1_44 vdout1_44ck46 = 1.0 time = 235
* CHECK dout1_45 vdout1_45ck46 = 0 time = 235
* CHECK dout1_46 vdout1_46ck46 = 0 time = 235
* CHECK dout1_47 vdout1_47ck46 = 0 time = 235
* CHECK dout1_48 vdout1_48ck46 = 0 time = 235
* CHECK dout1_49 vdout1_49ck46 = 0 time = 235
* CHECK dout1_50 vdout1_50ck46 = 1.0 time = 235
* CHECK dout1_51 vdout1_51ck46 = 1.0 time = 235
* CHECK dout1_52 vdout1_52ck46 = 1.0 time = 235
* CHECK dout1_53 vdout1_53ck46 = 0 time = 235
* CHECK dout1_54 vdout1_54ck46 = 1.0 time = 235
* CHECK dout1_55 vdout1_55ck46 = 0 time = 235
* CHECK dout1_56 vdout1_56ck46 = 1.0 time = 235
* CHECK dout1_57 vdout1_57ck46 = 1.0 time = 235
* CHECK dout1_58 vdout1_58ck46 = 1.0 time = 235
* CHECK dout1_59 vdout1_59ck46 = 0 time = 235
* CHECK dout1_60 vdout1_60ck46 = 0 time = 235
* CHECK dout1_61 vdout1_61ck46 = 1.0 time = 235
* CHECK dout1_62 vdout1_62ck46 = 1.0 time = 235
* CHECK dout1_63 vdout1_63ck46 = 1.0 time = 235
* CHECK dout0_0 vdout0_0ck47 = 1.0 time = 240
* CHECK dout0_1 vdout0_1ck47 = 0 time = 240
* CHECK dout0_2 vdout0_2ck47 = 0 time = 240
* CHECK dout0_3 vdout0_3ck47 = 1.0 time = 240
* CHECK dout0_4 vdout0_4ck47 = 1.0 time = 240
* CHECK dout0_5 vdout0_5ck47 = 0 time = 240
* CHECK dout0_6 vdout0_6ck47 = 1.0 time = 240
* CHECK dout0_7 vdout0_7ck47 = 1.0 time = 240
* CHECK dout0_8 vdout0_8ck47 = 0 time = 240
* CHECK dout0_9 vdout0_9ck47 = 1.0 time = 240
* CHECK dout0_10 vdout0_10ck47 = 0 time = 240
* CHECK dout0_11 vdout0_11ck47 = 1.0 time = 240
* CHECK dout0_12 vdout0_12ck47 = 0 time = 240
* CHECK dout0_13 vdout0_13ck47 = 1.0 time = 240
* CHECK dout0_14 vdout0_14ck47 = 1.0 time = 240
* CHECK dout0_15 vdout0_15ck47 = 1.0 time = 240
* CHECK dout0_16 vdout0_16ck47 = 1.0 time = 240
* CHECK dout0_17 vdout0_17ck47 = 1.0 time = 240
* CHECK dout0_18 vdout0_18ck47 = 1.0 time = 240
* CHECK dout0_19 vdout0_19ck47 = 1.0 time = 240
* CHECK dout0_20 vdout0_20ck47 = 0 time = 240
* CHECK dout0_21 vdout0_21ck47 = 0 time = 240
* CHECK dout0_22 vdout0_22ck47 = 1.0 time = 240
* CHECK dout0_23 vdout0_23ck47 = 0 time = 240
* CHECK dout0_24 vdout0_24ck47 = 1.0 time = 240
* CHECK dout0_25 vdout0_25ck47 = 1.0 time = 240
* CHECK dout0_26 vdout0_26ck47 = 1.0 time = 240
* CHECK dout0_27 vdout0_27ck47 = 0 time = 240
* CHECK dout0_28 vdout0_28ck47 = 0 time = 240
* CHECK dout0_29 vdout0_29ck47 = 1.0 time = 240
* CHECK dout0_30 vdout0_30ck47 = 1.0 time = 240
* CHECK dout0_31 vdout0_31ck47 = 1.0 time = 240
* CHECK dout0_32 vdout0_32ck47 = 1.0 time = 240
* CHECK dout0_33 vdout0_33ck47 = 0 time = 240
* CHECK dout0_34 vdout0_34ck47 = 1.0 time = 240
* CHECK dout0_35 vdout0_35ck47 = 0 time = 240
* CHECK dout0_36 vdout0_36ck47 = 1.0 time = 240
* CHECK dout0_37 vdout0_37ck47 = 0 time = 240
* CHECK dout0_38 vdout0_38ck47 = 0 time = 240
* CHECK dout0_39 vdout0_39ck47 = 0 time = 240
* CHECK dout0_40 vdout0_40ck47 = 1.0 time = 240
* CHECK dout0_41 vdout0_41ck47 = 0 time = 240
* CHECK dout0_42 vdout0_42ck47 = 1.0 time = 240
* CHECK dout0_43 vdout0_43ck47 = 1.0 time = 240
* CHECK dout0_44 vdout0_44ck47 = 1.0 time = 240
* CHECK dout0_45 vdout0_45ck47 = 0 time = 240
* CHECK dout0_46 vdout0_46ck47 = 0 time = 240
* CHECK dout0_47 vdout0_47ck47 = 1.0 time = 240
* CHECK dout0_48 vdout0_48ck47 = 1.0 time = 240
* CHECK dout0_49 vdout0_49ck47 = 0 time = 240
* CHECK dout0_50 vdout0_50ck47 = 1.0 time = 240
* CHECK dout0_51 vdout0_51ck47 = 1.0 time = 240
* CHECK dout0_52 vdout0_52ck47 = 1.0 time = 240
* CHECK dout0_53 vdout0_53ck47 = 1.0 time = 240
* CHECK dout0_54 vdout0_54ck47 = 1.0 time = 240
* CHECK dout0_55 vdout0_55ck47 = 1.0 time = 240
* CHECK dout0_56 vdout0_56ck47 = 0 time = 240
* CHECK dout0_57 vdout0_57ck47 = 0 time = 240
* CHECK dout0_58 vdout0_58ck47 = 0 time = 240
* CHECK dout0_59 vdout0_59ck47 = 0 time = 240
* CHECK dout0_60 vdout0_60ck47 = 0 time = 240
* CHECK dout0_61 vdout0_61ck47 = 1.0 time = 240
* CHECK dout0_62 vdout0_62ck47 = 0 time = 240
* CHECK dout0_63 vdout0_63ck47 = 1.0 time = 240
* CHECK dout1_0 vdout1_0ck47 = 0 time = 240
* CHECK dout1_1 vdout1_1ck47 = 1.0 time = 240
* CHECK dout1_2 vdout1_2ck47 = 0 time = 240
* CHECK dout1_3 vdout1_3ck47 = 1.0 time = 240
* CHECK dout1_4 vdout1_4ck47 = 0 time = 240
* CHECK dout1_5 vdout1_5ck47 = 1.0 time = 240
* CHECK dout1_6 vdout1_6ck47 = 1.0 time = 240
* CHECK dout1_7 vdout1_7ck47 = 0 time = 240
* CHECK dout1_8 vdout1_8ck47 = 1.0 time = 240
* CHECK dout1_9 vdout1_9ck47 = 1.0 time = 240
* CHECK dout1_10 vdout1_10ck47 = 0 time = 240
* CHECK dout1_11 vdout1_11ck47 = 1.0 time = 240
* CHECK dout1_12 vdout1_12ck47 = 1.0 time = 240
* CHECK dout1_13 vdout1_13ck47 = 0 time = 240
* CHECK dout1_14 vdout1_14ck47 = 0 time = 240
* CHECK dout1_15 vdout1_15ck47 = 0 time = 240
* CHECK dout1_16 vdout1_16ck47 = 0 time = 240
* CHECK dout1_17 vdout1_17ck47 = 0 time = 240
* CHECK dout1_18 vdout1_18ck47 = 1.0 time = 240
* CHECK dout1_19 vdout1_19ck47 = 1.0 time = 240
* CHECK dout1_20 vdout1_20ck47 = 0 time = 240
* CHECK dout1_21 vdout1_21ck47 = 1.0 time = 240
* CHECK dout1_22 vdout1_22ck47 = 0 time = 240
* CHECK dout1_23 vdout1_23ck47 = 0 time = 240
* CHECK dout1_24 vdout1_24ck47 = 1.0 time = 240
* CHECK dout1_25 vdout1_25ck47 = 1.0 time = 240
* CHECK dout1_26 vdout1_26ck47 = 1.0 time = 240
* CHECK dout1_27 vdout1_27ck47 = 1.0 time = 240
* CHECK dout1_28 vdout1_28ck47 = 0 time = 240
* CHECK dout1_29 vdout1_29ck47 = 0 time = 240
* CHECK dout1_30 vdout1_30ck47 = 1.0 time = 240
* CHECK dout1_31 vdout1_31ck47 = 0 time = 240
* CHECK dout1_32 vdout1_32ck47 = 0 time = 240
* CHECK dout1_33 vdout1_33ck47 = 0 time = 240
* CHECK dout1_34 vdout1_34ck47 = 1.0 time = 240
* CHECK dout1_35 vdout1_35ck47 = 0 time = 240
* CHECK dout1_36 vdout1_36ck47 = 0 time = 240
* CHECK dout1_37 vdout1_37ck47 = 1.0 time = 240
* CHECK dout1_38 vdout1_38ck47 = 1.0 time = 240
* CHECK dout1_39 vdout1_39ck47 = 0 time = 240
* CHECK dout1_40 vdout1_40ck47 = 0 time = 240
* CHECK dout1_41 vdout1_41ck47 = 0 time = 240
* CHECK dout1_42 vdout1_42ck47 = 0 time = 240
* CHECK dout1_43 vdout1_43ck47 = 1.0 time = 240
* CHECK dout1_44 vdout1_44ck47 = 0 time = 240
* CHECK dout1_45 vdout1_45ck47 = 1.0 time = 240
* CHECK dout1_46 vdout1_46ck47 = 0 time = 240
* CHECK dout1_47 vdout1_47ck47 = 0 time = 240
* CHECK dout1_48 vdout1_48ck47 = 1.0 time = 240
* CHECK dout1_49 vdout1_49ck47 = 1.0 time = 240
* CHECK dout1_50 vdout1_50ck47 = 0 time = 240
* CHECK dout1_51 vdout1_51ck47 = 0 time = 240
* CHECK dout1_52 vdout1_52ck47 = 0 time = 240
* CHECK dout1_53 vdout1_53ck47 = 1.0 time = 240
* CHECK dout1_54 vdout1_54ck47 = 0 time = 240
* CHECK dout1_55 vdout1_55ck47 = 0 time = 240
* CHECK dout1_56 vdout1_56ck47 = 1.0 time = 240
* CHECK dout1_57 vdout1_57ck47 = 0 time = 240
* CHECK dout1_58 vdout1_58ck47 = 1.0 time = 240
* CHECK dout1_59 vdout1_59ck47 = 0 time = 240
* CHECK dout1_60 vdout1_60ck47 = 1.0 time = 240
* CHECK dout1_61 vdout1_61ck47 = 1.0 time = 240
* CHECK dout1_62 vdout1_62ck47 = 0 time = 240
* CHECK dout1_63 vdout1_63ck47 = 0 time = 240
* CHECK dout0_0 vdout0_0ck48 = 1.0 time = 245
* CHECK dout0_1 vdout0_1ck48 = 1.0 time = 245
* CHECK dout0_2 vdout0_2ck48 = 0 time = 245
* CHECK dout0_3 vdout0_3ck48 = 1.0 time = 245
* CHECK dout0_4 vdout0_4ck48 = 0 time = 245
* CHECK dout0_5 vdout0_5ck48 = 1.0 time = 245
* CHECK dout0_6 vdout0_6ck48 = 0 time = 245
* CHECK dout0_7 vdout0_7ck48 = 0 time = 245
* CHECK dout0_8 vdout0_8ck48 = 0 time = 245
* CHECK dout0_9 vdout0_9ck48 = 1.0 time = 245
* CHECK dout0_10 vdout0_10ck48 = 0 time = 245
* CHECK dout0_11 vdout0_11ck48 = 0 time = 245
* CHECK dout0_12 vdout0_12ck48 = 1.0 time = 245
* CHECK dout0_13 vdout0_13ck48 = 1.0 time = 245
* CHECK dout0_14 vdout0_14ck48 = 1.0 time = 245
* CHECK dout0_15 vdout0_15ck48 = 0 time = 245
* CHECK dout0_16 vdout0_16ck48 = 1.0 time = 245
* CHECK dout0_17 vdout0_17ck48 = 0 time = 245
* CHECK dout0_18 vdout0_18ck48 = 0 time = 245
* CHECK dout0_19 vdout0_19ck48 = 1.0 time = 245
* CHECK dout0_20 vdout0_20ck48 = 0 time = 245
* CHECK dout0_21 vdout0_21ck48 = 0 time = 245
* CHECK dout0_22 vdout0_22ck48 = 0 time = 245
* CHECK dout0_23 vdout0_23ck48 = 1.0 time = 245
* CHECK dout0_24 vdout0_24ck48 = 0 time = 245
* CHECK dout0_25 vdout0_25ck48 = 1.0 time = 245
* CHECK dout0_26 vdout0_26ck48 = 0 time = 245
* CHECK dout0_27 vdout0_27ck48 = 1.0 time = 245
* CHECK dout0_28 vdout0_28ck48 = 0 time = 245
* CHECK dout0_29 vdout0_29ck48 = 0 time = 245
* CHECK dout0_30 vdout0_30ck48 = 1.0 time = 245
* CHECK dout0_31 vdout0_31ck48 = 0 time = 245
* CHECK dout0_32 vdout0_32ck48 = 1.0 time = 245
* CHECK dout0_33 vdout0_33ck48 = 1.0 time = 245
* CHECK dout0_34 vdout0_34ck48 = 1.0 time = 245
* CHECK dout0_35 vdout0_35ck48 = 1.0 time = 245
* CHECK dout0_36 vdout0_36ck48 = 1.0 time = 245
* CHECK dout0_37 vdout0_37ck48 = 1.0 time = 245
* CHECK dout0_38 vdout0_38ck48 = 0 time = 245
* CHECK dout0_39 vdout0_39ck48 = 1.0 time = 245
* CHECK dout0_40 vdout0_40ck48 = 0 time = 245
* CHECK dout0_41 vdout0_41ck48 = 0 time = 245
* CHECK dout0_42 vdout0_42ck48 = 1.0 time = 245
* CHECK dout0_43 vdout0_43ck48 = 1.0 time = 245
* CHECK dout0_44 vdout0_44ck48 = 1.0 time = 245
* CHECK dout0_45 vdout0_45ck48 = 0 time = 245
* CHECK dout0_46 vdout0_46ck48 = 0 time = 245
* CHECK dout0_47 vdout0_47ck48 = 0 time = 245
* CHECK dout0_48 vdout0_48ck48 = 0 time = 245
* CHECK dout0_49 vdout0_49ck48 = 0 time = 245
* CHECK dout0_50 vdout0_50ck48 = 1.0 time = 245
* CHECK dout0_51 vdout0_51ck48 = 1.0 time = 245
* CHECK dout0_52 vdout0_52ck48 = 1.0 time = 245
* CHECK dout0_53 vdout0_53ck48 = 0 time = 245
* CHECK dout0_54 vdout0_54ck48 = 1.0 time = 245
* CHECK dout0_55 vdout0_55ck48 = 0 time = 245
* CHECK dout0_56 vdout0_56ck48 = 1.0 time = 245
* CHECK dout0_57 vdout0_57ck48 = 1.0 time = 245
* CHECK dout0_58 vdout0_58ck48 = 1.0 time = 245
* CHECK dout0_59 vdout0_59ck48 = 0 time = 245
* CHECK dout0_60 vdout0_60ck48 = 0 time = 245
* CHECK dout0_61 vdout0_61ck48 = 1.0 time = 245
* CHECK dout0_62 vdout0_62ck48 = 1.0 time = 245
* CHECK dout0_63 vdout0_63ck48 = 1.0 time = 245
* CHECK dout1_0 vdout1_0ck48 = 1.0 time = 245
* CHECK dout1_1 vdout1_1ck48 = 1.0 time = 245
* CHECK dout1_2 vdout1_2ck48 = 1.0 time = 245
* CHECK dout1_3 vdout1_3ck48 = 1.0 time = 245
* CHECK dout1_4 vdout1_4ck48 = 1.0 time = 245
* CHECK dout1_5 vdout1_5ck48 = 1.0 time = 245
* CHECK dout1_6 vdout1_6ck48 = 0 time = 245
* CHECK dout1_7 vdout1_7ck48 = 0 time = 245
* CHECK dout1_8 vdout1_8ck48 = 0 time = 245
* CHECK dout1_9 vdout1_9ck48 = 1.0 time = 245
* CHECK dout1_10 vdout1_10ck48 = 0 time = 245
* CHECK dout1_11 vdout1_11ck48 = 0 time = 245
* CHECK dout1_12 vdout1_12ck48 = 1.0 time = 245
* CHECK dout1_13 vdout1_13ck48 = 0 time = 245
* CHECK dout1_14 vdout1_14ck48 = 1.0 time = 245
* CHECK dout1_15 vdout1_15ck48 = 1.0 time = 245
* CHECK dout1_16 vdout1_16ck48 = 1.0 time = 245
* CHECK dout1_17 vdout1_17ck48 = 0 time = 245
* CHECK dout1_18 vdout1_18ck48 = 1.0 time = 245
* CHECK dout1_19 vdout1_19ck48 = 1.0 time = 245
* CHECK dout1_20 vdout1_20ck48 = 1.0 time = 245
* CHECK dout1_21 vdout1_21ck48 = 0 time = 245
* CHECK dout1_22 vdout1_22ck48 = 0 time = 245
* CHECK dout1_23 vdout1_23ck48 = 1.0 time = 245
* CHECK dout1_24 vdout1_24ck48 = 0 time = 245
* CHECK dout1_25 vdout1_25ck48 = 1.0 time = 245
* CHECK dout1_26 vdout1_26ck48 = 1.0 time = 245
* CHECK dout1_27 vdout1_27ck48 = 0 time = 245
* CHECK dout1_28 vdout1_28ck48 = 1.0 time = 245
* CHECK dout1_29 vdout1_29ck48 = 1.0 time = 245
* CHECK dout1_30 vdout1_30ck48 = 1.0 time = 245
* CHECK dout1_31 vdout1_31ck48 = 1.0 time = 245
* CHECK dout1_32 vdout1_32ck48 = 0 time = 245
* CHECK dout1_33 vdout1_33ck48 = 1.0 time = 245
* CHECK dout1_34 vdout1_34ck48 = 0 time = 245
* CHECK dout1_35 vdout1_35ck48 = 1.0 time = 245
* CHECK dout1_36 vdout1_36ck48 = 1.0 time = 245
* CHECK dout1_37 vdout1_37ck48 = 1.0 time = 245
* CHECK dout1_38 vdout1_38ck48 = 0 time = 245
* CHECK dout1_39 vdout1_39ck48 = 1.0 time = 245
* CHECK dout1_40 vdout1_40ck48 = 1.0 time = 245
* CHECK dout1_41 vdout1_41ck48 = 1.0 time = 245
* CHECK dout1_42 vdout1_42ck48 = 1.0 time = 245
* CHECK dout1_43 vdout1_43ck48 = 0 time = 245
* CHECK dout1_44 vdout1_44ck48 = 1.0 time = 245
* CHECK dout1_45 vdout1_45ck48 = 1.0 time = 245
* CHECK dout1_46 vdout1_46ck48 = 0 time = 245
* CHECK dout1_47 vdout1_47ck48 = 0 time = 245
* CHECK dout1_48 vdout1_48ck48 = 0 time = 245
* CHECK dout1_49 vdout1_49ck48 = 1.0 time = 245
* CHECK dout1_50 vdout1_50ck48 = 1.0 time = 245
* CHECK dout1_51 vdout1_51ck48 = 1.0 time = 245
* CHECK dout1_52 vdout1_52ck48 = 1.0 time = 245
* CHECK dout1_53 vdout1_53ck48 = 1.0 time = 245
* CHECK dout1_54 vdout1_54ck48 = 1.0 time = 245
* CHECK dout1_55 vdout1_55ck48 = 1.0 time = 245
* CHECK dout1_56 vdout1_56ck48 = 1.0 time = 245
* CHECK dout1_57 vdout1_57ck48 = 1.0 time = 245
* CHECK dout1_58 vdout1_58ck48 = 0 time = 245
* CHECK dout1_59 vdout1_59ck48 = 1.0 time = 245
* CHECK dout1_60 vdout1_60ck48 = 1.0 time = 245
* CHECK dout1_61 vdout1_61ck48 = 1.0 time = 245
* CHECK dout1_62 vdout1_62ck48 = 1.0 time = 245
* CHECK dout1_63 vdout1_63ck48 = 0 time = 245
* CHECK dout0_0 vdout0_0ck50 = 0 time = 255
* CHECK dout0_1 vdout0_1ck50 = 0 time = 255
* CHECK dout0_2 vdout0_2ck50 = 0 time = 255
* CHECK dout0_3 vdout0_3ck50 = 0 time = 255
* CHECK dout0_4 vdout0_4ck50 = 0 time = 255
* CHECK dout0_5 vdout0_5ck50 = 0 time = 255
* CHECK dout0_6 vdout0_6ck50 = 1.0 time = 255
* CHECK dout0_7 vdout0_7ck50 = 0 time = 255
* CHECK dout0_8 vdout0_8ck50 = 0 time = 255
* CHECK dout0_9 vdout0_9ck50 = 0 time = 255
* CHECK dout0_10 vdout0_10ck50 = 1.0 time = 255
* CHECK dout0_11 vdout0_11ck50 = 1.0 time = 255
* CHECK dout0_12 vdout0_12ck50 = 0 time = 255
* CHECK dout0_13 vdout0_13ck50 = 1.0 time = 255
* CHECK dout0_14 vdout0_14ck50 = 1.0 time = 255
* CHECK dout0_15 vdout0_15ck50 = 0 time = 255
* CHECK dout0_16 vdout0_16ck50 = 0 time = 255
* CHECK dout0_17 vdout0_17ck50 = 0 time = 255
* CHECK dout0_18 vdout0_18ck50 = 1.0 time = 255
* CHECK dout0_19 vdout0_19ck50 = 0 time = 255
* CHECK dout0_20 vdout0_20ck50 = 0 time = 255
* CHECK dout0_21 vdout0_21ck50 = 0 time = 255
* CHECK dout0_22 vdout0_22ck50 = 1.0 time = 255
* CHECK dout0_23 vdout0_23ck50 = 0 time = 255
* CHECK dout0_24 vdout0_24ck50 = 0 time = 255
* CHECK dout0_25 vdout0_25ck50 = 1.0 time = 255
* CHECK dout0_26 vdout0_26ck50 = 1.0 time = 255
* CHECK dout0_27 vdout0_27ck50 = 1.0 time = 255
* CHECK dout0_28 vdout0_28ck50 = 0 time = 255
* CHECK dout0_29 vdout0_29ck50 = 0 time = 255
* CHECK dout0_30 vdout0_30ck50 = 1.0 time = 255
* CHECK dout0_31 vdout0_31ck50 = 0 time = 255
* CHECK dout0_32 vdout0_32ck50 = 0 time = 255
* CHECK dout0_33 vdout0_33ck50 = 0 time = 255
* CHECK dout0_34 vdout0_34ck50 = 0 time = 255
* CHECK dout0_35 vdout0_35ck50 = 1.0 time = 255
* CHECK dout0_36 vdout0_36ck50 = 0 time = 255
* CHECK dout0_37 vdout0_37ck50 = 1.0 time = 255
* CHECK dout0_38 vdout0_38ck50 = 0 time = 255
* CHECK dout0_39 vdout0_39ck50 = 1.0 time = 255
* CHECK dout0_40 vdout0_40ck50 = 0 time = 255
* CHECK dout0_41 vdout0_41ck50 = 0 time = 255
* CHECK dout0_42 vdout0_42ck50 = 1.0 time = 255
* CHECK dout0_43 vdout0_43ck50 = 1.0 time = 255
* CHECK dout0_44 vdout0_44ck50 = 1.0 time = 255
* CHECK dout0_45 vdout0_45ck50 = 0 time = 255
* CHECK dout0_46 vdout0_46ck50 = 1.0 time = 255
* CHECK dout0_47 vdout0_47ck50 = 0 time = 255
* CHECK dout0_48 vdout0_48ck50 = 0 time = 255
* CHECK dout0_49 vdout0_49ck50 = 0 time = 255
* CHECK dout0_50 vdout0_50ck50 = 0 time = 255
* CHECK dout0_51 vdout0_51ck50 = 1.0 time = 255
* CHECK dout0_52 vdout0_52ck50 = 1.0 time = 255
* CHECK dout0_53 vdout0_53ck50 = 1.0 time = 255
* CHECK dout0_54 vdout0_54ck50 = 1.0 time = 255
* CHECK dout0_55 vdout0_55ck50 = 1.0 time = 255
* CHECK dout0_56 vdout0_56ck50 = 0 time = 255
* CHECK dout0_57 vdout0_57ck50 = 1.0 time = 255
* CHECK dout0_58 vdout0_58ck50 = 1.0 time = 255
* CHECK dout0_59 vdout0_59ck50 = 0 time = 255
* CHECK dout0_60 vdout0_60ck50 = 1.0 time = 255
* CHECK dout0_61 vdout0_61ck50 = 1.0 time = 255
* CHECK dout0_62 vdout0_62ck50 = 1.0 time = 255
* CHECK dout0_63 vdout0_63ck50 = 0 time = 255
* CHECK dout1_0 vdout1_0ck51 = 1.0 time = 260
* CHECK dout1_1 vdout1_1ck51 = 0 time = 260
* CHECK dout1_2 vdout1_2ck51 = 0 time = 260
* CHECK dout1_3 vdout1_3ck51 = 1.0 time = 260
* CHECK dout1_4 vdout1_4ck51 = 1.0 time = 260
* CHECK dout1_5 vdout1_5ck51 = 1.0 time = 260
* CHECK dout1_6 vdout1_6ck51 = 1.0 time = 260
* CHECK dout1_7 vdout1_7ck51 = 1.0 time = 260
* CHECK dout1_8 vdout1_8ck51 = 0 time = 260
* CHECK dout1_9 vdout1_9ck51 = 0 time = 260
* CHECK dout1_10 vdout1_10ck51 = 1.0 time = 260
* CHECK dout1_11 vdout1_11ck51 = 0 time = 260
* CHECK dout1_12 vdout1_12ck51 = 1.0 time = 260
* CHECK dout1_13 vdout1_13ck51 = 0 time = 260
* CHECK dout1_14 vdout1_14ck51 = 0 time = 260
* CHECK dout1_15 vdout1_15ck51 = 1.0 time = 260
* CHECK dout1_16 vdout1_16ck51 = 0 time = 260
* CHECK dout1_17 vdout1_17ck51 = 0 time = 260
* CHECK dout1_18 vdout1_18ck51 = 1.0 time = 260
* CHECK dout1_19 vdout1_19ck51 = 0 time = 260
* CHECK dout1_20 vdout1_20ck51 = 0 time = 260
* CHECK dout1_21 vdout1_21ck51 = 0 time = 260
* CHECK dout1_22 vdout1_22ck51 = 0 time = 260
* CHECK dout1_23 vdout1_23ck51 = 1.0 time = 260
* CHECK dout1_24 vdout1_24ck51 = 1.0 time = 260
* CHECK dout1_25 vdout1_25ck51 = 1.0 time = 260
* CHECK dout1_26 vdout1_26ck51 = 1.0 time = 260
* CHECK dout1_27 vdout1_27ck51 = 0 time = 260
* CHECK dout1_28 vdout1_28ck51 = 0 time = 260
* CHECK dout1_29 vdout1_29ck51 = 0 time = 260
* CHECK dout1_30 vdout1_30ck51 = 1.0 time = 260
* CHECK dout1_31 vdout1_31ck51 = 0 time = 260
* CHECK dout1_32 vdout1_32ck51 = 0 time = 260
* CHECK dout1_33 vdout1_33ck51 = 0 time = 260
* CHECK dout1_34 vdout1_34ck51 = 1.0 time = 260
* CHECK dout1_35 vdout1_35ck51 = 0 time = 260
* CHECK dout1_36 vdout1_36ck51 = 1.0 time = 260
* CHECK dout1_37 vdout1_37ck51 = 0 time = 260
* CHECK dout1_38 vdout1_38ck51 = 0 time = 260
* CHECK dout1_39 vdout1_39ck51 = 1.0 time = 260
* CHECK dout1_40 vdout1_40ck51 = 0 time = 260
* CHECK dout1_41 vdout1_41ck51 = 1.0 time = 260
* CHECK dout1_42 vdout1_42ck51 = 1.0 time = 260
* CHECK dout1_43 vdout1_43ck51 = 0 time = 260
* CHECK dout1_44 vdout1_44ck51 = 0 time = 260
* CHECK dout1_45 vdout1_45ck51 = 1.0 time = 260
* CHECK dout1_46 vdout1_46ck51 = 1.0 time = 260
* CHECK dout1_47 vdout1_47ck51 = 1.0 time = 260
* CHECK dout1_48 vdout1_48ck51 = 1.0 time = 260
* CHECK dout1_49 vdout1_49ck51 = 0 time = 260
* CHECK dout1_50 vdout1_50ck51 = 0 time = 260
* CHECK dout1_51 vdout1_51ck51 = 1.0 time = 260
* CHECK dout1_52 vdout1_52ck51 = 1.0 time = 260
* CHECK dout1_53 vdout1_53ck51 = 1.0 time = 260
* CHECK dout1_54 vdout1_54ck51 = 0 time = 260
* CHECK dout1_55 vdout1_55ck51 = 0 time = 260
* CHECK dout1_56 vdout1_56ck51 = 1.0 time = 260
* CHECK dout1_57 vdout1_57ck51 = 1.0 time = 260
* CHECK dout1_58 vdout1_58ck51 = 0 time = 260
* CHECK dout1_59 vdout1_59ck51 = 1.0 time = 260
* CHECK dout1_60 vdout1_60ck51 = 0 time = 260
* CHECK dout1_61 vdout1_61ck51 = 1.0 time = 260
* CHECK dout1_62 vdout1_62ck51 = 0 time = 260
* CHECK dout1_63 vdout1_63ck51 = 1.0 time = 260
* CHECK dout0_0 vdout0_0ck53 = 0 time = 270
* CHECK dout0_1 vdout0_1ck53 = 1.0 time = 270
* CHECK dout0_2 vdout0_2ck53 = 1.0 time = 270
* CHECK dout0_3 vdout0_3ck53 = 0 time = 270
* CHECK dout0_4 vdout0_4ck53 = 1.0 time = 270
* CHECK dout0_5 vdout0_5ck53 = 0 time = 270
* CHECK dout0_6 vdout0_6ck53 = 0 time = 270
* CHECK dout0_7 vdout0_7ck53 = 1.0 time = 270
* CHECK dout0_8 vdout0_8ck53 = 0 time = 270
* CHECK dout0_9 vdout0_9ck53 = 0 time = 270
* CHECK dout0_10 vdout0_10ck53 = 1.0 time = 270
* CHECK dout0_11 vdout0_11ck53 = 1.0 time = 270
* CHECK dout0_12 vdout0_12ck53 = 1.0 time = 270
* CHECK dout0_13 vdout0_13ck53 = 1.0 time = 270
* CHECK dout0_14 vdout0_14ck53 = 0 time = 270
* CHECK dout0_15 vdout0_15ck53 = 0 time = 270
* CHECK dout0_16 vdout0_16ck53 = 1.0 time = 270
* CHECK dout0_17 vdout0_17ck53 = 1.0 time = 270
* CHECK dout0_18 vdout0_18ck53 = 0 time = 270
* CHECK dout0_19 vdout0_19ck53 = 0 time = 270
* CHECK dout0_20 vdout0_20ck53 = 0 time = 270
* CHECK dout0_21 vdout0_21ck53 = 0 time = 270
* CHECK dout0_22 vdout0_22ck53 = 1.0 time = 270
* CHECK dout0_23 vdout0_23ck53 = 0 time = 270
* CHECK dout0_24 vdout0_24ck53 = 0 time = 270
* CHECK dout0_25 vdout0_25ck53 = 1.0 time = 270
* CHECK dout0_26 vdout0_26ck53 = 0 time = 270
* CHECK dout0_27 vdout0_27ck53 = 1.0 time = 270
* CHECK dout0_28 vdout0_28ck53 = 0 time = 270
* CHECK dout0_29 vdout0_29ck53 = 1.0 time = 270
* CHECK dout0_30 vdout0_30ck53 = 1.0 time = 270
* CHECK dout0_31 vdout0_31ck53 = 0 time = 270
* CHECK dout0_32 vdout0_32ck53 = 0 time = 270
* CHECK dout0_33 vdout0_33ck53 = 0 time = 270
* CHECK dout0_34 vdout0_34ck53 = 1.0 time = 270
* CHECK dout0_35 vdout0_35ck53 = 0 time = 270
* CHECK dout0_36 vdout0_36ck53 = 1.0 time = 270
* CHECK dout0_37 vdout0_37ck53 = 0 time = 270
* CHECK dout0_38 vdout0_38ck53 = 0 time = 270
* CHECK dout0_39 vdout0_39ck53 = 1.0 time = 270
* CHECK dout0_40 vdout0_40ck53 = 0 time = 270
* CHECK dout0_41 vdout0_41ck53 = 0 time = 270
* CHECK dout0_42 vdout0_42ck53 = 1.0 time = 270
* CHECK dout0_43 vdout0_43ck53 = 1.0 time = 270
* CHECK dout0_44 vdout0_44ck53 = 1.0 time = 270
* CHECK dout0_45 vdout0_45ck53 = 1.0 time = 270
* CHECK dout0_46 vdout0_46ck53 = 0 time = 270
* CHECK dout0_47 vdout0_47ck53 = 1.0 time = 270
* CHECK dout0_48 vdout0_48ck53 = 1.0 time = 270
* CHECK dout0_49 vdout0_49ck53 = 0 time = 270
* CHECK dout0_50 vdout0_50ck53 = 1.0 time = 270
* CHECK dout0_51 vdout0_51ck53 = 1.0 time = 270
* CHECK dout0_52 vdout0_52ck53 = 1.0 time = 270
* CHECK dout0_53 vdout0_53ck53 = 0 time = 270
* CHECK dout0_54 vdout0_54ck53 = 0 time = 270
* CHECK dout0_55 vdout0_55ck53 = 0 time = 270
* CHECK dout0_56 vdout0_56ck53 = 1.0 time = 270
* CHECK dout0_57 vdout0_57ck53 = 0 time = 270
* CHECK dout0_58 vdout0_58ck53 = 1.0 time = 270
* CHECK dout0_59 vdout0_59ck53 = 1.0 time = 270
* CHECK dout0_60 vdout0_60ck53 = 0 time = 270
* CHECK dout0_61 vdout0_61ck53 = 0 time = 270
* CHECK dout0_62 vdout0_62ck53 = 0 time = 270
* CHECK dout0_63 vdout0_63ck53 = 0 time = 270
* CHECK dout1_0 vdout1_0ck53 = 1.0 time = 270
* CHECK dout1_1 vdout1_1ck53 = 0 time = 270
* CHECK dout1_2 vdout1_2ck53 = 0 time = 270
* CHECK dout1_3 vdout1_3ck53 = 1.0 time = 270
* CHECK dout1_4 vdout1_4ck53 = 1.0 time = 270
* CHECK dout1_5 vdout1_5ck53 = 0 time = 270
* CHECK dout1_6 vdout1_6ck53 = 1.0 time = 270
* CHECK dout1_7 vdout1_7ck53 = 1.0 time = 270
* CHECK dout1_8 vdout1_8ck53 = 0 time = 270
* CHECK dout1_9 vdout1_9ck53 = 1.0 time = 270
* CHECK dout1_10 vdout1_10ck53 = 0 time = 270
* CHECK dout1_11 vdout1_11ck53 = 1.0 time = 270
* CHECK dout1_12 vdout1_12ck53 = 0 time = 270
* CHECK dout1_13 vdout1_13ck53 = 1.0 time = 270
* CHECK dout1_14 vdout1_14ck53 = 1.0 time = 270
* CHECK dout1_15 vdout1_15ck53 = 1.0 time = 270
* CHECK dout1_16 vdout1_16ck53 = 1.0 time = 270
* CHECK dout1_17 vdout1_17ck53 = 1.0 time = 270
* CHECK dout1_18 vdout1_18ck53 = 1.0 time = 270
* CHECK dout1_19 vdout1_19ck53 = 1.0 time = 270
* CHECK dout1_20 vdout1_20ck53 = 0 time = 270
* CHECK dout1_21 vdout1_21ck53 = 0 time = 270
* CHECK dout1_22 vdout1_22ck53 = 1.0 time = 270
* CHECK dout1_23 vdout1_23ck53 = 0 time = 270
* CHECK dout1_24 vdout1_24ck53 = 1.0 time = 270
* CHECK dout1_25 vdout1_25ck53 = 1.0 time = 270
* CHECK dout1_26 vdout1_26ck53 = 1.0 time = 270
* CHECK dout1_27 vdout1_27ck53 = 0 time = 270
* CHECK dout1_28 vdout1_28ck53 = 0 time = 270
* CHECK dout1_29 vdout1_29ck53 = 1.0 time = 270
* CHECK dout1_30 vdout1_30ck53 = 1.0 time = 270
* CHECK dout1_31 vdout1_31ck53 = 1.0 time = 270
* CHECK dout1_32 vdout1_32ck53 = 1.0 time = 270
* CHECK dout1_33 vdout1_33ck53 = 0 time = 270
* CHECK dout1_34 vdout1_34ck53 = 1.0 time = 270
* CHECK dout1_35 vdout1_35ck53 = 0 time = 270
* CHECK dout1_36 vdout1_36ck53 = 1.0 time = 270
* CHECK dout1_37 vdout1_37ck53 = 0 time = 270
* CHECK dout1_38 vdout1_38ck53 = 0 time = 270
* CHECK dout1_39 vdout1_39ck53 = 0 time = 270
* CHECK dout1_40 vdout1_40ck53 = 1.0 time = 270
* CHECK dout1_41 vdout1_41ck53 = 0 time = 270
* CHECK dout1_42 vdout1_42ck53 = 1.0 time = 270
* CHECK dout1_43 vdout1_43ck53 = 1.0 time = 270
* CHECK dout1_44 vdout1_44ck53 = 1.0 time = 270
* CHECK dout1_45 vdout1_45ck53 = 0 time = 270
* CHECK dout1_46 vdout1_46ck53 = 0 time = 270
* CHECK dout1_47 vdout1_47ck53 = 1.0 time = 270
* CHECK dout1_48 vdout1_48ck53 = 1.0 time = 270
* CHECK dout1_49 vdout1_49ck53 = 0 time = 270
* CHECK dout1_50 vdout1_50ck53 = 1.0 time = 270
* CHECK dout1_51 vdout1_51ck53 = 1.0 time = 270
* CHECK dout1_52 vdout1_52ck53 = 1.0 time = 270
* CHECK dout1_53 vdout1_53ck53 = 1.0 time = 270
* CHECK dout1_54 vdout1_54ck53 = 1.0 time = 270
* CHECK dout1_55 vdout1_55ck53 = 1.0 time = 270
* CHECK dout1_56 vdout1_56ck53 = 0 time = 270
* CHECK dout1_57 vdout1_57ck53 = 0 time = 270
* CHECK dout1_58 vdout1_58ck53 = 0 time = 270
* CHECK dout1_59 vdout1_59ck53 = 0 time = 270
* CHECK dout1_60 vdout1_60ck53 = 0 time = 270
* CHECK dout1_61 vdout1_61ck53 = 1.0 time = 270
* CHECK dout1_62 vdout1_62ck53 = 0 time = 270
* CHECK dout1_63 vdout1_63ck53 = 1.0 time = 270
* CHECK dout0_0 vdout0_0ck55 = 0 time = 280
* CHECK dout0_1 vdout0_1ck55 = 0 time = 280
* CHECK dout0_2 vdout0_2ck55 = 0 time = 280
* CHECK dout0_3 vdout0_3ck55 = 0 time = 280
* CHECK dout0_4 vdout0_4ck55 = 1.0 time = 280
* CHECK dout0_5 vdout0_5ck55 = 0 time = 280
* CHECK dout0_6 vdout0_6ck55 = 1.0 time = 280
* CHECK dout0_7 vdout0_7ck55 = 1.0 time = 280
* CHECK dout0_8 vdout0_8ck55 = 0 time = 280
* CHECK dout0_9 vdout0_9ck55 = 1.0 time = 280
* CHECK dout0_10 vdout0_10ck55 = 0 time = 280
* CHECK dout0_11 vdout0_11ck55 = 1.0 time = 280
* CHECK dout0_12 vdout0_12ck55 = 0 time = 280
* CHECK dout0_13 vdout0_13ck55 = 1.0 time = 280
* CHECK dout0_14 vdout0_14ck55 = 0 time = 280
* CHECK dout0_15 vdout0_15ck55 = 1.0 time = 280
* CHECK dout0_16 vdout0_16ck55 = 1.0 time = 280
* CHECK dout0_17 vdout0_17ck55 = 0 time = 280
* CHECK dout0_18 vdout0_18ck55 = 0 time = 280
* CHECK dout0_19 vdout0_19ck55 = 1.0 time = 280
* CHECK dout0_20 vdout0_20ck55 = 1.0 time = 280
* CHECK dout0_21 vdout0_21ck55 = 0 time = 280
* CHECK dout0_22 vdout0_22ck55 = 1.0 time = 280
* CHECK dout0_23 vdout0_23ck55 = 1.0 time = 280
* CHECK dout0_24 vdout0_24ck55 = 0 time = 280
* CHECK dout0_25 vdout0_25ck55 = 0 time = 280
* CHECK dout0_26 vdout0_26ck55 = 0 time = 280
* CHECK dout0_27 vdout0_27ck55 = 1.0 time = 280
* CHECK dout0_28 vdout0_28ck55 = 0 time = 280
* CHECK dout0_29 vdout0_29ck55 = 0 time = 280
* CHECK dout0_30 vdout0_30ck55 = 1.0 time = 280
* CHECK dout0_31 vdout0_31ck55 = 0 time = 280
* CHECK dout0_32 vdout0_32ck55 = 1.0 time = 280
* CHECK dout0_33 vdout0_33ck55 = 0 time = 280
* CHECK dout0_34 vdout0_34ck55 = 1.0 time = 280
* CHECK dout0_35 vdout0_35ck55 = 1.0 time = 280
* CHECK dout0_36 vdout0_36ck55 = 1.0 time = 280
* CHECK dout0_37 vdout0_37ck55 = 1.0 time = 280
* CHECK dout0_38 vdout0_38ck55 = 0 time = 280
* CHECK dout0_39 vdout0_39ck55 = 0 time = 280
* CHECK dout0_40 vdout0_40ck55 = 0 time = 280
* CHECK dout0_41 vdout0_41ck55 = 0 time = 280
* CHECK dout0_42 vdout0_42ck55 = 0 time = 280
* CHECK dout0_43 vdout0_43ck55 = 1.0 time = 280
* CHECK dout0_44 vdout0_44ck55 = 0 time = 280
* CHECK dout0_45 vdout0_45ck55 = 0 time = 280
* CHECK dout0_46 vdout0_46ck55 = 0 time = 280
* CHECK dout0_47 vdout0_47ck55 = 0 time = 280
* CHECK dout0_48 vdout0_48ck55 = 0 time = 280
* CHECK dout0_49 vdout0_49ck55 = 1.0 time = 280
* CHECK dout0_50 vdout0_50ck55 = 0 time = 280
* CHECK dout0_51 vdout0_51ck55 = 0 time = 280
* CHECK dout0_52 vdout0_52ck55 = 1.0 time = 280
* CHECK dout0_53 vdout0_53ck55 = 0 time = 280
* CHECK dout0_54 vdout0_54ck55 = 0 time = 280
* CHECK dout0_55 vdout0_55ck55 = 1.0 time = 280
* CHECK dout0_56 vdout0_56ck55 = 1.0 time = 280
* CHECK dout0_57 vdout0_57ck55 = 1.0 time = 280
* CHECK dout0_58 vdout0_58ck55 = 0 time = 280
* CHECK dout0_59 vdout0_59ck55 = 0 time = 280
* CHECK dout0_60 vdout0_60ck55 = 1.0 time = 280
* CHECK dout0_61 vdout0_61ck55 = 0 time = 280
* CHECK dout0_62 vdout0_62ck55 = 1.0 time = 280
* CHECK dout0_63 vdout0_63ck55 = 0 time = 280
* CHECK dout1_0 vdout1_0ck55 = 0 time = 280
* CHECK dout1_1 vdout1_1ck55 = 0 time = 280
* CHECK dout1_2 vdout1_2ck55 = 0 time = 280
* CHECK dout1_3 vdout1_3ck55 = 0 time = 280
* CHECK dout1_4 vdout1_4ck55 = 1.0 time = 280
* CHECK dout1_5 vdout1_5ck55 = 0 time = 280
* CHECK dout1_6 vdout1_6ck55 = 1.0 time = 280
* CHECK dout1_7 vdout1_7ck55 = 1.0 time = 280
* CHECK dout1_8 vdout1_8ck55 = 0 time = 280
* CHECK dout1_9 vdout1_9ck55 = 1.0 time = 280
* CHECK dout1_10 vdout1_10ck55 = 0 time = 280
* CHECK dout1_11 vdout1_11ck55 = 1.0 time = 280
* CHECK dout1_12 vdout1_12ck55 = 0 time = 280
* CHECK dout1_13 vdout1_13ck55 = 1.0 time = 280
* CHECK dout1_14 vdout1_14ck55 = 0 time = 280
* CHECK dout1_15 vdout1_15ck55 = 1.0 time = 280
* CHECK dout1_16 vdout1_16ck55 = 1.0 time = 280
* CHECK dout1_17 vdout1_17ck55 = 0 time = 280
* CHECK dout1_18 vdout1_18ck55 = 0 time = 280
* CHECK dout1_19 vdout1_19ck55 = 1.0 time = 280
* CHECK dout1_20 vdout1_20ck55 = 1.0 time = 280
* CHECK dout1_21 vdout1_21ck55 = 0 time = 280
* CHECK dout1_22 vdout1_22ck55 = 1.0 time = 280
* CHECK dout1_23 vdout1_23ck55 = 1.0 time = 280
* CHECK dout1_24 vdout1_24ck55 = 0 time = 280
* CHECK dout1_25 vdout1_25ck55 = 0 time = 280
* CHECK dout1_26 vdout1_26ck55 = 0 time = 280
* CHECK dout1_27 vdout1_27ck55 = 1.0 time = 280
* CHECK dout1_28 vdout1_28ck55 = 0 time = 280
* CHECK dout1_29 vdout1_29ck55 = 0 time = 280
* CHECK dout1_30 vdout1_30ck55 = 1.0 time = 280
* CHECK dout1_31 vdout1_31ck55 = 0 time = 280
* CHECK dout1_32 vdout1_32ck55 = 1.0 time = 280
* CHECK dout1_33 vdout1_33ck55 = 0 time = 280
* CHECK dout1_34 vdout1_34ck55 = 1.0 time = 280
* CHECK dout1_35 vdout1_35ck55 = 1.0 time = 280
* CHECK dout1_36 vdout1_36ck55 = 1.0 time = 280
* CHECK dout1_37 vdout1_37ck55 = 1.0 time = 280
* CHECK dout1_38 vdout1_38ck55 = 0 time = 280
* CHECK dout1_39 vdout1_39ck55 = 0 time = 280
* CHECK dout1_40 vdout1_40ck55 = 0 time = 280
* CHECK dout1_41 vdout1_41ck55 = 0 time = 280
* CHECK dout1_42 vdout1_42ck55 = 0 time = 280
* CHECK dout1_43 vdout1_43ck55 = 1.0 time = 280
* CHECK dout1_44 vdout1_44ck55 = 0 time = 280
* CHECK dout1_45 vdout1_45ck55 = 0 time = 280
* CHECK dout1_46 vdout1_46ck55 = 0 time = 280
* CHECK dout1_47 vdout1_47ck55 = 0 time = 280
* CHECK dout1_48 vdout1_48ck55 = 0 time = 280
* CHECK dout1_49 vdout1_49ck55 = 1.0 time = 280
* CHECK dout1_50 vdout1_50ck55 = 0 time = 280
* CHECK dout1_51 vdout1_51ck55 = 0 time = 280
* CHECK dout1_52 vdout1_52ck55 = 1.0 time = 280
* CHECK dout1_53 vdout1_53ck55 = 0 time = 280
* CHECK dout1_54 vdout1_54ck55 = 0 time = 280
* CHECK dout1_55 vdout1_55ck55 = 1.0 time = 280
* CHECK dout1_56 vdout1_56ck55 = 1.0 time = 280
* CHECK dout1_57 vdout1_57ck55 = 1.0 time = 280
* CHECK dout1_58 vdout1_58ck55 = 0 time = 280
* CHECK dout1_59 vdout1_59ck55 = 0 time = 280
* CHECK dout1_60 vdout1_60ck55 = 1.0 time = 280
* CHECK dout1_61 vdout1_61ck55 = 0 time = 280
* CHECK dout1_62 vdout1_62ck55 = 1.0 time = 280
* CHECK dout1_63 vdout1_63ck55 = 0 time = 280
* CHECK dout0_0 vdout0_0ck56 = 0 time = 285
* CHECK dout0_1 vdout0_1ck56 = 0 time = 285
* CHECK dout0_2 vdout0_2ck56 = 0 time = 285
* CHECK dout0_3 vdout0_3ck56 = 0 time = 285
* CHECK dout0_4 vdout0_4ck56 = 1.0 time = 285
* CHECK dout0_5 vdout0_5ck56 = 0 time = 285
* CHECK dout0_6 vdout0_6ck56 = 1.0 time = 285
* CHECK dout0_7 vdout0_7ck56 = 1.0 time = 285
* CHECK dout0_8 vdout0_8ck56 = 0 time = 285
* CHECK dout0_9 vdout0_9ck56 = 1.0 time = 285
* CHECK dout0_10 vdout0_10ck56 = 0 time = 285
* CHECK dout0_11 vdout0_11ck56 = 1.0 time = 285
* CHECK dout0_12 vdout0_12ck56 = 0 time = 285
* CHECK dout0_13 vdout0_13ck56 = 1.0 time = 285
* CHECK dout0_14 vdout0_14ck56 = 0 time = 285
* CHECK dout0_15 vdout0_15ck56 = 1.0 time = 285
* CHECK dout0_16 vdout0_16ck56 = 1.0 time = 285
* CHECK dout0_17 vdout0_17ck56 = 0 time = 285
* CHECK dout0_18 vdout0_18ck56 = 0 time = 285
* CHECK dout0_19 vdout0_19ck56 = 1.0 time = 285
* CHECK dout0_20 vdout0_20ck56 = 1.0 time = 285
* CHECK dout0_21 vdout0_21ck56 = 0 time = 285
* CHECK dout0_22 vdout0_22ck56 = 1.0 time = 285
* CHECK dout0_23 vdout0_23ck56 = 1.0 time = 285
* CHECK dout0_24 vdout0_24ck56 = 0 time = 285
* CHECK dout0_25 vdout0_25ck56 = 0 time = 285
* CHECK dout0_26 vdout0_26ck56 = 0 time = 285
* CHECK dout0_27 vdout0_27ck56 = 1.0 time = 285
* CHECK dout0_28 vdout0_28ck56 = 0 time = 285
* CHECK dout0_29 vdout0_29ck56 = 0 time = 285
* CHECK dout0_30 vdout0_30ck56 = 1.0 time = 285
* CHECK dout0_31 vdout0_31ck56 = 0 time = 285
* CHECK dout0_32 vdout0_32ck56 = 1.0 time = 285
* CHECK dout0_33 vdout0_33ck56 = 0 time = 285
* CHECK dout0_34 vdout0_34ck56 = 1.0 time = 285
* CHECK dout0_35 vdout0_35ck56 = 1.0 time = 285
* CHECK dout0_36 vdout0_36ck56 = 1.0 time = 285
* CHECK dout0_37 vdout0_37ck56 = 1.0 time = 285
* CHECK dout0_38 vdout0_38ck56 = 0 time = 285
* CHECK dout0_39 vdout0_39ck56 = 0 time = 285
* CHECK dout0_40 vdout0_40ck56 = 0 time = 285
* CHECK dout0_41 vdout0_41ck56 = 0 time = 285
* CHECK dout0_42 vdout0_42ck56 = 0 time = 285
* CHECK dout0_43 vdout0_43ck56 = 1.0 time = 285
* CHECK dout0_44 vdout0_44ck56 = 0 time = 285
* CHECK dout0_45 vdout0_45ck56 = 0 time = 285
* CHECK dout0_46 vdout0_46ck56 = 0 time = 285
* CHECK dout0_47 vdout0_47ck56 = 0 time = 285
* CHECK dout0_48 vdout0_48ck56 = 0 time = 285
* CHECK dout0_49 vdout0_49ck56 = 1.0 time = 285
* CHECK dout0_50 vdout0_50ck56 = 0 time = 285
* CHECK dout0_51 vdout0_51ck56 = 0 time = 285
* CHECK dout0_52 vdout0_52ck56 = 1.0 time = 285
* CHECK dout0_53 vdout0_53ck56 = 0 time = 285
* CHECK dout0_54 vdout0_54ck56 = 0 time = 285
* CHECK dout0_55 vdout0_55ck56 = 1.0 time = 285
* CHECK dout0_56 vdout0_56ck56 = 1.0 time = 285
* CHECK dout0_57 vdout0_57ck56 = 1.0 time = 285
* CHECK dout0_58 vdout0_58ck56 = 0 time = 285
* CHECK dout0_59 vdout0_59ck56 = 0 time = 285
* CHECK dout0_60 vdout0_60ck56 = 1.0 time = 285
* CHECK dout0_61 vdout0_61ck56 = 0 time = 285
* CHECK dout0_62 vdout0_62ck56 = 1.0 time = 285
* CHECK dout0_63 vdout0_63ck56 = 0 time = 285
* CHECK dout1_0 vdout1_0ck56 = 0 time = 285
* CHECK dout1_1 vdout1_1ck56 = 0 time = 285
* CHECK dout1_2 vdout1_2ck56 = 0 time = 285
* CHECK dout1_3 vdout1_3ck56 = 0 time = 285
* CHECK dout1_4 vdout1_4ck56 = 1.0 time = 285
* CHECK dout1_5 vdout1_5ck56 = 0 time = 285
* CHECK dout1_6 vdout1_6ck56 = 1.0 time = 285
* CHECK dout1_7 vdout1_7ck56 = 1.0 time = 285
* CHECK dout1_8 vdout1_8ck56 = 0 time = 285
* CHECK dout1_9 vdout1_9ck56 = 1.0 time = 285
* CHECK dout1_10 vdout1_10ck56 = 0 time = 285
* CHECK dout1_11 vdout1_11ck56 = 1.0 time = 285
* CHECK dout1_12 vdout1_12ck56 = 0 time = 285
* CHECK dout1_13 vdout1_13ck56 = 1.0 time = 285
* CHECK dout1_14 vdout1_14ck56 = 0 time = 285
* CHECK dout1_15 vdout1_15ck56 = 1.0 time = 285
* CHECK dout1_16 vdout1_16ck56 = 1.0 time = 285
* CHECK dout1_17 vdout1_17ck56 = 0 time = 285
* CHECK dout1_18 vdout1_18ck56 = 0 time = 285
* CHECK dout1_19 vdout1_19ck56 = 1.0 time = 285
* CHECK dout1_20 vdout1_20ck56 = 1.0 time = 285
* CHECK dout1_21 vdout1_21ck56 = 0 time = 285
* CHECK dout1_22 vdout1_22ck56 = 1.0 time = 285
* CHECK dout1_23 vdout1_23ck56 = 1.0 time = 285
* CHECK dout1_24 vdout1_24ck56 = 0 time = 285
* CHECK dout1_25 vdout1_25ck56 = 0 time = 285
* CHECK dout1_26 vdout1_26ck56 = 0 time = 285
* CHECK dout1_27 vdout1_27ck56 = 1.0 time = 285
* CHECK dout1_28 vdout1_28ck56 = 0 time = 285
* CHECK dout1_29 vdout1_29ck56 = 0 time = 285
* CHECK dout1_30 vdout1_30ck56 = 1.0 time = 285
* CHECK dout1_31 vdout1_31ck56 = 0 time = 285
* CHECK dout1_32 vdout1_32ck56 = 1.0 time = 285
* CHECK dout1_33 vdout1_33ck56 = 0 time = 285
* CHECK dout1_34 vdout1_34ck56 = 1.0 time = 285
* CHECK dout1_35 vdout1_35ck56 = 1.0 time = 285
* CHECK dout1_36 vdout1_36ck56 = 1.0 time = 285
* CHECK dout1_37 vdout1_37ck56 = 1.0 time = 285
* CHECK dout1_38 vdout1_38ck56 = 0 time = 285
* CHECK dout1_39 vdout1_39ck56 = 0 time = 285
* CHECK dout1_40 vdout1_40ck56 = 0 time = 285
* CHECK dout1_41 vdout1_41ck56 = 0 time = 285
* CHECK dout1_42 vdout1_42ck56 = 0 time = 285
* CHECK dout1_43 vdout1_43ck56 = 1.0 time = 285
* CHECK dout1_44 vdout1_44ck56 = 0 time = 285
* CHECK dout1_45 vdout1_45ck56 = 0 time = 285
* CHECK dout1_46 vdout1_46ck56 = 0 time = 285
* CHECK dout1_47 vdout1_47ck56 = 0 time = 285
* CHECK dout1_48 vdout1_48ck56 = 0 time = 285
* CHECK dout1_49 vdout1_49ck56 = 1.0 time = 285
* CHECK dout1_50 vdout1_50ck56 = 0 time = 285
* CHECK dout1_51 vdout1_51ck56 = 0 time = 285
* CHECK dout1_52 vdout1_52ck56 = 1.0 time = 285
* CHECK dout1_53 vdout1_53ck56 = 0 time = 285
* CHECK dout1_54 vdout1_54ck56 = 0 time = 285
* CHECK dout1_55 vdout1_55ck56 = 1.0 time = 285
* CHECK dout1_56 vdout1_56ck56 = 1.0 time = 285
* CHECK dout1_57 vdout1_57ck56 = 1.0 time = 285
* CHECK dout1_58 vdout1_58ck56 = 0 time = 285
* CHECK dout1_59 vdout1_59ck56 = 0 time = 285
* CHECK dout1_60 vdout1_60ck56 = 1.0 time = 285
* CHECK dout1_61 vdout1_61ck56 = 0 time = 285
* CHECK dout1_62 vdout1_62ck56 = 1.0 time = 285
* CHECK dout1_63 vdout1_63ck56 = 0 time = 285
* CHECK dout0_0 vdout0_0ck57 = 1.0 time = 290
* CHECK dout0_1 vdout0_1ck57 = 0 time = 290
* CHECK dout0_2 vdout0_2ck57 = 1.0 time = 290
* CHECK dout0_3 vdout0_3ck57 = 0 time = 290
* CHECK dout0_4 vdout0_4ck57 = 0 time = 290
* CHECK dout0_5 vdout0_5ck57 = 1.0 time = 290
* CHECK dout0_6 vdout0_6ck57 = 1.0 time = 290
* CHECK dout0_7 vdout0_7ck57 = 0 time = 290
* CHECK dout0_8 vdout0_8ck57 = 0 time = 290
* CHECK dout0_9 vdout0_9ck57 = 1.0 time = 290
* CHECK dout0_10 vdout0_10ck57 = 0 time = 290
* CHECK dout0_11 vdout0_11ck57 = 1.0 time = 290
* CHECK dout0_12 vdout0_12ck57 = 0 time = 290
* CHECK dout0_13 vdout0_13ck57 = 0 time = 290
* CHECK dout0_14 vdout0_14ck57 = 1.0 time = 290
* CHECK dout0_15 vdout0_15ck57 = 1.0 time = 290
* CHECK dout0_16 vdout0_16ck57 = 1.0 time = 290
* CHECK dout0_17 vdout0_17ck57 = 0 time = 290
* CHECK dout0_18 vdout0_18ck57 = 0 time = 290
* CHECK dout0_19 vdout0_19ck57 = 0 time = 290
* CHECK dout0_20 vdout0_20ck57 = 0 time = 290
* CHECK dout0_21 vdout0_21ck57 = 0 time = 290
* CHECK dout0_22 vdout0_22ck57 = 1.0 time = 290
* CHECK dout0_23 vdout0_23ck57 = 1.0 time = 290
* CHECK dout0_24 vdout0_24ck57 = 1.0 time = 290
* CHECK dout0_25 vdout0_25ck57 = 0 time = 290
* CHECK dout0_26 vdout0_26ck57 = 0 time = 290
* CHECK dout0_27 vdout0_27ck57 = 1.0 time = 290
* CHECK dout0_28 vdout0_28ck57 = 0 time = 290
* CHECK dout0_29 vdout0_29ck57 = 1.0 time = 290
* CHECK dout0_30 vdout0_30ck57 = 1.0 time = 290
* CHECK dout0_31 vdout0_31ck57 = 0 time = 290
* CHECK dout0_32 vdout0_32ck57 = 0 time = 290
* CHECK dout0_33 vdout0_33ck57 = 1.0 time = 290
* CHECK dout0_34 vdout0_34ck57 = 0 time = 290
* CHECK dout0_35 vdout0_35ck57 = 1.0 time = 290
* CHECK dout0_36 vdout0_36ck57 = 0 time = 290
* CHECK dout0_37 vdout0_37ck57 = 0 time = 290
* CHECK dout0_38 vdout0_38ck57 = 0 time = 290
* CHECK dout0_39 vdout0_39ck57 = 1.0 time = 290
* CHECK dout0_40 vdout0_40ck57 = 1.0 time = 290
* CHECK dout0_41 vdout0_41ck57 = 0 time = 290
* CHECK dout0_42 vdout0_42ck57 = 0 time = 290
* CHECK dout0_43 vdout0_43ck57 = 0 time = 290
* CHECK dout0_44 vdout0_44ck57 = 1.0 time = 290
* CHECK dout0_45 vdout0_45ck57 = 0 time = 290
* CHECK dout0_46 vdout0_46ck57 = 1.0 time = 290
* CHECK dout0_47 vdout0_47ck57 = 0 time = 290
* CHECK dout0_48 vdout0_48ck57 = 0 time = 290
* CHECK dout0_49 vdout0_49ck57 = 0 time = 290
* CHECK dout0_50 vdout0_50ck57 = 0 time = 290
* CHECK dout0_51 vdout0_51ck57 = 1.0 time = 290
* CHECK dout0_52 vdout0_52ck57 = 0 time = 290
* CHECK dout0_53 vdout0_53ck57 = 0 time = 290
* CHECK dout0_54 vdout0_54ck57 = 0 time = 290
* CHECK dout0_55 vdout0_55ck57 = 1.0 time = 290
* CHECK dout0_56 vdout0_56ck57 = 1.0 time = 290
* CHECK dout0_57 vdout0_57ck57 = 0 time = 290
* CHECK dout0_58 vdout0_58ck57 = 1.0 time = 290
* CHECK dout0_59 vdout0_59ck57 = 0 time = 290
* CHECK dout0_60 vdout0_60ck57 = 0 time = 290
* CHECK dout0_61 vdout0_61ck57 = 0 time = 290
* CHECK dout0_62 vdout0_62ck57 = 1.0 time = 290
* CHECK dout0_63 vdout0_63ck57 = 1.0 time = 290
* CHECK dout0_0 vdout0_0ck59 = 0 time = 300
* CHECK dout0_1 vdout0_1ck59 = 0 time = 300
* CHECK dout0_2 vdout0_2ck59 = 0 time = 300
* CHECK dout0_3 vdout0_3ck59 = 0 time = 300
* CHECK dout0_4 vdout0_4ck59 = 0 time = 300
* CHECK dout0_5 vdout0_5ck59 = 0 time = 300
* CHECK dout0_6 vdout0_6ck59 = 1.0 time = 300
* CHECK dout0_7 vdout0_7ck59 = 0 time = 300
* CHECK dout0_8 vdout0_8ck59 = 0 time = 300
* CHECK dout0_9 vdout0_9ck59 = 0 time = 300
* CHECK dout0_10 vdout0_10ck59 = 1.0 time = 300
* CHECK dout0_11 vdout0_11ck59 = 1.0 time = 300
* CHECK dout0_12 vdout0_12ck59 = 0 time = 300
* CHECK dout0_13 vdout0_13ck59 = 1.0 time = 300
* CHECK dout0_14 vdout0_14ck59 = 1.0 time = 300
* CHECK dout0_15 vdout0_15ck59 = 0 time = 300
* CHECK dout0_16 vdout0_16ck59 = 0 time = 300
* CHECK dout0_17 vdout0_17ck59 = 0 time = 300
* CHECK dout0_18 vdout0_18ck59 = 1.0 time = 300
* CHECK dout0_19 vdout0_19ck59 = 0 time = 300
* CHECK dout0_20 vdout0_20ck59 = 0 time = 300
* CHECK dout0_21 vdout0_21ck59 = 0 time = 300
* CHECK dout0_22 vdout0_22ck59 = 1.0 time = 300
* CHECK dout0_23 vdout0_23ck59 = 0 time = 300
* CHECK dout0_24 vdout0_24ck59 = 0 time = 300
* CHECK dout0_25 vdout0_25ck59 = 1.0 time = 300
* CHECK dout0_26 vdout0_26ck59 = 1.0 time = 300
* CHECK dout0_27 vdout0_27ck59 = 1.0 time = 300
* CHECK dout0_28 vdout0_28ck59 = 0 time = 300
* CHECK dout0_29 vdout0_29ck59 = 0 time = 300
* CHECK dout0_30 vdout0_30ck59 = 1.0 time = 300
* CHECK dout0_31 vdout0_31ck59 = 0 time = 300
* CHECK dout0_32 vdout0_32ck59 = 0 time = 300
* CHECK dout0_33 vdout0_33ck59 = 0 time = 300
* CHECK dout0_34 vdout0_34ck59 = 0 time = 300
* CHECK dout0_35 vdout0_35ck59 = 1.0 time = 300
* CHECK dout0_36 vdout0_36ck59 = 0 time = 300
* CHECK dout0_37 vdout0_37ck59 = 1.0 time = 300
* CHECK dout0_38 vdout0_38ck59 = 0 time = 300
* CHECK dout0_39 vdout0_39ck59 = 1.0 time = 300
* CHECK dout0_40 vdout0_40ck59 = 0 time = 300
* CHECK dout0_41 vdout0_41ck59 = 0 time = 300
* CHECK dout0_42 vdout0_42ck59 = 1.0 time = 300
* CHECK dout0_43 vdout0_43ck59 = 1.0 time = 300
* CHECK dout0_44 vdout0_44ck59 = 1.0 time = 300
* CHECK dout0_45 vdout0_45ck59 = 0 time = 300
* CHECK dout0_46 vdout0_46ck59 = 1.0 time = 300
* CHECK dout0_47 vdout0_47ck59 = 0 time = 300
* CHECK dout0_48 vdout0_48ck59 = 0 time = 300
* CHECK dout0_49 vdout0_49ck59 = 0 time = 300
* CHECK dout0_50 vdout0_50ck59 = 0 time = 300
* CHECK dout0_51 vdout0_51ck59 = 1.0 time = 300
* CHECK dout0_52 vdout0_52ck59 = 1.0 time = 300
* CHECK dout0_53 vdout0_53ck59 = 1.0 time = 300
* CHECK dout0_54 vdout0_54ck59 = 1.0 time = 300
* CHECK dout0_55 vdout0_55ck59 = 1.0 time = 300
* CHECK dout0_56 vdout0_56ck59 = 0 time = 300
* CHECK dout0_57 vdout0_57ck59 = 1.0 time = 300
* CHECK dout0_58 vdout0_58ck59 = 1.0 time = 300
* CHECK dout0_59 vdout0_59ck59 = 0 time = 300
* CHECK dout0_60 vdout0_60ck59 = 1.0 time = 300
* CHECK dout0_61 vdout0_61ck59 = 1.0 time = 300
* CHECK dout0_62 vdout0_62ck59 = 1.0 time = 300
* CHECK dout0_63 vdout0_63ck59 = 0 time = 300
* CHECK dout1_0 vdout1_0ck59 = 1.0 time = 300
* CHECK dout1_1 vdout1_1ck59 = 0 time = 300
* CHECK dout1_2 vdout1_2ck59 = 0 time = 300
* CHECK dout1_3 vdout1_3ck59 = 1.0 time = 300
* CHECK dout1_4 vdout1_4ck59 = 1.0 time = 300
* CHECK dout1_5 vdout1_5ck59 = 0 time = 300
* CHECK dout1_6 vdout1_6ck59 = 1.0 time = 300
* CHECK dout1_7 vdout1_7ck59 = 1.0 time = 300
* CHECK dout1_8 vdout1_8ck59 = 0 time = 300
* CHECK dout1_9 vdout1_9ck59 = 1.0 time = 300
* CHECK dout1_10 vdout1_10ck59 = 0 time = 300
* CHECK dout1_11 vdout1_11ck59 = 1.0 time = 300
* CHECK dout1_12 vdout1_12ck59 = 0 time = 300
* CHECK dout1_13 vdout1_13ck59 = 1.0 time = 300
* CHECK dout1_14 vdout1_14ck59 = 1.0 time = 300
* CHECK dout1_15 vdout1_15ck59 = 1.0 time = 300
* CHECK dout1_16 vdout1_16ck59 = 1.0 time = 300
* CHECK dout1_17 vdout1_17ck59 = 1.0 time = 300
* CHECK dout1_18 vdout1_18ck59 = 1.0 time = 300
* CHECK dout1_19 vdout1_19ck59 = 1.0 time = 300
* CHECK dout1_20 vdout1_20ck59 = 0 time = 300
* CHECK dout1_21 vdout1_21ck59 = 0 time = 300
* CHECK dout1_22 vdout1_22ck59 = 1.0 time = 300
* CHECK dout1_23 vdout1_23ck59 = 0 time = 300
* CHECK dout1_24 vdout1_24ck59 = 1.0 time = 300
* CHECK dout1_25 vdout1_25ck59 = 1.0 time = 300
* CHECK dout1_26 vdout1_26ck59 = 1.0 time = 300
* CHECK dout1_27 vdout1_27ck59 = 0 time = 300
* CHECK dout1_28 vdout1_28ck59 = 0 time = 300
* CHECK dout1_29 vdout1_29ck59 = 1.0 time = 300
* CHECK dout1_30 vdout1_30ck59 = 1.0 time = 300
* CHECK dout1_31 vdout1_31ck59 = 1.0 time = 300
* CHECK dout1_32 vdout1_32ck59 = 1.0 time = 300
* CHECK dout1_33 vdout1_33ck59 = 0 time = 300
* CHECK dout1_34 vdout1_34ck59 = 1.0 time = 300
* CHECK dout1_35 vdout1_35ck59 = 0 time = 300
* CHECK dout1_36 vdout1_36ck59 = 1.0 time = 300
* CHECK dout1_37 vdout1_37ck59 = 0 time = 300
* CHECK dout1_38 vdout1_38ck59 = 0 time = 300
* CHECK dout1_39 vdout1_39ck59 = 0 time = 300
* CHECK dout1_40 vdout1_40ck59 = 1.0 time = 300
* CHECK dout1_41 vdout1_41ck59 = 0 time = 300
* CHECK dout1_42 vdout1_42ck59 = 1.0 time = 300
* CHECK dout1_43 vdout1_43ck59 = 1.0 time = 300
* CHECK dout1_44 vdout1_44ck59 = 1.0 time = 300
* CHECK dout1_45 vdout1_45ck59 = 0 time = 300
* CHECK dout1_46 vdout1_46ck59 = 0 time = 300
* CHECK dout1_47 vdout1_47ck59 = 1.0 time = 300
* CHECK dout1_48 vdout1_48ck59 = 1.0 time = 300
* CHECK dout1_49 vdout1_49ck59 = 0 time = 300
* CHECK dout1_50 vdout1_50ck59 = 1.0 time = 300
* CHECK dout1_51 vdout1_51ck59 = 1.0 time = 300
* CHECK dout1_52 vdout1_52ck59 = 1.0 time = 300
* CHECK dout1_53 vdout1_53ck59 = 1.0 time = 300
* CHECK dout1_54 vdout1_54ck59 = 1.0 time = 300
* CHECK dout1_55 vdout1_55ck59 = 1.0 time = 300
* CHECK dout1_56 vdout1_56ck59 = 0 time = 300
* CHECK dout1_57 vdout1_57ck59 = 0 time = 300
* CHECK dout1_58 vdout1_58ck59 = 0 time = 300
* CHECK dout1_59 vdout1_59ck59 = 0 time = 300
* CHECK dout1_60 vdout1_60ck59 = 0 time = 300
* CHECK dout1_61 vdout1_61ck59 = 1.0 time = 300
* CHECK dout1_62 vdout1_62ck59 = 0 time = 300
* CHECK dout1_63 vdout1_63ck59 = 1.0 time = 300
* CHECK dout0_0 vdout0_0ck60 = 0 time = 305
* CHECK dout0_1 vdout0_1ck60 = 0 time = 305
* CHECK dout0_2 vdout0_2ck60 = 0 time = 305
* CHECK dout0_3 vdout0_3ck60 = 0 time = 305
* CHECK dout0_4 vdout0_4ck60 = 1.0 time = 305
* CHECK dout0_5 vdout0_5ck60 = 0 time = 305
* CHECK dout0_6 vdout0_6ck60 = 1.0 time = 305
* CHECK dout0_7 vdout0_7ck60 = 1.0 time = 305
* CHECK dout0_8 vdout0_8ck60 = 0 time = 305
* CHECK dout0_9 vdout0_9ck60 = 1.0 time = 305
* CHECK dout0_10 vdout0_10ck60 = 0 time = 305
* CHECK dout0_11 vdout0_11ck60 = 1.0 time = 305
* CHECK dout0_12 vdout0_12ck60 = 0 time = 305
* CHECK dout0_13 vdout0_13ck60 = 1.0 time = 305
* CHECK dout0_14 vdout0_14ck60 = 0 time = 305
* CHECK dout0_15 vdout0_15ck60 = 1.0 time = 305
* CHECK dout0_16 vdout0_16ck60 = 1.0 time = 305
* CHECK dout0_17 vdout0_17ck60 = 0 time = 305
* CHECK dout0_18 vdout0_18ck60 = 0 time = 305
* CHECK dout0_19 vdout0_19ck60 = 1.0 time = 305
* CHECK dout0_20 vdout0_20ck60 = 1.0 time = 305
* CHECK dout0_21 vdout0_21ck60 = 0 time = 305
* CHECK dout0_22 vdout0_22ck60 = 1.0 time = 305
* CHECK dout0_23 vdout0_23ck60 = 1.0 time = 305
* CHECK dout0_24 vdout0_24ck60 = 0 time = 305
* CHECK dout0_25 vdout0_25ck60 = 0 time = 305
* CHECK dout0_26 vdout0_26ck60 = 0 time = 305
* CHECK dout0_27 vdout0_27ck60 = 1.0 time = 305
* CHECK dout0_28 vdout0_28ck60 = 0 time = 305
* CHECK dout0_29 vdout0_29ck60 = 0 time = 305
* CHECK dout0_30 vdout0_30ck60 = 1.0 time = 305
* CHECK dout0_31 vdout0_31ck60 = 0 time = 305
* CHECK dout0_32 vdout0_32ck60 = 1.0 time = 305
* CHECK dout0_33 vdout0_33ck60 = 0 time = 305
* CHECK dout0_34 vdout0_34ck60 = 1.0 time = 305
* CHECK dout0_35 vdout0_35ck60 = 1.0 time = 305
* CHECK dout0_36 vdout0_36ck60 = 1.0 time = 305
* CHECK dout0_37 vdout0_37ck60 = 1.0 time = 305
* CHECK dout0_38 vdout0_38ck60 = 0 time = 305
* CHECK dout0_39 vdout0_39ck60 = 0 time = 305
* CHECK dout0_40 vdout0_40ck60 = 0 time = 305
* CHECK dout0_41 vdout0_41ck60 = 0 time = 305
* CHECK dout0_42 vdout0_42ck60 = 0 time = 305
* CHECK dout0_43 vdout0_43ck60 = 1.0 time = 305
* CHECK dout0_44 vdout0_44ck60 = 0 time = 305
* CHECK dout0_45 vdout0_45ck60 = 0 time = 305
* CHECK dout0_46 vdout0_46ck60 = 0 time = 305
* CHECK dout0_47 vdout0_47ck60 = 0 time = 305
* CHECK dout0_48 vdout0_48ck60 = 0 time = 305
* CHECK dout0_49 vdout0_49ck60 = 1.0 time = 305
* CHECK dout0_50 vdout0_50ck60 = 0 time = 305
* CHECK dout0_51 vdout0_51ck60 = 0 time = 305
* CHECK dout0_52 vdout0_52ck60 = 1.0 time = 305
* CHECK dout0_53 vdout0_53ck60 = 0 time = 305
* CHECK dout0_54 vdout0_54ck60 = 0 time = 305
* CHECK dout0_55 vdout0_55ck60 = 1.0 time = 305
* CHECK dout0_56 vdout0_56ck60 = 1.0 time = 305
* CHECK dout0_57 vdout0_57ck60 = 1.0 time = 305
* CHECK dout0_58 vdout0_58ck60 = 0 time = 305
* CHECK dout0_59 vdout0_59ck60 = 0 time = 305
* CHECK dout0_60 vdout0_60ck60 = 1.0 time = 305
* CHECK dout0_61 vdout0_61ck60 = 0 time = 305
* CHECK dout0_62 vdout0_62ck60 = 1.0 time = 305
* CHECK dout0_63 vdout0_63ck60 = 0 time = 305
* CHECK dout0_0 vdout0_0ck62 = 1.0 time = 315
* CHECK dout0_1 vdout0_1ck62 = 1.0 time = 315
* CHECK dout0_2 vdout0_2ck62 = 0 time = 315
* CHECK dout0_3 vdout0_3ck62 = 1.0 time = 315
* CHECK dout0_4 vdout0_4ck62 = 0 time = 315
* CHECK dout0_5 vdout0_5ck62 = 1.0 time = 315
* CHECK dout0_6 vdout0_6ck62 = 0 time = 315
* CHECK dout0_7 vdout0_7ck62 = 0 time = 315
* CHECK dout0_8 vdout0_8ck62 = 0 time = 315
* CHECK dout0_9 vdout0_9ck62 = 1.0 time = 315
* CHECK dout0_10 vdout0_10ck62 = 0 time = 315
* CHECK dout0_11 vdout0_11ck62 = 0 time = 315
* CHECK dout0_12 vdout0_12ck62 = 1.0 time = 315
* CHECK dout0_13 vdout0_13ck62 = 1.0 time = 315
* CHECK dout0_14 vdout0_14ck62 = 1.0 time = 315
* CHECK dout0_15 vdout0_15ck62 = 0 time = 315
* CHECK dout0_16 vdout0_16ck62 = 1.0 time = 315
* CHECK dout0_17 vdout0_17ck62 = 0 time = 315
* CHECK dout0_18 vdout0_18ck62 = 0 time = 315
* CHECK dout0_19 vdout0_19ck62 = 1.0 time = 315
* CHECK dout0_20 vdout0_20ck62 = 0 time = 315
* CHECK dout0_21 vdout0_21ck62 = 0 time = 315
* CHECK dout0_22 vdout0_22ck62 = 0 time = 315
* CHECK dout0_23 vdout0_23ck62 = 1.0 time = 315
* CHECK dout0_24 vdout0_24ck62 = 0 time = 315
* CHECK dout0_25 vdout0_25ck62 = 1.0 time = 315
* CHECK dout0_26 vdout0_26ck62 = 0 time = 315
* CHECK dout0_27 vdout0_27ck62 = 1.0 time = 315
* CHECK dout0_28 vdout0_28ck62 = 0 time = 315
* CHECK dout0_29 vdout0_29ck62 = 0 time = 315
* CHECK dout0_30 vdout0_30ck62 = 1.0 time = 315
* CHECK dout0_31 vdout0_31ck62 = 0 time = 315
* CHECK dout0_32 vdout0_32ck62 = 1.0 time = 315
* CHECK dout0_33 vdout0_33ck62 = 1.0 time = 315
* CHECK dout0_34 vdout0_34ck62 = 1.0 time = 315
* CHECK dout0_35 vdout0_35ck62 = 1.0 time = 315
* CHECK dout0_36 vdout0_36ck62 = 1.0 time = 315
* CHECK dout0_37 vdout0_37ck62 = 1.0 time = 315
* CHECK dout0_38 vdout0_38ck62 = 0 time = 315
* CHECK dout0_39 vdout0_39ck62 = 1.0 time = 315
* CHECK dout0_40 vdout0_40ck62 = 0 time = 315
* CHECK dout0_41 vdout0_41ck62 = 0 time = 315
* CHECK dout0_42 vdout0_42ck62 = 1.0 time = 315
* CHECK dout0_43 vdout0_43ck62 = 1.0 time = 315
* CHECK dout0_44 vdout0_44ck62 = 1.0 time = 315
* CHECK dout0_45 vdout0_45ck62 = 0 time = 315
* CHECK dout0_46 vdout0_46ck62 = 0 time = 315
* CHECK dout0_47 vdout0_47ck62 = 0 time = 315
* CHECK dout0_48 vdout0_48ck62 = 0 time = 315
* CHECK dout0_49 vdout0_49ck62 = 0 time = 315
* CHECK dout0_50 vdout0_50ck62 = 1.0 time = 315
* CHECK dout0_51 vdout0_51ck62 = 1.0 time = 315
* CHECK dout0_52 vdout0_52ck62 = 1.0 time = 315
* CHECK dout0_53 vdout0_53ck62 = 0 time = 315
* CHECK dout0_54 vdout0_54ck62 = 1.0 time = 315
* CHECK dout0_55 vdout0_55ck62 = 0 time = 315
* CHECK dout0_56 vdout0_56ck62 = 1.0 time = 315
* CHECK dout0_57 vdout0_57ck62 = 1.0 time = 315
* CHECK dout0_58 vdout0_58ck62 = 1.0 time = 315
* CHECK dout0_59 vdout0_59ck62 = 0 time = 315
* CHECK dout0_60 vdout0_60ck62 = 0 time = 315
* CHECK dout0_61 vdout0_61ck62 = 1.0 time = 315
* CHECK dout0_62 vdout0_62ck62 = 1.0 time = 315
* CHECK dout0_63 vdout0_63ck62 = 1.0 time = 315
* CHECK dout1_0 vdout1_0ck62 = 1.0 time = 315
* CHECK dout1_1 vdout1_1ck62 = 1.0 time = 315
* CHECK dout1_2 vdout1_2ck62 = 0 time = 315
* CHECK dout1_3 vdout1_3ck62 = 1.0 time = 315
* CHECK dout1_4 vdout1_4ck62 = 0 time = 315
* CHECK dout1_5 vdout1_5ck62 = 1.0 time = 315
* CHECK dout1_6 vdout1_6ck62 = 0 time = 315
* CHECK dout1_7 vdout1_7ck62 = 0 time = 315
* CHECK dout1_8 vdout1_8ck62 = 0 time = 315
* CHECK dout1_9 vdout1_9ck62 = 1.0 time = 315
* CHECK dout1_10 vdout1_10ck62 = 0 time = 315
* CHECK dout1_11 vdout1_11ck62 = 0 time = 315
* CHECK dout1_12 vdout1_12ck62 = 1.0 time = 315
* CHECK dout1_13 vdout1_13ck62 = 1.0 time = 315
* CHECK dout1_14 vdout1_14ck62 = 1.0 time = 315
* CHECK dout1_15 vdout1_15ck62 = 0 time = 315
* CHECK dout1_16 vdout1_16ck62 = 1.0 time = 315
* CHECK dout1_17 vdout1_17ck62 = 0 time = 315
* CHECK dout1_18 vdout1_18ck62 = 0 time = 315
* CHECK dout1_19 vdout1_19ck62 = 1.0 time = 315
* CHECK dout1_20 vdout1_20ck62 = 0 time = 315
* CHECK dout1_21 vdout1_21ck62 = 0 time = 315
* CHECK dout1_22 vdout1_22ck62 = 0 time = 315
* CHECK dout1_23 vdout1_23ck62 = 1.0 time = 315
* CHECK dout1_24 vdout1_24ck62 = 0 time = 315
* CHECK dout1_25 vdout1_25ck62 = 1.0 time = 315
* CHECK dout1_26 vdout1_26ck62 = 0 time = 315
* CHECK dout1_27 vdout1_27ck62 = 1.0 time = 315
* CHECK dout1_28 vdout1_28ck62 = 0 time = 315
* CHECK dout1_29 vdout1_29ck62 = 0 time = 315
* CHECK dout1_30 vdout1_30ck62 = 1.0 time = 315
* CHECK dout1_31 vdout1_31ck62 = 0 time = 315
* CHECK dout1_32 vdout1_32ck62 = 1.0 time = 315
* CHECK dout1_33 vdout1_33ck62 = 1.0 time = 315
* CHECK dout1_34 vdout1_34ck62 = 1.0 time = 315
* CHECK dout1_35 vdout1_35ck62 = 1.0 time = 315
* CHECK dout1_36 vdout1_36ck62 = 1.0 time = 315
* CHECK dout1_37 vdout1_37ck62 = 1.0 time = 315
* CHECK dout1_38 vdout1_38ck62 = 0 time = 315
* CHECK dout1_39 vdout1_39ck62 = 1.0 time = 315
* CHECK dout1_40 vdout1_40ck62 = 0 time = 315
* CHECK dout1_41 vdout1_41ck62 = 0 time = 315
* CHECK dout1_42 vdout1_42ck62 = 1.0 time = 315
* CHECK dout1_43 vdout1_43ck62 = 1.0 time = 315
* CHECK dout1_44 vdout1_44ck62 = 1.0 time = 315
* CHECK dout1_45 vdout1_45ck62 = 0 time = 315
* CHECK dout1_46 vdout1_46ck62 = 0 time = 315
* CHECK dout1_47 vdout1_47ck62 = 0 time = 315
* CHECK dout1_48 vdout1_48ck62 = 0 time = 315
* CHECK dout1_49 vdout1_49ck62 = 0 time = 315
* CHECK dout1_50 vdout1_50ck62 = 1.0 time = 315
* CHECK dout1_51 vdout1_51ck62 = 1.0 time = 315
* CHECK dout1_52 vdout1_52ck62 = 1.0 time = 315
* CHECK dout1_53 vdout1_53ck62 = 0 time = 315
* CHECK dout1_54 vdout1_54ck62 = 1.0 time = 315
* CHECK dout1_55 vdout1_55ck62 = 0 time = 315
* CHECK dout1_56 vdout1_56ck62 = 1.0 time = 315
* CHECK dout1_57 vdout1_57ck62 = 1.0 time = 315
* CHECK dout1_58 vdout1_58ck62 = 1.0 time = 315
* CHECK dout1_59 vdout1_59ck62 = 0 time = 315
* CHECK dout1_60 vdout1_60ck62 = 0 time = 315
* CHECK dout1_61 vdout1_61ck62 = 1.0 time = 315
* CHECK dout1_62 vdout1_62ck62 = 1.0 time = 315
* CHECK dout1_63 vdout1_63ck62 = 1.0 time = 315
* CHECK dout1_0 vdout1_0ck64 = 0 time = 325
* CHECK dout1_1 vdout1_1ck64 = 0 time = 325
* CHECK dout1_2 vdout1_2ck64 = 0 time = 325
* CHECK dout1_3 vdout1_3ck64 = 0 time = 325
* CHECK dout1_4 vdout1_4ck64 = 0 time = 325
* CHECK dout1_5 vdout1_5ck64 = 0 time = 325
* CHECK dout1_6 vdout1_6ck64 = 1.0 time = 325
* CHECK dout1_7 vdout1_7ck64 = 0 time = 325
* CHECK dout1_8 vdout1_8ck64 = 0 time = 325
* CHECK dout1_9 vdout1_9ck64 = 0 time = 325
* CHECK dout1_10 vdout1_10ck64 = 1.0 time = 325
* CHECK dout1_11 vdout1_11ck64 = 1.0 time = 325
* CHECK dout1_12 vdout1_12ck64 = 0 time = 325
* CHECK dout1_13 vdout1_13ck64 = 1.0 time = 325
* CHECK dout1_14 vdout1_14ck64 = 1.0 time = 325
* CHECK dout1_15 vdout1_15ck64 = 0 time = 325
* CHECK dout1_16 vdout1_16ck64 = 0 time = 325
* CHECK dout1_17 vdout1_17ck64 = 0 time = 325
* CHECK dout1_18 vdout1_18ck64 = 1.0 time = 325
* CHECK dout1_19 vdout1_19ck64 = 0 time = 325
* CHECK dout1_20 vdout1_20ck64 = 0 time = 325
* CHECK dout1_21 vdout1_21ck64 = 0 time = 325
* CHECK dout1_22 vdout1_22ck64 = 1.0 time = 325
* CHECK dout1_23 vdout1_23ck64 = 0 time = 325
* CHECK dout1_24 vdout1_24ck64 = 0 time = 325
* CHECK dout1_25 vdout1_25ck64 = 1.0 time = 325
* CHECK dout1_26 vdout1_26ck64 = 1.0 time = 325
* CHECK dout1_27 vdout1_27ck64 = 1.0 time = 325
* CHECK dout1_28 vdout1_28ck64 = 0 time = 325
* CHECK dout1_29 vdout1_29ck64 = 0 time = 325
* CHECK dout1_30 vdout1_30ck64 = 1.0 time = 325
* CHECK dout1_31 vdout1_31ck64 = 0 time = 325
* CHECK dout1_32 vdout1_32ck64 = 0 time = 325
* CHECK dout1_33 vdout1_33ck64 = 0 time = 325
* CHECK dout1_34 vdout1_34ck64 = 0 time = 325
* CHECK dout1_35 vdout1_35ck64 = 1.0 time = 325
* CHECK dout1_36 vdout1_36ck64 = 0 time = 325
* CHECK dout1_37 vdout1_37ck64 = 1.0 time = 325
* CHECK dout1_38 vdout1_38ck64 = 0 time = 325
* CHECK dout1_39 vdout1_39ck64 = 1.0 time = 325
* CHECK dout1_40 vdout1_40ck64 = 0 time = 325
* CHECK dout1_41 vdout1_41ck64 = 0 time = 325
* CHECK dout1_42 vdout1_42ck64 = 1.0 time = 325
* CHECK dout1_43 vdout1_43ck64 = 1.0 time = 325
* CHECK dout1_44 vdout1_44ck64 = 1.0 time = 325
* CHECK dout1_45 vdout1_45ck64 = 0 time = 325
* CHECK dout1_46 vdout1_46ck64 = 1.0 time = 325
* CHECK dout1_47 vdout1_47ck64 = 0 time = 325
* CHECK dout1_48 vdout1_48ck64 = 0 time = 325
* CHECK dout1_49 vdout1_49ck64 = 0 time = 325
* CHECK dout1_50 vdout1_50ck64 = 0 time = 325
* CHECK dout1_51 vdout1_51ck64 = 1.0 time = 325
* CHECK dout1_52 vdout1_52ck64 = 1.0 time = 325
* CHECK dout1_53 vdout1_53ck64 = 1.0 time = 325
* CHECK dout1_54 vdout1_54ck64 = 1.0 time = 325
* CHECK dout1_55 vdout1_55ck64 = 1.0 time = 325
* CHECK dout1_56 vdout1_56ck64 = 0 time = 325
* CHECK dout1_57 vdout1_57ck64 = 1.0 time = 325
* CHECK dout1_58 vdout1_58ck64 = 1.0 time = 325
* CHECK dout1_59 vdout1_59ck64 = 0 time = 325
* CHECK dout1_60 vdout1_60ck64 = 1.0 time = 325
* CHECK dout1_61 vdout1_61ck64 = 1.0 time = 325
* CHECK dout1_62 vdout1_62ck64 = 1.0 time = 325
* CHECK dout1_63 vdout1_63ck64 = 0 time = 325
* CHECK dout1_0 vdout1_0ck65 = 1.0 time = 330
* CHECK dout1_1 vdout1_1ck65 = 0 time = 330
* CHECK dout1_2 vdout1_2ck65 = 1.0 time = 330
* CHECK dout1_3 vdout1_3ck65 = 0 time = 330
* CHECK dout1_4 vdout1_4ck65 = 0 time = 330
* CHECK dout1_5 vdout1_5ck65 = 1.0 time = 330
* CHECK dout1_6 vdout1_6ck65 = 1.0 time = 330
* CHECK dout1_7 vdout1_7ck65 = 0 time = 330
* CHECK dout1_8 vdout1_8ck65 = 0 time = 330
* CHECK dout1_9 vdout1_9ck65 = 1.0 time = 330
* CHECK dout1_10 vdout1_10ck65 = 0 time = 330
* CHECK dout1_11 vdout1_11ck65 = 1.0 time = 330
* CHECK dout1_12 vdout1_12ck65 = 0 time = 330
* CHECK dout1_13 vdout1_13ck65 = 0 time = 330
* CHECK dout1_14 vdout1_14ck65 = 1.0 time = 330
* CHECK dout1_15 vdout1_15ck65 = 1.0 time = 330
* CHECK dout1_16 vdout1_16ck65 = 1.0 time = 330
* CHECK dout1_17 vdout1_17ck65 = 0 time = 330
* CHECK dout1_18 vdout1_18ck65 = 0 time = 330
* CHECK dout1_19 vdout1_19ck65 = 0 time = 330
* CHECK dout1_20 vdout1_20ck65 = 0 time = 330
* CHECK dout1_21 vdout1_21ck65 = 0 time = 330
* CHECK dout1_22 vdout1_22ck65 = 1.0 time = 330
* CHECK dout1_23 vdout1_23ck65 = 1.0 time = 330
* CHECK dout1_24 vdout1_24ck65 = 1.0 time = 330
* CHECK dout1_25 vdout1_25ck65 = 0 time = 330
* CHECK dout1_26 vdout1_26ck65 = 0 time = 330
* CHECK dout1_27 vdout1_27ck65 = 1.0 time = 330
* CHECK dout1_28 vdout1_28ck65 = 0 time = 330
* CHECK dout1_29 vdout1_29ck65 = 1.0 time = 330
* CHECK dout1_30 vdout1_30ck65 = 1.0 time = 330
* CHECK dout1_31 vdout1_31ck65 = 0 time = 330
* CHECK dout1_32 vdout1_32ck65 = 0 time = 330
* CHECK dout1_33 vdout1_33ck65 = 1.0 time = 330
* CHECK dout1_34 vdout1_34ck65 = 0 time = 330
* CHECK dout1_35 vdout1_35ck65 = 1.0 time = 330
* CHECK dout1_36 vdout1_36ck65 = 0 time = 330
* CHECK dout1_37 vdout1_37ck65 = 0 time = 330
* CHECK dout1_38 vdout1_38ck65 = 0 time = 330
* CHECK dout1_39 vdout1_39ck65 = 1.0 time = 330
* CHECK dout1_40 vdout1_40ck65 = 1.0 time = 330
* CHECK dout1_41 vdout1_41ck65 = 0 time = 330
* CHECK dout1_42 vdout1_42ck65 = 0 time = 330
* CHECK dout1_43 vdout1_43ck65 = 0 time = 330
* CHECK dout1_44 vdout1_44ck65 = 1.0 time = 330
* CHECK dout1_45 vdout1_45ck65 = 0 time = 330
* CHECK dout1_46 vdout1_46ck65 = 1.0 time = 330
* CHECK dout1_47 vdout1_47ck65 = 0 time = 330
* CHECK dout1_48 vdout1_48ck65 = 0 time = 330
* CHECK dout1_49 vdout1_49ck65 = 0 time = 330
* CHECK dout1_50 vdout1_50ck65 = 0 time = 330
* CHECK dout1_51 vdout1_51ck65 = 1.0 time = 330
* CHECK dout1_52 vdout1_52ck65 = 0 time = 330
* CHECK dout1_53 vdout1_53ck65 = 0 time = 330
* CHECK dout1_54 vdout1_54ck65 = 0 time = 330
* CHECK dout1_55 vdout1_55ck65 = 1.0 time = 330
* CHECK dout1_56 vdout1_56ck65 = 1.0 time = 330
* CHECK dout1_57 vdout1_57ck65 = 0 time = 330
* CHECK dout1_58 vdout1_58ck65 = 1.0 time = 330
* CHECK dout1_59 vdout1_59ck65 = 0 time = 330
* CHECK dout1_60 vdout1_60ck65 = 0 time = 330
* CHECK dout1_61 vdout1_61ck65 = 0 time = 330
* CHECK dout1_62 vdout1_62ck65 = 1.0 time = 330
* CHECK dout1_63 vdout1_63ck65 = 1.0 time = 330
* CHECK dout0_0 vdout0_0ck68 = 0 time = 345
* CHECK dout0_1 vdout0_1ck68 = 0 time = 345
* CHECK dout0_2 vdout0_2ck68 = 0 time = 345
* CHECK dout0_3 vdout0_3ck68 = 0 time = 345
* CHECK dout0_4 vdout0_4ck68 = 0 time = 345
* CHECK dout0_5 vdout0_5ck68 = 0 time = 345
* CHECK dout0_6 vdout0_6ck68 = 1.0 time = 345
* CHECK dout0_7 vdout0_7ck68 = 0 time = 345
* CHECK dout0_8 vdout0_8ck68 = 0 time = 345
* CHECK dout0_9 vdout0_9ck68 = 0 time = 345
* CHECK dout0_10 vdout0_10ck68 = 1.0 time = 345
* CHECK dout0_11 vdout0_11ck68 = 1.0 time = 345
* CHECK dout0_12 vdout0_12ck68 = 0 time = 345
* CHECK dout0_13 vdout0_13ck68 = 1.0 time = 345
* CHECK dout0_14 vdout0_14ck68 = 1.0 time = 345
* CHECK dout0_15 vdout0_15ck68 = 0 time = 345
* CHECK dout0_16 vdout0_16ck68 = 0 time = 345
* CHECK dout0_17 vdout0_17ck68 = 0 time = 345
* CHECK dout0_18 vdout0_18ck68 = 1.0 time = 345
* CHECK dout0_19 vdout0_19ck68 = 0 time = 345
* CHECK dout0_20 vdout0_20ck68 = 0 time = 345
* CHECK dout0_21 vdout0_21ck68 = 0 time = 345
* CHECK dout0_22 vdout0_22ck68 = 1.0 time = 345
* CHECK dout0_23 vdout0_23ck68 = 0 time = 345
* CHECK dout0_24 vdout0_24ck68 = 0 time = 345
* CHECK dout0_25 vdout0_25ck68 = 1.0 time = 345
* CHECK dout0_26 vdout0_26ck68 = 1.0 time = 345
* CHECK dout0_27 vdout0_27ck68 = 1.0 time = 345
* CHECK dout0_28 vdout0_28ck68 = 0 time = 345
* CHECK dout0_29 vdout0_29ck68 = 0 time = 345
* CHECK dout0_30 vdout0_30ck68 = 1.0 time = 345
* CHECK dout0_31 vdout0_31ck68 = 0 time = 345
* CHECK dout0_32 vdout0_32ck68 = 0 time = 345
* CHECK dout0_33 vdout0_33ck68 = 0 time = 345
* CHECK dout0_34 vdout0_34ck68 = 0 time = 345
* CHECK dout0_35 vdout0_35ck68 = 1.0 time = 345
* CHECK dout0_36 vdout0_36ck68 = 0 time = 345
* CHECK dout0_37 vdout0_37ck68 = 1.0 time = 345
* CHECK dout0_38 vdout0_38ck68 = 0 time = 345
* CHECK dout0_39 vdout0_39ck68 = 1.0 time = 345
* CHECK dout0_40 vdout0_40ck68 = 0 time = 345
* CHECK dout0_41 vdout0_41ck68 = 0 time = 345
* CHECK dout0_42 vdout0_42ck68 = 1.0 time = 345
* CHECK dout0_43 vdout0_43ck68 = 1.0 time = 345
* CHECK dout0_44 vdout0_44ck68 = 1.0 time = 345
* CHECK dout0_45 vdout0_45ck68 = 0 time = 345
* CHECK dout0_46 vdout0_46ck68 = 1.0 time = 345
* CHECK dout0_47 vdout0_47ck68 = 0 time = 345
* CHECK dout0_48 vdout0_48ck68 = 0 time = 345
* CHECK dout0_49 vdout0_49ck68 = 0 time = 345
* CHECK dout0_50 vdout0_50ck68 = 0 time = 345
* CHECK dout0_51 vdout0_51ck68 = 1.0 time = 345
* CHECK dout0_52 vdout0_52ck68 = 1.0 time = 345
* CHECK dout0_53 vdout0_53ck68 = 1.0 time = 345
* CHECK dout0_54 vdout0_54ck68 = 1.0 time = 345
* CHECK dout0_55 vdout0_55ck68 = 1.0 time = 345
* CHECK dout0_56 vdout0_56ck68 = 0 time = 345
* CHECK dout0_57 vdout0_57ck68 = 1.0 time = 345
* CHECK dout0_58 vdout0_58ck68 = 1.0 time = 345
* CHECK dout0_59 vdout0_59ck68 = 0 time = 345
* CHECK dout0_60 vdout0_60ck68 = 1.0 time = 345
* CHECK dout0_61 vdout0_61ck68 = 1.0 time = 345
* CHECK dout0_62 vdout0_62ck68 = 1.0 time = 345
* CHECK dout0_63 vdout0_63ck68 = 0 time = 345
* CHECK dout1_0 vdout1_0ck68 = 1.0 time = 345
* CHECK dout1_1 vdout1_1ck68 = 0 time = 345
* CHECK dout1_2 vdout1_2ck68 = 1.0 time = 345
* CHECK dout1_3 vdout1_3ck68 = 0 time = 345
* CHECK dout1_4 vdout1_4ck68 = 0 time = 345
* CHECK dout1_5 vdout1_5ck68 = 1.0 time = 345
* CHECK dout1_6 vdout1_6ck68 = 1.0 time = 345
* CHECK dout1_7 vdout1_7ck68 = 0 time = 345
* CHECK dout1_8 vdout1_8ck68 = 0 time = 345
* CHECK dout1_9 vdout1_9ck68 = 1.0 time = 345
* CHECK dout1_10 vdout1_10ck68 = 0 time = 345
* CHECK dout1_11 vdout1_11ck68 = 1.0 time = 345
* CHECK dout1_12 vdout1_12ck68 = 0 time = 345
* CHECK dout1_13 vdout1_13ck68 = 0 time = 345
* CHECK dout1_14 vdout1_14ck68 = 1.0 time = 345
* CHECK dout1_15 vdout1_15ck68 = 1.0 time = 345
* CHECK dout1_16 vdout1_16ck68 = 1.0 time = 345
* CHECK dout1_17 vdout1_17ck68 = 0 time = 345
* CHECK dout1_18 vdout1_18ck68 = 0 time = 345
* CHECK dout1_19 vdout1_19ck68 = 0 time = 345
* CHECK dout1_20 vdout1_20ck68 = 0 time = 345
* CHECK dout1_21 vdout1_21ck68 = 0 time = 345
* CHECK dout1_22 vdout1_22ck68 = 1.0 time = 345
* CHECK dout1_23 vdout1_23ck68 = 1.0 time = 345
* CHECK dout1_24 vdout1_24ck68 = 1.0 time = 345
* CHECK dout1_25 vdout1_25ck68 = 0 time = 345
* CHECK dout1_26 vdout1_26ck68 = 0 time = 345
* CHECK dout1_27 vdout1_27ck68 = 1.0 time = 345
* CHECK dout1_28 vdout1_28ck68 = 0 time = 345
* CHECK dout1_29 vdout1_29ck68 = 1.0 time = 345
* CHECK dout1_30 vdout1_30ck68 = 1.0 time = 345
* CHECK dout1_31 vdout1_31ck68 = 0 time = 345
* CHECK dout1_32 vdout1_32ck68 = 0 time = 345
* CHECK dout1_33 vdout1_33ck68 = 1.0 time = 345
* CHECK dout1_34 vdout1_34ck68 = 0 time = 345
* CHECK dout1_35 vdout1_35ck68 = 1.0 time = 345
* CHECK dout1_36 vdout1_36ck68 = 0 time = 345
* CHECK dout1_37 vdout1_37ck68 = 0 time = 345
* CHECK dout1_38 vdout1_38ck68 = 0 time = 345
* CHECK dout1_39 vdout1_39ck68 = 1.0 time = 345
* CHECK dout1_40 vdout1_40ck68 = 1.0 time = 345
* CHECK dout1_41 vdout1_41ck68 = 0 time = 345
* CHECK dout1_42 vdout1_42ck68 = 0 time = 345
* CHECK dout1_43 vdout1_43ck68 = 0 time = 345
* CHECK dout1_44 vdout1_44ck68 = 1.0 time = 345
* CHECK dout1_45 vdout1_45ck68 = 0 time = 345
* CHECK dout1_46 vdout1_46ck68 = 1.0 time = 345
* CHECK dout1_47 vdout1_47ck68 = 0 time = 345
* CHECK dout1_48 vdout1_48ck68 = 0 time = 345
* CHECK dout1_49 vdout1_49ck68 = 0 time = 345
* CHECK dout1_50 vdout1_50ck68 = 0 time = 345
* CHECK dout1_51 vdout1_51ck68 = 1.0 time = 345
* CHECK dout1_52 vdout1_52ck68 = 0 time = 345
* CHECK dout1_53 vdout1_53ck68 = 0 time = 345
* CHECK dout1_54 vdout1_54ck68 = 0 time = 345
* CHECK dout1_55 vdout1_55ck68 = 1.0 time = 345
* CHECK dout1_56 vdout1_56ck68 = 1.0 time = 345
* CHECK dout1_57 vdout1_57ck68 = 0 time = 345
* CHECK dout1_58 vdout1_58ck68 = 1.0 time = 345
* CHECK dout1_59 vdout1_59ck68 = 0 time = 345
* CHECK dout1_60 vdout1_60ck68 = 0 time = 345
* CHECK dout1_61 vdout1_61ck68 = 0 time = 345
* CHECK dout1_62 vdout1_62ck68 = 1.0 time = 345
* CHECK dout1_63 vdout1_63ck68 = 1.0 time = 345
* CHECK dout0_0 vdout0_0ck69 = 1.0 time = 350
* CHECK dout0_1 vdout0_1ck69 = 0 time = 350
* CHECK dout0_2 vdout0_2ck69 = 0 time = 350
* CHECK dout0_3 vdout0_3ck69 = 0 time = 350
* CHECK dout0_4 vdout0_4ck69 = 0 time = 350
* CHECK dout0_5 vdout0_5ck69 = 1.0 time = 350
* CHECK dout0_6 vdout0_6ck69 = 0 time = 350
* CHECK dout0_7 vdout0_7ck69 = 0 time = 350
* CHECK dout0_8 vdout0_8ck69 = 0 time = 350
* CHECK dout0_9 vdout0_9ck69 = 0 time = 350
* CHECK dout0_10 vdout0_10ck69 = 1.0 time = 350
* CHECK dout0_11 vdout0_11ck69 = 0 time = 350
* CHECK dout0_12 vdout0_12ck69 = 1.0 time = 350
* CHECK dout0_13 vdout0_13ck69 = 0 time = 350
* CHECK dout0_14 vdout0_14ck69 = 1.0 time = 350
* CHECK dout0_15 vdout0_15ck69 = 0 time = 350
* CHECK dout0_16 vdout0_16ck69 = 0 time = 350
* CHECK dout0_17 vdout0_17ck69 = 0 time = 350
* CHECK dout0_18 vdout0_18ck69 = 1.0 time = 350
* CHECK dout0_19 vdout0_19ck69 = 1.0 time = 350
* CHECK dout0_20 vdout0_20ck69 = 0 time = 350
* CHECK dout0_21 vdout0_21ck69 = 1.0 time = 350
* CHECK dout0_22 vdout0_22ck69 = 0 time = 350
* CHECK dout0_23 vdout0_23ck69 = 1.0 time = 350
* CHECK dout0_24 vdout0_24ck69 = 0 time = 350
* CHECK dout0_25 vdout0_25ck69 = 0 time = 350
* CHECK dout0_26 vdout0_26ck69 = 1.0 time = 350
* CHECK dout0_27 vdout0_27ck69 = 1.0 time = 350
* CHECK dout0_28 vdout0_28ck69 = 0 time = 350
* CHECK dout0_29 vdout0_29ck69 = 1.0 time = 350
* CHECK dout0_30 vdout0_30ck69 = 1.0 time = 350
* CHECK dout0_31 vdout0_31ck69 = 0 time = 350
* CHECK dout0_32 vdout0_32ck69 = 0 time = 350
* CHECK dout0_33 vdout0_33ck69 = 1.0 time = 350
* CHECK dout0_34 vdout0_34ck69 = 0 time = 350
* CHECK dout0_35 vdout0_35ck69 = 0 time = 350
* CHECK dout0_36 vdout0_36ck69 = 0 time = 350
* CHECK dout0_37 vdout0_37ck69 = 0 time = 350
* CHECK dout0_38 vdout0_38ck69 = 0 time = 350
* CHECK dout0_39 vdout0_39ck69 = 0 time = 350
* CHECK dout0_40 vdout0_40ck69 = 1.0 time = 350
* CHECK dout0_41 vdout0_41ck69 = 1.0 time = 350
* CHECK dout0_42 vdout0_42ck69 = 1.0 time = 350
* CHECK dout0_43 vdout0_43ck69 = 1.0 time = 350
* CHECK dout0_44 vdout0_44ck69 = 0 time = 350
* CHECK dout0_45 vdout0_45ck69 = 1.0 time = 350
* CHECK dout0_46 vdout0_46ck69 = 0 time = 350
* CHECK dout0_47 vdout0_47ck69 = 0 time = 350
* CHECK dout0_48 vdout0_48ck69 = 1.0 time = 350
* CHECK dout0_49 vdout0_49ck69 = 0 time = 350
* CHECK dout0_50 vdout0_50ck69 = 0 time = 350
* CHECK dout0_51 vdout0_51ck69 = 0 time = 350
* CHECK dout0_52 vdout0_52ck69 = 0 time = 350
* CHECK dout0_53 vdout0_53ck69 = 0 time = 350
* CHECK dout0_54 vdout0_54ck69 = 1.0 time = 350
* CHECK dout0_55 vdout0_55ck69 = 0 time = 350
* CHECK dout0_56 vdout0_56ck69 = 1.0 time = 350
* CHECK dout0_57 vdout0_57ck69 = 0 time = 350
* CHECK dout0_58 vdout0_58ck69 = 1.0 time = 350
* CHECK dout0_59 vdout0_59ck69 = 1.0 time = 350
* CHECK dout0_60 vdout0_60ck69 = 1.0 time = 350
* CHECK dout0_61 vdout0_61ck69 = 1.0 time = 350
* CHECK dout0_62 vdout0_62ck69 = 0 time = 350
* CHECK dout0_63 vdout0_63ck69 = 0 time = 350
* CHECK dout1_0 vdout1_0ck69 = 0 time = 350
* CHECK dout1_1 vdout1_1ck69 = 0 time = 350
* CHECK dout1_2 vdout1_2ck69 = 0 time = 350
* CHECK dout1_3 vdout1_3ck69 = 0 time = 350
* CHECK dout1_4 vdout1_4ck69 = 0 time = 350
* CHECK dout1_5 vdout1_5ck69 = 0 time = 350
* CHECK dout1_6 vdout1_6ck69 = 1.0 time = 350
* CHECK dout1_7 vdout1_7ck69 = 0 time = 350
* CHECK dout1_8 vdout1_8ck69 = 0 time = 350
* CHECK dout1_9 vdout1_9ck69 = 0 time = 350
* CHECK dout1_10 vdout1_10ck69 = 1.0 time = 350
* CHECK dout1_11 vdout1_11ck69 = 1.0 time = 350
* CHECK dout1_12 vdout1_12ck69 = 0 time = 350
* CHECK dout1_13 vdout1_13ck69 = 1.0 time = 350
* CHECK dout1_14 vdout1_14ck69 = 1.0 time = 350
* CHECK dout1_15 vdout1_15ck69 = 0 time = 350
* CHECK dout1_16 vdout1_16ck69 = 0 time = 350
* CHECK dout1_17 vdout1_17ck69 = 0 time = 350
* CHECK dout1_18 vdout1_18ck69 = 1.0 time = 350
* CHECK dout1_19 vdout1_19ck69 = 0 time = 350
* CHECK dout1_20 vdout1_20ck69 = 0 time = 350
* CHECK dout1_21 vdout1_21ck69 = 0 time = 350
* CHECK dout1_22 vdout1_22ck69 = 1.0 time = 350
* CHECK dout1_23 vdout1_23ck69 = 0 time = 350
* CHECK dout1_24 vdout1_24ck69 = 0 time = 350
* CHECK dout1_25 vdout1_25ck69 = 1.0 time = 350
* CHECK dout1_26 vdout1_26ck69 = 1.0 time = 350
* CHECK dout1_27 vdout1_27ck69 = 1.0 time = 350
* CHECK dout1_28 vdout1_28ck69 = 0 time = 350
* CHECK dout1_29 vdout1_29ck69 = 0 time = 350
* CHECK dout1_30 vdout1_30ck69 = 1.0 time = 350
* CHECK dout1_31 vdout1_31ck69 = 0 time = 350
* CHECK dout1_32 vdout1_32ck69 = 0 time = 350
* CHECK dout1_33 vdout1_33ck69 = 0 time = 350
* CHECK dout1_34 vdout1_34ck69 = 0 time = 350
* CHECK dout1_35 vdout1_35ck69 = 1.0 time = 350
* CHECK dout1_36 vdout1_36ck69 = 0 time = 350
* CHECK dout1_37 vdout1_37ck69 = 1.0 time = 350
* CHECK dout1_38 vdout1_38ck69 = 0 time = 350
* CHECK dout1_39 vdout1_39ck69 = 1.0 time = 350
* CHECK dout1_40 vdout1_40ck69 = 0 time = 350
* CHECK dout1_41 vdout1_41ck69 = 0 time = 350
* CHECK dout1_42 vdout1_42ck69 = 1.0 time = 350
* CHECK dout1_43 vdout1_43ck69 = 1.0 time = 350
* CHECK dout1_44 vdout1_44ck69 = 1.0 time = 350
* CHECK dout1_45 vdout1_45ck69 = 0 time = 350
* CHECK dout1_46 vdout1_46ck69 = 1.0 time = 350
* CHECK dout1_47 vdout1_47ck69 = 0 time = 350
* CHECK dout1_48 vdout1_48ck69 = 0 time = 350
* CHECK dout1_49 vdout1_49ck69 = 0 time = 350
* CHECK dout1_50 vdout1_50ck69 = 0 time = 350
* CHECK dout1_51 vdout1_51ck69 = 1.0 time = 350
* CHECK dout1_52 vdout1_52ck69 = 1.0 time = 350
* CHECK dout1_53 vdout1_53ck69 = 1.0 time = 350
* CHECK dout1_54 vdout1_54ck69 = 1.0 time = 350
* CHECK dout1_55 vdout1_55ck69 = 1.0 time = 350
* CHECK dout1_56 vdout1_56ck69 = 0 time = 350
* CHECK dout1_57 vdout1_57ck69 = 1.0 time = 350
* CHECK dout1_58 vdout1_58ck69 = 1.0 time = 350
* CHECK dout1_59 vdout1_59ck69 = 0 time = 350
* CHECK dout1_60 vdout1_60ck69 = 1.0 time = 350
* CHECK dout1_61 vdout1_61ck69 = 1.0 time = 350
* CHECK dout1_62 vdout1_62ck69 = 1.0 time = 350
* CHECK dout1_63 vdout1_63ck69 = 0 time = 350
* CHECK dout1_0 vdout1_0ck70 = 1.0 time = 355
* CHECK dout1_1 vdout1_1ck70 = 0 time = 355
* CHECK dout1_2 vdout1_2ck70 = 1.0 time = 355
* CHECK dout1_3 vdout1_3ck70 = 0 time = 355
* CHECK dout1_4 vdout1_4ck70 = 0 time = 355
* CHECK dout1_5 vdout1_5ck70 = 1.0 time = 355
* CHECK dout1_6 vdout1_6ck70 = 1.0 time = 355
* CHECK dout1_7 vdout1_7ck70 = 0 time = 355
* CHECK dout1_8 vdout1_8ck70 = 0 time = 355
* CHECK dout1_9 vdout1_9ck70 = 1.0 time = 355
* CHECK dout1_10 vdout1_10ck70 = 0 time = 355
* CHECK dout1_11 vdout1_11ck70 = 1.0 time = 355
* CHECK dout1_12 vdout1_12ck70 = 0 time = 355
* CHECK dout1_13 vdout1_13ck70 = 0 time = 355
* CHECK dout1_14 vdout1_14ck70 = 1.0 time = 355
* CHECK dout1_15 vdout1_15ck70 = 1.0 time = 355
* CHECK dout1_16 vdout1_16ck70 = 1.0 time = 355
* CHECK dout1_17 vdout1_17ck70 = 0 time = 355
* CHECK dout1_18 vdout1_18ck70 = 0 time = 355
* CHECK dout1_19 vdout1_19ck70 = 0 time = 355
* CHECK dout1_20 vdout1_20ck70 = 0 time = 355
* CHECK dout1_21 vdout1_21ck70 = 0 time = 355
* CHECK dout1_22 vdout1_22ck70 = 1.0 time = 355
* CHECK dout1_23 vdout1_23ck70 = 1.0 time = 355
* CHECK dout1_24 vdout1_24ck70 = 1.0 time = 355
* CHECK dout1_25 vdout1_25ck70 = 0 time = 355
* CHECK dout1_26 vdout1_26ck70 = 0 time = 355
* CHECK dout1_27 vdout1_27ck70 = 1.0 time = 355
* CHECK dout1_28 vdout1_28ck70 = 0 time = 355
* CHECK dout1_29 vdout1_29ck70 = 1.0 time = 355
* CHECK dout1_30 vdout1_30ck70 = 1.0 time = 355
* CHECK dout1_31 vdout1_31ck70 = 0 time = 355
* CHECK dout1_32 vdout1_32ck70 = 0 time = 355
* CHECK dout1_33 vdout1_33ck70 = 1.0 time = 355
* CHECK dout1_34 vdout1_34ck70 = 0 time = 355
* CHECK dout1_35 vdout1_35ck70 = 1.0 time = 355
* CHECK dout1_36 vdout1_36ck70 = 0 time = 355
* CHECK dout1_37 vdout1_37ck70 = 0 time = 355
* CHECK dout1_38 vdout1_38ck70 = 0 time = 355
* CHECK dout1_39 vdout1_39ck70 = 1.0 time = 355
* CHECK dout1_40 vdout1_40ck70 = 1.0 time = 355
* CHECK dout1_41 vdout1_41ck70 = 0 time = 355
* CHECK dout1_42 vdout1_42ck70 = 0 time = 355
* CHECK dout1_43 vdout1_43ck70 = 0 time = 355
* CHECK dout1_44 vdout1_44ck70 = 1.0 time = 355
* CHECK dout1_45 vdout1_45ck70 = 0 time = 355
* CHECK dout1_46 vdout1_46ck70 = 1.0 time = 355
* CHECK dout1_47 vdout1_47ck70 = 0 time = 355
* CHECK dout1_48 vdout1_48ck70 = 0 time = 355
* CHECK dout1_49 vdout1_49ck70 = 0 time = 355
* CHECK dout1_50 vdout1_50ck70 = 0 time = 355
* CHECK dout1_51 vdout1_51ck70 = 1.0 time = 355
* CHECK dout1_52 vdout1_52ck70 = 0 time = 355
* CHECK dout1_53 vdout1_53ck70 = 0 time = 355
* CHECK dout1_54 vdout1_54ck70 = 0 time = 355
* CHECK dout1_55 vdout1_55ck70 = 1.0 time = 355
* CHECK dout1_56 vdout1_56ck70 = 1.0 time = 355
* CHECK dout1_57 vdout1_57ck70 = 0 time = 355
* CHECK dout1_58 vdout1_58ck70 = 1.0 time = 355
* CHECK dout1_59 vdout1_59ck70 = 0 time = 355
* CHECK dout1_60 vdout1_60ck70 = 0 time = 355
* CHECK dout1_61 vdout1_61ck70 = 0 time = 355
* CHECK dout1_62 vdout1_62ck70 = 1.0 time = 355
* CHECK dout1_63 vdout1_63ck70 = 1.0 time = 355
* CHECK dout1_0 vdout1_0ck71 = 1.0 time = 360
* CHECK dout1_1 vdout1_1ck71 = 1.0 time = 360
* CHECK dout1_2 vdout1_2ck71 = 0 time = 360
* CHECK dout1_3 vdout1_3ck71 = 1.0 time = 360
* CHECK dout1_4 vdout1_4ck71 = 0 time = 360
* CHECK dout1_5 vdout1_5ck71 = 1.0 time = 360
* CHECK dout1_6 vdout1_6ck71 = 0 time = 360
* CHECK dout1_7 vdout1_7ck71 = 0 time = 360
* CHECK dout1_8 vdout1_8ck71 = 0 time = 360
* CHECK dout1_9 vdout1_9ck71 = 1.0 time = 360
* CHECK dout1_10 vdout1_10ck71 = 0 time = 360
* CHECK dout1_11 vdout1_11ck71 = 0 time = 360
* CHECK dout1_12 vdout1_12ck71 = 1.0 time = 360
* CHECK dout1_13 vdout1_13ck71 = 1.0 time = 360
* CHECK dout1_14 vdout1_14ck71 = 1.0 time = 360
* CHECK dout1_15 vdout1_15ck71 = 0 time = 360
* CHECK dout1_16 vdout1_16ck71 = 1.0 time = 360
* CHECK dout1_17 vdout1_17ck71 = 0 time = 360
* CHECK dout1_18 vdout1_18ck71 = 0 time = 360
* CHECK dout1_19 vdout1_19ck71 = 1.0 time = 360
* CHECK dout1_20 vdout1_20ck71 = 0 time = 360
* CHECK dout1_21 vdout1_21ck71 = 0 time = 360
* CHECK dout1_22 vdout1_22ck71 = 0 time = 360
* CHECK dout1_23 vdout1_23ck71 = 1.0 time = 360
* CHECK dout1_24 vdout1_24ck71 = 0 time = 360
* CHECK dout1_25 vdout1_25ck71 = 1.0 time = 360
* CHECK dout1_26 vdout1_26ck71 = 0 time = 360
* CHECK dout1_27 vdout1_27ck71 = 1.0 time = 360
* CHECK dout1_28 vdout1_28ck71 = 0 time = 360
* CHECK dout1_29 vdout1_29ck71 = 0 time = 360
* CHECK dout1_30 vdout1_30ck71 = 1.0 time = 360
* CHECK dout1_31 vdout1_31ck71 = 0 time = 360
* CHECK dout1_32 vdout1_32ck71 = 1.0 time = 360
* CHECK dout1_33 vdout1_33ck71 = 1.0 time = 360
* CHECK dout1_34 vdout1_34ck71 = 1.0 time = 360
* CHECK dout1_35 vdout1_35ck71 = 1.0 time = 360
* CHECK dout1_36 vdout1_36ck71 = 1.0 time = 360
* CHECK dout1_37 vdout1_37ck71 = 1.0 time = 360
* CHECK dout1_38 vdout1_38ck71 = 0 time = 360
* CHECK dout1_39 vdout1_39ck71 = 1.0 time = 360
* CHECK dout1_40 vdout1_40ck71 = 0 time = 360
* CHECK dout1_41 vdout1_41ck71 = 0 time = 360
* CHECK dout1_42 vdout1_42ck71 = 1.0 time = 360
* CHECK dout1_43 vdout1_43ck71 = 1.0 time = 360
* CHECK dout1_44 vdout1_44ck71 = 1.0 time = 360
* CHECK dout1_45 vdout1_45ck71 = 0 time = 360
* CHECK dout1_46 vdout1_46ck71 = 0 time = 360
* CHECK dout1_47 vdout1_47ck71 = 0 time = 360
* CHECK dout1_48 vdout1_48ck71 = 0 time = 360
* CHECK dout1_49 vdout1_49ck71 = 0 time = 360
* CHECK dout1_50 vdout1_50ck71 = 1.0 time = 360
* CHECK dout1_51 vdout1_51ck71 = 1.0 time = 360
* CHECK dout1_52 vdout1_52ck71 = 1.0 time = 360
* CHECK dout1_53 vdout1_53ck71 = 0 time = 360
* CHECK dout1_54 vdout1_54ck71 = 1.0 time = 360
* CHECK dout1_55 vdout1_55ck71 = 0 time = 360
* CHECK dout1_56 vdout1_56ck71 = 1.0 time = 360
* CHECK dout1_57 vdout1_57ck71 = 1.0 time = 360
* CHECK dout1_58 vdout1_58ck71 = 1.0 time = 360
* CHECK dout1_59 vdout1_59ck71 = 0 time = 360
* CHECK dout1_60 vdout1_60ck71 = 0 time = 360
* CHECK dout1_61 vdout1_61ck71 = 1.0 time = 360
* CHECK dout1_62 vdout1_62ck71 = 1.0 time = 360
* CHECK dout1_63 vdout1_63ck71 = 1.0 time = 360
* CHECK dout1_0 vdout1_0ck72 = 1.0 time = 365
* CHECK dout1_1 vdout1_1ck72 = 1.0 time = 365
* CHECK dout1_2 vdout1_2ck72 = 0 time = 365
* CHECK dout1_3 vdout1_3ck72 = 1.0 time = 365
* CHECK dout1_4 vdout1_4ck72 = 0 time = 365
* CHECK dout1_5 vdout1_5ck72 = 1.0 time = 365
* CHECK dout1_6 vdout1_6ck72 = 0 time = 365
* CHECK dout1_7 vdout1_7ck72 = 0 time = 365
* CHECK dout1_8 vdout1_8ck72 = 0 time = 365
* CHECK dout1_9 vdout1_9ck72 = 1.0 time = 365
* CHECK dout1_10 vdout1_10ck72 = 0 time = 365
* CHECK dout1_11 vdout1_11ck72 = 0 time = 365
* CHECK dout1_12 vdout1_12ck72 = 1.0 time = 365
* CHECK dout1_13 vdout1_13ck72 = 1.0 time = 365
* CHECK dout1_14 vdout1_14ck72 = 1.0 time = 365
* CHECK dout1_15 vdout1_15ck72 = 0 time = 365
* CHECK dout1_16 vdout1_16ck72 = 1.0 time = 365
* CHECK dout1_17 vdout1_17ck72 = 0 time = 365
* CHECK dout1_18 vdout1_18ck72 = 0 time = 365
* CHECK dout1_19 vdout1_19ck72 = 1.0 time = 365
* CHECK dout1_20 vdout1_20ck72 = 0 time = 365
* CHECK dout1_21 vdout1_21ck72 = 0 time = 365
* CHECK dout1_22 vdout1_22ck72 = 0 time = 365
* CHECK dout1_23 vdout1_23ck72 = 1.0 time = 365
* CHECK dout1_24 vdout1_24ck72 = 0 time = 365
* CHECK dout1_25 vdout1_25ck72 = 1.0 time = 365
* CHECK dout1_26 vdout1_26ck72 = 0 time = 365
* CHECK dout1_27 vdout1_27ck72 = 1.0 time = 365
* CHECK dout1_28 vdout1_28ck72 = 0 time = 365
* CHECK dout1_29 vdout1_29ck72 = 0 time = 365
* CHECK dout1_30 vdout1_30ck72 = 1.0 time = 365
* CHECK dout1_31 vdout1_31ck72 = 0 time = 365
* CHECK dout1_32 vdout1_32ck72 = 1.0 time = 365
* CHECK dout1_33 vdout1_33ck72 = 1.0 time = 365
* CHECK dout1_34 vdout1_34ck72 = 1.0 time = 365
* CHECK dout1_35 vdout1_35ck72 = 1.0 time = 365
* CHECK dout1_36 vdout1_36ck72 = 1.0 time = 365
* CHECK dout1_37 vdout1_37ck72 = 1.0 time = 365
* CHECK dout1_38 vdout1_38ck72 = 0 time = 365
* CHECK dout1_39 vdout1_39ck72 = 1.0 time = 365
* CHECK dout1_40 vdout1_40ck72 = 0 time = 365
* CHECK dout1_41 vdout1_41ck72 = 0 time = 365
* CHECK dout1_42 vdout1_42ck72 = 1.0 time = 365
* CHECK dout1_43 vdout1_43ck72 = 1.0 time = 365
* CHECK dout1_44 vdout1_44ck72 = 1.0 time = 365
* CHECK dout1_45 vdout1_45ck72 = 0 time = 365
* CHECK dout1_46 vdout1_46ck72 = 0 time = 365
* CHECK dout1_47 vdout1_47ck72 = 0 time = 365
* CHECK dout1_48 vdout1_48ck72 = 0 time = 365
* CHECK dout1_49 vdout1_49ck72 = 0 time = 365
* CHECK dout1_50 vdout1_50ck72 = 1.0 time = 365
* CHECK dout1_51 vdout1_51ck72 = 1.0 time = 365
* CHECK dout1_52 vdout1_52ck72 = 1.0 time = 365
* CHECK dout1_53 vdout1_53ck72 = 0 time = 365
* CHECK dout1_54 vdout1_54ck72 = 1.0 time = 365
* CHECK dout1_55 vdout1_55ck72 = 0 time = 365
* CHECK dout1_56 vdout1_56ck72 = 1.0 time = 365
* CHECK dout1_57 vdout1_57ck72 = 1.0 time = 365
* CHECK dout1_58 vdout1_58ck72 = 1.0 time = 365
* CHECK dout1_59 vdout1_59ck72 = 0 time = 365
* CHECK dout1_60 vdout1_60ck72 = 0 time = 365
* CHECK dout1_61 vdout1_61ck72 = 1.0 time = 365
* CHECK dout1_62 vdout1_62ck72 = 1.0 time = 365
* CHECK dout1_63 vdout1_63ck72 = 1.0 time = 365
* CHECK dout0_0 vdout0_0ck73 = 1.0 time = 370
* CHECK dout0_1 vdout0_1ck73 = 0 time = 370
* CHECK dout0_2 vdout0_2ck73 = 1.0 time = 370
* CHECK dout0_3 vdout0_3ck73 = 1.0 time = 370
* CHECK dout0_4 vdout0_4ck73 = 0 time = 370
* CHECK dout0_5 vdout0_5ck73 = 1.0 time = 370
* CHECK dout0_6 vdout0_6ck73 = 0 time = 370
* CHECK dout0_7 vdout0_7ck73 = 0 time = 370
* CHECK dout0_8 vdout0_8ck73 = 1.0 time = 370
* CHECK dout0_9 vdout0_9ck73 = 0 time = 370
* CHECK dout0_10 vdout0_10ck73 = 0 time = 370
* CHECK dout0_11 vdout0_11ck73 = 1.0 time = 370
* CHECK dout0_12 vdout0_12ck73 = 0 time = 370
* CHECK dout0_13 vdout0_13ck73 = 0 time = 370
* CHECK dout0_14 vdout0_14ck73 = 0 time = 370
* CHECK dout0_15 vdout0_15ck73 = 1.0 time = 370
* CHECK dout0_16 vdout0_16ck73 = 0 time = 370
* CHECK dout0_17 vdout0_17ck73 = 1.0 time = 370
* CHECK dout0_18 vdout0_18ck73 = 0 time = 370
* CHECK dout0_19 vdout0_19ck73 = 0 time = 370
* CHECK dout0_20 vdout0_20ck73 = 1.0 time = 370
* CHECK dout0_21 vdout0_21ck73 = 0 time = 370
* CHECK dout0_22 vdout0_22ck73 = 1.0 time = 370
* CHECK dout0_23 vdout0_23ck73 = 0 time = 370
* CHECK dout0_24 vdout0_24ck73 = 1.0 time = 370
* CHECK dout0_25 vdout0_25ck73 = 1.0 time = 370
* CHECK dout0_26 vdout0_26ck73 = 0 time = 370
* CHECK dout0_27 vdout0_27ck73 = 0 time = 370
* CHECK dout0_28 vdout0_28ck73 = 1.0 time = 370
* CHECK dout0_29 vdout0_29ck73 = 1.0 time = 370
* CHECK dout0_30 vdout0_30ck73 = 0 time = 370
* CHECK dout0_31 vdout0_31ck73 = 1.0 time = 370
* CHECK dout0_32 vdout0_32ck73 = 1.0 time = 370
* CHECK dout0_33 vdout0_33ck73 = 1.0 time = 370
* CHECK dout0_34 vdout0_34ck73 = 1.0 time = 370
* CHECK dout0_35 vdout0_35ck73 = 0 time = 370
* CHECK dout0_36 vdout0_36ck73 = 0 time = 370
* CHECK dout0_37 vdout0_37ck73 = 1.0 time = 370
* CHECK dout0_38 vdout0_38ck73 = 0 time = 370
* CHECK dout0_39 vdout0_39ck73 = 0 time = 370
* CHECK dout0_40 vdout0_40ck73 = 0 time = 370
* CHECK dout0_41 vdout0_41ck73 = 1.0 time = 370
* CHECK dout0_42 vdout0_42ck73 = 1.0 time = 370
* CHECK dout0_43 vdout0_43ck73 = 0 time = 370
* CHECK dout0_44 vdout0_44ck73 = 0 time = 370
* CHECK dout0_45 vdout0_45ck73 = 0 time = 370
* CHECK dout0_46 vdout0_46ck73 = 1.0 time = 370
* CHECK dout0_47 vdout0_47ck73 = 1.0 time = 370
* CHECK dout0_48 vdout0_48ck73 = 0 time = 370
* CHECK dout0_49 vdout0_49ck73 = 1.0 time = 370
* CHECK dout0_50 vdout0_50ck73 = 0 time = 370
* CHECK dout0_51 vdout0_51ck73 = 1.0 time = 370
* CHECK dout0_52 vdout0_52ck73 = 0 time = 370
* CHECK dout0_53 vdout0_53ck73 = 0 time = 370
* CHECK dout0_54 vdout0_54ck73 = 1.0 time = 370
* CHECK dout0_55 vdout0_55ck73 = 1.0 time = 370
* CHECK dout0_56 vdout0_56ck73 = 0 time = 370
* CHECK dout0_57 vdout0_57ck73 = 1.0 time = 370
* CHECK dout0_58 vdout0_58ck73 = 1.0 time = 370
* CHECK dout0_59 vdout0_59ck73 = 1.0 time = 370
* CHECK dout0_60 vdout0_60ck73 = 1.0 time = 370
* CHECK dout0_61 vdout0_61ck73 = 0 time = 370
* CHECK dout0_62 vdout0_62ck73 = 1.0 time = 370
* CHECK dout0_63 vdout0_63ck73 = 1.0 time = 370
* CHECK dout0_0 vdout0_0ck74 = 1.0 time = 375
* CHECK dout0_1 vdout0_1ck74 = 0 time = 375
* CHECK dout0_2 vdout0_2ck74 = 1.0 time = 375
* CHECK dout0_3 vdout0_3ck74 = 1.0 time = 375
* CHECK dout0_4 vdout0_4ck74 = 0 time = 375
* CHECK dout0_5 vdout0_5ck74 = 1.0 time = 375
* CHECK dout0_6 vdout0_6ck74 = 0 time = 375
* CHECK dout0_7 vdout0_7ck74 = 0 time = 375
* CHECK dout0_8 vdout0_8ck74 = 1.0 time = 375
* CHECK dout0_9 vdout0_9ck74 = 0 time = 375
* CHECK dout0_10 vdout0_10ck74 = 0 time = 375
* CHECK dout0_11 vdout0_11ck74 = 1.0 time = 375
* CHECK dout0_12 vdout0_12ck74 = 0 time = 375
* CHECK dout0_13 vdout0_13ck74 = 0 time = 375
* CHECK dout0_14 vdout0_14ck74 = 0 time = 375
* CHECK dout0_15 vdout0_15ck74 = 1.0 time = 375
* CHECK dout0_16 vdout0_16ck74 = 0 time = 375
* CHECK dout0_17 vdout0_17ck74 = 1.0 time = 375
* CHECK dout0_18 vdout0_18ck74 = 0 time = 375
* CHECK dout0_19 vdout0_19ck74 = 0 time = 375
* CHECK dout0_20 vdout0_20ck74 = 1.0 time = 375
* CHECK dout0_21 vdout0_21ck74 = 0 time = 375
* CHECK dout0_22 vdout0_22ck74 = 1.0 time = 375
* CHECK dout0_23 vdout0_23ck74 = 0 time = 375
* CHECK dout0_24 vdout0_24ck74 = 1.0 time = 375
* CHECK dout0_25 vdout0_25ck74 = 1.0 time = 375
* CHECK dout0_26 vdout0_26ck74 = 0 time = 375
* CHECK dout0_27 vdout0_27ck74 = 0 time = 375
* CHECK dout0_28 vdout0_28ck74 = 1.0 time = 375
* CHECK dout0_29 vdout0_29ck74 = 1.0 time = 375
* CHECK dout0_30 vdout0_30ck74 = 0 time = 375
* CHECK dout0_31 vdout0_31ck74 = 1.0 time = 375
* CHECK dout0_32 vdout0_32ck74 = 1.0 time = 375
* CHECK dout0_33 vdout0_33ck74 = 1.0 time = 375
* CHECK dout0_34 vdout0_34ck74 = 1.0 time = 375
* CHECK dout0_35 vdout0_35ck74 = 0 time = 375
* CHECK dout0_36 vdout0_36ck74 = 0 time = 375
* CHECK dout0_37 vdout0_37ck74 = 1.0 time = 375
* CHECK dout0_38 vdout0_38ck74 = 0 time = 375
* CHECK dout0_39 vdout0_39ck74 = 0 time = 375
* CHECK dout0_40 vdout0_40ck74 = 0 time = 375
* CHECK dout0_41 vdout0_41ck74 = 1.0 time = 375
* CHECK dout0_42 vdout0_42ck74 = 1.0 time = 375
* CHECK dout0_43 vdout0_43ck74 = 0 time = 375
* CHECK dout0_44 vdout0_44ck74 = 0 time = 375
* CHECK dout0_45 vdout0_45ck74 = 0 time = 375
* CHECK dout0_46 vdout0_46ck74 = 1.0 time = 375
* CHECK dout0_47 vdout0_47ck74 = 1.0 time = 375
* CHECK dout0_48 vdout0_48ck74 = 0 time = 375
* CHECK dout0_49 vdout0_49ck74 = 1.0 time = 375
* CHECK dout0_50 vdout0_50ck74 = 0 time = 375
* CHECK dout0_51 vdout0_51ck74 = 1.0 time = 375
* CHECK dout0_52 vdout0_52ck74 = 0 time = 375
* CHECK dout0_53 vdout0_53ck74 = 0 time = 375
* CHECK dout0_54 vdout0_54ck74 = 1.0 time = 375
* CHECK dout0_55 vdout0_55ck74 = 1.0 time = 375
* CHECK dout0_56 vdout0_56ck74 = 0 time = 375
* CHECK dout0_57 vdout0_57ck74 = 1.0 time = 375
* CHECK dout0_58 vdout0_58ck74 = 1.0 time = 375
* CHECK dout0_59 vdout0_59ck74 = 1.0 time = 375
* CHECK dout0_60 vdout0_60ck74 = 1.0 time = 375
* CHECK dout0_61 vdout0_61ck74 = 0 time = 375
* CHECK dout0_62 vdout0_62ck74 = 1.0 time = 375
* CHECK dout0_63 vdout0_63ck74 = 1.0 time = 375
* CHECK dout1_0 vdout1_0ck75 = 0 time = 380
* CHECK dout1_1 vdout1_1ck75 = 1.0 time = 380
* CHECK dout1_2 vdout1_2ck75 = 1.0 time = 380
* CHECK dout1_3 vdout1_3ck75 = 0 time = 380
* CHECK dout1_4 vdout1_4ck75 = 0 time = 380
* CHECK dout1_5 vdout1_5ck75 = 1.0 time = 380
* CHECK dout1_6 vdout1_6ck75 = 1.0 time = 380
* CHECK dout1_7 vdout1_7ck75 = 1.0 time = 380
* CHECK dout1_8 vdout1_8ck75 = 0 time = 380
* CHECK dout1_9 vdout1_9ck75 = 1.0 time = 380
* CHECK dout1_10 vdout1_10ck75 = 1.0 time = 380
* CHECK dout1_11 vdout1_11ck75 = 1.0 time = 380
* CHECK dout1_12 vdout1_12ck75 = 0 time = 380
* CHECK dout1_13 vdout1_13ck75 = 1.0 time = 380
* CHECK dout1_14 vdout1_14ck75 = 1.0 time = 380
* CHECK dout1_15 vdout1_15ck75 = 0 time = 380
* CHECK dout1_16 vdout1_16ck75 = 0 time = 380
* CHECK dout1_17 vdout1_17ck75 = 0 time = 380
* CHECK dout1_18 vdout1_18ck75 = 1.0 time = 380
* CHECK dout1_19 vdout1_19ck75 = 1.0 time = 380
* CHECK dout1_20 vdout1_20ck75 = 1.0 time = 380
* CHECK dout1_21 vdout1_21ck75 = 1.0 time = 380
* CHECK dout1_22 vdout1_22ck75 = 0 time = 380
* CHECK dout1_23 vdout1_23ck75 = 1.0 time = 380
* CHECK dout1_24 vdout1_24ck75 = 0 time = 380
* CHECK dout1_25 vdout1_25ck75 = 0 time = 380
* CHECK dout1_26 vdout1_26ck75 = 1.0 time = 380
* CHECK dout1_27 vdout1_27ck75 = 0 time = 380
* CHECK dout1_28 vdout1_28ck75 = 1.0 time = 380
* CHECK dout1_29 vdout1_29ck75 = 1.0 time = 380
* CHECK dout1_30 vdout1_30ck75 = 1.0 time = 380
* CHECK dout1_31 vdout1_31ck75 = 1.0 time = 380
* CHECK dout1_32 vdout1_32ck75 = 1.0 time = 380
* CHECK dout1_33 vdout1_33ck75 = 1.0 time = 380
* CHECK dout1_34 vdout1_34ck75 = 1.0 time = 380
* CHECK dout1_35 vdout1_35ck75 = 1.0 time = 380
* CHECK dout1_36 vdout1_36ck75 = 0 time = 380
* CHECK dout1_37 vdout1_37ck75 = 1.0 time = 380
* CHECK dout1_38 vdout1_38ck75 = 0 time = 380
* CHECK dout1_39 vdout1_39ck75 = 0 time = 380
* CHECK dout1_40 vdout1_40ck75 = 1.0 time = 380
* CHECK dout1_41 vdout1_41ck75 = 1.0 time = 380
* CHECK dout1_42 vdout1_42ck75 = 1.0 time = 380
* CHECK dout1_43 vdout1_43ck75 = 0 time = 380
* CHECK dout1_44 vdout1_44ck75 = 0 time = 380
* CHECK dout1_45 vdout1_45ck75 = 1.0 time = 380
* CHECK dout1_46 vdout1_46ck75 = 1.0 time = 380
* CHECK dout1_47 vdout1_47ck75 = 1.0 time = 380
* CHECK dout1_48 vdout1_48ck75 = 1.0 time = 380
* CHECK dout1_49 vdout1_49ck75 = 0 time = 380
* CHECK dout1_50 vdout1_50ck75 = 1.0 time = 380
* CHECK dout1_51 vdout1_51ck75 = 0 time = 380
* CHECK dout1_52 vdout1_52ck75 = 1.0 time = 380
* CHECK dout1_53 vdout1_53ck75 = 1.0 time = 380
* CHECK dout1_54 vdout1_54ck75 = 1.0 time = 380
* CHECK dout1_55 vdout1_55ck75 = 1.0 time = 380
* CHECK dout1_56 vdout1_56ck75 = 0 time = 380
* CHECK dout1_57 vdout1_57ck75 = 1.0 time = 380
* CHECK dout1_58 vdout1_58ck75 = 0 time = 380
* CHECK dout1_59 vdout1_59ck75 = 0 time = 380
* CHECK dout1_60 vdout1_60ck75 = 1.0 time = 380
* CHECK dout1_61 vdout1_61ck75 = 1.0 time = 380
* CHECK dout1_62 vdout1_62ck75 = 1.0 time = 380
* CHECK dout1_63 vdout1_63ck75 = 0 time = 380
* CHECK dout0_0 vdout0_0ck76 = 0 time = 385
* CHECK dout0_1 vdout0_1ck76 = 0 time = 385
* CHECK dout0_2 vdout0_2ck76 = 0 time = 385
* CHECK dout0_3 vdout0_3ck76 = 1.0 time = 385
* CHECK dout0_4 vdout0_4ck76 = 1.0 time = 385
* CHECK dout0_5 vdout0_5ck76 = 1.0 time = 385
* CHECK dout0_6 vdout0_6ck76 = 1.0 time = 385
* CHECK dout0_7 vdout0_7ck76 = 1.0 time = 385
* CHECK dout0_8 vdout0_8ck76 = 1.0 time = 385
* CHECK dout0_9 vdout0_9ck76 = 1.0 time = 385
* CHECK dout0_10 vdout0_10ck76 = 1.0 time = 385
* CHECK dout0_11 vdout0_11ck76 = 0 time = 385
* CHECK dout0_12 vdout0_12ck76 = 1.0 time = 385
* CHECK dout0_13 vdout0_13ck76 = 0 time = 385
* CHECK dout0_14 vdout0_14ck76 = 1.0 time = 385
* CHECK dout0_15 vdout0_15ck76 = 1.0 time = 385
* CHECK dout0_16 vdout0_16ck76 = 1.0 time = 385
* CHECK dout0_17 vdout0_17ck76 = 1.0 time = 385
* CHECK dout0_18 vdout0_18ck76 = 1.0 time = 385
* CHECK dout0_19 vdout0_19ck76 = 1.0 time = 385
* CHECK dout0_20 vdout0_20ck76 = 1.0 time = 385
* CHECK dout0_21 vdout0_21ck76 = 1.0 time = 385
* CHECK dout0_22 vdout0_22ck76 = 1.0 time = 385
* CHECK dout0_23 vdout0_23ck76 = 1.0 time = 385
* CHECK dout0_24 vdout0_24ck76 = 1.0 time = 385
* CHECK dout0_25 vdout0_25ck76 = 0 time = 385
* CHECK dout0_26 vdout0_26ck76 = 0 time = 385
* CHECK dout0_27 vdout0_27ck76 = 0 time = 385
* CHECK dout0_28 vdout0_28ck76 = 1.0 time = 385
* CHECK dout0_29 vdout0_29ck76 = 0 time = 385
* CHECK dout0_30 vdout0_30ck76 = 0 time = 385
* CHECK dout0_31 vdout0_31ck76 = 0 time = 385
* CHECK dout0_32 vdout0_32ck76 = 0 time = 385
* CHECK dout0_33 vdout0_33ck76 = 1.0 time = 385
* CHECK dout0_34 vdout0_34ck76 = 1.0 time = 385
* CHECK dout0_35 vdout0_35ck76 = 0 time = 385
* CHECK dout0_36 vdout0_36ck76 = 0 time = 385
* CHECK dout0_37 vdout0_37ck76 = 0 time = 385
* CHECK dout0_38 vdout0_38ck76 = 0 time = 385
* CHECK dout0_39 vdout0_39ck76 = 1.0 time = 385
* CHECK dout0_40 vdout0_40ck76 = 0 time = 385
* CHECK dout0_41 vdout0_41ck76 = 1.0 time = 385
* CHECK dout0_42 vdout0_42ck76 = 0 time = 385
* CHECK dout0_43 vdout0_43ck76 = 0 time = 385
* CHECK dout0_44 vdout0_44ck76 = 0 time = 385
* CHECK dout0_45 vdout0_45ck76 = 0 time = 385
* CHECK dout0_46 vdout0_46ck76 = 1.0 time = 385
* CHECK dout0_47 vdout0_47ck76 = 1.0 time = 385
* CHECK dout0_48 vdout0_48ck76 = 0 time = 385
* CHECK dout0_49 vdout0_49ck76 = 0 time = 385
* CHECK dout0_50 vdout0_50ck76 = 1.0 time = 385
* CHECK dout0_51 vdout0_51ck76 = 1.0 time = 385
* CHECK dout0_52 vdout0_52ck76 = 0 time = 385
* CHECK dout0_53 vdout0_53ck76 = 1.0 time = 385
* CHECK dout0_54 vdout0_54ck76 = 0 time = 385
* CHECK dout0_55 vdout0_55ck76 = 1.0 time = 385
* CHECK dout0_56 vdout0_56ck76 = 0 time = 385
* CHECK dout0_57 vdout0_57ck76 = 1.0 time = 385
* CHECK dout0_58 vdout0_58ck76 = 0 time = 385
* CHECK dout0_59 vdout0_59ck76 = 0 time = 385
* CHECK dout0_60 vdout0_60ck76 = 1.0 time = 385
* CHECK dout0_61 vdout0_61ck76 = 0 time = 385
* CHECK dout0_62 vdout0_62ck76 = 1.0 time = 385
* CHECK dout0_63 vdout0_63ck76 = 0 time = 385
* CHECK dout1_0 vdout1_0ck77 = 0 time = 390
* CHECK dout1_1 vdout1_1ck77 = 0 time = 390
* CHECK dout1_2 vdout1_2ck77 = 0 time = 390
* CHECK dout1_3 vdout1_3ck77 = 0 time = 390
* CHECK dout1_4 vdout1_4ck77 = 1.0 time = 390
* CHECK dout1_5 vdout1_5ck77 = 0 time = 390
* CHECK dout1_6 vdout1_6ck77 = 1.0 time = 390
* CHECK dout1_7 vdout1_7ck77 = 1.0 time = 390
* CHECK dout1_8 vdout1_8ck77 = 0 time = 390
* CHECK dout1_9 vdout1_9ck77 = 1.0 time = 390
* CHECK dout1_10 vdout1_10ck77 = 0 time = 390
* CHECK dout1_11 vdout1_11ck77 = 1.0 time = 390
* CHECK dout1_12 vdout1_12ck77 = 0 time = 390
* CHECK dout1_13 vdout1_13ck77 = 1.0 time = 390
* CHECK dout1_14 vdout1_14ck77 = 0 time = 390
* CHECK dout1_15 vdout1_15ck77 = 1.0 time = 390
* CHECK dout1_16 vdout1_16ck77 = 1.0 time = 390
* CHECK dout1_17 vdout1_17ck77 = 0 time = 390
* CHECK dout1_18 vdout1_18ck77 = 0 time = 390
* CHECK dout1_19 vdout1_19ck77 = 1.0 time = 390
* CHECK dout1_20 vdout1_20ck77 = 1.0 time = 390
* CHECK dout1_21 vdout1_21ck77 = 0 time = 390
* CHECK dout1_22 vdout1_22ck77 = 1.0 time = 390
* CHECK dout1_23 vdout1_23ck77 = 1.0 time = 390
* CHECK dout1_24 vdout1_24ck77 = 0 time = 390
* CHECK dout1_25 vdout1_25ck77 = 0 time = 390
* CHECK dout1_26 vdout1_26ck77 = 0 time = 390
* CHECK dout1_27 vdout1_27ck77 = 1.0 time = 390
* CHECK dout1_28 vdout1_28ck77 = 0 time = 390
* CHECK dout1_29 vdout1_29ck77 = 0 time = 390
* CHECK dout1_30 vdout1_30ck77 = 1.0 time = 390
* CHECK dout1_31 vdout1_31ck77 = 0 time = 390
* CHECK dout1_32 vdout1_32ck77 = 1.0 time = 390
* CHECK dout1_33 vdout1_33ck77 = 0 time = 390
* CHECK dout1_34 vdout1_34ck77 = 1.0 time = 390
* CHECK dout1_35 vdout1_35ck77 = 1.0 time = 390
* CHECK dout1_36 vdout1_36ck77 = 1.0 time = 390
* CHECK dout1_37 vdout1_37ck77 = 1.0 time = 390
* CHECK dout1_38 vdout1_38ck77 = 0 time = 390
* CHECK dout1_39 vdout1_39ck77 = 0 time = 390
* CHECK dout1_40 vdout1_40ck77 = 0 time = 390
* CHECK dout1_41 vdout1_41ck77 = 0 time = 390
* CHECK dout1_42 vdout1_42ck77 = 0 time = 390
* CHECK dout1_43 vdout1_43ck77 = 1.0 time = 390
* CHECK dout1_44 vdout1_44ck77 = 0 time = 390
* CHECK dout1_45 vdout1_45ck77 = 0 time = 390
* CHECK dout1_46 vdout1_46ck77 = 0 time = 390
* CHECK dout1_47 vdout1_47ck77 = 0 time = 390
* CHECK dout1_48 vdout1_48ck77 = 0 time = 390
* CHECK dout1_49 vdout1_49ck77 = 1.0 time = 390
* CHECK dout1_50 vdout1_50ck77 = 0 time = 390
* CHECK dout1_51 vdout1_51ck77 = 0 time = 390
* CHECK dout1_52 vdout1_52ck77 = 1.0 time = 390
* CHECK dout1_53 vdout1_53ck77 = 0 time = 390
* CHECK dout1_54 vdout1_54ck77 = 0 time = 390
* CHECK dout1_55 vdout1_55ck77 = 1.0 time = 390
* CHECK dout1_56 vdout1_56ck77 = 1.0 time = 390
* CHECK dout1_57 vdout1_57ck77 = 1.0 time = 390
* CHECK dout1_58 vdout1_58ck77 = 0 time = 390
* CHECK dout1_59 vdout1_59ck77 = 0 time = 390
* CHECK dout1_60 vdout1_60ck77 = 1.0 time = 390
* CHECK dout1_61 vdout1_61ck77 = 0 time = 390
* CHECK dout1_62 vdout1_62ck77 = 1.0 time = 390
* CHECK dout1_63 vdout1_63ck77 = 0 time = 390
* CHECK dout0_0 vdout0_0ck78 = 0 time = 395
* CHECK dout0_1 vdout0_1ck78 = 0 time = 395
* CHECK dout0_2 vdout0_2ck78 = 0 time = 395
* CHECK dout0_3 vdout0_3ck78 = 0 time = 395
* CHECK dout0_4 vdout0_4ck78 = 1.0 time = 395
* CHECK dout0_5 vdout0_5ck78 = 0 time = 395
* CHECK dout0_6 vdout0_6ck78 = 1.0 time = 395
* CHECK dout0_7 vdout0_7ck78 = 1.0 time = 395
* CHECK dout0_8 vdout0_8ck78 = 0 time = 395
* CHECK dout0_9 vdout0_9ck78 = 1.0 time = 395
* CHECK dout0_10 vdout0_10ck78 = 0 time = 395
* CHECK dout0_11 vdout0_11ck78 = 1.0 time = 395
* CHECK dout0_12 vdout0_12ck78 = 0 time = 395
* CHECK dout0_13 vdout0_13ck78 = 1.0 time = 395
* CHECK dout0_14 vdout0_14ck78 = 0 time = 395
* CHECK dout0_15 vdout0_15ck78 = 1.0 time = 395
* CHECK dout0_16 vdout0_16ck78 = 1.0 time = 395
* CHECK dout0_17 vdout0_17ck78 = 0 time = 395
* CHECK dout0_18 vdout0_18ck78 = 0 time = 395
* CHECK dout0_19 vdout0_19ck78 = 1.0 time = 395
* CHECK dout0_20 vdout0_20ck78 = 1.0 time = 395
* CHECK dout0_21 vdout0_21ck78 = 0 time = 395
* CHECK dout0_22 vdout0_22ck78 = 1.0 time = 395
* CHECK dout0_23 vdout0_23ck78 = 1.0 time = 395
* CHECK dout0_24 vdout0_24ck78 = 0 time = 395
* CHECK dout0_25 vdout0_25ck78 = 0 time = 395
* CHECK dout0_26 vdout0_26ck78 = 0 time = 395
* CHECK dout0_27 vdout0_27ck78 = 1.0 time = 395
* CHECK dout0_28 vdout0_28ck78 = 0 time = 395
* CHECK dout0_29 vdout0_29ck78 = 0 time = 395
* CHECK dout0_30 vdout0_30ck78 = 1.0 time = 395
* CHECK dout0_31 vdout0_31ck78 = 0 time = 395
* CHECK dout0_32 vdout0_32ck78 = 1.0 time = 395
* CHECK dout0_33 vdout0_33ck78 = 0 time = 395
* CHECK dout0_34 vdout0_34ck78 = 1.0 time = 395
* CHECK dout0_35 vdout0_35ck78 = 1.0 time = 395
* CHECK dout0_36 vdout0_36ck78 = 1.0 time = 395
* CHECK dout0_37 vdout0_37ck78 = 1.0 time = 395
* CHECK dout0_38 vdout0_38ck78 = 0 time = 395
* CHECK dout0_39 vdout0_39ck78 = 0 time = 395
* CHECK dout0_40 vdout0_40ck78 = 0 time = 395
* CHECK dout0_41 vdout0_41ck78 = 0 time = 395
* CHECK dout0_42 vdout0_42ck78 = 0 time = 395
* CHECK dout0_43 vdout0_43ck78 = 1.0 time = 395
* CHECK dout0_44 vdout0_44ck78 = 0 time = 395
* CHECK dout0_45 vdout0_45ck78 = 0 time = 395
* CHECK dout0_46 vdout0_46ck78 = 0 time = 395
* CHECK dout0_47 vdout0_47ck78 = 0 time = 395
* CHECK dout0_48 vdout0_48ck78 = 0 time = 395
* CHECK dout0_49 vdout0_49ck78 = 1.0 time = 395
* CHECK dout0_50 vdout0_50ck78 = 0 time = 395
* CHECK dout0_51 vdout0_51ck78 = 0 time = 395
* CHECK dout0_52 vdout0_52ck78 = 1.0 time = 395
* CHECK dout0_53 vdout0_53ck78 = 0 time = 395
* CHECK dout0_54 vdout0_54ck78 = 0 time = 395
* CHECK dout0_55 vdout0_55ck78 = 1.0 time = 395
* CHECK dout0_56 vdout0_56ck78 = 1.0 time = 395
* CHECK dout0_57 vdout0_57ck78 = 1.0 time = 395
* CHECK dout0_58 vdout0_58ck78 = 0 time = 395
* CHECK dout0_59 vdout0_59ck78 = 0 time = 395
* CHECK dout0_60 vdout0_60ck78 = 1.0 time = 395
* CHECK dout0_61 vdout0_61ck78 = 0 time = 395
* CHECK dout0_62 vdout0_62ck78 = 1.0 time = 395
* CHECK dout0_63 vdout0_63ck78 = 0 time = 395
* CHECK dout0_0 vdout0_0ck79 = 0 time = 400
* CHECK dout0_1 vdout0_1ck79 = 1.0 time = 400
* CHECK dout0_2 vdout0_2ck79 = 1.0 time = 400
* CHECK dout0_3 vdout0_3ck79 = 1.0 time = 400
* CHECK dout0_4 vdout0_4ck79 = 0 time = 400
* CHECK dout0_5 vdout0_5ck79 = 1.0 time = 400
* CHECK dout0_6 vdout0_6ck79 = 1.0 time = 400
* CHECK dout0_7 vdout0_7ck79 = 1.0 time = 400
* CHECK dout0_8 vdout0_8ck79 = 0 time = 400
* CHECK dout0_9 vdout0_9ck79 = 0 time = 400
* CHECK dout0_10 vdout0_10ck79 = 0 time = 400
* CHECK dout0_11 vdout0_11ck79 = 0 time = 400
* CHECK dout0_12 vdout0_12ck79 = 0 time = 400
* CHECK dout0_13 vdout0_13ck79 = 0 time = 400
* CHECK dout0_14 vdout0_14ck79 = 0 time = 400
* CHECK dout0_15 vdout0_15ck79 = 1.0 time = 400
* CHECK dout0_16 vdout0_16ck79 = 0 time = 400
* CHECK dout0_17 vdout0_17ck79 = 1.0 time = 400
* CHECK dout0_18 vdout0_18ck79 = 0 time = 400
* CHECK dout0_19 vdout0_19ck79 = 0 time = 400
* CHECK dout0_20 vdout0_20ck79 = 0 time = 400
* CHECK dout0_21 vdout0_21ck79 = 0 time = 400
* CHECK dout0_22 vdout0_22ck79 = 0 time = 400
* CHECK dout0_23 vdout0_23ck79 = 0 time = 400
* CHECK dout0_24 vdout0_24ck79 = 0 time = 400
* CHECK dout0_25 vdout0_25ck79 = 1.0 time = 400
* CHECK dout0_26 vdout0_26ck79 = 1.0 time = 400
* CHECK dout0_27 vdout0_27ck79 = 0 time = 400
* CHECK dout0_28 vdout0_28ck79 = 1.0 time = 400
* CHECK dout0_29 vdout0_29ck79 = 1.0 time = 400
* CHECK dout0_30 vdout0_30ck79 = 0 time = 400
* CHECK dout0_31 vdout0_31ck79 = 1.0 time = 400
* CHECK dout0_32 vdout0_32ck79 = 1.0 time = 400
* CHECK dout0_33 vdout0_33ck79 = 1.0 time = 400
* CHECK dout0_34 vdout0_34ck79 = 0 time = 400
* CHECK dout0_35 vdout0_35ck79 = 1.0 time = 400
* CHECK dout0_36 vdout0_36ck79 = 1.0 time = 400
* CHECK dout0_37 vdout0_37ck79 = 1.0 time = 400
* CHECK dout0_38 vdout0_38ck79 = 1.0 time = 400
* CHECK dout0_39 vdout0_39ck79 = 0 time = 400
* CHECK dout0_40 vdout0_40ck79 = 1.0 time = 400
* CHECK dout0_41 vdout0_41ck79 = 0 time = 400
* CHECK dout0_42 vdout0_42ck79 = 0 time = 400
* CHECK dout0_43 vdout0_43ck79 = 0 time = 400
* CHECK dout0_44 vdout0_44ck79 = 0 time = 400
* CHECK dout0_45 vdout0_45ck79 = 0 time = 400
* CHECK dout0_46 vdout0_46ck79 = 0 time = 400
* CHECK dout0_47 vdout0_47ck79 = 1.0 time = 400
* CHECK dout0_48 vdout0_48ck79 = 0 time = 400
* CHECK dout0_49 vdout0_49ck79 = 0 time = 400
* CHECK dout0_50 vdout0_50ck79 = 1.0 time = 400
* CHECK dout0_51 vdout0_51ck79 = 1.0 time = 400
* CHECK dout0_52 vdout0_52ck79 = 0 time = 400
* CHECK dout0_53 vdout0_53ck79 = 0 time = 400
* CHECK dout0_54 vdout0_54ck79 = 0 time = 400
* CHECK dout0_55 vdout0_55ck79 = 0 time = 400
* CHECK dout0_56 vdout0_56ck79 = 0 time = 400
* CHECK dout0_57 vdout0_57ck79 = 0 time = 400
* CHECK dout0_58 vdout0_58ck79 = 0 time = 400
* CHECK dout0_59 vdout0_59ck79 = 1.0 time = 400
* CHECK dout0_60 vdout0_60ck79 = 0 time = 400
* CHECK dout0_61 vdout0_61ck79 = 1.0 time = 400
* CHECK dout0_62 vdout0_62ck79 = 0 time = 400
* CHECK dout0_63 vdout0_63ck79 = 0 time = 400
* CHECK dout0_0 vdout0_0ck81 = 0 time = 410
* CHECK dout0_1 vdout0_1ck81 = 1.0 time = 410
* CHECK dout0_2 vdout0_2ck81 = 1.0 time = 410
* CHECK dout0_3 vdout0_3ck81 = 0 time = 410
* CHECK dout0_4 vdout0_4ck81 = 0 time = 410
* CHECK dout0_5 vdout0_5ck81 = 1.0 time = 410
* CHECK dout0_6 vdout0_6ck81 = 1.0 time = 410
* CHECK dout0_7 vdout0_7ck81 = 1.0 time = 410
* CHECK dout0_8 vdout0_8ck81 = 0 time = 410
* CHECK dout0_9 vdout0_9ck81 = 1.0 time = 410
* CHECK dout0_10 vdout0_10ck81 = 1.0 time = 410
* CHECK dout0_11 vdout0_11ck81 = 1.0 time = 410
* CHECK dout0_12 vdout0_12ck81 = 0 time = 410
* CHECK dout0_13 vdout0_13ck81 = 1.0 time = 410
* CHECK dout0_14 vdout0_14ck81 = 1.0 time = 410
* CHECK dout0_15 vdout0_15ck81 = 0 time = 410
* CHECK dout0_16 vdout0_16ck81 = 0 time = 410
* CHECK dout0_17 vdout0_17ck81 = 0 time = 410
* CHECK dout0_18 vdout0_18ck81 = 1.0 time = 410
* CHECK dout0_19 vdout0_19ck81 = 1.0 time = 410
* CHECK dout0_20 vdout0_20ck81 = 1.0 time = 410
* CHECK dout0_21 vdout0_21ck81 = 1.0 time = 410
* CHECK dout0_22 vdout0_22ck81 = 0 time = 410
* CHECK dout0_23 vdout0_23ck81 = 1.0 time = 410
* CHECK dout0_24 vdout0_24ck81 = 0 time = 410
* CHECK dout0_25 vdout0_25ck81 = 0 time = 410
* CHECK dout0_26 vdout0_26ck81 = 1.0 time = 410
* CHECK dout0_27 vdout0_27ck81 = 0 time = 410
* CHECK dout0_28 vdout0_28ck81 = 1.0 time = 410
* CHECK dout0_29 vdout0_29ck81 = 1.0 time = 410
* CHECK dout0_30 vdout0_30ck81 = 1.0 time = 410
* CHECK dout0_31 vdout0_31ck81 = 1.0 time = 410
* CHECK dout0_32 vdout0_32ck81 = 1.0 time = 410
* CHECK dout0_33 vdout0_33ck81 = 1.0 time = 410
* CHECK dout0_34 vdout0_34ck81 = 1.0 time = 410
* CHECK dout0_35 vdout0_35ck81 = 1.0 time = 410
* CHECK dout0_36 vdout0_36ck81 = 0 time = 410
* CHECK dout0_37 vdout0_37ck81 = 1.0 time = 410
* CHECK dout0_38 vdout0_38ck81 = 0 time = 410
* CHECK dout0_39 vdout0_39ck81 = 0 time = 410
* CHECK dout0_40 vdout0_40ck81 = 1.0 time = 410
* CHECK dout0_41 vdout0_41ck81 = 1.0 time = 410
* CHECK dout0_42 vdout0_42ck81 = 1.0 time = 410
* CHECK dout0_43 vdout0_43ck81 = 0 time = 410
* CHECK dout0_44 vdout0_44ck81 = 0 time = 410
* CHECK dout0_45 vdout0_45ck81 = 1.0 time = 410
* CHECK dout0_46 vdout0_46ck81 = 1.0 time = 410
* CHECK dout0_47 vdout0_47ck81 = 1.0 time = 410
* CHECK dout0_48 vdout0_48ck81 = 1.0 time = 410
* CHECK dout0_49 vdout0_49ck81 = 0 time = 410
* CHECK dout0_50 vdout0_50ck81 = 1.0 time = 410
* CHECK dout0_51 vdout0_51ck81 = 0 time = 410
* CHECK dout0_52 vdout0_52ck81 = 1.0 time = 410
* CHECK dout0_53 vdout0_53ck81 = 1.0 time = 410
* CHECK dout0_54 vdout0_54ck81 = 1.0 time = 410
* CHECK dout0_55 vdout0_55ck81 = 1.0 time = 410
* CHECK dout0_56 vdout0_56ck81 = 0 time = 410
* CHECK dout0_57 vdout0_57ck81 = 1.0 time = 410
* CHECK dout0_58 vdout0_58ck81 = 0 time = 410
* CHECK dout0_59 vdout0_59ck81 = 0 time = 410
* CHECK dout0_60 vdout0_60ck81 = 1.0 time = 410
* CHECK dout0_61 vdout0_61ck81 = 1.0 time = 410
* CHECK dout0_62 vdout0_62ck81 = 1.0 time = 410
* CHECK dout0_63 vdout0_63ck81 = 0 time = 410
* CHECK dout1_0 vdout1_0ck81 = 0 time = 410
* CHECK dout1_1 vdout1_1ck81 = 1.0 time = 410
* CHECK dout1_2 vdout1_2ck81 = 1.0 time = 410
* CHECK dout1_3 vdout1_3ck81 = 0 time = 410
* CHECK dout1_4 vdout1_4ck81 = 0 time = 410
* CHECK dout1_5 vdout1_5ck81 = 1.0 time = 410
* CHECK dout1_6 vdout1_6ck81 = 1.0 time = 410
* CHECK dout1_7 vdout1_7ck81 = 1.0 time = 410
* CHECK dout1_8 vdout1_8ck81 = 0 time = 410
* CHECK dout1_9 vdout1_9ck81 = 1.0 time = 410
* CHECK dout1_10 vdout1_10ck81 = 1.0 time = 410
* CHECK dout1_11 vdout1_11ck81 = 1.0 time = 410
* CHECK dout1_12 vdout1_12ck81 = 0 time = 410
* CHECK dout1_13 vdout1_13ck81 = 1.0 time = 410
* CHECK dout1_14 vdout1_14ck81 = 1.0 time = 410
* CHECK dout1_15 vdout1_15ck81 = 0 time = 410
* CHECK dout1_16 vdout1_16ck81 = 0 time = 410
* CHECK dout1_17 vdout1_17ck81 = 0 time = 410
* CHECK dout1_18 vdout1_18ck81 = 1.0 time = 410
* CHECK dout1_19 vdout1_19ck81 = 1.0 time = 410
* CHECK dout1_20 vdout1_20ck81 = 1.0 time = 410
* CHECK dout1_21 vdout1_21ck81 = 1.0 time = 410
* CHECK dout1_22 vdout1_22ck81 = 0 time = 410
* CHECK dout1_23 vdout1_23ck81 = 1.0 time = 410
* CHECK dout1_24 vdout1_24ck81 = 0 time = 410
* CHECK dout1_25 vdout1_25ck81 = 0 time = 410
* CHECK dout1_26 vdout1_26ck81 = 1.0 time = 410
* CHECK dout1_27 vdout1_27ck81 = 0 time = 410
* CHECK dout1_28 vdout1_28ck81 = 1.0 time = 410
* CHECK dout1_29 vdout1_29ck81 = 1.0 time = 410
* CHECK dout1_30 vdout1_30ck81 = 1.0 time = 410
* CHECK dout1_31 vdout1_31ck81 = 1.0 time = 410
* CHECK dout1_32 vdout1_32ck81 = 1.0 time = 410
* CHECK dout1_33 vdout1_33ck81 = 1.0 time = 410
* CHECK dout1_34 vdout1_34ck81 = 1.0 time = 410
* CHECK dout1_35 vdout1_35ck81 = 1.0 time = 410
* CHECK dout1_36 vdout1_36ck81 = 0 time = 410
* CHECK dout1_37 vdout1_37ck81 = 1.0 time = 410
* CHECK dout1_38 vdout1_38ck81 = 0 time = 410
* CHECK dout1_39 vdout1_39ck81 = 0 time = 410
* CHECK dout1_40 vdout1_40ck81 = 1.0 time = 410
* CHECK dout1_41 vdout1_41ck81 = 1.0 time = 410
* CHECK dout1_42 vdout1_42ck81 = 1.0 time = 410
* CHECK dout1_43 vdout1_43ck81 = 0 time = 410
* CHECK dout1_44 vdout1_44ck81 = 0 time = 410
* CHECK dout1_45 vdout1_45ck81 = 1.0 time = 410
* CHECK dout1_46 vdout1_46ck81 = 1.0 time = 410
* CHECK dout1_47 vdout1_47ck81 = 1.0 time = 410
* CHECK dout1_48 vdout1_48ck81 = 1.0 time = 410
* CHECK dout1_49 vdout1_49ck81 = 0 time = 410
* CHECK dout1_50 vdout1_50ck81 = 1.0 time = 410
* CHECK dout1_51 vdout1_51ck81 = 0 time = 410
* CHECK dout1_52 vdout1_52ck81 = 1.0 time = 410
* CHECK dout1_53 vdout1_53ck81 = 1.0 time = 410
* CHECK dout1_54 vdout1_54ck81 = 1.0 time = 410
* CHECK dout1_55 vdout1_55ck81 = 1.0 time = 410
* CHECK dout1_56 vdout1_56ck81 = 0 time = 410
* CHECK dout1_57 vdout1_57ck81 = 1.0 time = 410
* CHECK dout1_58 vdout1_58ck81 = 0 time = 410
* CHECK dout1_59 vdout1_59ck81 = 0 time = 410
* CHECK dout1_60 vdout1_60ck81 = 1.0 time = 410
* CHECK dout1_61 vdout1_61ck81 = 1.0 time = 410
* CHECK dout1_62 vdout1_62ck81 = 1.0 time = 410
* CHECK dout1_63 vdout1_63ck81 = 0 time = 410
* CHECK dout1_0 vdout1_0ck82 = 0 time = 415
* CHECK dout1_1 vdout1_1ck82 = 1.0 time = 415
* CHECK dout1_2 vdout1_2ck82 = 0 time = 415
* CHECK dout1_3 vdout1_3ck82 = 0 time = 415
* CHECK dout1_4 vdout1_4ck82 = 0 time = 415
* CHECK dout1_5 vdout1_5ck82 = 1.0 time = 415
* CHECK dout1_6 vdout1_6ck82 = 0 time = 415
* CHECK dout1_7 vdout1_7ck82 = 0 time = 415
* CHECK dout1_8 vdout1_8ck82 = 0 time = 415
* CHECK dout1_9 vdout1_9ck82 = 0 time = 415
* CHECK dout1_10 vdout1_10ck82 = 1.0 time = 415
* CHECK dout1_11 vdout1_11ck82 = 1.0 time = 415
* CHECK dout1_12 vdout1_12ck82 = 1.0 time = 415
* CHECK dout1_13 vdout1_13ck82 = 0 time = 415
* CHECK dout1_14 vdout1_14ck82 = 1.0 time = 415
* CHECK dout1_15 vdout1_15ck82 = 0 time = 415
* CHECK dout1_16 vdout1_16ck82 = 1.0 time = 415
* CHECK dout1_17 vdout1_17ck82 = 0 time = 415
* CHECK dout1_18 vdout1_18ck82 = 0 time = 415
* CHECK dout1_19 vdout1_19ck82 = 1.0 time = 415
* CHECK dout1_20 vdout1_20ck82 = 0 time = 415
* CHECK dout1_21 vdout1_21ck82 = 0 time = 415
* CHECK dout1_22 vdout1_22ck82 = 0 time = 415
* CHECK dout1_23 vdout1_23ck82 = 1.0 time = 415
* CHECK dout1_24 vdout1_24ck82 = 0 time = 415
* CHECK dout1_25 vdout1_25ck82 = 0 time = 415
* CHECK dout1_26 vdout1_26ck82 = 1.0 time = 415
* CHECK dout1_27 vdout1_27ck82 = 0 time = 415
* CHECK dout1_28 vdout1_28ck82 = 0 time = 415
* CHECK dout1_29 vdout1_29ck82 = 1.0 time = 415
* CHECK dout1_30 vdout1_30ck82 = 1.0 time = 415
* CHECK dout1_31 vdout1_31ck82 = 0 time = 415
* CHECK dout1_32 vdout1_32ck82 = 0 time = 415
* CHECK dout1_33 vdout1_33ck82 = 1.0 time = 415
* CHECK dout1_34 vdout1_34ck82 = 0 time = 415
* CHECK dout1_35 vdout1_35ck82 = 0 time = 415
* CHECK dout1_36 vdout1_36ck82 = 0 time = 415
* CHECK dout1_37 vdout1_37ck82 = 1.0 time = 415
* CHECK dout1_38 vdout1_38ck82 = 1.0 time = 415
* CHECK dout1_39 vdout1_39ck82 = 1.0 time = 415
* CHECK dout1_40 vdout1_40ck82 = 1.0 time = 415
* CHECK dout1_41 vdout1_41ck82 = 0 time = 415
* CHECK dout1_42 vdout1_42ck82 = 1.0 time = 415
* CHECK dout1_43 vdout1_43ck82 = 1.0 time = 415
* CHECK dout1_44 vdout1_44ck82 = 1.0 time = 415
* CHECK dout1_45 vdout1_45ck82 = 1.0 time = 415
* CHECK dout1_46 vdout1_46ck82 = 0 time = 415
* CHECK dout1_47 vdout1_47ck82 = 0 time = 415
* CHECK dout1_48 vdout1_48ck82 = 0 time = 415
* CHECK dout1_49 vdout1_49ck82 = 1.0 time = 415
* CHECK dout1_50 vdout1_50ck82 = 1.0 time = 415
* CHECK dout1_51 vdout1_51ck82 = 0 time = 415
* CHECK dout1_52 vdout1_52ck82 = 1.0 time = 415
* CHECK dout1_53 vdout1_53ck82 = 0 time = 415
* CHECK dout1_54 vdout1_54ck82 = 0 time = 415
* CHECK dout1_55 vdout1_55ck82 = 1.0 time = 415
* CHECK dout1_56 vdout1_56ck82 = 0 time = 415
* CHECK dout1_57 vdout1_57ck82 = 0 time = 415
* CHECK dout1_58 vdout1_58ck82 = 1.0 time = 415
* CHECK dout1_59 vdout1_59ck82 = 1.0 time = 415
* CHECK dout1_60 vdout1_60ck82 = 1.0 time = 415
* CHECK dout1_61 vdout1_61ck82 = 1.0 time = 415
* CHECK dout1_62 vdout1_62ck82 = 0 time = 415
* CHECK dout1_63 vdout1_63ck82 = 1.0 time = 415
* CHECK dout0_0 vdout0_0ck83 = 1.0 time = 420
* CHECK dout0_1 vdout0_1ck83 = 0 time = 420
* CHECK dout0_2 vdout0_2ck83 = 0 time = 420
* CHECK dout0_3 vdout0_3ck83 = 0 time = 420
* CHECK dout0_4 vdout0_4ck83 = 0 time = 420
* CHECK dout0_5 vdout0_5ck83 = 1.0 time = 420
* CHECK dout0_6 vdout0_6ck83 = 0 time = 420
* CHECK dout0_7 vdout0_7ck83 = 0 time = 420
* CHECK dout0_8 vdout0_8ck83 = 0 time = 420
* CHECK dout0_9 vdout0_9ck83 = 0 time = 420
* CHECK dout0_10 vdout0_10ck83 = 1.0 time = 420
* CHECK dout0_11 vdout0_11ck83 = 0 time = 420
* CHECK dout0_12 vdout0_12ck83 = 1.0 time = 420
* CHECK dout0_13 vdout0_13ck83 = 0 time = 420
* CHECK dout0_14 vdout0_14ck83 = 1.0 time = 420
* CHECK dout0_15 vdout0_15ck83 = 0 time = 420
* CHECK dout0_16 vdout0_16ck83 = 0 time = 420
* CHECK dout0_17 vdout0_17ck83 = 0 time = 420
* CHECK dout0_18 vdout0_18ck83 = 1.0 time = 420
* CHECK dout0_19 vdout0_19ck83 = 1.0 time = 420
* CHECK dout0_20 vdout0_20ck83 = 0 time = 420
* CHECK dout0_21 vdout0_21ck83 = 1.0 time = 420
* CHECK dout0_22 vdout0_22ck83 = 0 time = 420
* CHECK dout0_23 vdout0_23ck83 = 1.0 time = 420
* CHECK dout0_24 vdout0_24ck83 = 0 time = 420
* CHECK dout0_25 vdout0_25ck83 = 0 time = 420
* CHECK dout0_26 vdout0_26ck83 = 1.0 time = 420
* CHECK dout0_27 vdout0_27ck83 = 1.0 time = 420
* CHECK dout0_28 vdout0_28ck83 = 0 time = 420
* CHECK dout0_29 vdout0_29ck83 = 1.0 time = 420
* CHECK dout0_30 vdout0_30ck83 = 1.0 time = 420
* CHECK dout0_31 vdout0_31ck83 = 0 time = 420
* CHECK dout0_32 vdout0_32ck83 = 0 time = 420
* CHECK dout0_33 vdout0_33ck83 = 1.0 time = 420
* CHECK dout0_34 vdout0_34ck83 = 0 time = 420
* CHECK dout0_35 vdout0_35ck83 = 0 time = 420
* CHECK dout0_36 vdout0_36ck83 = 0 time = 420
* CHECK dout0_37 vdout0_37ck83 = 0 time = 420
* CHECK dout0_38 vdout0_38ck83 = 0 time = 420
* CHECK dout0_39 vdout0_39ck83 = 0 time = 420
* CHECK dout0_40 vdout0_40ck83 = 1.0 time = 420
* CHECK dout0_41 vdout0_41ck83 = 1.0 time = 420
* CHECK dout0_42 vdout0_42ck83 = 1.0 time = 420
* CHECK dout0_43 vdout0_43ck83 = 1.0 time = 420
* CHECK dout0_44 vdout0_44ck83 = 0 time = 420
* CHECK dout0_45 vdout0_45ck83 = 1.0 time = 420
* CHECK dout0_46 vdout0_46ck83 = 0 time = 420
* CHECK dout0_47 vdout0_47ck83 = 0 time = 420
* CHECK dout0_48 vdout0_48ck83 = 1.0 time = 420
* CHECK dout0_49 vdout0_49ck83 = 0 time = 420
* CHECK dout0_50 vdout0_50ck83 = 0 time = 420
* CHECK dout0_51 vdout0_51ck83 = 0 time = 420
* CHECK dout0_52 vdout0_52ck83 = 0 time = 420
* CHECK dout0_53 vdout0_53ck83 = 0 time = 420
* CHECK dout0_54 vdout0_54ck83 = 1.0 time = 420
* CHECK dout0_55 vdout0_55ck83 = 0 time = 420
* CHECK dout0_56 vdout0_56ck83 = 1.0 time = 420
* CHECK dout0_57 vdout0_57ck83 = 0 time = 420
* CHECK dout0_58 vdout0_58ck83 = 1.0 time = 420
* CHECK dout0_59 vdout0_59ck83 = 1.0 time = 420
* CHECK dout0_60 vdout0_60ck83 = 1.0 time = 420
* CHECK dout0_61 vdout0_61ck83 = 1.0 time = 420
* CHECK dout0_62 vdout0_62ck83 = 0 time = 420
* CHECK dout0_63 vdout0_63ck83 = 0 time = 420
* CHECK dout1_0 vdout1_0ck83 = 1.0 time = 420
* CHECK dout1_1 vdout1_1ck83 = 0 time = 420
* CHECK dout1_2 vdout1_2ck83 = 1.0 time = 420
* CHECK dout1_3 vdout1_3ck83 = 1.0 time = 420
* CHECK dout1_4 vdout1_4ck83 = 0 time = 420
* CHECK dout1_5 vdout1_5ck83 = 1.0 time = 420
* CHECK dout1_6 vdout1_6ck83 = 0 time = 420
* CHECK dout1_7 vdout1_7ck83 = 0 time = 420
* CHECK dout1_8 vdout1_8ck83 = 1.0 time = 420
* CHECK dout1_9 vdout1_9ck83 = 0 time = 420
* CHECK dout1_10 vdout1_10ck83 = 0 time = 420
* CHECK dout1_11 vdout1_11ck83 = 1.0 time = 420
* CHECK dout1_12 vdout1_12ck83 = 0 time = 420
* CHECK dout1_13 vdout1_13ck83 = 0 time = 420
* CHECK dout1_14 vdout1_14ck83 = 0 time = 420
* CHECK dout1_15 vdout1_15ck83 = 1.0 time = 420
* CHECK dout1_16 vdout1_16ck83 = 0 time = 420
* CHECK dout1_17 vdout1_17ck83 = 1.0 time = 420
* CHECK dout1_18 vdout1_18ck83 = 0 time = 420
* CHECK dout1_19 vdout1_19ck83 = 0 time = 420
* CHECK dout1_20 vdout1_20ck83 = 1.0 time = 420
* CHECK dout1_21 vdout1_21ck83 = 0 time = 420
* CHECK dout1_22 vdout1_22ck83 = 1.0 time = 420
* CHECK dout1_23 vdout1_23ck83 = 0 time = 420
* CHECK dout1_24 vdout1_24ck83 = 1.0 time = 420
* CHECK dout1_25 vdout1_25ck83 = 1.0 time = 420
* CHECK dout1_26 vdout1_26ck83 = 0 time = 420
* CHECK dout1_27 vdout1_27ck83 = 0 time = 420
* CHECK dout1_28 vdout1_28ck83 = 1.0 time = 420
* CHECK dout1_29 vdout1_29ck83 = 1.0 time = 420
* CHECK dout1_30 vdout1_30ck83 = 0 time = 420
* CHECK dout1_31 vdout1_31ck83 = 1.0 time = 420
* CHECK dout1_32 vdout1_32ck83 = 1.0 time = 420
* CHECK dout1_33 vdout1_33ck83 = 1.0 time = 420
* CHECK dout1_34 vdout1_34ck83 = 1.0 time = 420
* CHECK dout1_35 vdout1_35ck83 = 0 time = 420
* CHECK dout1_36 vdout1_36ck83 = 0 time = 420
* CHECK dout1_37 vdout1_37ck83 = 1.0 time = 420
* CHECK dout1_38 vdout1_38ck83 = 0 time = 420
* CHECK dout1_39 vdout1_39ck83 = 0 time = 420
* CHECK dout1_40 vdout1_40ck83 = 0 time = 420
* CHECK dout1_41 vdout1_41ck83 = 1.0 time = 420
* CHECK dout1_42 vdout1_42ck83 = 1.0 time = 420
* CHECK dout1_43 vdout1_43ck83 = 0 time = 420
* CHECK dout1_44 vdout1_44ck83 = 0 time = 420
* CHECK dout1_45 vdout1_45ck83 = 0 time = 420
* CHECK dout1_46 vdout1_46ck83 = 1.0 time = 420
* CHECK dout1_47 vdout1_47ck83 = 1.0 time = 420
* CHECK dout1_48 vdout1_48ck83 = 0 time = 420
* CHECK dout1_49 vdout1_49ck83 = 1.0 time = 420
* CHECK dout1_50 vdout1_50ck83 = 0 time = 420
* CHECK dout1_51 vdout1_51ck83 = 1.0 time = 420
* CHECK dout1_52 vdout1_52ck83 = 0 time = 420
* CHECK dout1_53 vdout1_53ck83 = 0 time = 420
* CHECK dout1_54 vdout1_54ck83 = 1.0 time = 420
* CHECK dout1_55 vdout1_55ck83 = 1.0 time = 420
* CHECK dout1_56 vdout1_56ck83 = 0 time = 420
* CHECK dout1_57 vdout1_57ck83 = 1.0 time = 420
* CHECK dout1_58 vdout1_58ck83 = 1.0 time = 420
* CHECK dout1_59 vdout1_59ck83 = 1.0 time = 420
* CHECK dout1_60 vdout1_60ck83 = 1.0 time = 420
* CHECK dout1_61 vdout1_61ck83 = 0 time = 420
* CHECK dout1_62 vdout1_62ck83 = 1.0 time = 420
* CHECK dout1_63 vdout1_63ck83 = 1.0 time = 420
* CHECK dout0_0 vdout0_0ck84 = 1.0 time = 425
* CHECK dout0_1 vdout0_1ck84 = 0 time = 425
* CHECK dout0_2 vdout0_2ck84 = 1.0 time = 425
* CHECK dout0_3 vdout0_3ck84 = 1.0 time = 425
* CHECK dout0_4 vdout0_4ck84 = 0 time = 425
* CHECK dout0_5 vdout0_5ck84 = 1.0 time = 425
* CHECK dout0_6 vdout0_6ck84 = 0 time = 425
* CHECK dout0_7 vdout0_7ck84 = 0 time = 425
* CHECK dout0_8 vdout0_8ck84 = 1.0 time = 425
* CHECK dout0_9 vdout0_9ck84 = 0 time = 425
* CHECK dout0_10 vdout0_10ck84 = 0 time = 425
* CHECK dout0_11 vdout0_11ck84 = 1.0 time = 425
* CHECK dout0_12 vdout0_12ck84 = 0 time = 425
* CHECK dout0_13 vdout0_13ck84 = 0 time = 425
* CHECK dout0_14 vdout0_14ck84 = 0 time = 425
* CHECK dout0_15 vdout0_15ck84 = 1.0 time = 425
* CHECK dout0_16 vdout0_16ck84 = 0 time = 425
* CHECK dout0_17 vdout0_17ck84 = 1.0 time = 425
* CHECK dout0_18 vdout0_18ck84 = 0 time = 425
* CHECK dout0_19 vdout0_19ck84 = 0 time = 425
* CHECK dout0_20 vdout0_20ck84 = 1.0 time = 425
* CHECK dout0_21 vdout0_21ck84 = 0 time = 425
* CHECK dout0_22 vdout0_22ck84 = 1.0 time = 425
* CHECK dout0_23 vdout0_23ck84 = 0 time = 425
* CHECK dout0_24 vdout0_24ck84 = 1.0 time = 425
* CHECK dout0_25 vdout0_25ck84 = 1.0 time = 425
* CHECK dout0_26 vdout0_26ck84 = 0 time = 425
* CHECK dout0_27 vdout0_27ck84 = 0 time = 425
* CHECK dout0_28 vdout0_28ck84 = 1.0 time = 425
* CHECK dout0_29 vdout0_29ck84 = 1.0 time = 425
* CHECK dout0_30 vdout0_30ck84 = 0 time = 425
* CHECK dout0_31 vdout0_31ck84 = 1.0 time = 425
* CHECK dout0_32 vdout0_32ck84 = 1.0 time = 425
* CHECK dout0_33 vdout0_33ck84 = 1.0 time = 425
* CHECK dout0_34 vdout0_34ck84 = 1.0 time = 425
* CHECK dout0_35 vdout0_35ck84 = 0 time = 425
* CHECK dout0_36 vdout0_36ck84 = 0 time = 425
* CHECK dout0_37 vdout0_37ck84 = 1.0 time = 425
* CHECK dout0_38 vdout0_38ck84 = 0 time = 425
* CHECK dout0_39 vdout0_39ck84 = 0 time = 425
* CHECK dout0_40 vdout0_40ck84 = 0 time = 425
* CHECK dout0_41 vdout0_41ck84 = 1.0 time = 425
* CHECK dout0_42 vdout0_42ck84 = 1.0 time = 425
* CHECK dout0_43 vdout0_43ck84 = 0 time = 425
* CHECK dout0_44 vdout0_44ck84 = 0 time = 425
* CHECK dout0_45 vdout0_45ck84 = 0 time = 425
* CHECK dout0_46 vdout0_46ck84 = 1.0 time = 425
* CHECK dout0_47 vdout0_47ck84 = 1.0 time = 425
* CHECK dout0_48 vdout0_48ck84 = 0 time = 425
* CHECK dout0_49 vdout0_49ck84 = 1.0 time = 425
* CHECK dout0_50 vdout0_50ck84 = 0 time = 425
* CHECK dout0_51 vdout0_51ck84 = 1.0 time = 425
* CHECK dout0_52 vdout0_52ck84 = 0 time = 425
* CHECK dout0_53 vdout0_53ck84 = 0 time = 425
* CHECK dout0_54 vdout0_54ck84 = 1.0 time = 425
* CHECK dout0_55 vdout0_55ck84 = 1.0 time = 425
* CHECK dout0_56 vdout0_56ck84 = 0 time = 425
* CHECK dout0_57 vdout0_57ck84 = 1.0 time = 425
* CHECK dout0_58 vdout0_58ck84 = 1.0 time = 425
* CHECK dout0_59 vdout0_59ck84 = 1.0 time = 425
* CHECK dout0_60 vdout0_60ck84 = 1.0 time = 425
* CHECK dout0_61 vdout0_61ck84 = 0 time = 425
* CHECK dout0_62 vdout0_62ck84 = 1.0 time = 425
* CHECK dout0_63 vdout0_63ck84 = 1.0 time = 425
* CHECK dout0_0 vdout0_0ck86 = 1.0 time = 435
* CHECK dout0_1 vdout0_1ck86 = 1.0 time = 435
* CHECK dout0_2 vdout0_2ck86 = 1.0 time = 435
* CHECK dout0_3 vdout0_3ck86 = 0 time = 435
* CHECK dout0_4 vdout0_4ck86 = 0 time = 435
* CHECK dout0_5 vdout0_5ck86 = 0 time = 435
* CHECK dout0_6 vdout0_6ck86 = 1.0 time = 435
* CHECK dout0_7 vdout0_7ck86 = 0 time = 435
* CHECK dout0_8 vdout0_8ck86 = 1.0 time = 435
* CHECK dout0_9 vdout0_9ck86 = 0 time = 435
* CHECK dout0_10 vdout0_10ck86 = 1.0 time = 435
* CHECK dout0_11 vdout0_11ck86 = 1.0 time = 435
* CHECK dout0_12 vdout0_12ck86 = 0 time = 435
* CHECK dout0_13 vdout0_13ck86 = 0 time = 435
* CHECK dout0_14 vdout0_14ck86 = 0 time = 435
* CHECK dout0_15 vdout0_15ck86 = 0 time = 435
* CHECK dout0_16 vdout0_16ck86 = 1.0 time = 435
* CHECK dout0_17 vdout0_17ck86 = 1.0 time = 435
* CHECK dout0_18 vdout0_18ck86 = 1.0 time = 435
* CHECK dout0_19 vdout0_19ck86 = 1.0 time = 435
* CHECK dout0_20 vdout0_20ck86 = 1.0 time = 435
* CHECK dout0_21 vdout0_21ck86 = 1.0 time = 435
* CHECK dout0_22 vdout0_22ck86 = 0 time = 435
* CHECK dout0_23 vdout0_23ck86 = 1.0 time = 435
* CHECK dout0_24 vdout0_24ck86 = 1.0 time = 435
* CHECK dout0_25 vdout0_25ck86 = 1.0 time = 435
* CHECK dout0_26 vdout0_26ck86 = 0 time = 435
* CHECK dout0_27 vdout0_27ck86 = 1.0 time = 435
* CHECK dout0_28 vdout0_28ck86 = 0 time = 435
* CHECK dout0_29 vdout0_29ck86 = 0 time = 435
* CHECK dout0_30 vdout0_30ck86 = 0 time = 435
* CHECK dout0_31 vdout0_31ck86 = 0 time = 435
* CHECK dout0_32 vdout0_32ck86 = 1.0 time = 435
* CHECK dout0_33 vdout0_33ck86 = 0 time = 435
* CHECK dout0_34 vdout0_34ck86 = 1.0 time = 435
* CHECK dout0_35 vdout0_35ck86 = 0 time = 435
* CHECK dout0_36 vdout0_36ck86 = 0 time = 435
* CHECK dout0_37 vdout0_37ck86 = 1.0 time = 435
* CHECK dout0_38 vdout0_38ck86 = 0 time = 435
* CHECK dout0_39 vdout0_39ck86 = 0 time = 435
* CHECK dout0_40 vdout0_40ck86 = 0 time = 435
* CHECK dout0_41 vdout0_41ck86 = 0 time = 435
* CHECK dout0_42 vdout0_42ck86 = 0 time = 435
* CHECK dout0_43 vdout0_43ck86 = 0 time = 435
* CHECK dout0_44 vdout0_44ck86 = 0 time = 435
* CHECK dout0_45 vdout0_45ck86 = 1.0 time = 435
* CHECK dout0_46 vdout0_46ck86 = 1.0 time = 435
* CHECK dout0_47 vdout0_47ck86 = 1.0 time = 435
* CHECK dout0_48 vdout0_48ck86 = 0 time = 435
* CHECK dout0_49 vdout0_49ck86 = 0 time = 435
* CHECK dout0_50 vdout0_50ck86 = 0 time = 435
* CHECK dout0_51 vdout0_51ck86 = 0 time = 435
* CHECK dout0_52 vdout0_52ck86 = 1.0 time = 435
* CHECK dout0_53 vdout0_53ck86 = 0 time = 435
* CHECK dout0_54 vdout0_54ck86 = 0 time = 435
* CHECK dout0_55 vdout0_55ck86 = 0 time = 435
* CHECK dout0_56 vdout0_56ck86 = 1.0 time = 435
* CHECK dout0_57 vdout0_57ck86 = 0 time = 435
* CHECK dout0_58 vdout0_58ck86 = 1.0 time = 435
* CHECK dout0_59 vdout0_59ck86 = 1.0 time = 435
* CHECK dout0_60 vdout0_60ck86 = 1.0 time = 435
* CHECK dout0_61 vdout0_61ck86 = 1.0 time = 435
* CHECK dout0_62 vdout0_62ck86 = 0 time = 435
* CHECK dout0_63 vdout0_63ck86 = 1.0 time = 435
* CHECK dout1_0 vdout1_0ck86 = 0 time = 435
* CHECK dout1_1 vdout1_1ck86 = 0 time = 435
* CHECK dout1_2 vdout1_2ck86 = 1.0 time = 435
* CHECK dout1_3 vdout1_3ck86 = 1.0 time = 435
* CHECK dout1_4 vdout1_4ck86 = 0 time = 435
* CHECK dout1_5 vdout1_5ck86 = 1.0 time = 435
* CHECK dout1_6 vdout1_6ck86 = 0 time = 435
* CHECK dout1_7 vdout1_7ck86 = 0 time = 435
* CHECK dout1_8 vdout1_8ck86 = 0 time = 435
* CHECK dout1_9 vdout1_9ck86 = 1.0 time = 435
* CHECK dout1_10 vdout1_10ck86 = 1.0 time = 435
* CHECK dout1_11 vdout1_11ck86 = 0 time = 435
* CHECK dout1_12 vdout1_12ck86 = 1.0 time = 435
* CHECK dout1_13 vdout1_13ck86 = 1.0 time = 435
* CHECK dout1_14 vdout1_14ck86 = 1.0 time = 435
* CHECK dout1_15 vdout1_15ck86 = 0 time = 435
* CHECK dout1_16 vdout1_16ck86 = 0 time = 435
* CHECK dout1_17 vdout1_17ck86 = 0 time = 435
* CHECK dout1_18 vdout1_18ck86 = 0 time = 435
* CHECK dout1_19 vdout1_19ck86 = 0 time = 435
* CHECK dout1_20 vdout1_20ck86 = 1.0 time = 435
* CHECK dout1_21 vdout1_21ck86 = 1.0 time = 435
* CHECK dout1_22 vdout1_22ck86 = 1.0 time = 435
* CHECK dout1_23 vdout1_23ck86 = 0 time = 435
* CHECK dout1_24 vdout1_24ck86 = 0 time = 435
* CHECK dout1_25 vdout1_25ck86 = 1.0 time = 435
* CHECK dout1_26 vdout1_26ck86 = 0 time = 435
* CHECK dout1_27 vdout1_27ck86 = 0 time = 435
* CHECK dout1_28 vdout1_28ck86 = 1.0 time = 435
* CHECK dout1_29 vdout1_29ck86 = 0 time = 435
* CHECK dout1_30 vdout1_30ck86 = 0 time = 435
* CHECK dout1_31 vdout1_31ck86 = 0 time = 435
* CHECK dout1_32 vdout1_32ck86 = 0 time = 435
* CHECK dout1_33 vdout1_33ck86 = 0 time = 435
* CHECK dout1_34 vdout1_34ck86 = 0 time = 435
* CHECK dout1_35 vdout1_35ck86 = 0 time = 435
* CHECK dout1_36 vdout1_36ck86 = 0 time = 435
* CHECK dout1_37 vdout1_37ck86 = 1.0 time = 435
* CHECK dout1_38 vdout1_38ck86 = 0 time = 435
* CHECK dout1_39 vdout1_39ck86 = 0 time = 435
* CHECK dout1_40 vdout1_40ck86 = 1.0 time = 435
* CHECK dout1_41 vdout1_41ck86 = 0 time = 435
* CHECK dout1_42 vdout1_42ck86 = 1.0 time = 435
* CHECK dout1_43 vdout1_43ck86 = 0 time = 435
* CHECK dout1_44 vdout1_44ck86 = 1.0 time = 435
* CHECK dout1_45 vdout1_45ck86 = 0 time = 435
* CHECK dout1_46 vdout1_46ck86 = 1.0 time = 435
* CHECK dout1_47 vdout1_47ck86 = 0 time = 435
* CHECK dout1_48 vdout1_48ck86 = 1.0 time = 435
* CHECK dout1_49 vdout1_49ck86 = 1.0 time = 435
* CHECK dout1_50 vdout1_50ck86 = 1.0 time = 435
* CHECK dout1_51 vdout1_51ck86 = 1.0 time = 435
* CHECK dout1_52 vdout1_52ck86 = 1.0 time = 435
* CHECK dout1_53 vdout1_53ck86 = 0 time = 435
* CHECK dout1_54 vdout1_54ck86 = 0 time = 435
* CHECK dout1_55 vdout1_55ck86 = 0 time = 435
* CHECK dout1_56 vdout1_56ck86 = 1.0 time = 435
* CHECK dout1_57 vdout1_57ck86 = 0 time = 435
* CHECK dout1_58 vdout1_58ck86 = 1.0 time = 435
* CHECK dout1_59 vdout1_59ck86 = 1.0 time = 435
* CHECK dout1_60 vdout1_60ck86 = 1.0 time = 435
* CHECK dout1_61 vdout1_61ck86 = 0 time = 435
* CHECK dout1_62 vdout1_62ck86 = 0 time = 435
* CHECK dout1_63 vdout1_63ck86 = 0 time = 435
* CHECK dout1_0 vdout1_0ck88 = 0 time = 445
* CHECK dout1_1 vdout1_1ck88 = 0 time = 445
* CHECK dout1_2 vdout1_2ck88 = 0 time = 445
* CHECK dout1_3 vdout1_3ck88 = 0 time = 445
* CHECK dout1_4 vdout1_4ck88 = 1.0 time = 445
* CHECK dout1_5 vdout1_5ck88 = 0 time = 445
* CHECK dout1_6 vdout1_6ck88 = 1.0 time = 445
* CHECK dout1_7 vdout1_7ck88 = 1.0 time = 445
* CHECK dout1_8 vdout1_8ck88 = 0 time = 445
* CHECK dout1_9 vdout1_9ck88 = 1.0 time = 445
* CHECK dout1_10 vdout1_10ck88 = 0 time = 445
* CHECK dout1_11 vdout1_11ck88 = 1.0 time = 445
* CHECK dout1_12 vdout1_12ck88 = 0 time = 445
* CHECK dout1_13 vdout1_13ck88 = 1.0 time = 445
* CHECK dout1_14 vdout1_14ck88 = 0 time = 445
* CHECK dout1_15 vdout1_15ck88 = 1.0 time = 445
* CHECK dout1_16 vdout1_16ck88 = 1.0 time = 445
* CHECK dout1_17 vdout1_17ck88 = 0 time = 445
* CHECK dout1_18 vdout1_18ck88 = 0 time = 445
* CHECK dout1_19 vdout1_19ck88 = 1.0 time = 445
* CHECK dout1_20 vdout1_20ck88 = 1.0 time = 445
* CHECK dout1_21 vdout1_21ck88 = 0 time = 445
* CHECK dout1_22 vdout1_22ck88 = 1.0 time = 445
* CHECK dout1_23 vdout1_23ck88 = 1.0 time = 445
* CHECK dout1_24 vdout1_24ck88 = 0 time = 445
* CHECK dout1_25 vdout1_25ck88 = 0 time = 445
* CHECK dout1_26 vdout1_26ck88 = 0 time = 445
* CHECK dout1_27 vdout1_27ck88 = 1.0 time = 445
* CHECK dout1_28 vdout1_28ck88 = 0 time = 445
* CHECK dout1_29 vdout1_29ck88 = 0 time = 445
* CHECK dout1_30 vdout1_30ck88 = 1.0 time = 445
* CHECK dout1_31 vdout1_31ck88 = 0 time = 445
* CHECK dout1_32 vdout1_32ck88 = 1.0 time = 445
* CHECK dout1_33 vdout1_33ck88 = 0 time = 445
* CHECK dout1_34 vdout1_34ck88 = 1.0 time = 445
* CHECK dout1_35 vdout1_35ck88 = 1.0 time = 445
* CHECK dout1_36 vdout1_36ck88 = 1.0 time = 445
* CHECK dout1_37 vdout1_37ck88 = 1.0 time = 445
* CHECK dout1_38 vdout1_38ck88 = 0 time = 445
* CHECK dout1_39 vdout1_39ck88 = 0 time = 445
* CHECK dout1_40 vdout1_40ck88 = 0 time = 445
* CHECK dout1_41 vdout1_41ck88 = 0 time = 445
* CHECK dout1_42 vdout1_42ck88 = 0 time = 445
* CHECK dout1_43 vdout1_43ck88 = 1.0 time = 445
* CHECK dout1_44 vdout1_44ck88 = 0 time = 445
* CHECK dout1_45 vdout1_45ck88 = 0 time = 445
* CHECK dout1_46 vdout1_46ck88 = 0 time = 445
* CHECK dout1_47 vdout1_47ck88 = 0 time = 445
* CHECK dout1_48 vdout1_48ck88 = 0 time = 445
* CHECK dout1_49 vdout1_49ck88 = 1.0 time = 445
* CHECK dout1_50 vdout1_50ck88 = 0 time = 445
* CHECK dout1_51 vdout1_51ck88 = 0 time = 445
* CHECK dout1_52 vdout1_52ck88 = 1.0 time = 445
* CHECK dout1_53 vdout1_53ck88 = 0 time = 445
* CHECK dout1_54 vdout1_54ck88 = 0 time = 445
* CHECK dout1_55 vdout1_55ck88 = 1.0 time = 445
* CHECK dout1_56 vdout1_56ck88 = 1.0 time = 445
* CHECK dout1_57 vdout1_57ck88 = 1.0 time = 445
* CHECK dout1_58 vdout1_58ck88 = 0 time = 445
* CHECK dout1_59 vdout1_59ck88 = 0 time = 445
* CHECK dout1_60 vdout1_60ck88 = 1.0 time = 445
* CHECK dout1_61 vdout1_61ck88 = 0 time = 445
* CHECK dout1_62 vdout1_62ck88 = 1.0 time = 445
* CHECK dout1_63 vdout1_63ck88 = 0 time = 445
* CHECK dout0_0 vdout0_0ck90 = 1.0 time = 455
* CHECK dout0_1 vdout0_1ck90 = 1.0 time = 455
* CHECK dout0_2 vdout0_2ck90 = 1.0 time = 455
* CHECK dout0_3 vdout0_3ck90 = 0 time = 455
* CHECK dout0_4 vdout0_4ck90 = 0 time = 455
* CHECK dout0_5 vdout0_5ck90 = 0 time = 455
* CHECK dout0_6 vdout0_6ck90 = 1.0 time = 455
* CHECK dout0_7 vdout0_7ck90 = 0 time = 455
* CHECK dout0_8 vdout0_8ck90 = 1.0 time = 455
* CHECK dout0_9 vdout0_9ck90 = 0 time = 455
* CHECK dout0_10 vdout0_10ck90 = 1.0 time = 455
* CHECK dout0_11 vdout0_11ck90 = 1.0 time = 455
* CHECK dout0_12 vdout0_12ck90 = 0 time = 455
* CHECK dout0_13 vdout0_13ck90 = 0 time = 455
* CHECK dout0_14 vdout0_14ck90 = 0 time = 455
* CHECK dout0_15 vdout0_15ck90 = 0 time = 455
* CHECK dout0_16 vdout0_16ck90 = 1.0 time = 455
* CHECK dout0_17 vdout0_17ck90 = 1.0 time = 455
* CHECK dout0_18 vdout0_18ck90 = 1.0 time = 455
* CHECK dout0_19 vdout0_19ck90 = 1.0 time = 455
* CHECK dout0_20 vdout0_20ck90 = 1.0 time = 455
* CHECK dout0_21 vdout0_21ck90 = 1.0 time = 455
* CHECK dout0_22 vdout0_22ck90 = 0 time = 455
* CHECK dout0_23 vdout0_23ck90 = 1.0 time = 455
* CHECK dout0_24 vdout0_24ck90 = 1.0 time = 455
* CHECK dout0_25 vdout0_25ck90 = 1.0 time = 455
* CHECK dout0_26 vdout0_26ck90 = 0 time = 455
* CHECK dout0_27 vdout0_27ck90 = 1.0 time = 455
* CHECK dout0_28 vdout0_28ck90 = 0 time = 455
* CHECK dout0_29 vdout0_29ck90 = 0 time = 455
* CHECK dout0_30 vdout0_30ck90 = 0 time = 455
* CHECK dout0_31 vdout0_31ck90 = 0 time = 455
* CHECK dout0_32 vdout0_32ck90 = 1.0 time = 455
* CHECK dout0_33 vdout0_33ck90 = 0 time = 455
* CHECK dout0_34 vdout0_34ck90 = 1.0 time = 455
* CHECK dout0_35 vdout0_35ck90 = 0 time = 455
* CHECK dout0_36 vdout0_36ck90 = 0 time = 455
* CHECK dout0_37 vdout0_37ck90 = 1.0 time = 455
* CHECK dout0_38 vdout0_38ck90 = 0 time = 455
* CHECK dout0_39 vdout0_39ck90 = 0 time = 455
* CHECK dout0_40 vdout0_40ck90 = 0 time = 455
* CHECK dout0_41 vdout0_41ck90 = 0 time = 455
* CHECK dout0_42 vdout0_42ck90 = 0 time = 455
* CHECK dout0_43 vdout0_43ck90 = 0 time = 455
* CHECK dout0_44 vdout0_44ck90 = 0 time = 455
* CHECK dout0_45 vdout0_45ck90 = 1.0 time = 455
* CHECK dout0_46 vdout0_46ck90 = 1.0 time = 455
* CHECK dout0_47 vdout0_47ck90 = 1.0 time = 455
* CHECK dout0_48 vdout0_48ck90 = 0 time = 455
* CHECK dout0_49 vdout0_49ck90 = 0 time = 455
* CHECK dout0_50 vdout0_50ck90 = 0 time = 455
* CHECK dout0_51 vdout0_51ck90 = 0 time = 455
* CHECK dout0_52 vdout0_52ck90 = 1.0 time = 455
* CHECK dout0_53 vdout0_53ck90 = 0 time = 455
* CHECK dout0_54 vdout0_54ck90 = 0 time = 455
* CHECK dout0_55 vdout0_55ck90 = 0 time = 455
* CHECK dout0_56 vdout0_56ck90 = 1.0 time = 455
* CHECK dout0_57 vdout0_57ck90 = 0 time = 455
* CHECK dout0_58 vdout0_58ck90 = 1.0 time = 455
* CHECK dout0_59 vdout0_59ck90 = 1.0 time = 455
* CHECK dout0_60 vdout0_60ck90 = 1.0 time = 455
* CHECK dout0_61 vdout0_61ck90 = 1.0 time = 455
* CHECK dout0_62 vdout0_62ck90 = 0 time = 455
* CHECK dout0_63 vdout0_63ck90 = 1.0 time = 455
* CHECK dout0_0 vdout0_0ck91 = 0 time = 460
* CHECK dout0_1 vdout0_1ck91 = 0 time = 460
* CHECK dout0_2 vdout0_2ck91 = 1.0 time = 460
* CHECK dout0_3 vdout0_3ck91 = 1.0 time = 460
* CHECK dout0_4 vdout0_4ck91 = 0 time = 460
* CHECK dout0_5 vdout0_5ck91 = 1.0 time = 460
* CHECK dout0_6 vdout0_6ck91 = 0 time = 460
* CHECK dout0_7 vdout0_7ck91 = 0 time = 460
* CHECK dout0_8 vdout0_8ck91 = 0 time = 460
* CHECK dout0_9 vdout0_9ck91 = 1.0 time = 460
* CHECK dout0_10 vdout0_10ck91 = 1.0 time = 460
* CHECK dout0_11 vdout0_11ck91 = 0 time = 460
* CHECK dout0_12 vdout0_12ck91 = 1.0 time = 460
* CHECK dout0_13 vdout0_13ck91 = 1.0 time = 460
* CHECK dout0_14 vdout0_14ck91 = 1.0 time = 460
* CHECK dout0_15 vdout0_15ck91 = 0 time = 460
* CHECK dout0_16 vdout0_16ck91 = 0 time = 460
* CHECK dout0_17 vdout0_17ck91 = 0 time = 460
* CHECK dout0_18 vdout0_18ck91 = 0 time = 460
* CHECK dout0_19 vdout0_19ck91 = 0 time = 460
* CHECK dout0_20 vdout0_20ck91 = 1.0 time = 460
* CHECK dout0_21 vdout0_21ck91 = 1.0 time = 460
* CHECK dout0_22 vdout0_22ck91 = 1.0 time = 460
* CHECK dout0_23 vdout0_23ck91 = 0 time = 460
* CHECK dout0_24 vdout0_24ck91 = 0 time = 460
* CHECK dout0_25 vdout0_25ck91 = 1.0 time = 460
* CHECK dout0_26 vdout0_26ck91 = 0 time = 460
* CHECK dout0_27 vdout0_27ck91 = 0 time = 460
* CHECK dout0_28 vdout0_28ck91 = 1.0 time = 460
* CHECK dout0_29 vdout0_29ck91 = 0 time = 460
* CHECK dout0_30 vdout0_30ck91 = 0 time = 460
* CHECK dout0_31 vdout0_31ck91 = 0 time = 460
* CHECK dout0_32 vdout0_32ck91 = 0 time = 460
* CHECK dout0_33 vdout0_33ck91 = 0 time = 460
* CHECK dout0_34 vdout0_34ck91 = 0 time = 460
* CHECK dout0_35 vdout0_35ck91 = 0 time = 460
* CHECK dout0_36 vdout0_36ck91 = 0 time = 460
* CHECK dout0_37 vdout0_37ck91 = 1.0 time = 460
* CHECK dout0_38 vdout0_38ck91 = 0 time = 460
* CHECK dout0_39 vdout0_39ck91 = 0 time = 460
* CHECK dout0_40 vdout0_40ck91 = 1.0 time = 460
* CHECK dout0_41 vdout0_41ck91 = 0 time = 460
* CHECK dout0_42 vdout0_42ck91 = 1.0 time = 460
* CHECK dout0_43 vdout0_43ck91 = 0 time = 460
* CHECK dout0_44 vdout0_44ck91 = 1.0 time = 460
* CHECK dout0_45 vdout0_45ck91 = 0 time = 460
* CHECK dout0_46 vdout0_46ck91 = 1.0 time = 460
* CHECK dout0_47 vdout0_47ck91 = 0 time = 460
* CHECK dout0_48 vdout0_48ck91 = 1.0 time = 460
* CHECK dout0_49 vdout0_49ck91 = 1.0 time = 460
* CHECK dout0_50 vdout0_50ck91 = 1.0 time = 460
* CHECK dout0_51 vdout0_51ck91 = 1.0 time = 460
* CHECK dout0_52 vdout0_52ck91 = 1.0 time = 460
* CHECK dout0_53 vdout0_53ck91 = 0 time = 460
* CHECK dout0_54 vdout0_54ck91 = 0 time = 460
* CHECK dout0_55 vdout0_55ck91 = 0 time = 460
* CHECK dout0_56 vdout0_56ck91 = 1.0 time = 460
* CHECK dout0_57 vdout0_57ck91 = 0 time = 460
* CHECK dout0_58 vdout0_58ck91 = 1.0 time = 460
* CHECK dout0_59 vdout0_59ck91 = 1.0 time = 460
* CHECK dout0_60 vdout0_60ck91 = 1.0 time = 460
* CHECK dout0_61 vdout0_61ck91 = 0 time = 460
* CHECK dout0_62 vdout0_62ck91 = 0 time = 460
* CHECK dout0_63 vdout0_63ck91 = 0 time = 460
* CHECK dout1_0 vdout1_0ck91 = 1.0 time = 460
* CHECK dout1_1 vdout1_1ck91 = 1.0 time = 460
* CHECK dout1_2 vdout1_2ck91 = 0 time = 460
* CHECK dout1_3 vdout1_3ck91 = 1.0 time = 460
* CHECK dout1_4 vdout1_4ck91 = 1.0 time = 460
* CHECK dout1_5 vdout1_5ck91 = 0 time = 460
* CHECK dout1_6 vdout1_6ck91 = 0 time = 460
* CHECK dout1_7 vdout1_7ck91 = 0 time = 460
* CHECK dout1_8 vdout1_8ck91 = 0 time = 460
* CHECK dout1_9 vdout1_9ck91 = 0 time = 460
* CHECK dout1_10 vdout1_10ck91 = 0 time = 460
* CHECK dout1_11 vdout1_11ck91 = 1.0 time = 460
* CHECK dout1_12 vdout1_12ck91 = 0 time = 460
* CHECK dout1_13 vdout1_13ck91 = 1.0 time = 460
* CHECK dout1_14 vdout1_14ck91 = 1.0 time = 460
* CHECK dout1_15 vdout1_15ck91 = 1.0 time = 460
* CHECK dout1_16 vdout1_16ck91 = 0 time = 460
* CHECK dout1_17 vdout1_17ck91 = 0 time = 460
* CHECK dout1_18 vdout1_18ck91 = 1.0 time = 460
* CHECK dout1_19 vdout1_19ck91 = 0 time = 460
* CHECK dout1_20 vdout1_20ck91 = 0 time = 460
* CHECK dout1_21 vdout1_21ck91 = 1.0 time = 460
* CHECK dout1_22 vdout1_22ck91 = 1.0 time = 460
* CHECK dout1_23 vdout1_23ck91 = 0 time = 460
* CHECK dout1_24 vdout1_24ck91 = 0 time = 460
* CHECK dout1_25 vdout1_25ck91 = 0 time = 460
* CHECK dout1_26 vdout1_26ck91 = 1.0 time = 460
* CHECK dout1_27 vdout1_27ck91 = 1.0 time = 460
* CHECK dout1_28 vdout1_28ck91 = 0 time = 460
* CHECK dout1_29 vdout1_29ck91 = 0 time = 460
* CHECK dout1_30 vdout1_30ck91 = 1.0 time = 460
* CHECK dout1_31 vdout1_31ck91 = 1.0 time = 460
* CHECK dout1_32 vdout1_32ck91 = 0 time = 460
* CHECK dout1_33 vdout1_33ck91 = 0 time = 460
* CHECK dout1_34 vdout1_34ck91 = 1.0 time = 460
* CHECK dout1_35 vdout1_35ck91 = 0 time = 460
* CHECK dout1_36 vdout1_36ck91 = 1.0 time = 460
* CHECK dout1_37 vdout1_37ck91 = 1.0 time = 460
* CHECK dout1_38 vdout1_38ck91 = 1.0 time = 460
* CHECK dout1_39 vdout1_39ck91 = 0 time = 460
* CHECK dout1_40 vdout1_40ck91 = 0 time = 460
* CHECK dout1_41 vdout1_41ck91 = 1.0 time = 460
* CHECK dout1_42 vdout1_42ck91 = 1.0 time = 460
* CHECK dout1_43 vdout1_43ck91 = 1.0 time = 460
* CHECK dout1_44 vdout1_44ck91 = 1.0 time = 460
* CHECK dout1_45 vdout1_45ck91 = 1.0 time = 460
* CHECK dout1_46 vdout1_46ck91 = 1.0 time = 460
* CHECK dout1_47 vdout1_47ck91 = 1.0 time = 460
* CHECK dout1_48 vdout1_48ck91 = 0 time = 460
* CHECK dout1_49 vdout1_49ck91 = 1.0 time = 460
* CHECK dout1_50 vdout1_50ck91 = 1.0 time = 460
* CHECK dout1_51 vdout1_51ck91 = 0 time = 460
* CHECK dout1_52 vdout1_52ck91 = 0 time = 460
* CHECK dout1_53 vdout1_53ck91 = 1.0 time = 460
* CHECK dout1_54 vdout1_54ck91 = 1.0 time = 460
* CHECK dout1_55 vdout1_55ck91 = 1.0 time = 460
* CHECK dout1_56 vdout1_56ck91 = 1.0 time = 460
* CHECK dout1_57 vdout1_57ck91 = 0 time = 460
* CHECK dout1_58 vdout1_58ck91 = 0 time = 460
* CHECK dout1_59 vdout1_59ck91 = 0 time = 460
* CHECK dout1_60 vdout1_60ck91 = 1.0 time = 460
* CHECK dout1_61 vdout1_61ck91 = 1.0 time = 460
* CHECK dout1_62 vdout1_62ck91 = 0 time = 460
* CHECK dout1_63 vdout1_63ck91 = 0 time = 460
* CHECK dout0_0 vdout0_0ck92 = 1.0 time = 465
* CHECK dout0_1 vdout0_1ck92 = 0 time = 465
* CHECK dout0_2 vdout0_2ck92 = 1.0 time = 465
* CHECK dout0_3 vdout0_3ck92 = 1.0 time = 465
* CHECK dout0_4 vdout0_4ck92 = 1.0 time = 465
* CHECK dout0_5 vdout0_5ck92 = 1.0 time = 465
* CHECK dout0_6 vdout0_6ck92 = 1.0 time = 465
* CHECK dout0_7 vdout0_7ck92 = 1.0 time = 465
* CHECK dout0_8 vdout0_8ck92 = 0 time = 465
* CHECK dout0_9 vdout0_9ck92 = 1.0 time = 465
* CHECK dout0_10 vdout0_10ck92 = 1.0 time = 465
* CHECK dout0_11 vdout0_11ck92 = 1.0 time = 465
* CHECK dout0_12 vdout0_12ck92 = 1.0 time = 465
* CHECK dout0_13 vdout0_13ck92 = 0 time = 465
* CHECK dout0_14 vdout0_14ck92 = 0 time = 465
* CHECK dout0_15 vdout0_15ck92 = 1.0 time = 465
* CHECK dout0_16 vdout0_16ck92 = 0 time = 465
* CHECK dout0_17 vdout0_17ck92 = 0 time = 465
* CHECK dout0_18 vdout0_18ck92 = 0 time = 465
* CHECK dout0_19 vdout0_19ck92 = 0 time = 465
* CHECK dout0_20 vdout0_20ck92 = 0 time = 465
* CHECK dout0_21 vdout0_21ck92 = 0 time = 465
* CHECK dout0_22 vdout0_22ck92 = 1.0 time = 465
* CHECK dout0_23 vdout0_23ck92 = 1.0 time = 465
* CHECK dout0_24 vdout0_24ck92 = 1.0 time = 465
* CHECK dout0_25 vdout0_25ck92 = 1.0 time = 465
* CHECK dout0_26 vdout0_26ck92 = 0 time = 465
* CHECK dout0_27 vdout0_27ck92 = 1.0 time = 465
* CHECK dout0_28 vdout0_28ck92 = 0 time = 465
* CHECK dout0_29 vdout0_29ck92 = 1.0 time = 465
* CHECK dout0_30 vdout0_30ck92 = 0 time = 465
* CHECK dout0_31 vdout0_31ck92 = 1.0 time = 465
* CHECK dout0_32 vdout0_32ck92 = 1.0 time = 465
* CHECK dout0_33 vdout0_33ck92 = 0 time = 465
* CHECK dout0_34 vdout0_34ck92 = 0 time = 465
* CHECK dout0_35 vdout0_35ck92 = 0 time = 465
* CHECK dout0_36 vdout0_36ck92 = 1.0 time = 465
* CHECK dout0_37 vdout0_37ck92 = 0 time = 465
* CHECK dout0_38 vdout0_38ck92 = 0 time = 465
* CHECK dout0_39 vdout0_39ck92 = 1.0 time = 465
* CHECK dout0_40 vdout0_40ck92 = 1.0 time = 465
* CHECK dout0_41 vdout0_41ck92 = 0 time = 465
* CHECK dout0_42 vdout0_42ck92 = 1.0 time = 465
* CHECK dout0_43 vdout0_43ck92 = 0 time = 465
* CHECK dout0_44 vdout0_44ck92 = 1.0 time = 465
* CHECK dout0_45 vdout0_45ck92 = 0 time = 465
* CHECK dout0_46 vdout0_46ck92 = 0 time = 465
* CHECK dout0_47 vdout0_47ck92 = 1.0 time = 465
* CHECK dout0_48 vdout0_48ck92 = 0 time = 465
* CHECK dout0_49 vdout0_49ck92 = 0 time = 465
* CHECK dout0_50 vdout0_50ck92 = 1.0 time = 465
* CHECK dout0_51 vdout0_51ck92 = 1.0 time = 465
* CHECK dout0_52 vdout0_52ck92 = 1.0 time = 465
* CHECK dout0_53 vdout0_53ck92 = 0 time = 465
* CHECK dout0_54 vdout0_54ck92 = 0 time = 465
* CHECK dout0_55 vdout0_55ck92 = 1.0 time = 465
* CHECK dout0_56 vdout0_56ck92 = 1.0 time = 465
* CHECK dout0_57 vdout0_57ck92 = 1.0 time = 465
* CHECK dout0_58 vdout0_58ck92 = 1.0 time = 465
* CHECK dout0_59 vdout0_59ck92 = 1.0 time = 465
* CHECK dout0_60 vdout0_60ck92 = 1.0 time = 465
* CHECK dout0_61 vdout0_61ck92 = 1.0 time = 465
* CHECK dout0_62 vdout0_62ck92 = 1.0 time = 465
* CHECK dout0_63 vdout0_63ck92 = 0 time = 465
* CHECK dout1_0 vdout1_0ck92 = 1.0 time = 465
* CHECK dout1_1 vdout1_1ck92 = 0 time = 465
* CHECK dout1_2 vdout1_2ck92 = 1.0 time = 465
* CHECK dout1_3 vdout1_3ck92 = 1.0 time = 465
* CHECK dout1_4 vdout1_4ck92 = 1.0 time = 465
* CHECK dout1_5 vdout1_5ck92 = 1.0 time = 465
* CHECK dout1_6 vdout1_6ck92 = 1.0 time = 465
* CHECK dout1_7 vdout1_7ck92 = 1.0 time = 465
* CHECK dout1_8 vdout1_8ck92 = 0 time = 465
* CHECK dout1_9 vdout1_9ck92 = 1.0 time = 465
* CHECK dout1_10 vdout1_10ck92 = 1.0 time = 465
* CHECK dout1_11 vdout1_11ck92 = 1.0 time = 465
* CHECK dout1_12 vdout1_12ck92 = 1.0 time = 465
* CHECK dout1_13 vdout1_13ck92 = 0 time = 465
* CHECK dout1_14 vdout1_14ck92 = 0 time = 465
* CHECK dout1_15 vdout1_15ck92 = 1.0 time = 465
* CHECK dout1_16 vdout1_16ck92 = 0 time = 465
* CHECK dout1_17 vdout1_17ck92 = 0 time = 465
* CHECK dout1_18 vdout1_18ck92 = 0 time = 465
* CHECK dout1_19 vdout1_19ck92 = 0 time = 465
* CHECK dout1_20 vdout1_20ck92 = 0 time = 465
* CHECK dout1_21 vdout1_21ck92 = 0 time = 465
* CHECK dout1_22 vdout1_22ck92 = 1.0 time = 465
* CHECK dout1_23 vdout1_23ck92 = 1.0 time = 465
* CHECK dout1_24 vdout1_24ck92 = 1.0 time = 465
* CHECK dout1_25 vdout1_25ck92 = 1.0 time = 465
* CHECK dout1_26 vdout1_26ck92 = 0 time = 465
* CHECK dout1_27 vdout1_27ck92 = 1.0 time = 465
* CHECK dout1_28 vdout1_28ck92 = 0 time = 465
* CHECK dout1_29 vdout1_29ck92 = 1.0 time = 465
* CHECK dout1_30 vdout1_30ck92 = 0 time = 465
* CHECK dout1_31 vdout1_31ck92 = 1.0 time = 465
* CHECK dout1_32 vdout1_32ck92 = 1.0 time = 465
* CHECK dout1_33 vdout1_33ck92 = 0 time = 465
* CHECK dout1_34 vdout1_34ck92 = 0 time = 465
* CHECK dout1_35 vdout1_35ck92 = 0 time = 465
* CHECK dout1_36 vdout1_36ck92 = 1.0 time = 465
* CHECK dout1_37 vdout1_37ck92 = 0 time = 465
* CHECK dout1_38 vdout1_38ck92 = 0 time = 465
* CHECK dout1_39 vdout1_39ck92 = 1.0 time = 465
* CHECK dout1_40 vdout1_40ck92 = 1.0 time = 465
* CHECK dout1_41 vdout1_41ck92 = 0 time = 465
* CHECK dout1_42 vdout1_42ck92 = 1.0 time = 465
* CHECK dout1_43 vdout1_43ck92 = 0 time = 465
* CHECK dout1_44 vdout1_44ck92 = 1.0 time = 465
* CHECK dout1_45 vdout1_45ck92 = 0 time = 465
* CHECK dout1_46 vdout1_46ck92 = 0 time = 465
* CHECK dout1_47 vdout1_47ck92 = 1.0 time = 465
* CHECK dout1_48 vdout1_48ck92 = 0 time = 465
* CHECK dout1_49 vdout1_49ck92 = 0 time = 465
* CHECK dout1_50 vdout1_50ck92 = 1.0 time = 465
* CHECK dout1_51 vdout1_51ck92 = 1.0 time = 465
* CHECK dout1_52 vdout1_52ck92 = 1.0 time = 465
* CHECK dout1_53 vdout1_53ck92 = 0 time = 465
* CHECK dout1_54 vdout1_54ck92 = 0 time = 465
* CHECK dout1_55 vdout1_55ck92 = 1.0 time = 465
* CHECK dout1_56 vdout1_56ck92 = 1.0 time = 465
* CHECK dout1_57 vdout1_57ck92 = 1.0 time = 465
* CHECK dout1_58 vdout1_58ck92 = 1.0 time = 465
* CHECK dout1_59 vdout1_59ck92 = 1.0 time = 465
* CHECK dout1_60 vdout1_60ck92 = 1.0 time = 465
* CHECK dout1_61 vdout1_61ck92 = 1.0 time = 465
* CHECK dout1_62 vdout1_62ck92 = 1.0 time = 465
* CHECK dout1_63 vdout1_63ck92 = 0 time = 465
* CHECK dout0_0 vdout0_0ck93 = 0 time = 470
* CHECK dout0_1 vdout0_1ck93 = 0 time = 470
* CHECK dout0_2 vdout0_2ck93 = 1.0 time = 470
* CHECK dout0_3 vdout0_3ck93 = 1.0 time = 470
* CHECK dout0_4 vdout0_4ck93 = 0 time = 470
* CHECK dout0_5 vdout0_5ck93 = 1.0 time = 470
* CHECK dout0_6 vdout0_6ck93 = 0 time = 470
* CHECK dout0_7 vdout0_7ck93 = 0 time = 470
* CHECK dout0_8 vdout0_8ck93 = 0 time = 470
* CHECK dout0_9 vdout0_9ck93 = 1.0 time = 470
* CHECK dout0_10 vdout0_10ck93 = 1.0 time = 470
* CHECK dout0_11 vdout0_11ck93 = 0 time = 470
* CHECK dout0_12 vdout0_12ck93 = 1.0 time = 470
* CHECK dout0_13 vdout0_13ck93 = 1.0 time = 470
* CHECK dout0_14 vdout0_14ck93 = 1.0 time = 470
* CHECK dout0_15 vdout0_15ck93 = 0 time = 470
* CHECK dout0_16 vdout0_16ck93 = 0 time = 470
* CHECK dout0_17 vdout0_17ck93 = 0 time = 470
* CHECK dout0_18 vdout0_18ck93 = 0 time = 470
* CHECK dout0_19 vdout0_19ck93 = 0 time = 470
* CHECK dout0_20 vdout0_20ck93 = 1.0 time = 470
* CHECK dout0_21 vdout0_21ck93 = 1.0 time = 470
* CHECK dout0_22 vdout0_22ck93 = 1.0 time = 470
* CHECK dout0_23 vdout0_23ck93 = 0 time = 470
* CHECK dout0_24 vdout0_24ck93 = 0 time = 470
* CHECK dout0_25 vdout0_25ck93 = 1.0 time = 470
* CHECK dout0_26 vdout0_26ck93 = 0 time = 470
* CHECK dout0_27 vdout0_27ck93 = 0 time = 470
* CHECK dout0_28 vdout0_28ck93 = 1.0 time = 470
* CHECK dout0_29 vdout0_29ck93 = 0 time = 470
* CHECK dout0_30 vdout0_30ck93 = 0 time = 470
* CHECK dout0_31 vdout0_31ck93 = 0 time = 470
* CHECK dout0_32 vdout0_32ck93 = 0 time = 470
* CHECK dout0_33 vdout0_33ck93 = 0 time = 470
* CHECK dout0_34 vdout0_34ck93 = 0 time = 470
* CHECK dout0_35 vdout0_35ck93 = 0 time = 470
* CHECK dout0_36 vdout0_36ck93 = 0 time = 470
* CHECK dout0_37 vdout0_37ck93 = 1.0 time = 470
* CHECK dout0_38 vdout0_38ck93 = 0 time = 470
* CHECK dout0_39 vdout0_39ck93 = 0 time = 470
* CHECK dout0_40 vdout0_40ck93 = 1.0 time = 470
* CHECK dout0_41 vdout0_41ck93 = 0 time = 470
* CHECK dout0_42 vdout0_42ck93 = 1.0 time = 470
* CHECK dout0_43 vdout0_43ck93 = 0 time = 470
* CHECK dout0_44 vdout0_44ck93 = 1.0 time = 470
* CHECK dout0_45 vdout0_45ck93 = 0 time = 470
* CHECK dout0_46 vdout0_46ck93 = 1.0 time = 470
* CHECK dout0_47 vdout0_47ck93 = 0 time = 470
* CHECK dout0_48 vdout0_48ck93 = 1.0 time = 470
* CHECK dout0_49 vdout0_49ck93 = 1.0 time = 470
* CHECK dout0_50 vdout0_50ck93 = 1.0 time = 470
* CHECK dout0_51 vdout0_51ck93 = 1.0 time = 470
* CHECK dout0_52 vdout0_52ck93 = 1.0 time = 470
* CHECK dout0_53 vdout0_53ck93 = 0 time = 470
* CHECK dout0_54 vdout0_54ck93 = 0 time = 470
* CHECK dout0_55 vdout0_55ck93 = 0 time = 470
* CHECK dout0_56 vdout0_56ck93 = 1.0 time = 470
* CHECK dout0_57 vdout0_57ck93 = 0 time = 470
* CHECK dout0_58 vdout0_58ck93 = 1.0 time = 470
* CHECK dout0_59 vdout0_59ck93 = 1.0 time = 470
* CHECK dout0_60 vdout0_60ck93 = 1.0 time = 470
* CHECK dout0_61 vdout0_61ck93 = 0 time = 470
* CHECK dout0_62 vdout0_62ck93 = 0 time = 470
* CHECK dout0_63 vdout0_63ck93 = 0 time = 470
* CHECK dout0_0 vdout0_0ck94 = 0 time = 475
* CHECK dout0_1 vdout0_1ck94 = 1.0 time = 475
* CHECK dout0_2 vdout0_2ck94 = 0 time = 475
* CHECK dout0_3 vdout0_3ck94 = 1.0 time = 475
* CHECK dout0_4 vdout0_4ck94 = 0 time = 475
* CHECK dout0_5 vdout0_5ck94 = 0 time = 475
* CHECK dout0_6 vdout0_6ck94 = 1.0 time = 475
* CHECK dout0_7 vdout0_7ck94 = 0 time = 475
* CHECK dout0_8 vdout0_8ck94 = 1.0 time = 475
* CHECK dout0_9 vdout0_9ck94 = 1.0 time = 475
* CHECK dout0_10 vdout0_10ck94 = 1.0 time = 475
* CHECK dout0_11 vdout0_11ck94 = 0 time = 475
* CHECK dout0_12 vdout0_12ck94 = 1.0 time = 475
* CHECK dout0_13 vdout0_13ck94 = 1.0 time = 475
* CHECK dout0_14 vdout0_14ck94 = 0 time = 475
* CHECK dout0_15 vdout0_15ck94 = 1.0 time = 475
* CHECK dout0_16 vdout0_16ck94 = 1.0 time = 475
* CHECK dout0_17 vdout0_17ck94 = 1.0 time = 475
* CHECK dout0_18 vdout0_18ck94 = 1.0 time = 475
* CHECK dout0_19 vdout0_19ck94 = 1.0 time = 475
* CHECK dout0_20 vdout0_20ck94 = 1.0 time = 475
* CHECK dout0_21 vdout0_21ck94 = 0 time = 475
* CHECK dout0_22 vdout0_22ck94 = 0 time = 475
* CHECK dout0_23 vdout0_23ck94 = 1.0 time = 475
* CHECK dout0_24 vdout0_24ck94 = 0 time = 475
* CHECK dout0_25 vdout0_25ck94 = 0 time = 475
* CHECK dout0_26 vdout0_26ck94 = 1.0 time = 475
* CHECK dout0_27 vdout0_27ck94 = 0 time = 475
* CHECK dout0_28 vdout0_28ck94 = 0 time = 475
* CHECK dout0_29 vdout0_29ck94 = 0 time = 475
* CHECK dout0_30 vdout0_30ck94 = 0 time = 475
* CHECK dout0_31 vdout0_31ck94 = 0 time = 475
* CHECK dout0_32 vdout0_32ck94 = 1.0 time = 475
* CHECK dout0_33 vdout0_33ck94 = 1.0 time = 475
* CHECK dout0_34 vdout0_34ck94 = 0 time = 475
* CHECK dout0_35 vdout0_35ck94 = 0 time = 475
* CHECK dout0_36 vdout0_36ck94 = 1.0 time = 475
* CHECK dout0_37 vdout0_37ck94 = 1.0 time = 475
* CHECK dout0_38 vdout0_38ck94 = 1.0 time = 475
* CHECK dout0_39 vdout0_39ck94 = 0 time = 475
* CHECK dout0_40 vdout0_40ck94 = 1.0 time = 475
* CHECK dout0_41 vdout0_41ck94 = 0 time = 475
* CHECK dout0_42 vdout0_42ck94 = 0 time = 475
* CHECK dout0_43 vdout0_43ck94 = 0 time = 475
* CHECK dout0_44 vdout0_44ck94 = 1.0 time = 475
* CHECK dout0_45 vdout0_45ck94 = 1.0 time = 475
* CHECK dout0_46 vdout0_46ck94 = 0 time = 475
* CHECK dout0_47 vdout0_47ck94 = 0 time = 475
* CHECK dout0_48 vdout0_48ck94 = 0 time = 475
* CHECK dout0_49 vdout0_49ck94 = 0 time = 475
* CHECK dout0_50 vdout0_50ck94 = 1.0 time = 475
* CHECK dout0_51 vdout0_51ck94 = 1.0 time = 475
* CHECK dout0_52 vdout0_52ck94 = 0 time = 475
* CHECK dout0_53 vdout0_53ck94 = 1.0 time = 475
* CHECK dout0_54 vdout0_54ck94 = 0 time = 475
* CHECK dout0_55 vdout0_55ck94 = 0 time = 475
* CHECK dout0_56 vdout0_56ck94 = 1.0 time = 475
* CHECK dout0_57 vdout0_57ck94 = 0 time = 475
* CHECK dout0_58 vdout0_58ck94 = 0 time = 475
* CHECK dout0_59 vdout0_59ck94 = 0 time = 475
* CHECK dout0_60 vdout0_60ck94 = 1.0 time = 475
* CHECK dout0_61 vdout0_61ck94 = 1.0 time = 475
* CHECK dout0_62 vdout0_62ck94 = 0 time = 475
* CHECK dout0_63 vdout0_63ck94 = 0 time = 475
* CHECK dout1_0 vdout1_0ck94 = 1.0 time = 475
* CHECK dout1_1 vdout1_1ck94 = 1.0 time = 475
* CHECK dout1_2 vdout1_2ck94 = 1.0 time = 475
* CHECK dout1_3 vdout1_3ck94 = 1.0 time = 475
* CHECK dout1_4 vdout1_4ck94 = 1.0 time = 475
* CHECK dout1_5 vdout1_5ck94 = 0 time = 475
* CHECK dout1_6 vdout1_6ck94 = 0 time = 475
* CHECK dout1_7 vdout1_7ck94 = 1.0 time = 475
* CHECK dout1_8 vdout1_8ck94 = 1.0 time = 475
* CHECK dout1_9 vdout1_9ck94 = 0 time = 475
* CHECK dout1_10 vdout1_10ck94 = 0 time = 475
* CHECK dout1_11 vdout1_11ck94 = 1.0 time = 475
* CHECK dout1_12 vdout1_12ck94 = 1.0 time = 475
* CHECK dout1_13 vdout1_13ck94 = 0 time = 475
* CHECK dout1_14 vdout1_14ck94 = 1.0 time = 475
* CHECK dout1_15 vdout1_15ck94 = 0 time = 475
* CHECK dout1_16 vdout1_16ck94 = 1.0 time = 475
* CHECK dout1_17 vdout1_17ck94 = 0 time = 475
* CHECK dout1_18 vdout1_18ck94 = 0 time = 475
* CHECK dout1_19 vdout1_19ck94 = 1.0 time = 475
* CHECK dout1_20 vdout1_20ck94 = 0 time = 475
* CHECK dout1_21 vdout1_21ck94 = 0 time = 475
* CHECK dout1_22 vdout1_22ck94 = 0 time = 475
* CHECK dout1_23 vdout1_23ck94 = 1.0 time = 475
* CHECK dout1_24 vdout1_24ck94 = 0 time = 475
* CHECK dout1_25 vdout1_25ck94 = 0 time = 475
* CHECK dout1_26 vdout1_26ck94 = 0 time = 475
* CHECK dout1_27 vdout1_27ck94 = 0 time = 475
* CHECK dout1_28 vdout1_28ck94 = 1.0 time = 475
* CHECK dout1_29 vdout1_29ck94 = 0 time = 475
* CHECK dout1_30 vdout1_30ck94 = 1.0 time = 475
* CHECK dout1_31 vdout1_31ck94 = 0 time = 475
* CHECK dout1_32 vdout1_32ck94 = 1.0 time = 475
* CHECK dout1_33 vdout1_33ck94 = 1.0 time = 475
* CHECK dout1_34 vdout1_34ck94 = 0 time = 475
* CHECK dout1_35 vdout1_35ck94 = 1.0 time = 475
* CHECK dout1_36 vdout1_36ck94 = 1.0 time = 475
* CHECK dout1_37 vdout1_37ck94 = 1.0 time = 475
* CHECK dout1_38 vdout1_38ck94 = 1.0 time = 475
* CHECK dout1_39 vdout1_39ck94 = 1.0 time = 475
* CHECK dout1_40 vdout1_40ck94 = 1.0 time = 475
* CHECK dout1_41 vdout1_41ck94 = 1.0 time = 475
* CHECK dout1_42 vdout1_42ck94 = 0 time = 475
* CHECK dout1_43 vdout1_43ck94 = 0 time = 475
* CHECK dout1_44 vdout1_44ck94 = 1.0 time = 475
* CHECK dout1_45 vdout1_45ck94 = 1.0 time = 475
* CHECK dout1_46 vdout1_46ck94 = 0 time = 475
* CHECK dout1_47 vdout1_47ck94 = 0 time = 475
* CHECK dout1_48 vdout1_48ck94 = 1.0 time = 475
* CHECK dout1_49 vdout1_49ck94 = 0 time = 475
* CHECK dout1_50 vdout1_50ck94 = 1.0 time = 475
* CHECK dout1_51 vdout1_51ck94 = 1.0 time = 475
* CHECK dout1_52 vdout1_52ck94 = 0 time = 475
* CHECK dout1_53 vdout1_53ck94 = 1.0 time = 475
* CHECK dout1_54 vdout1_54ck94 = 1.0 time = 475
* CHECK dout1_55 vdout1_55ck94 = 1.0 time = 475
* CHECK dout1_56 vdout1_56ck94 = 0 time = 475
* CHECK dout1_57 vdout1_57ck94 = 1.0 time = 475
* CHECK dout1_58 vdout1_58ck94 = 1.0 time = 475
* CHECK dout1_59 vdout1_59ck94 = 0 time = 475
* CHECK dout1_60 vdout1_60ck94 = 0 time = 475
* CHECK dout1_61 vdout1_61ck94 = 1.0 time = 475
* CHECK dout1_62 vdout1_62ck94 = 1.0 time = 475
* CHECK dout1_63 vdout1_63ck94 = 1.0 time = 475
* CHECK dout0_0 vdout0_0ck95 = 0 time = 480
* CHECK dout0_1 vdout0_1ck95 = 1.0 time = 480
* CHECK dout0_2 vdout0_2ck95 = 0 time = 480
* CHECK dout0_3 vdout0_3ck95 = 0 time = 480
* CHECK dout0_4 vdout0_4ck95 = 0 time = 480
* CHECK dout0_5 vdout0_5ck95 = 1.0 time = 480
* CHECK dout0_6 vdout0_6ck95 = 0 time = 480
* CHECK dout0_7 vdout0_7ck95 = 0 time = 480
* CHECK dout0_8 vdout0_8ck95 = 0 time = 480
* CHECK dout0_9 vdout0_9ck95 = 0 time = 480
* CHECK dout0_10 vdout0_10ck95 = 1.0 time = 480
* CHECK dout0_11 vdout0_11ck95 = 1.0 time = 480
* CHECK dout0_12 vdout0_12ck95 = 1.0 time = 480
* CHECK dout0_13 vdout0_13ck95 = 0 time = 480
* CHECK dout0_14 vdout0_14ck95 = 1.0 time = 480
* CHECK dout0_15 vdout0_15ck95 = 0 time = 480
* CHECK dout0_16 vdout0_16ck95 = 1.0 time = 480
* CHECK dout0_17 vdout0_17ck95 = 0 time = 480
* CHECK dout0_18 vdout0_18ck95 = 0 time = 480
* CHECK dout0_19 vdout0_19ck95 = 1.0 time = 480
* CHECK dout0_20 vdout0_20ck95 = 0 time = 480
* CHECK dout0_21 vdout0_21ck95 = 0 time = 480
* CHECK dout0_22 vdout0_22ck95 = 0 time = 480
* CHECK dout0_23 vdout0_23ck95 = 1.0 time = 480
* CHECK dout0_24 vdout0_24ck95 = 0 time = 480
* CHECK dout0_25 vdout0_25ck95 = 0 time = 480
* CHECK dout0_26 vdout0_26ck95 = 1.0 time = 480
* CHECK dout0_27 vdout0_27ck95 = 0 time = 480
* CHECK dout0_28 vdout0_28ck95 = 0 time = 480
* CHECK dout0_29 vdout0_29ck95 = 1.0 time = 480
* CHECK dout0_30 vdout0_30ck95 = 1.0 time = 480
* CHECK dout0_31 vdout0_31ck95 = 0 time = 480
* CHECK dout0_32 vdout0_32ck95 = 0 time = 480
* CHECK dout0_33 vdout0_33ck95 = 1.0 time = 480
* CHECK dout0_34 vdout0_34ck95 = 0 time = 480
* CHECK dout0_35 vdout0_35ck95 = 0 time = 480
* CHECK dout0_36 vdout0_36ck95 = 0 time = 480
* CHECK dout0_37 vdout0_37ck95 = 1.0 time = 480
* CHECK dout0_38 vdout0_38ck95 = 1.0 time = 480
* CHECK dout0_39 vdout0_39ck95 = 1.0 time = 480
* CHECK dout0_40 vdout0_40ck95 = 1.0 time = 480
* CHECK dout0_41 vdout0_41ck95 = 0 time = 480
* CHECK dout0_42 vdout0_42ck95 = 1.0 time = 480
* CHECK dout0_43 vdout0_43ck95 = 1.0 time = 480
* CHECK dout0_44 vdout0_44ck95 = 1.0 time = 480
* CHECK dout0_45 vdout0_45ck95 = 1.0 time = 480
* CHECK dout0_46 vdout0_46ck95 = 0 time = 480
* CHECK dout0_47 vdout0_47ck95 = 0 time = 480
* CHECK dout0_48 vdout0_48ck95 = 0 time = 480
* CHECK dout0_49 vdout0_49ck95 = 1.0 time = 480
* CHECK dout0_50 vdout0_50ck95 = 1.0 time = 480
* CHECK dout0_51 vdout0_51ck95 = 0 time = 480
* CHECK dout0_52 vdout0_52ck95 = 1.0 time = 480
* CHECK dout0_53 vdout0_53ck95 = 0 time = 480
* CHECK dout0_54 vdout0_54ck95 = 0 time = 480
* CHECK dout0_55 vdout0_55ck95 = 1.0 time = 480
* CHECK dout0_56 vdout0_56ck95 = 0 time = 480
* CHECK dout0_57 vdout0_57ck95 = 0 time = 480
* CHECK dout0_58 vdout0_58ck95 = 1.0 time = 480
* CHECK dout0_59 vdout0_59ck95 = 1.0 time = 480
* CHECK dout0_60 vdout0_60ck95 = 1.0 time = 480
* CHECK dout0_61 vdout0_61ck95 = 1.0 time = 480
* CHECK dout0_62 vdout0_62ck95 = 0 time = 480
* CHECK dout0_63 vdout0_63ck95 = 1.0 time = 480
* CHECK dout1_0 vdout1_0ck95 = 0 time = 480
* CHECK dout1_1 vdout1_1ck95 = 0 time = 480
* CHECK dout1_2 vdout1_2ck95 = 1.0 time = 480
* CHECK dout1_3 vdout1_3ck95 = 1.0 time = 480
* CHECK dout1_4 vdout1_4ck95 = 0 time = 480
* CHECK dout1_5 vdout1_5ck95 = 1.0 time = 480
* CHECK dout1_6 vdout1_6ck95 = 0 time = 480
* CHECK dout1_7 vdout1_7ck95 = 0 time = 480
* CHECK dout1_8 vdout1_8ck95 = 0 time = 480
* CHECK dout1_9 vdout1_9ck95 = 1.0 time = 480
* CHECK dout1_10 vdout1_10ck95 = 1.0 time = 480
* CHECK dout1_11 vdout1_11ck95 = 0 time = 480
* CHECK dout1_12 vdout1_12ck95 = 1.0 time = 480
* CHECK dout1_13 vdout1_13ck95 = 1.0 time = 480
* CHECK dout1_14 vdout1_14ck95 = 1.0 time = 480
* CHECK dout1_15 vdout1_15ck95 = 0 time = 480
* CHECK dout1_16 vdout1_16ck95 = 0 time = 480
* CHECK dout1_17 vdout1_17ck95 = 0 time = 480
* CHECK dout1_18 vdout1_18ck95 = 0 time = 480
* CHECK dout1_19 vdout1_19ck95 = 0 time = 480
* CHECK dout1_20 vdout1_20ck95 = 1.0 time = 480
* CHECK dout1_21 vdout1_21ck95 = 1.0 time = 480
* CHECK dout1_22 vdout1_22ck95 = 1.0 time = 480
* CHECK dout1_23 vdout1_23ck95 = 0 time = 480
* CHECK dout1_24 vdout1_24ck95 = 0 time = 480
* CHECK dout1_25 vdout1_25ck95 = 1.0 time = 480
* CHECK dout1_26 vdout1_26ck95 = 0 time = 480
* CHECK dout1_27 vdout1_27ck95 = 0 time = 480
* CHECK dout1_28 vdout1_28ck95 = 1.0 time = 480
* CHECK dout1_29 vdout1_29ck95 = 0 time = 480
* CHECK dout1_30 vdout1_30ck95 = 0 time = 480
* CHECK dout1_31 vdout1_31ck95 = 0 time = 480
* CHECK dout1_32 vdout1_32ck95 = 0 time = 480
* CHECK dout1_33 vdout1_33ck95 = 0 time = 480
* CHECK dout1_34 vdout1_34ck95 = 0 time = 480
* CHECK dout1_35 vdout1_35ck95 = 0 time = 480
* CHECK dout1_36 vdout1_36ck95 = 0 time = 480
* CHECK dout1_37 vdout1_37ck95 = 1.0 time = 480
* CHECK dout1_38 vdout1_38ck95 = 0 time = 480
* CHECK dout1_39 vdout1_39ck95 = 0 time = 480
* CHECK dout1_40 vdout1_40ck95 = 1.0 time = 480
* CHECK dout1_41 vdout1_41ck95 = 0 time = 480
* CHECK dout1_42 vdout1_42ck95 = 1.0 time = 480
* CHECK dout1_43 vdout1_43ck95 = 0 time = 480
* CHECK dout1_44 vdout1_44ck95 = 1.0 time = 480
* CHECK dout1_45 vdout1_45ck95 = 0 time = 480
* CHECK dout1_46 vdout1_46ck95 = 1.0 time = 480
* CHECK dout1_47 vdout1_47ck95 = 0 time = 480
* CHECK dout1_48 vdout1_48ck95 = 1.0 time = 480
* CHECK dout1_49 vdout1_49ck95 = 1.0 time = 480
* CHECK dout1_50 vdout1_50ck95 = 1.0 time = 480
* CHECK dout1_51 vdout1_51ck95 = 1.0 time = 480
* CHECK dout1_52 vdout1_52ck95 = 1.0 time = 480
* CHECK dout1_53 vdout1_53ck95 = 0 time = 480
* CHECK dout1_54 vdout1_54ck95 = 0 time = 480
* CHECK dout1_55 vdout1_55ck95 = 0 time = 480
* CHECK dout1_56 vdout1_56ck95 = 1.0 time = 480
* CHECK dout1_57 vdout1_57ck95 = 0 time = 480
* CHECK dout1_58 vdout1_58ck95 = 1.0 time = 480
* CHECK dout1_59 vdout1_59ck95 = 1.0 time = 480
* CHECK dout1_60 vdout1_60ck95 = 1.0 time = 480
* CHECK dout1_61 vdout1_61ck95 = 0 time = 480
* CHECK dout1_62 vdout1_62ck95 = 0 time = 480
* CHECK dout1_63 vdout1_63ck95 = 0 time = 480
* CHECK dout0_0 vdout0_0ck96 = 1.0 time = 485
* CHECK dout0_1 vdout0_1ck96 = 1.0 time = 485
* CHECK dout0_2 vdout0_2ck96 = 1.0 time = 485
* CHECK dout0_3 vdout0_3ck96 = 0 time = 485
* CHECK dout0_4 vdout0_4ck96 = 0 time = 485
* CHECK dout0_5 vdout0_5ck96 = 0 time = 485
* CHECK dout0_6 vdout0_6ck96 = 1.0 time = 485
* CHECK dout0_7 vdout0_7ck96 = 0 time = 485
* CHECK dout0_8 vdout0_8ck96 = 1.0 time = 485
* CHECK dout0_9 vdout0_9ck96 = 0 time = 485
* CHECK dout0_10 vdout0_10ck96 = 1.0 time = 485
* CHECK dout0_11 vdout0_11ck96 = 1.0 time = 485
* CHECK dout0_12 vdout0_12ck96 = 0 time = 485
* CHECK dout0_13 vdout0_13ck96 = 0 time = 485
* CHECK dout0_14 vdout0_14ck96 = 0 time = 485
* CHECK dout0_15 vdout0_15ck96 = 0 time = 485
* CHECK dout0_16 vdout0_16ck96 = 1.0 time = 485
* CHECK dout0_17 vdout0_17ck96 = 1.0 time = 485
* CHECK dout0_18 vdout0_18ck96 = 1.0 time = 485
* CHECK dout0_19 vdout0_19ck96 = 1.0 time = 485
* CHECK dout0_20 vdout0_20ck96 = 1.0 time = 485
* CHECK dout0_21 vdout0_21ck96 = 1.0 time = 485
* CHECK dout0_22 vdout0_22ck96 = 0 time = 485
* CHECK dout0_23 vdout0_23ck96 = 1.0 time = 485
* CHECK dout0_24 vdout0_24ck96 = 1.0 time = 485
* CHECK dout0_25 vdout0_25ck96 = 1.0 time = 485
* CHECK dout0_26 vdout0_26ck96 = 0 time = 485
* CHECK dout0_27 vdout0_27ck96 = 1.0 time = 485
* CHECK dout0_28 vdout0_28ck96 = 0 time = 485
* CHECK dout0_29 vdout0_29ck96 = 0 time = 485
* CHECK dout0_30 vdout0_30ck96 = 0 time = 485
* CHECK dout0_31 vdout0_31ck96 = 0 time = 485
* CHECK dout0_32 vdout0_32ck96 = 1.0 time = 485
* CHECK dout0_33 vdout0_33ck96 = 0 time = 485
* CHECK dout0_34 vdout0_34ck96 = 1.0 time = 485
* CHECK dout0_35 vdout0_35ck96 = 0 time = 485
* CHECK dout0_36 vdout0_36ck96 = 0 time = 485
* CHECK dout0_37 vdout0_37ck96 = 1.0 time = 485
* CHECK dout0_38 vdout0_38ck96 = 0 time = 485
* CHECK dout0_39 vdout0_39ck96 = 0 time = 485
* CHECK dout0_40 vdout0_40ck96 = 0 time = 485
* CHECK dout0_41 vdout0_41ck96 = 0 time = 485
* CHECK dout0_42 vdout0_42ck96 = 0 time = 485
* CHECK dout0_43 vdout0_43ck96 = 0 time = 485
* CHECK dout0_44 vdout0_44ck96 = 0 time = 485
* CHECK dout0_45 vdout0_45ck96 = 1.0 time = 485
* CHECK dout0_46 vdout0_46ck96 = 1.0 time = 485
* CHECK dout0_47 vdout0_47ck96 = 1.0 time = 485
* CHECK dout0_48 vdout0_48ck96 = 0 time = 485
* CHECK dout0_49 vdout0_49ck96 = 0 time = 485
* CHECK dout0_50 vdout0_50ck96 = 0 time = 485
* CHECK dout0_51 vdout0_51ck96 = 0 time = 485
* CHECK dout0_52 vdout0_52ck96 = 1.0 time = 485
* CHECK dout0_53 vdout0_53ck96 = 0 time = 485
* CHECK dout0_54 vdout0_54ck96 = 0 time = 485
* CHECK dout0_55 vdout0_55ck96 = 0 time = 485
* CHECK dout0_56 vdout0_56ck96 = 1.0 time = 485
* CHECK dout0_57 vdout0_57ck96 = 0 time = 485
* CHECK dout0_58 vdout0_58ck96 = 1.0 time = 485
* CHECK dout0_59 vdout0_59ck96 = 1.0 time = 485
* CHECK dout0_60 vdout0_60ck96 = 1.0 time = 485
* CHECK dout0_61 vdout0_61ck96 = 1.0 time = 485
* CHECK dout0_62 vdout0_62ck96 = 0 time = 485
* CHECK dout0_63 vdout0_63ck96 = 1.0 time = 485
* CHECK dout1_0 vdout1_0ck98 = 1.0 time = 495
* CHECK dout1_1 vdout1_1ck98 = 1.0 time = 495
* CHECK dout1_2 vdout1_2ck98 = 1.0 time = 495
* CHECK dout1_3 vdout1_3ck98 = 0 time = 495
* CHECK dout1_4 vdout1_4ck98 = 0 time = 495
* CHECK dout1_5 vdout1_5ck98 = 0 time = 495
* CHECK dout1_6 vdout1_6ck98 = 1.0 time = 495
* CHECK dout1_7 vdout1_7ck98 = 0 time = 495
* CHECK dout1_8 vdout1_8ck98 = 1.0 time = 495
* CHECK dout1_9 vdout1_9ck98 = 0 time = 495
* CHECK dout1_10 vdout1_10ck98 = 1.0 time = 495
* CHECK dout1_11 vdout1_11ck98 = 1.0 time = 495
* CHECK dout1_12 vdout1_12ck98 = 0 time = 495
* CHECK dout1_13 vdout1_13ck98 = 0 time = 495
* CHECK dout1_14 vdout1_14ck98 = 0 time = 495
* CHECK dout1_15 vdout1_15ck98 = 0 time = 495
* CHECK dout1_16 vdout1_16ck98 = 1.0 time = 495
* CHECK dout1_17 vdout1_17ck98 = 1.0 time = 495
* CHECK dout1_18 vdout1_18ck98 = 1.0 time = 495
* CHECK dout1_19 vdout1_19ck98 = 1.0 time = 495
* CHECK dout1_20 vdout1_20ck98 = 1.0 time = 495
* CHECK dout1_21 vdout1_21ck98 = 1.0 time = 495
* CHECK dout1_22 vdout1_22ck98 = 0 time = 495
* CHECK dout1_23 vdout1_23ck98 = 1.0 time = 495
* CHECK dout1_24 vdout1_24ck98 = 1.0 time = 495
* CHECK dout1_25 vdout1_25ck98 = 1.0 time = 495
* CHECK dout1_26 vdout1_26ck98 = 0 time = 495
* CHECK dout1_27 vdout1_27ck98 = 1.0 time = 495
* CHECK dout1_28 vdout1_28ck98 = 0 time = 495
* CHECK dout1_29 vdout1_29ck98 = 0 time = 495
* CHECK dout1_30 vdout1_30ck98 = 0 time = 495
* CHECK dout1_31 vdout1_31ck98 = 0 time = 495
* CHECK dout1_32 vdout1_32ck98 = 1.0 time = 495
* CHECK dout1_33 vdout1_33ck98 = 0 time = 495
* CHECK dout1_34 vdout1_34ck98 = 1.0 time = 495
* CHECK dout1_35 vdout1_35ck98 = 0 time = 495
* CHECK dout1_36 vdout1_36ck98 = 0 time = 495
* CHECK dout1_37 vdout1_37ck98 = 1.0 time = 495
* CHECK dout1_38 vdout1_38ck98 = 0 time = 495
* CHECK dout1_39 vdout1_39ck98 = 0 time = 495
* CHECK dout1_40 vdout1_40ck98 = 0 time = 495
* CHECK dout1_41 vdout1_41ck98 = 0 time = 495
* CHECK dout1_42 vdout1_42ck98 = 0 time = 495
* CHECK dout1_43 vdout1_43ck98 = 0 time = 495
* CHECK dout1_44 vdout1_44ck98 = 0 time = 495
* CHECK dout1_45 vdout1_45ck98 = 1.0 time = 495
* CHECK dout1_46 vdout1_46ck98 = 1.0 time = 495
* CHECK dout1_47 vdout1_47ck98 = 1.0 time = 495
* CHECK dout1_48 vdout1_48ck98 = 0 time = 495
* CHECK dout1_49 vdout1_49ck98 = 0 time = 495
* CHECK dout1_50 vdout1_50ck98 = 0 time = 495
* CHECK dout1_51 vdout1_51ck98 = 0 time = 495
* CHECK dout1_52 vdout1_52ck98 = 1.0 time = 495
* CHECK dout1_53 vdout1_53ck98 = 0 time = 495
* CHECK dout1_54 vdout1_54ck98 = 0 time = 495
* CHECK dout1_55 vdout1_55ck98 = 0 time = 495
* CHECK dout1_56 vdout1_56ck98 = 1.0 time = 495
* CHECK dout1_57 vdout1_57ck98 = 0 time = 495
* CHECK dout1_58 vdout1_58ck98 = 1.0 time = 495
* CHECK dout1_59 vdout1_59ck98 = 1.0 time = 495
* CHECK dout1_60 vdout1_60ck98 = 1.0 time = 495
* CHECK dout1_61 vdout1_61ck98 = 1.0 time = 495
* CHECK dout1_62 vdout1_62ck98 = 0 time = 495
* CHECK dout1_63 vdout1_63ck98 = 1.0 time = 495
* CHECK dout0_0 vdout0_0ck99 = 1.0 time = 500
* CHECK dout0_1 vdout0_1ck99 = 1.0 time = 500
* CHECK dout0_2 vdout0_2ck99 = 1.0 time = 500
* CHECK dout0_3 vdout0_3ck99 = 0 time = 500
* CHECK dout0_4 vdout0_4ck99 = 0 time = 500
* CHECK dout0_5 vdout0_5ck99 = 0 time = 500
* CHECK dout0_6 vdout0_6ck99 = 1.0 time = 500
* CHECK dout0_7 vdout0_7ck99 = 0 time = 500
* CHECK dout0_8 vdout0_8ck99 = 1.0 time = 500
* CHECK dout0_9 vdout0_9ck99 = 0 time = 500
* CHECK dout0_10 vdout0_10ck99 = 1.0 time = 500
* CHECK dout0_11 vdout0_11ck99 = 1.0 time = 500
* CHECK dout0_12 vdout0_12ck99 = 0 time = 500
* CHECK dout0_13 vdout0_13ck99 = 0 time = 500
* CHECK dout0_14 vdout0_14ck99 = 0 time = 500
* CHECK dout0_15 vdout0_15ck99 = 0 time = 500
* CHECK dout0_16 vdout0_16ck99 = 1.0 time = 500
* CHECK dout0_17 vdout0_17ck99 = 1.0 time = 500
* CHECK dout0_18 vdout0_18ck99 = 1.0 time = 500
* CHECK dout0_19 vdout0_19ck99 = 1.0 time = 500
* CHECK dout0_20 vdout0_20ck99 = 1.0 time = 500
* CHECK dout0_21 vdout0_21ck99 = 1.0 time = 500
* CHECK dout0_22 vdout0_22ck99 = 0 time = 500
* CHECK dout0_23 vdout0_23ck99 = 1.0 time = 500
* CHECK dout0_24 vdout0_24ck99 = 1.0 time = 500
* CHECK dout0_25 vdout0_25ck99 = 1.0 time = 500
* CHECK dout0_26 vdout0_26ck99 = 0 time = 500
* CHECK dout0_27 vdout0_27ck99 = 1.0 time = 500
* CHECK dout0_28 vdout0_28ck99 = 0 time = 500
* CHECK dout0_29 vdout0_29ck99 = 0 time = 500
* CHECK dout0_30 vdout0_30ck99 = 0 time = 500
* CHECK dout0_31 vdout0_31ck99 = 0 time = 500
* CHECK dout0_32 vdout0_32ck99 = 1.0 time = 500
* CHECK dout0_33 vdout0_33ck99 = 0 time = 500
* CHECK dout0_34 vdout0_34ck99 = 1.0 time = 500
* CHECK dout0_35 vdout0_35ck99 = 0 time = 500
* CHECK dout0_36 vdout0_36ck99 = 0 time = 500
* CHECK dout0_37 vdout0_37ck99 = 1.0 time = 500
* CHECK dout0_38 vdout0_38ck99 = 0 time = 500
* CHECK dout0_39 vdout0_39ck99 = 0 time = 500
* CHECK dout0_40 vdout0_40ck99 = 0 time = 500
* CHECK dout0_41 vdout0_41ck99 = 0 time = 500
* CHECK dout0_42 vdout0_42ck99 = 0 time = 500
* CHECK dout0_43 vdout0_43ck99 = 0 time = 500
* CHECK dout0_44 vdout0_44ck99 = 0 time = 500
* CHECK dout0_45 vdout0_45ck99 = 1.0 time = 500
* CHECK dout0_46 vdout0_46ck99 = 1.0 time = 500
* CHECK dout0_47 vdout0_47ck99 = 1.0 time = 500
* CHECK dout0_48 vdout0_48ck99 = 0 time = 500
* CHECK dout0_49 vdout0_49ck99 = 0 time = 500
* CHECK dout0_50 vdout0_50ck99 = 0 time = 500
* CHECK dout0_51 vdout0_51ck99 = 0 time = 500
* CHECK dout0_52 vdout0_52ck99 = 1.0 time = 500
* CHECK dout0_53 vdout0_53ck99 = 0 time = 500
* CHECK dout0_54 vdout0_54ck99 = 0 time = 500
* CHECK dout0_55 vdout0_55ck99 = 0 time = 500
* CHECK dout0_56 vdout0_56ck99 = 1.0 time = 500
* CHECK dout0_57 vdout0_57ck99 = 0 time = 500
* CHECK dout0_58 vdout0_58ck99 = 1.0 time = 500
* CHECK dout0_59 vdout0_59ck99 = 1.0 time = 500
* CHECK dout0_60 vdout0_60ck99 = 1.0 time = 500
* CHECK dout0_61 vdout0_61ck99 = 1.0 time = 500
* CHECK dout0_62 vdout0_62ck99 = 0 time = 500
* CHECK dout0_63 vdout0_63ck99 = 1.0 time = 500
* CHECK dout1_0 vdout1_0ck99 = 1.0 time = 500
* CHECK dout1_1 vdout1_1ck99 = 1.0 time = 500
* CHECK dout1_2 vdout1_2ck99 = 1.0 time = 500
* CHECK dout1_3 vdout1_3ck99 = 0 time = 500
* CHECK dout1_4 vdout1_4ck99 = 0 time = 500
* CHECK dout1_5 vdout1_5ck99 = 0 time = 500
* CHECK dout1_6 vdout1_6ck99 = 1.0 time = 500
* CHECK dout1_7 vdout1_7ck99 = 1.0 time = 500
* CHECK dout1_8 vdout1_8ck99 = 0 time = 500
* CHECK dout1_9 vdout1_9ck99 = 0 time = 500
* CHECK dout1_10 vdout1_10ck99 = 0 time = 500
* CHECK dout1_11 vdout1_11ck99 = 0 time = 500
* CHECK dout1_12 vdout1_12ck99 = 1.0 time = 500
* CHECK dout1_13 vdout1_13ck99 = 1.0 time = 500
* CHECK dout1_14 vdout1_14ck99 = 1.0 time = 500
* CHECK dout1_15 vdout1_15ck99 = 0 time = 500
* CHECK dout1_16 vdout1_16ck99 = 0 time = 500
* CHECK dout1_17 vdout1_17ck99 = 1.0 time = 500
* CHECK dout1_18 vdout1_18ck99 = 1.0 time = 500
* CHECK dout1_19 vdout1_19ck99 = 1.0 time = 500
* CHECK dout1_20 vdout1_20ck99 = 1.0 time = 500
* CHECK dout1_21 vdout1_21ck99 = 1.0 time = 500
* CHECK dout1_22 vdout1_22ck99 = 1.0 time = 500
* CHECK dout1_23 vdout1_23ck99 = 0 time = 500
* CHECK dout1_24 vdout1_24ck99 = 1.0 time = 500
* CHECK dout1_25 vdout1_25ck99 = 1.0 time = 500
* CHECK dout1_26 vdout1_26ck99 = 1.0 time = 500
* CHECK dout1_27 vdout1_27ck99 = 1.0 time = 500
* CHECK dout1_28 vdout1_28ck99 = 0 time = 500
* CHECK dout1_29 vdout1_29ck99 = 1.0 time = 500
* CHECK dout1_30 vdout1_30ck99 = 1.0 time = 500
* CHECK dout1_31 vdout1_31ck99 = 0 time = 500
* CHECK dout1_32 vdout1_32ck99 = 0 time = 500
* CHECK dout1_33 vdout1_33ck99 = 0 time = 500
* CHECK dout1_34 vdout1_34ck99 = 0 time = 500
* CHECK dout1_35 vdout1_35ck99 = 1.0 time = 500
* CHECK dout1_36 vdout1_36ck99 = 0 time = 500
* CHECK dout1_37 vdout1_37ck99 = 1.0 time = 500
* CHECK dout1_38 vdout1_38ck99 = 1.0 time = 500
* CHECK dout1_39 vdout1_39ck99 = 1.0 time = 500
* CHECK dout1_40 vdout1_40ck99 = 1.0 time = 500
* CHECK dout1_41 vdout1_41ck99 = 0 time = 500
* CHECK dout1_42 vdout1_42ck99 = 0 time = 500
* CHECK dout1_43 vdout1_43ck99 = 0 time = 500
* CHECK dout1_44 vdout1_44ck99 = 0 time = 500
* CHECK dout1_45 vdout1_45ck99 = 1.0 time = 500
* CHECK dout1_46 vdout1_46ck99 = 1.0 time = 500
* CHECK dout1_47 vdout1_47ck99 = 0 time = 500
* CHECK dout1_48 vdout1_48ck99 = 1.0 time = 500
* CHECK dout1_49 vdout1_49ck99 = 1.0 time = 500
* CHECK dout1_50 vdout1_50ck99 = 1.0 time = 500
* CHECK dout1_51 vdout1_51ck99 = 1.0 time = 500
* CHECK dout1_52 vdout1_52ck99 = 0 time = 500
* CHECK dout1_53 vdout1_53ck99 = 0 time = 500
* CHECK dout1_54 vdout1_54ck99 = 0 time = 500
* CHECK dout1_55 vdout1_55ck99 = 1.0 time = 500
* CHECK dout1_56 vdout1_56ck99 = 0 time = 500
* CHECK dout1_57 vdout1_57ck99 = 0 time = 500
* CHECK dout1_58 vdout1_58ck99 = 1.0 time = 500
* CHECK dout1_59 vdout1_59ck99 = 1.0 time = 500
* CHECK dout1_60 vdout1_60ck99 = 1.0 time = 500
* CHECK dout1_61 vdout1_61ck99 = 0 time = 500
* CHECK dout1_62 vdout1_62ck99 = 1.0 time = 500
* CHECK dout1_63 vdout1_63ck99 = 0 time = 500
* CHECK dout1_0 vdout1_0ck100 = 1.0 time = 505
* CHECK dout1_1 vdout1_1ck100 = 0 time = 505
* CHECK dout1_2 vdout1_2ck100 = 1.0 time = 505
* CHECK dout1_3 vdout1_3ck100 = 1.0 time = 505
* CHECK dout1_4 vdout1_4ck100 = 1.0 time = 505
* CHECK dout1_5 vdout1_5ck100 = 1.0 time = 505
* CHECK dout1_6 vdout1_6ck100 = 1.0 time = 505
* CHECK dout1_7 vdout1_7ck100 = 1.0 time = 505
* CHECK dout1_8 vdout1_8ck100 = 0 time = 505
* CHECK dout1_9 vdout1_9ck100 = 1.0 time = 505
* CHECK dout1_10 vdout1_10ck100 = 1.0 time = 505
* CHECK dout1_11 vdout1_11ck100 = 1.0 time = 505
* CHECK dout1_12 vdout1_12ck100 = 1.0 time = 505
* CHECK dout1_13 vdout1_13ck100 = 0 time = 505
* CHECK dout1_14 vdout1_14ck100 = 0 time = 505
* CHECK dout1_15 vdout1_15ck100 = 1.0 time = 505
* CHECK dout1_16 vdout1_16ck100 = 0 time = 505
* CHECK dout1_17 vdout1_17ck100 = 0 time = 505
* CHECK dout1_18 vdout1_18ck100 = 0 time = 505
* CHECK dout1_19 vdout1_19ck100 = 0 time = 505
* CHECK dout1_20 vdout1_20ck100 = 0 time = 505
* CHECK dout1_21 vdout1_21ck100 = 0 time = 505
* CHECK dout1_22 vdout1_22ck100 = 1.0 time = 505
* CHECK dout1_23 vdout1_23ck100 = 1.0 time = 505
* CHECK dout1_24 vdout1_24ck100 = 1.0 time = 505
* CHECK dout1_25 vdout1_25ck100 = 1.0 time = 505
* CHECK dout1_26 vdout1_26ck100 = 0 time = 505
* CHECK dout1_27 vdout1_27ck100 = 1.0 time = 505
* CHECK dout1_28 vdout1_28ck100 = 0 time = 505
* CHECK dout1_29 vdout1_29ck100 = 1.0 time = 505
* CHECK dout1_30 vdout1_30ck100 = 0 time = 505
* CHECK dout1_31 vdout1_31ck100 = 1.0 time = 505
* CHECK dout1_32 vdout1_32ck100 = 1.0 time = 505
* CHECK dout1_33 vdout1_33ck100 = 0 time = 505
* CHECK dout1_34 vdout1_34ck100 = 0 time = 505
* CHECK dout1_35 vdout1_35ck100 = 0 time = 505
* CHECK dout1_36 vdout1_36ck100 = 1.0 time = 505
* CHECK dout1_37 vdout1_37ck100 = 0 time = 505
* CHECK dout1_38 vdout1_38ck100 = 0 time = 505
* CHECK dout1_39 vdout1_39ck100 = 1.0 time = 505
* CHECK dout1_40 vdout1_40ck100 = 1.0 time = 505
* CHECK dout1_41 vdout1_41ck100 = 0 time = 505
* CHECK dout1_42 vdout1_42ck100 = 1.0 time = 505
* CHECK dout1_43 vdout1_43ck100 = 0 time = 505
* CHECK dout1_44 vdout1_44ck100 = 1.0 time = 505
* CHECK dout1_45 vdout1_45ck100 = 0 time = 505
* CHECK dout1_46 vdout1_46ck100 = 0 time = 505
* CHECK dout1_47 vdout1_47ck100 = 1.0 time = 505
* CHECK dout1_48 vdout1_48ck100 = 0 time = 505
* CHECK dout1_49 vdout1_49ck100 = 0 time = 505
* CHECK dout1_50 vdout1_50ck100 = 1.0 time = 505
* CHECK dout1_51 vdout1_51ck100 = 1.0 time = 505
* CHECK dout1_52 vdout1_52ck100 = 1.0 time = 505
* CHECK dout1_53 vdout1_53ck100 = 0 time = 505
* CHECK dout1_54 vdout1_54ck100 = 0 time = 505
* CHECK dout1_55 vdout1_55ck100 = 1.0 time = 505
* CHECK dout1_56 vdout1_56ck100 = 1.0 time = 505
* CHECK dout1_57 vdout1_57ck100 = 1.0 time = 505
* CHECK dout1_58 vdout1_58ck100 = 1.0 time = 505
* CHECK dout1_59 vdout1_59ck100 = 1.0 time = 505
* CHECK dout1_60 vdout1_60ck100 = 1.0 time = 505
* CHECK dout1_61 vdout1_61ck100 = 1.0 time = 505
* CHECK dout1_62 vdout1_62ck100 = 1.0 time = 505
* CHECK dout1_63 vdout1_63ck100 = 0 time = 505
* CHECK dout0_0 vdout0_0ck101 = 0 time = 510
* CHECK dout0_1 vdout0_1ck101 = 1.0 time = 510
* CHECK dout0_2 vdout0_2ck101 = 0 time = 510
* CHECK dout0_3 vdout0_3ck101 = 0 time = 510
* CHECK dout0_4 vdout0_4ck101 = 0 time = 510
* CHECK dout0_5 vdout0_5ck101 = 1.0 time = 510
* CHECK dout0_6 vdout0_6ck101 = 0 time = 510
* CHECK dout0_7 vdout0_7ck101 = 0 time = 510
* CHECK dout0_8 vdout0_8ck101 = 0 time = 510
* CHECK dout0_9 vdout0_9ck101 = 0 time = 510
* CHECK dout0_10 vdout0_10ck101 = 1.0 time = 510
* CHECK dout0_11 vdout0_11ck101 = 1.0 time = 510
* CHECK dout0_12 vdout0_12ck101 = 1.0 time = 510
* CHECK dout0_13 vdout0_13ck101 = 0 time = 510
* CHECK dout0_14 vdout0_14ck101 = 1.0 time = 510
* CHECK dout0_15 vdout0_15ck101 = 0 time = 510
* CHECK dout0_16 vdout0_16ck101 = 1.0 time = 510
* CHECK dout0_17 vdout0_17ck101 = 0 time = 510
* CHECK dout0_18 vdout0_18ck101 = 0 time = 510
* CHECK dout0_19 vdout0_19ck101 = 1.0 time = 510
* CHECK dout0_20 vdout0_20ck101 = 0 time = 510
* CHECK dout0_21 vdout0_21ck101 = 0 time = 510
* CHECK dout0_22 vdout0_22ck101 = 0 time = 510
* CHECK dout0_23 vdout0_23ck101 = 1.0 time = 510
* CHECK dout0_24 vdout0_24ck101 = 0 time = 510
* CHECK dout0_25 vdout0_25ck101 = 0 time = 510
* CHECK dout0_26 vdout0_26ck101 = 1.0 time = 510
* CHECK dout0_27 vdout0_27ck101 = 0 time = 510
* CHECK dout0_28 vdout0_28ck101 = 0 time = 510
* CHECK dout0_29 vdout0_29ck101 = 1.0 time = 510
* CHECK dout0_30 vdout0_30ck101 = 1.0 time = 510
* CHECK dout0_31 vdout0_31ck101 = 0 time = 510
* CHECK dout0_32 vdout0_32ck101 = 0 time = 510
* CHECK dout0_33 vdout0_33ck101 = 1.0 time = 510
* CHECK dout0_34 vdout0_34ck101 = 0 time = 510
* CHECK dout0_35 vdout0_35ck101 = 0 time = 510
* CHECK dout0_36 vdout0_36ck101 = 0 time = 510
* CHECK dout0_37 vdout0_37ck101 = 1.0 time = 510
* CHECK dout0_38 vdout0_38ck101 = 1.0 time = 510
* CHECK dout0_39 vdout0_39ck101 = 1.0 time = 510
* CHECK dout0_40 vdout0_40ck101 = 1.0 time = 510
* CHECK dout0_41 vdout0_41ck101 = 0 time = 510
* CHECK dout0_42 vdout0_42ck101 = 1.0 time = 510
* CHECK dout0_43 vdout0_43ck101 = 1.0 time = 510
* CHECK dout0_44 vdout0_44ck101 = 1.0 time = 510
* CHECK dout0_45 vdout0_45ck101 = 1.0 time = 510
* CHECK dout0_46 vdout0_46ck101 = 0 time = 510
* CHECK dout0_47 vdout0_47ck101 = 0 time = 510
* CHECK dout0_48 vdout0_48ck101 = 0 time = 510
* CHECK dout0_49 vdout0_49ck101 = 1.0 time = 510
* CHECK dout0_50 vdout0_50ck101 = 1.0 time = 510
* CHECK dout0_51 vdout0_51ck101 = 0 time = 510
* CHECK dout0_52 vdout0_52ck101 = 1.0 time = 510
* CHECK dout0_53 vdout0_53ck101 = 0 time = 510
* CHECK dout0_54 vdout0_54ck101 = 0 time = 510
* CHECK dout0_55 vdout0_55ck101 = 1.0 time = 510
* CHECK dout0_56 vdout0_56ck101 = 0 time = 510
* CHECK dout0_57 vdout0_57ck101 = 0 time = 510
* CHECK dout0_58 vdout0_58ck101 = 1.0 time = 510
* CHECK dout0_59 vdout0_59ck101 = 1.0 time = 510
* CHECK dout0_60 vdout0_60ck101 = 1.0 time = 510
* CHECK dout0_61 vdout0_61ck101 = 1.0 time = 510
* CHECK dout0_62 vdout0_62ck101 = 0 time = 510
* CHECK dout0_63 vdout0_63ck101 = 1.0 time = 510
* CHECK dout1_0 vdout1_0ck102 = 0 time = 515
* CHECK dout1_1 vdout1_1ck102 = 1.0 time = 515
* CHECK dout1_2 vdout1_2ck102 = 0 time = 515
* CHECK dout1_3 vdout1_3ck102 = 0 time = 515
* CHECK dout1_4 vdout1_4ck102 = 0 time = 515
* CHECK dout1_5 vdout1_5ck102 = 1.0 time = 515
* CHECK dout1_6 vdout1_6ck102 = 0 time = 515
* CHECK dout1_7 vdout1_7ck102 = 0 time = 515
* CHECK dout1_8 vdout1_8ck102 = 0 time = 515
* CHECK dout1_9 vdout1_9ck102 = 0 time = 515
* CHECK dout1_10 vdout1_10ck102 = 1.0 time = 515
* CHECK dout1_11 vdout1_11ck102 = 1.0 time = 515
* CHECK dout1_12 vdout1_12ck102 = 1.0 time = 515
* CHECK dout1_13 vdout1_13ck102 = 0 time = 515
* CHECK dout1_14 vdout1_14ck102 = 1.0 time = 515
* CHECK dout1_15 vdout1_15ck102 = 0 time = 515
* CHECK dout1_16 vdout1_16ck102 = 1.0 time = 515
* CHECK dout1_17 vdout1_17ck102 = 0 time = 515
* CHECK dout1_18 vdout1_18ck102 = 0 time = 515
* CHECK dout1_19 vdout1_19ck102 = 1.0 time = 515
* CHECK dout1_20 vdout1_20ck102 = 0 time = 515
* CHECK dout1_21 vdout1_21ck102 = 0 time = 515
* CHECK dout1_22 vdout1_22ck102 = 0 time = 515
* CHECK dout1_23 vdout1_23ck102 = 1.0 time = 515
* CHECK dout1_24 vdout1_24ck102 = 0 time = 515
* CHECK dout1_25 vdout1_25ck102 = 0 time = 515
* CHECK dout1_26 vdout1_26ck102 = 1.0 time = 515
* CHECK dout1_27 vdout1_27ck102 = 0 time = 515
* CHECK dout1_28 vdout1_28ck102 = 0 time = 515
* CHECK dout1_29 vdout1_29ck102 = 1.0 time = 515
* CHECK dout1_30 vdout1_30ck102 = 1.0 time = 515
* CHECK dout1_31 vdout1_31ck102 = 0 time = 515
* CHECK dout1_32 vdout1_32ck102 = 0 time = 515
* CHECK dout1_33 vdout1_33ck102 = 1.0 time = 515
* CHECK dout1_34 vdout1_34ck102 = 0 time = 515
* CHECK dout1_35 vdout1_35ck102 = 0 time = 515
* CHECK dout1_36 vdout1_36ck102 = 0 time = 515
* CHECK dout1_37 vdout1_37ck102 = 1.0 time = 515
* CHECK dout1_38 vdout1_38ck102 = 1.0 time = 515
* CHECK dout1_39 vdout1_39ck102 = 1.0 time = 515
* CHECK dout1_40 vdout1_40ck102 = 1.0 time = 515
* CHECK dout1_41 vdout1_41ck102 = 0 time = 515
* CHECK dout1_42 vdout1_42ck102 = 1.0 time = 515
* CHECK dout1_43 vdout1_43ck102 = 1.0 time = 515
* CHECK dout1_44 vdout1_44ck102 = 1.0 time = 515
* CHECK dout1_45 vdout1_45ck102 = 1.0 time = 515
* CHECK dout1_46 vdout1_46ck102 = 0 time = 515
* CHECK dout1_47 vdout1_47ck102 = 0 time = 515
* CHECK dout1_48 vdout1_48ck102 = 0 time = 515
* CHECK dout1_49 vdout1_49ck102 = 1.0 time = 515
* CHECK dout1_50 vdout1_50ck102 = 1.0 time = 515
* CHECK dout1_51 vdout1_51ck102 = 0 time = 515
* CHECK dout1_52 vdout1_52ck102 = 1.0 time = 515
* CHECK dout1_53 vdout1_53ck102 = 0 time = 515
* CHECK dout1_54 vdout1_54ck102 = 0 time = 515
* CHECK dout1_55 vdout1_55ck102 = 1.0 time = 515
* CHECK dout1_56 vdout1_56ck102 = 0 time = 515
* CHECK dout1_57 vdout1_57ck102 = 0 time = 515
* CHECK dout1_58 vdout1_58ck102 = 1.0 time = 515
* CHECK dout1_59 vdout1_59ck102 = 1.0 time = 515
* CHECK dout1_60 vdout1_60ck102 = 1.0 time = 515
* CHECK dout1_61 vdout1_61ck102 = 1.0 time = 515
* CHECK dout1_62 vdout1_62ck102 = 0 time = 515
* CHECK dout1_63 vdout1_63ck102 = 1.0 time = 515
* CHECK dout1_0 vdout1_0ck103 = 1.0 time = 520
* CHECK dout1_1 vdout1_1ck103 = 0 time = 520
* CHECK dout1_2 vdout1_2ck103 = 0 time = 520
* CHECK dout1_3 vdout1_3ck103 = 0 time = 520
* CHECK dout1_4 vdout1_4ck103 = 0 time = 520
* CHECK dout1_5 vdout1_5ck103 = 1.0 time = 520
* CHECK dout1_6 vdout1_6ck103 = 0 time = 520
* CHECK dout1_7 vdout1_7ck103 = 0 time = 520
* CHECK dout1_8 vdout1_8ck103 = 1.0 time = 520
* CHECK dout1_9 vdout1_9ck103 = 1.0 time = 520
* CHECK dout1_10 vdout1_10ck103 = 1.0 time = 520
* CHECK dout1_11 vdout1_11ck103 = 1.0 time = 520
* CHECK dout1_12 vdout1_12ck103 = 1.0 time = 520
* CHECK dout1_13 vdout1_13ck103 = 1.0 time = 520
* CHECK dout1_14 vdout1_14ck103 = 1.0 time = 520
* CHECK dout1_15 vdout1_15ck103 = 0 time = 520
* CHECK dout1_16 vdout1_16ck103 = 0 time = 520
* CHECK dout1_17 vdout1_17ck103 = 0 time = 520
* CHECK dout1_18 vdout1_18ck103 = 1.0 time = 520
* CHECK dout1_19 vdout1_19ck103 = 0 time = 520
* CHECK dout1_20 vdout1_20ck103 = 1.0 time = 520
* CHECK dout1_21 vdout1_21ck103 = 1.0 time = 520
* CHECK dout1_22 vdout1_22ck103 = 1.0 time = 520
* CHECK dout1_23 vdout1_23ck103 = 1.0 time = 520
* CHECK dout1_24 vdout1_24ck103 = 1.0 time = 520
* CHECK dout1_25 vdout1_25ck103 = 1.0 time = 520
* CHECK dout1_26 vdout1_26ck103 = 0 time = 520
* CHECK dout1_27 vdout1_27ck103 = 0 time = 520
* CHECK dout1_28 vdout1_28ck103 = 0 time = 520
* CHECK dout1_29 vdout1_29ck103 = 1.0 time = 520
* CHECK dout1_30 vdout1_30ck103 = 1.0 time = 520
* CHECK dout1_31 vdout1_31ck103 = 0 time = 520
* CHECK dout1_32 vdout1_32ck103 = 0 time = 520
* CHECK dout1_33 vdout1_33ck103 = 1.0 time = 520
* CHECK dout1_34 vdout1_34ck103 = 1.0 time = 520
* CHECK dout1_35 vdout1_35ck103 = 1.0 time = 520
* CHECK dout1_36 vdout1_36ck103 = 1.0 time = 520
* CHECK dout1_37 vdout1_37ck103 = 1.0 time = 520
* CHECK dout1_38 vdout1_38ck103 = 0 time = 520
* CHECK dout1_39 vdout1_39ck103 = 1.0 time = 520
* CHECK dout1_40 vdout1_40ck103 = 1.0 time = 520
* CHECK dout1_41 vdout1_41ck103 = 0 time = 520
* CHECK dout1_42 vdout1_42ck103 = 0 time = 520
* CHECK dout1_43 vdout1_43ck103 = 1.0 time = 520
* CHECK dout1_44 vdout1_44ck103 = 0 time = 520
* CHECK dout1_45 vdout1_45ck103 = 0 time = 520
* CHECK dout1_46 vdout1_46ck103 = 0 time = 520
* CHECK dout1_47 vdout1_47ck103 = 1.0 time = 520
* CHECK dout1_48 vdout1_48ck103 = 1.0 time = 520
* CHECK dout1_49 vdout1_49ck103 = 0 time = 520
* CHECK dout1_50 vdout1_50ck103 = 0 time = 520
* CHECK dout1_51 vdout1_51ck103 = 0 time = 520
* CHECK dout1_52 vdout1_52ck103 = 0 time = 520
* CHECK dout1_53 vdout1_53ck103 = 0 time = 520
* CHECK dout1_54 vdout1_54ck103 = 0 time = 520
* CHECK dout1_55 vdout1_55ck103 = 0 time = 520
* CHECK dout1_56 vdout1_56ck103 = 0 time = 520
* CHECK dout1_57 vdout1_57ck103 = 0 time = 520
* CHECK dout1_58 vdout1_58ck103 = 1.0 time = 520
* CHECK dout1_59 vdout1_59ck103 = 0 time = 520
* CHECK dout1_60 vdout1_60ck103 = 1.0 time = 520
* CHECK dout1_61 vdout1_61ck103 = 0 time = 520
* CHECK dout1_62 vdout1_62ck103 = 0 time = 520
* CHECK dout1_63 vdout1_63ck103 = 1.0 time = 520
* CHECK dout0_0 vdout0_0ck104 = 0 time = 525
* CHECK dout0_1 vdout0_1ck104 = 1.0 time = 525
* CHECK dout0_2 vdout0_2ck104 = 0 time = 525
* CHECK dout0_3 vdout0_3ck104 = 1.0 time = 525
* CHECK dout0_4 vdout0_4ck104 = 0 time = 525
* CHECK dout0_5 vdout0_5ck104 = 0 time = 525
* CHECK dout0_6 vdout0_6ck104 = 1.0 time = 525
* CHECK dout0_7 vdout0_7ck104 = 0 time = 525
* CHECK dout0_8 vdout0_8ck104 = 1.0 time = 525
* CHECK dout0_9 vdout0_9ck104 = 1.0 time = 525
* CHECK dout0_10 vdout0_10ck104 = 1.0 time = 525
* CHECK dout0_11 vdout0_11ck104 = 0 time = 525
* CHECK dout0_12 vdout0_12ck104 = 1.0 time = 525
* CHECK dout0_13 vdout0_13ck104 = 1.0 time = 525
* CHECK dout0_14 vdout0_14ck104 = 0 time = 525
* CHECK dout0_15 vdout0_15ck104 = 1.0 time = 525
* CHECK dout0_16 vdout0_16ck104 = 1.0 time = 525
* CHECK dout0_17 vdout0_17ck104 = 1.0 time = 525
* CHECK dout0_18 vdout0_18ck104 = 1.0 time = 525
* CHECK dout0_19 vdout0_19ck104 = 1.0 time = 525
* CHECK dout0_20 vdout0_20ck104 = 1.0 time = 525
* CHECK dout0_21 vdout0_21ck104 = 0 time = 525
* CHECK dout0_22 vdout0_22ck104 = 0 time = 525
* CHECK dout0_23 vdout0_23ck104 = 1.0 time = 525
* CHECK dout0_24 vdout0_24ck104 = 0 time = 525
* CHECK dout0_25 vdout0_25ck104 = 0 time = 525
* CHECK dout0_26 vdout0_26ck104 = 1.0 time = 525
* CHECK dout0_27 vdout0_27ck104 = 0 time = 525
* CHECK dout0_28 vdout0_28ck104 = 0 time = 525
* CHECK dout0_29 vdout0_29ck104 = 0 time = 525
* CHECK dout0_30 vdout0_30ck104 = 0 time = 525
* CHECK dout0_31 vdout0_31ck104 = 0 time = 525
* CHECK dout0_32 vdout0_32ck104 = 1.0 time = 525
* CHECK dout0_33 vdout0_33ck104 = 1.0 time = 525
* CHECK dout0_34 vdout0_34ck104 = 0 time = 525
* CHECK dout0_35 vdout0_35ck104 = 0 time = 525
* CHECK dout0_36 vdout0_36ck104 = 1.0 time = 525
* CHECK dout0_37 vdout0_37ck104 = 1.0 time = 525
* CHECK dout0_38 vdout0_38ck104 = 1.0 time = 525
* CHECK dout0_39 vdout0_39ck104 = 0 time = 525
* CHECK dout0_40 vdout0_40ck104 = 1.0 time = 525
* CHECK dout0_41 vdout0_41ck104 = 0 time = 525
* CHECK dout0_42 vdout0_42ck104 = 0 time = 525
* CHECK dout0_43 vdout0_43ck104 = 0 time = 525
* CHECK dout0_44 vdout0_44ck104 = 1.0 time = 525
* CHECK dout0_45 vdout0_45ck104 = 1.0 time = 525
* CHECK dout0_46 vdout0_46ck104 = 0 time = 525
* CHECK dout0_47 vdout0_47ck104 = 0 time = 525
* CHECK dout0_48 vdout0_48ck104 = 0 time = 525
* CHECK dout0_49 vdout0_49ck104 = 0 time = 525
* CHECK dout0_50 vdout0_50ck104 = 1.0 time = 525
* CHECK dout0_51 vdout0_51ck104 = 1.0 time = 525
* CHECK dout0_52 vdout0_52ck104 = 0 time = 525
* CHECK dout0_53 vdout0_53ck104 = 1.0 time = 525
* CHECK dout0_54 vdout0_54ck104 = 0 time = 525
* CHECK dout0_55 vdout0_55ck104 = 0 time = 525
* CHECK dout0_56 vdout0_56ck104 = 1.0 time = 525
* CHECK dout0_57 vdout0_57ck104 = 0 time = 525
* CHECK dout0_58 vdout0_58ck104 = 0 time = 525
* CHECK dout0_59 vdout0_59ck104 = 0 time = 525
* CHECK dout0_60 vdout0_60ck104 = 1.0 time = 525
* CHECK dout0_61 vdout0_61ck104 = 1.0 time = 525
* CHECK dout0_62 vdout0_62ck104 = 0 time = 525
* CHECK dout0_63 vdout0_63ck104 = 0 time = 525
* CHECK dout0_0 vdout0_0ck105 = 1.0 time = 530
* CHECK dout0_1 vdout0_1ck105 = 1.0 time = 530
* CHECK dout0_2 vdout0_2ck105 = 1.0 time = 530
* CHECK dout0_3 vdout0_3ck105 = 0 time = 530
* CHECK dout0_4 vdout0_4ck105 = 0 time = 530
* CHECK dout0_5 vdout0_5ck105 = 0 time = 530
* CHECK dout0_6 vdout0_6ck105 = 1.0 time = 530
* CHECK dout0_7 vdout0_7ck105 = 0 time = 530
* CHECK dout0_8 vdout0_8ck105 = 1.0 time = 530
* CHECK dout0_9 vdout0_9ck105 = 0 time = 530
* CHECK dout0_10 vdout0_10ck105 = 1.0 time = 530
* CHECK dout0_11 vdout0_11ck105 = 1.0 time = 530
* CHECK dout0_12 vdout0_12ck105 = 0 time = 530
* CHECK dout0_13 vdout0_13ck105 = 0 time = 530
* CHECK dout0_14 vdout0_14ck105 = 0 time = 530
* CHECK dout0_15 vdout0_15ck105 = 0 time = 530
* CHECK dout0_16 vdout0_16ck105 = 1.0 time = 530
* CHECK dout0_17 vdout0_17ck105 = 1.0 time = 530
* CHECK dout0_18 vdout0_18ck105 = 1.0 time = 530
* CHECK dout0_19 vdout0_19ck105 = 1.0 time = 530
* CHECK dout0_20 vdout0_20ck105 = 1.0 time = 530
* CHECK dout0_21 vdout0_21ck105 = 1.0 time = 530
* CHECK dout0_22 vdout0_22ck105 = 0 time = 530
* CHECK dout0_23 vdout0_23ck105 = 1.0 time = 530
* CHECK dout0_24 vdout0_24ck105 = 1.0 time = 530
* CHECK dout0_25 vdout0_25ck105 = 1.0 time = 530
* CHECK dout0_26 vdout0_26ck105 = 0 time = 530
* CHECK dout0_27 vdout0_27ck105 = 1.0 time = 530
* CHECK dout0_28 vdout0_28ck105 = 0 time = 530
* CHECK dout0_29 vdout0_29ck105 = 0 time = 530
* CHECK dout0_30 vdout0_30ck105 = 0 time = 530
* CHECK dout0_31 vdout0_31ck105 = 0 time = 530
* CHECK dout0_32 vdout0_32ck105 = 1.0 time = 530
* CHECK dout0_33 vdout0_33ck105 = 0 time = 530
* CHECK dout0_34 vdout0_34ck105 = 1.0 time = 530
* CHECK dout0_35 vdout0_35ck105 = 0 time = 530
* CHECK dout0_36 vdout0_36ck105 = 0 time = 530
* CHECK dout0_37 vdout0_37ck105 = 1.0 time = 530
* CHECK dout0_38 vdout0_38ck105 = 0 time = 530
* CHECK dout0_39 vdout0_39ck105 = 0 time = 530
* CHECK dout0_40 vdout0_40ck105 = 0 time = 530
* CHECK dout0_41 vdout0_41ck105 = 0 time = 530
* CHECK dout0_42 vdout0_42ck105 = 0 time = 530
* CHECK dout0_43 vdout0_43ck105 = 0 time = 530
* CHECK dout0_44 vdout0_44ck105 = 0 time = 530
* CHECK dout0_45 vdout0_45ck105 = 1.0 time = 530
* CHECK dout0_46 vdout0_46ck105 = 1.0 time = 530
* CHECK dout0_47 vdout0_47ck105 = 1.0 time = 530
* CHECK dout0_48 vdout0_48ck105 = 0 time = 530
* CHECK dout0_49 vdout0_49ck105 = 0 time = 530
* CHECK dout0_50 vdout0_50ck105 = 0 time = 530
* CHECK dout0_51 vdout0_51ck105 = 0 time = 530
* CHECK dout0_52 vdout0_52ck105 = 1.0 time = 530
* CHECK dout0_53 vdout0_53ck105 = 0 time = 530
* CHECK dout0_54 vdout0_54ck105 = 0 time = 530
* CHECK dout0_55 vdout0_55ck105 = 0 time = 530
* CHECK dout0_56 vdout0_56ck105 = 1.0 time = 530
* CHECK dout0_57 vdout0_57ck105 = 0 time = 530
* CHECK dout0_58 vdout0_58ck105 = 1.0 time = 530
* CHECK dout0_59 vdout0_59ck105 = 1.0 time = 530
* CHECK dout0_60 vdout0_60ck105 = 1.0 time = 530
* CHECK dout0_61 vdout0_61ck105 = 1.0 time = 530
* CHECK dout0_62 vdout0_62ck105 = 0 time = 530
* CHECK dout0_63 vdout0_63ck105 = 1.0 time = 530
* CHECK dout1_0 vdout1_0ck107 = 1.0 time = 540
* CHECK dout1_1 vdout1_1ck107 = 1.0 time = 540
* CHECK dout1_2 vdout1_2ck107 = 1.0 time = 540
* CHECK dout1_3 vdout1_3ck107 = 0 time = 540
* CHECK dout1_4 vdout1_4ck107 = 1.0 time = 540
* CHECK dout1_5 vdout1_5ck107 = 1.0 time = 540
* CHECK dout1_6 vdout1_6ck107 = 1.0 time = 540
* CHECK dout1_7 vdout1_7ck107 = 0 time = 540
* CHECK dout1_8 vdout1_8ck107 = 0 time = 540
* CHECK dout1_9 vdout1_9ck107 = 0 time = 540
* CHECK dout1_10 vdout1_10ck107 = 0 time = 540
* CHECK dout1_11 vdout1_11ck107 = 0 time = 540
* CHECK dout1_12 vdout1_12ck107 = 1.0 time = 540
* CHECK dout1_13 vdout1_13ck107 = 1.0 time = 540
* CHECK dout1_14 vdout1_14ck107 = 1.0 time = 540
* CHECK dout1_15 vdout1_15ck107 = 0 time = 540
* CHECK dout1_16 vdout1_16ck107 = 1.0 time = 540
* CHECK dout1_17 vdout1_17ck107 = 1.0 time = 540
* CHECK dout1_18 vdout1_18ck107 = 1.0 time = 540
* CHECK dout1_19 vdout1_19ck107 = 1.0 time = 540
* CHECK dout1_20 vdout1_20ck107 = 0 time = 540
* CHECK dout1_21 vdout1_21ck107 = 0 time = 540
* CHECK dout1_22 vdout1_22ck107 = 1.0 time = 540
* CHECK dout1_23 vdout1_23ck107 = 0 time = 540
* CHECK dout1_24 vdout1_24ck107 = 1.0 time = 540
* CHECK dout1_25 vdout1_25ck107 = 0 time = 540
* CHECK dout1_26 vdout1_26ck107 = 1.0 time = 540
* CHECK dout1_27 vdout1_27ck107 = 0 time = 540
* CHECK dout1_28 vdout1_28ck107 = 0 time = 540
* CHECK dout1_29 vdout1_29ck107 = 1.0 time = 540
* CHECK dout1_30 vdout1_30ck107 = 0 time = 540
* CHECK dout1_31 vdout1_31ck107 = 1.0 time = 540
* CHECK dout1_32 vdout1_32ck107 = 1.0 time = 540
* CHECK dout1_33 vdout1_33ck107 = 0 time = 540
* CHECK dout1_34 vdout1_34ck107 = 1.0 time = 540
* CHECK dout1_35 vdout1_35ck107 = 1.0 time = 540
* CHECK dout1_36 vdout1_36ck107 = 1.0 time = 540
* CHECK dout1_37 vdout1_37ck107 = 0 time = 540
* CHECK dout1_38 vdout1_38ck107 = 1.0 time = 540
* CHECK dout1_39 vdout1_39ck107 = 0 time = 540
* CHECK dout1_40 vdout1_40ck107 = 0 time = 540
* CHECK dout1_41 vdout1_41ck107 = 1.0 time = 540
* CHECK dout1_42 vdout1_42ck107 = 0 time = 540
* CHECK dout1_43 vdout1_43ck107 = 0 time = 540
* CHECK dout1_44 vdout1_44ck107 = 0 time = 540
* CHECK dout1_45 vdout1_45ck107 = 1.0 time = 540
* CHECK dout1_46 vdout1_46ck107 = 0 time = 540
* CHECK dout1_47 vdout1_47ck107 = 0 time = 540
* CHECK dout1_48 vdout1_48ck107 = 0 time = 540
* CHECK dout1_49 vdout1_49ck107 = 0 time = 540
* CHECK dout1_50 vdout1_50ck107 = 1.0 time = 540
* CHECK dout1_51 vdout1_51ck107 = 1.0 time = 540
* CHECK dout1_52 vdout1_52ck107 = 1.0 time = 540
* CHECK dout1_53 vdout1_53ck107 = 0 time = 540
* CHECK dout1_54 vdout1_54ck107 = 0 time = 540
* CHECK dout1_55 vdout1_55ck107 = 0 time = 540
* CHECK dout1_56 vdout1_56ck107 = 1.0 time = 540
* CHECK dout1_57 vdout1_57ck107 = 1.0 time = 540
* CHECK dout1_58 vdout1_58ck107 = 1.0 time = 540
* CHECK dout1_59 vdout1_59ck107 = 1.0 time = 540
* CHECK dout1_60 vdout1_60ck107 = 0 time = 540
* CHECK dout1_61 vdout1_61ck107 = 0 time = 540
* CHECK dout1_62 vdout1_62ck107 = 1.0 time = 540
* CHECK dout1_63 vdout1_63ck107 = 0 time = 540
* CHECK dout0_0 vdout0_0ck111 = 0 time = 560
* CHECK dout0_1 vdout0_1ck111 = 1.0 time = 560
* CHECK dout0_2 vdout0_2ck111 = 0 time = 560
* CHECK dout0_3 vdout0_3ck111 = 1.0 time = 560
* CHECK dout0_4 vdout0_4ck111 = 0 time = 560
* CHECK dout0_5 vdout0_5ck111 = 0 time = 560
* CHECK dout0_6 vdout0_6ck111 = 1.0 time = 560
* CHECK dout0_7 vdout0_7ck111 = 0 time = 560
* CHECK dout0_8 vdout0_8ck111 = 1.0 time = 560
* CHECK dout0_9 vdout0_9ck111 = 1.0 time = 560
* CHECK dout0_10 vdout0_10ck111 = 1.0 time = 560
* CHECK dout0_11 vdout0_11ck111 = 0 time = 560
* CHECK dout0_12 vdout0_12ck111 = 1.0 time = 560
* CHECK dout0_13 vdout0_13ck111 = 1.0 time = 560
* CHECK dout0_14 vdout0_14ck111 = 0 time = 560
* CHECK dout0_15 vdout0_15ck111 = 1.0 time = 560
* CHECK dout0_16 vdout0_16ck111 = 1.0 time = 560
* CHECK dout0_17 vdout0_17ck111 = 1.0 time = 560
* CHECK dout0_18 vdout0_18ck111 = 1.0 time = 560
* CHECK dout0_19 vdout0_19ck111 = 1.0 time = 560
* CHECK dout0_20 vdout0_20ck111 = 1.0 time = 560
* CHECK dout0_21 vdout0_21ck111 = 0 time = 560
* CHECK dout0_22 vdout0_22ck111 = 0 time = 560
* CHECK dout0_23 vdout0_23ck111 = 1.0 time = 560
* CHECK dout0_24 vdout0_24ck111 = 0 time = 560
* CHECK dout0_25 vdout0_25ck111 = 0 time = 560
* CHECK dout0_26 vdout0_26ck111 = 1.0 time = 560
* CHECK dout0_27 vdout0_27ck111 = 0 time = 560
* CHECK dout0_28 vdout0_28ck111 = 0 time = 560
* CHECK dout0_29 vdout0_29ck111 = 0 time = 560
* CHECK dout0_30 vdout0_30ck111 = 0 time = 560
* CHECK dout0_31 vdout0_31ck111 = 0 time = 560
* CHECK dout0_32 vdout0_32ck111 = 1.0 time = 560
* CHECK dout0_33 vdout0_33ck111 = 1.0 time = 560
* CHECK dout0_34 vdout0_34ck111 = 0 time = 560
* CHECK dout0_35 vdout0_35ck111 = 0 time = 560
* CHECK dout0_36 vdout0_36ck111 = 1.0 time = 560
* CHECK dout0_37 vdout0_37ck111 = 1.0 time = 560
* CHECK dout0_38 vdout0_38ck111 = 1.0 time = 560
* CHECK dout0_39 vdout0_39ck111 = 0 time = 560
* CHECK dout0_40 vdout0_40ck111 = 1.0 time = 560
* CHECK dout0_41 vdout0_41ck111 = 0 time = 560
* CHECK dout0_42 vdout0_42ck111 = 0 time = 560
* CHECK dout0_43 vdout0_43ck111 = 0 time = 560
* CHECK dout0_44 vdout0_44ck111 = 1.0 time = 560
* CHECK dout0_45 vdout0_45ck111 = 1.0 time = 560
* CHECK dout0_46 vdout0_46ck111 = 0 time = 560
* CHECK dout0_47 vdout0_47ck111 = 0 time = 560
* CHECK dout0_48 vdout0_48ck111 = 0 time = 560
* CHECK dout0_49 vdout0_49ck111 = 0 time = 560
* CHECK dout0_50 vdout0_50ck111 = 1.0 time = 560
* CHECK dout0_51 vdout0_51ck111 = 1.0 time = 560
* CHECK dout0_52 vdout0_52ck111 = 0 time = 560
* CHECK dout0_53 vdout0_53ck111 = 1.0 time = 560
* CHECK dout0_54 vdout0_54ck111 = 0 time = 560
* CHECK dout0_55 vdout0_55ck111 = 0 time = 560
* CHECK dout0_56 vdout0_56ck111 = 1.0 time = 560
* CHECK dout0_57 vdout0_57ck111 = 0 time = 560
* CHECK dout0_58 vdout0_58ck111 = 0 time = 560
* CHECK dout0_59 vdout0_59ck111 = 0 time = 560
* CHECK dout0_60 vdout0_60ck111 = 1.0 time = 560
* CHECK dout0_61 vdout0_61ck111 = 1.0 time = 560
* CHECK dout0_62 vdout0_62ck111 = 0 time = 560
* CHECK dout0_63 vdout0_63ck111 = 0 time = 560
* CHECK dout1_0 vdout1_0ck111 = 0 time = 560
* CHECK dout1_1 vdout1_1ck111 = 0 time = 560
* CHECK dout1_2 vdout1_2ck111 = 1.0 time = 560
* CHECK dout1_3 vdout1_3ck111 = 0 time = 560
* CHECK dout1_4 vdout1_4ck111 = 1.0 time = 560
* CHECK dout1_5 vdout1_5ck111 = 0 time = 560
* CHECK dout1_6 vdout1_6ck111 = 0 time = 560
* CHECK dout1_7 vdout1_7ck111 = 0 time = 560
* CHECK dout1_8 vdout1_8ck111 = 1.0 time = 560
* CHECK dout1_9 vdout1_9ck111 = 0 time = 560
* CHECK dout1_10 vdout1_10ck111 = 1.0 time = 560
* CHECK dout1_11 vdout1_11ck111 = 1.0 time = 560
* CHECK dout1_12 vdout1_12ck111 = 0 time = 560
* CHECK dout1_13 vdout1_13ck111 = 0 time = 560
* CHECK dout1_14 vdout1_14ck111 = 0 time = 560
* CHECK dout1_15 vdout1_15ck111 = 0 time = 560
* CHECK dout1_16 vdout1_16ck111 = 0 time = 560
* CHECK dout1_17 vdout1_17ck111 = 1.0 time = 560
* CHECK dout1_18 vdout1_18ck111 = 1.0 time = 560
* CHECK dout1_19 vdout1_19ck111 = 1.0 time = 560
* CHECK dout1_20 vdout1_20ck111 = 0 time = 560
* CHECK dout1_21 vdout1_21ck111 = 0 time = 560
* CHECK dout1_22 vdout1_22ck111 = 0 time = 560
* CHECK dout1_23 vdout1_23ck111 = 1.0 time = 560
* CHECK dout1_24 vdout1_24ck111 = 0 time = 560
* CHECK dout1_25 vdout1_25ck111 = 0 time = 560
* CHECK dout1_26 vdout1_26ck111 = 1.0 time = 560
* CHECK dout1_27 vdout1_27ck111 = 0 time = 560
* CHECK dout1_28 vdout1_28ck111 = 1.0 time = 560
* CHECK dout1_29 vdout1_29ck111 = 1.0 time = 560
* CHECK dout1_30 vdout1_30ck111 = 0 time = 560
* CHECK dout1_31 vdout1_31ck111 = 1.0 time = 560
* CHECK dout1_32 vdout1_32ck111 = 0 time = 560
* CHECK dout1_33 vdout1_33ck111 = 1.0 time = 560
* CHECK dout1_34 vdout1_34ck111 = 0 time = 560
* CHECK dout1_35 vdout1_35ck111 = 1.0 time = 560
* CHECK dout1_36 vdout1_36ck111 = 1.0 time = 560
* CHECK dout1_37 vdout1_37ck111 = 0 time = 560
* CHECK dout1_38 vdout1_38ck111 = 0 time = 560
* CHECK dout1_39 vdout1_39ck111 = 1.0 time = 560
* CHECK dout1_40 vdout1_40ck111 = 0 time = 560
* CHECK dout1_41 vdout1_41ck111 = 1.0 time = 560
* CHECK dout1_42 vdout1_42ck111 = 1.0 time = 560
* CHECK dout1_43 vdout1_43ck111 = 0 time = 560
* CHECK dout1_44 vdout1_44ck111 = 1.0 time = 560
* CHECK dout1_45 vdout1_45ck111 = 1.0 time = 560
* CHECK dout1_46 vdout1_46ck111 = 0 time = 560
* CHECK dout1_47 vdout1_47ck111 = 0 time = 560
* CHECK dout1_48 vdout1_48ck111 = 0 time = 560
* CHECK dout1_49 vdout1_49ck111 = 1.0 time = 560
* CHECK dout1_50 vdout1_50ck111 = 0 time = 560
* CHECK dout1_51 vdout1_51ck111 = 0 time = 560
* CHECK dout1_52 vdout1_52ck111 = 0 time = 560
* CHECK dout1_53 vdout1_53ck111 = 1.0 time = 560
* CHECK dout1_54 vdout1_54ck111 = 0 time = 560
* CHECK dout1_55 vdout1_55ck111 = 0 time = 560
* CHECK dout1_56 vdout1_56ck111 = 1.0 time = 560
* CHECK dout1_57 vdout1_57ck111 = 1.0 time = 560
* CHECK dout1_58 vdout1_58ck111 = 0 time = 560
* CHECK dout1_59 vdout1_59ck111 = 1.0 time = 560
* CHECK dout1_60 vdout1_60ck111 = 1.0 time = 560
* CHECK dout1_61 vdout1_61ck111 = 1.0 time = 560
* CHECK dout1_62 vdout1_62ck111 = 1.0 time = 560
* CHECK dout1_63 vdout1_63ck111 = 0 time = 560
* CHECK dout1_0 vdout1_0ck112 = 0 time = 565
* CHECK dout1_1 vdout1_1ck112 = 0 time = 565
* CHECK dout1_2 vdout1_2ck112 = 0 time = 565
* CHECK dout1_3 vdout1_3ck112 = 1.0 time = 565
* CHECK dout1_4 vdout1_4ck112 = 0 time = 565
* CHECK dout1_5 vdout1_5ck112 = 0 time = 565
* CHECK dout1_6 vdout1_6ck112 = 1.0 time = 565
* CHECK dout1_7 vdout1_7ck112 = 1.0 time = 565
* CHECK dout1_8 vdout1_8ck112 = 1.0 time = 565
* CHECK dout1_9 vdout1_9ck112 = 0 time = 565
* CHECK dout1_10 vdout1_10ck112 = 0 time = 565
* CHECK dout1_11 vdout1_11ck112 = 0 time = 565
* CHECK dout1_12 vdout1_12ck112 = 0 time = 565
* CHECK dout1_13 vdout1_13ck112 = 1.0 time = 565
* CHECK dout1_14 vdout1_14ck112 = 0 time = 565
* CHECK dout1_15 vdout1_15ck112 = 0 time = 565
* CHECK dout1_16 vdout1_16ck112 = 1.0 time = 565
* CHECK dout1_17 vdout1_17ck112 = 0 time = 565
* CHECK dout1_18 vdout1_18ck112 = 1.0 time = 565
* CHECK dout1_19 vdout1_19ck112 = 0 time = 565
* CHECK dout1_20 vdout1_20ck112 = 1.0 time = 565
* CHECK dout1_21 vdout1_21ck112 = 1.0 time = 565
* CHECK dout1_22 vdout1_22ck112 = 0 time = 565
* CHECK dout1_23 vdout1_23ck112 = 0 time = 565
* CHECK dout1_24 vdout1_24ck112 = 0 time = 565
* CHECK dout1_25 vdout1_25ck112 = 1.0 time = 565
* CHECK dout1_26 vdout1_26ck112 = 0 time = 565
* CHECK dout1_27 vdout1_27ck112 = 0 time = 565
* CHECK dout1_28 vdout1_28ck112 = 0 time = 565
* CHECK dout1_29 vdout1_29ck112 = 1.0 time = 565
* CHECK dout1_30 vdout1_30ck112 = 0 time = 565
* CHECK dout1_31 vdout1_31ck112 = 0 time = 565
* CHECK dout1_32 vdout1_32ck112 = 0 time = 565
* CHECK dout1_33 vdout1_33ck112 = 0 time = 565
* CHECK dout1_34 vdout1_34ck112 = 1.0 time = 565
* CHECK dout1_35 vdout1_35ck112 = 1.0 time = 565
* CHECK dout1_36 vdout1_36ck112 = 0 time = 565
* CHECK dout1_37 vdout1_37ck112 = 0 time = 565
* CHECK dout1_38 vdout1_38ck112 = 1.0 time = 565
* CHECK dout1_39 vdout1_39ck112 = 1.0 time = 565
* CHECK dout1_40 vdout1_40ck112 = 0 time = 565
* CHECK dout1_41 vdout1_41ck112 = 0 time = 565
* CHECK dout1_42 vdout1_42ck112 = 0 time = 565
* CHECK dout1_43 vdout1_43ck112 = 0 time = 565
* CHECK dout1_44 vdout1_44ck112 = 1.0 time = 565
* CHECK dout1_45 vdout1_45ck112 = 1.0 time = 565
* CHECK dout1_46 vdout1_46ck112 = 0 time = 565
* CHECK dout1_47 vdout1_47ck112 = 1.0 time = 565
* CHECK dout1_48 vdout1_48ck112 = 1.0 time = 565
* CHECK dout1_49 vdout1_49ck112 = 0 time = 565
* CHECK dout1_50 vdout1_50ck112 = 0 time = 565
* CHECK dout1_51 vdout1_51ck112 = 1.0 time = 565
* CHECK dout1_52 vdout1_52ck112 = 0 time = 565
* CHECK dout1_53 vdout1_53ck112 = 1.0 time = 565
* CHECK dout1_54 vdout1_54ck112 = 0 time = 565
* CHECK dout1_55 vdout1_55ck112 = 1.0 time = 565
* CHECK dout1_56 vdout1_56ck112 = 1.0 time = 565
* CHECK dout1_57 vdout1_57ck112 = 0 time = 565
* CHECK dout1_58 vdout1_58ck112 = 1.0 time = 565
* CHECK dout1_59 vdout1_59ck112 = 1.0 time = 565
* CHECK dout1_60 vdout1_60ck112 = 0 time = 565
* CHECK dout1_61 vdout1_61ck112 = 0 time = 565
* CHECK dout1_62 vdout1_62ck112 = 0 time = 565
* CHECK dout1_63 vdout1_63ck112 = 0 time = 565
* CHECK dout0_0 vdout0_0ck113 = 0 time = 570
* CHECK dout0_1 vdout0_1ck113 = 0 time = 570
* CHECK dout0_2 vdout0_2ck113 = 1.0 time = 570
* CHECK dout0_3 vdout0_3ck113 = 0 time = 570
* CHECK dout0_4 vdout0_4ck113 = 1.0 time = 570
* CHECK dout0_5 vdout0_5ck113 = 0 time = 570
* CHECK dout0_6 vdout0_6ck113 = 0 time = 570
* CHECK dout0_7 vdout0_7ck113 = 0 time = 570
* CHECK dout0_8 vdout0_8ck113 = 1.0 time = 570
* CHECK dout0_9 vdout0_9ck113 = 0 time = 570
* CHECK dout0_10 vdout0_10ck113 = 1.0 time = 570
* CHECK dout0_11 vdout0_11ck113 = 1.0 time = 570
* CHECK dout0_12 vdout0_12ck113 = 0 time = 570
* CHECK dout0_13 vdout0_13ck113 = 0 time = 570
* CHECK dout0_14 vdout0_14ck113 = 0 time = 570
* CHECK dout0_15 vdout0_15ck113 = 0 time = 570
* CHECK dout0_16 vdout0_16ck113 = 0 time = 570
* CHECK dout0_17 vdout0_17ck113 = 1.0 time = 570
* CHECK dout0_18 vdout0_18ck113 = 1.0 time = 570
* CHECK dout0_19 vdout0_19ck113 = 1.0 time = 570
* CHECK dout0_20 vdout0_20ck113 = 0 time = 570
* CHECK dout0_21 vdout0_21ck113 = 0 time = 570
* CHECK dout0_22 vdout0_22ck113 = 0 time = 570
* CHECK dout0_23 vdout0_23ck113 = 1.0 time = 570
* CHECK dout0_24 vdout0_24ck113 = 0 time = 570
* CHECK dout0_25 vdout0_25ck113 = 0 time = 570
* CHECK dout0_26 vdout0_26ck113 = 1.0 time = 570
* CHECK dout0_27 vdout0_27ck113 = 0 time = 570
* CHECK dout0_28 vdout0_28ck113 = 1.0 time = 570
* CHECK dout0_29 vdout0_29ck113 = 1.0 time = 570
* CHECK dout0_30 vdout0_30ck113 = 0 time = 570
* CHECK dout0_31 vdout0_31ck113 = 1.0 time = 570
* CHECK dout0_32 vdout0_32ck113 = 0 time = 570
* CHECK dout0_33 vdout0_33ck113 = 1.0 time = 570
* CHECK dout0_34 vdout0_34ck113 = 0 time = 570
* CHECK dout0_35 vdout0_35ck113 = 1.0 time = 570
* CHECK dout0_36 vdout0_36ck113 = 1.0 time = 570
* CHECK dout0_37 vdout0_37ck113 = 0 time = 570
* CHECK dout0_38 vdout0_38ck113 = 0 time = 570
* CHECK dout0_39 vdout0_39ck113 = 1.0 time = 570
* CHECK dout0_40 vdout0_40ck113 = 0 time = 570
* CHECK dout0_41 vdout0_41ck113 = 1.0 time = 570
* CHECK dout0_42 vdout0_42ck113 = 1.0 time = 570
* CHECK dout0_43 vdout0_43ck113 = 0 time = 570
* CHECK dout0_44 vdout0_44ck113 = 1.0 time = 570
* CHECK dout0_45 vdout0_45ck113 = 1.0 time = 570
* CHECK dout0_46 vdout0_46ck113 = 0 time = 570
* CHECK dout0_47 vdout0_47ck113 = 0 time = 570
* CHECK dout0_48 vdout0_48ck113 = 0 time = 570
* CHECK dout0_49 vdout0_49ck113 = 1.0 time = 570
* CHECK dout0_50 vdout0_50ck113 = 0 time = 570
* CHECK dout0_51 vdout0_51ck113 = 0 time = 570
* CHECK dout0_52 vdout0_52ck113 = 0 time = 570
* CHECK dout0_53 vdout0_53ck113 = 1.0 time = 570
* CHECK dout0_54 vdout0_54ck113 = 0 time = 570
* CHECK dout0_55 vdout0_55ck113 = 0 time = 570
* CHECK dout0_56 vdout0_56ck113 = 1.0 time = 570
* CHECK dout0_57 vdout0_57ck113 = 1.0 time = 570
* CHECK dout0_58 vdout0_58ck113 = 0 time = 570
* CHECK dout0_59 vdout0_59ck113 = 1.0 time = 570
* CHECK dout0_60 vdout0_60ck113 = 1.0 time = 570
* CHECK dout0_61 vdout0_61ck113 = 1.0 time = 570
* CHECK dout0_62 vdout0_62ck113 = 1.0 time = 570
* CHECK dout0_63 vdout0_63ck113 = 0 time = 570
* CHECK dout1_0 vdout1_0ck113 = 0 time = 570
* CHECK dout1_1 vdout1_1ck113 = 1.0 time = 570
* CHECK dout1_2 vdout1_2ck113 = 0 time = 570
* CHECK dout1_3 vdout1_3ck113 = 1.0 time = 570
* CHECK dout1_4 vdout1_4ck113 = 0 time = 570
* CHECK dout1_5 vdout1_5ck113 = 0 time = 570
* CHECK dout1_6 vdout1_6ck113 = 1.0 time = 570
* CHECK dout1_7 vdout1_7ck113 = 0 time = 570
* CHECK dout1_8 vdout1_8ck113 = 1.0 time = 570
* CHECK dout1_9 vdout1_9ck113 = 1.0 time = 570
* CHECK dout1_10 vdout1_10ck113 = 1.0 time = 570
* CHECK dout1_11 vdout1_11ck113 = 0 time = 570
* CHECK dout1_12 vdout1_12ck113 = 1.0 time = 570
* CHECK dout1_13 vdout1_13ck113 = 1.0 time = 570
* CHECK dout1_14 vdout1_14ck113 = 0 time = 570
* CHECK dout1_15 vdout1_15ck113 = 1.0 time = 570
* CHECK dout1_16 vdout1_16ck113 = 1.0 time = 570
* CHECK dout1_17 vdout1_17ck113 = 1.0 time = 570
* CHECK dout1_18 vdout1_18ck113 = 1.0 time = 570
* CHECK dout1_19 vdout1_19ck113 = 1.0 time = 570
* CHECK dout1_20 vdout1_20ck113 = 1.0 time = 570
* CHECK dout1_21 vdout1_21ck113 = 0 time = 570
* CHECK dout1_22 vdout1_22ck113 = 0 time = 570
* CHECK dout1_23 vdout1_23ck113 = 1.0 time = 570
* CHECK dout1_24 vdout1_24ck113 = 0 time = 570
* CHECK dout1_25 vdout1_25ck113 = 0 time = 570
* CHECK dout1_26 vdout1_26ck113 = 1.0 time = 570
* CHECK dout1_27 vdout1_27ck113 = 0 time = 570
* CHECK dout1_28 vdout1_28ck113 = 0 time = 570
* CHECK dout1_29 vdout1_29ck113 = 0 time = 570
* CHECK dout1_30 vdout1_30ck113 = 0 time = 570
* CHECK dout1_31 vdout1_31ck113 = 0 time = 570
* CHECK dout1_32 vdout1_32ck113 = 1.0 time = 570
* CHECK dout1_33 vdout1_33ck113 = 1.0 time = 570
* CHECK dout1_34 vdout1_34ck113 = 0 time = 570
* CHECK dout1_35 vdout1_35ck113 = 0 time = 570
* CHECK dout1_36 vdout1_36ck113 = 1.0 time = 570
* CHECK dout1_37 vdout1_37ck113 = 1.0 time = 570
* CHECK dout1_38 vdout1_38ck113 = 1.0 time = 570
* CHECK dout1_39 vdout1_39ck113 = 0 time = 570
* CHECK dout1_40 vdout1_40ck113 = 1.0 time = 570
* CHECK dout1_41 vdout1_41ck113 = 0 time = 570
* CHECK dout1_42 vdout1_42ck113 = 0 time = 570
* CHECK dout1_43 vdout1_43ck113 = 0 time = 570
* CHECK dout1_44 vdout1_44ck113 = 1.0 time = 570
* CHECK dout1_45 vdout1_45ck113 = 1.0 time = 570
* CHECK dout1_46 vdout1_46ck113 = 0 time = 570
* CHECK dout1_47 vdout1_47ck113 = 0 time = 570
* CHECK dout1_48 vdout1_48ck113 = 0 time = 570
* CHECK dout1_49 vdout1_49ck113 = 0 time = 570
* CHECK dout1_50 vdout1_50ck113 = 1.0 time = 570
* CHECK dout1_51 vdout1_51ck113 = 1.0 time = 570
* CHECK dout1_52 vdout1_52ck113 = 0 time = 570
* CHECK dout1_53 vdout1_53ck113 = 1.0 time = 570
* CHECK dout1_54 vdout1_54ck113 = 0 time = 570
* CHECK dout1_55 vdout1_55ck113 = 0 time = 570
* CHECK dout1_56 vdout1_56ck113 = 1.0 time = 570
* CHECK dout1_57 vdout1_57ck113 = 0 time = 570
* CHECK dout1_58 vdout1_58ck113 = 0 time = 570
* CHECK dout1_59 vdout1_59ck113 = 0 time = 570
* CHECK dout1_60 vdout1_60ck113 = 1.0 time = 570
* CHECK dout1_61 vdout1_61ck113 = 1.0 time = 570
* CHECK dout1_62 vdout1_62ck113 = 0 time = 570
* CHECK dout1_63 vdout1_63ck113 = 0 time = 570
* CHECK dout0_0 vdout0_0ck114 = 0 time = 575
* CHECK dout0_1 vdout0_1ck114 = 1.0 time = 575
* CHECK dout0_2 vdout0_2ck114 = 0 time = 575
* CHECK dout0_3 vdout0_3ck114 = 0 time = 575
* CHECK dout0_4 vdout0_4ck114 = 0 time = 575
* CHECK dout0_5 vdout0_5ck114 = 1.0 time = 575
* CHECK dout0_6 vdout0_6ck114 = 0 time = 575
* CHECK dout0_7 vdout0_7ck114 = 0 time = 575
* CHECK dout0_8 vdout0_8ck114 = 0 time = 575
* CHECK dout0_9 vdout0_9ck114 = 0 time = 575
* CHECK dout0_10 vdout0_10ck114 = 1.0 time = 575
* CHECK dout0_11 vdout0_11ck114 = 1.0 time = 575
* CHECK dout0_12 vdout0_12ck114 = 1.0 time = 575
* CHECK dout0_13 vdout0_13ck114 = 0 time = 575
* CHECK dout0_14 vdout0_14ck114 = 1.0 time = 575
* CHECK dout0_15 vdout0_15ck114 = 0 time = 575
* CHECK dout0_16 vdout0_16ck114 = 1.0 time = 575
* CHECK dout0_17 vdout0_17ck114 = 0 time = 575
* CHECK dout0_18 vdout0_18ck114 = 0 time = 575
* CHECK dout0_19 vdout0_19ck114 = 1.0 time = 575
* CHECK dout0_20 vdout0_20ck114 = 0 time = 575
* CHECK dout0_21 vdout0_21ck114 = 0 time = 575
* CHECK dout0_22 vdout0_22ck114 = 0 time = 575
* CHECK dout0_23 vdout0_23ck114 = 1.0 time = 575
* CHECK dout0_24 vdout0_24ck114 = 0 time = 575
* CHECK dout0_25 vdout0_25ck114 = 0 time = 575
* CHECK dout0_26 vdout0_26ck114 = 1.0 time = 575
* CHECK dout0_27 vdout0_27ck114 = 0 time = 575
* CHECK dout0_28 vdout0_28ck114 = 0 time = 575
* CHECK dout0_29 vdout0_29ck114 = 1.0 time = 575
* CHECK dout0_30 vdout0_30ck114 = 1.0 time = 575
* CHECK dout0_31 vdout0_31ck114 = 0 time = 575
* CHECK dout0_32 vdout0_32ck114 = 0 time = 575
* CHECK dout0_33 vdout0_33ck114 = 1.0 time = 575
* CHECK dout0_34 vdout0_34ck114 = 0 time = 575
* CHECK dout0_35 vdout0_35ck114 = 0 time = 575
* CHECK dout0_36 vdout0_36ck114 = 0 time = 575
* CHECK dout0_37 vdout0_37ck114 = 1.0 time = 575
* CHECK dout0_38 vdout0_38ck114 = 1.0 time = 575
* CHECK dout0_39 vdout0_39ck114 = 1.0 time = 575
* CHECK dout0_40 vdout0_40ck114 = 1.0 time = 575
* CHECK dout0_41 vdout0_41ck114 = 0 time = 575
* CHECK dout0_42 vdout0_42ck114 = 1.0 time = 575
* CHECK dout0_43 vdout0_43ck114 = 1.0 time = 575
* CHECK dout0_44 vdout0_44ck114 = 1.0 time = 575
* CHECK dout0_45 vdout0_45ck114 = 1.0 time = 575
* CHECK dout0_46 vdout0_46ck114 = 0 time = 575
* CHECK dout0_47 vdout0_47ck114 = 0 time = 575
* CHECK dout0_48 vdout0_48ck114 = 0 time = 575
* CHECK dout0_49 vdout0_49ck114 = 1.0 time = 575
* CHECK dout0_50 vdout0_50ck114 = 1.0 time = 575
* CHECK dout0_51 vdout0_51ck114 = 0 time = 575
* CHECK dout0_52 vdout0_52ck114 = 1.0 time = 575
* CHECK dout0_53 vdout0_53ck114 = 0 time = 575
* CHECK dout0_54 vdout0_54ck114 = 0 time = 575
* CHECK dout0_55 vdout0_55ck114 = 1.0 time = 575
* CHECK dout0_56 vdout0_56ck114 = 0 time = 575
* CHECK dout0_57 vdout0_57ck114 = 0 time = 575
* CHECK dout0_58 vdout0_58ck114 = 1.0 time = 575
* CHECK dout0_59 vdout0_59ck114 = 1.0 time = 575
* CHECK dout0_60 vdout0_60ck114 = 1.0 time = 575
* CHECK dout0_61 vdout0_61ck114 = 1.0 time = 575
* CHECK dout0_62 vdout0_62ck114 = 0 time = 575
* CHECK dout0_63 vdout0_63ck114 = 1.0 time = 575
* CHECK dout1_0 vdout1_0ck114 = 0 time = 575
* CHECK dout1_1 vdout1_1ck114 = 1.0 time = 575
* CHECK dout1_2 vdout1_2ck114 = 0 time = 575
* CHECK dout1_3 vdout1_3ck114 = 0 time = 575
* CHECK dout1_4 vdout1_4ck114 = 0 time = 575
* CHECK dout1_5 vdout1_5ck114 = 1.0 time = 575
* CHECK dout1_6 vdout1_6ck114 = 0 time = 575
* CHECK dout1_7 vdout1_7ck114 = 0 time = 575
* CHECK dout1_8 vdout1_8ck114 = 0 time = 575
* CHECK dout1_9 vdout1_9ck114 = 0 time = 575
* CHECK dout1_10 vdout1_10ck114 = 1.0 time = 575
* CHECK dout1_11 vdout1_11ck114 = 1.0 time = 575
* CHECK dout1_12 vdout1_12ck114 = 1.0 time = 575
* CHECK dout1_13 vdout1_13ck114 = 0 time = 575
* CHECK dout1_14 vdout1_14ck114 = 1.0 time = 575
* CHECK dout1_15 vdout1_15ck114 = 0 time = 575
* CHECK dout1_16 vdout1_16ck114 = 1.0 time = 575
* CHECK dout1_17 vdout1_17ck114 = 0 time = 575
* CHECK dout1_18 vdout1_18ck114 = 0 time = 575
* CHECK dout1_19 vdout1_19ck114 = 1.0 time = 575
* CHECK dout1_20 vdout1_20ck114 = 0 time = 575
* CHECK dout1_21 vdout1_21ck114 = 0 time = 575
* CHECK dout1_22 vdout1_22ck114 = 0 time = 575
* CHECK dout1_23 vdout1_23ck114 = 1.0 time = 575
* CHECK dout1_24 vdout1_24ck114 = 0 time = 575
* CHECK dout1_25 vdout1_25ck114 = 0 time = 575
* CHECK dout1_26 vdout1_26ck114 = 1.0 time = 575
* CHECK dout1_27 vdout1_27ck114 = 0 time = 575
* CHECK dout1_28 vdout1_28ck114 = 0 time = 575
* CHECK dout1_29 vdout1_29ck114 = 1.0 time = 575
* CHECK dout1_30 vdout1_30ck114 = 1.0 time = 575
* CHECK dout1_31 vdout1_31ck114 = 0 time = 575
* CHECK dout1_32 vdout1_32ck114 = 0 time = 575
* CHECK dout1_33 vdout1_33ck114 = 1.0 time = 575
* CHECK dout1_34 vdout1_34ck114 = 0 time = 575
* CHECK dout1_35 vdout1_35ck114 = 0 time = 575
* CHECK dout1_36 vdout1_36ck114 = 0 time = 575
* CHECK dout1_37 vdout1_37ck114 = 1.0 time = 575
* CHECK dout1_38 vdout1_38ck114 = 1.0 time = 575
* CHECK dout1_39 vdout1_39ck114 = 1.0 time = 575
* CHECK dout1_40 vdout1_40ck114 = 1.0 time = 575
* CHECK dout1_41 vdout1_41ck114 = 0 time = 575
* CHECK dout1_42 vdout1_42ck114 = 1.0 time = 575
* CHECK dout1_43 vdout1_43ck114 = 1.0 time = 575
* CHECK dout1_44 vdout1_44ck114 = 1.0 time = 575
* CHECK dout1_45 vdout1_45ck114 = 1.0 time = 575
* CHECK dout1_46 vdout1_46ck114 = 0 time = 575
* CHECK dout1_47 vdout1_47ck114 = 0 time = 575
* CHECK dout1_48 vdout1_48ck114 = 0 time = 575
* CHECK dout1_49 vdout1_49ck114 = 1.0 time = 575
* CHECK dout1_50 vdout1_50ck114 = 1.0 time = 575
* CHECK dout1_51 vdout1_51ck114 = 0 time = 575
* CHECK dout1_52 vdout1_52ck114 = 1.0 time = 575
* CHECK dout1_53 vdout1_53ck114 = 0 time = 575
* CHECK dout1_54 vdout1_54ck114 = 0 time = 575
* CHECK dout1_55 vdout1_55ck114 = 1.0 time = 575
* CHECK dout1_56 vdout1_56ck114 = 0 time = 575
* CHECK dout1_57 vdout1_57ck114 = 0 time = 575
* CHECK dout1_58 vdout1_58ck114 = 1.0 time = 575
* CHECK dout1_59 vdout1_59ck114 = 1.0 time = 575
* CHECK dout1_60 vdout1_60ck114 = 1.0 time = 575
* CHECK dout1_61 vdout1_61ck114 = 1.0 time = 575
* CHECK dout1_62 vdout1_62ck114 = 0 time = 575
* CHECK dout1_63 vdout1_63ck114 = 1.0 time = 575
* CHECK dout0_0 vdout0_0ck115 = 1.0 time = 580
* CHECK dout0_1 vdout0_1ck115 = 1.0 time = 580
* CHECK dout0_2 vdout0_2ck115 = 1.0 time = 580
* CHECK dout0_3 vdout0_3ck115 = 0 time = 580
* CHECK dout0_4 vdout0_4ck115 = 0 time = 580
* CHECK dout0_5 vdout0_5ck115 = 1.0 time = 580
* CHECK dout0_6 vdout0_6ck115 = 0 time = 580
* CHECK dout0_7 vdout0_7ck115 = 1.0 time = 580
* CHECK dout0_8 vdout0_8ck115 = 1.0 time = 580
* CHECK dout0_9 vdout0_9ck115 = 1.0 time = 580
* CHECK dout0_10 vdout0_10ck115 = 0 time = 580
* CHECK dout0_11 vdout0_11ck115 = 1.0 time = 580
* CHECK dout0_12 vdout0_12ck115 = 0 time = 580
* CHECK dout0_13 vdout0_13ck115 = 0 time = 580
* CHECK dout0_14 vdout0_14ck115 = 0 time = 580
* CHECK dout0_15 vdout0_15ck115 = 0 time = 580
* CHECK dout0_16 vdout0_16ck115 = 0 time = 580
* CHECK dout0_17 vdout0_17ck115 = 1.0 time = 580
* CHECK dout0_18 vdout0_18ck115 = 1.0 time = 580
* CHECK dout0_19 vdout0_19ck115 = 1.0 time = 580
* CHECK dout0_20 vdout0_20ck115 = 1.0 time = 580
* CHECK dout0_21 vdout0_21ck115 = 0 time = 580
* CHECK dout0_22 vdout0_22ck115 = 0 time = 580
* CHECK dout0_23 vdout0_23ck115 = 0 time = 580
* CHECK dout0_24 vdout0_24ck115 = 0 time = 580
* CHECK dout0_25 vdout0_25ck115 = 0 time = 580
* CHECK dout0_26 vdout0_26ck115 = 0 time = 580
* CHECK dout0_27 vdout0_27ck115 = 0 time = 580
* CHECK dout0_28 vdout0_28ck115 = 1.0 time = 580
* CHECK dout0_29 vdout0_29ck115 = 0 time = 580
* CHECK dout0_30 vdout0_30ck115 = 0 time = 580
* CHECK dout0_31 vdout0_31ck115 = 0 time = 580
* CHECK dout0_32 vdout0_32ck115 = 1.0 time = 580
* CHECK dout0_33 vdout0_33ck115 = 1.0 time = 580
* CHECK dout0_34 vdout0_34ck115 = 0 time = 580
* CHECK dout0_35 vdout0_35ck115 = 1.0 time = 580
* CHECK dout0_36 vdout0_36ck115 = 0 time = 580
* CHECK dout0_37 vdout0_37ck115 = 0 time = 580
* CHECK dout0_38 vdout0_38ck115 = 0 time = 580
* CHECK dout0_39 vdout0_39ck115 = 0 time = 580
* CHECK dout0_40 vdout0_40ck115 = 1.0 time = 580
* CHECK dout0_41 vdout0_41ck115 = 0 time = 580
* CHECK dout0_42 vdout0_42ck115 = 1.0 time = 580
* CHECK dout0_43 vdout0_43ck115 = 1.0 time = 580
* CHECK dout0_44 vdout0_44ck115 = 1.0 time = 580
* CHECK dout0_45 vdout0_45ck115 = 0 time = 580
* CHECK dout0_46 vdout0_46ck115 = 1.0 time = 580
* CHECK dout0_47 vdout0_47ck115 = 0 time = 580
* CHECK dout0_48 vdout0_48ck115 = 1.0 time = 580
* CHECK dout0_49 vdout0_49ck115 = 0 time = 580
* CHECK dout0_50 vdout0_50ck115 = 1.0 time = 580
* CHECK dout0_51 vdout0_51ck115 = 0 time = 580
* CHECK dout0_52 vdout0_52ck115 = 0 time = 580
* CHECK dout0_53 vdout0_53ck115 = 1.0 time = 580
* CHECK dout0_54 vdout0_54ck115 = 1.0 time = 580
* CHECK dout0_55 vdout0_55ck115 = 0 time = 580
* CHECK dout0_56 vdout0_56ck115 = 1.0 time = 580
* CHECK dout0_57 vdout0_57ck115 = 1.0 time = 580
* CHECK dout0_58 vdout0_58ck115 = 0 time = 580
* CHECK dout0_59 vdout0_59ck115 = 0 time = 580
* CHECK dout0_60 vdout0_60ck115 = 1.0 time = 580
* CHECK dout0_61 vdout0_61ck115 = 0 time = 580
* CHECK dout0_62 vdout0_62ck115 = 1.0 time = 580
* CHECK dout0_63 vdout0_63ck115 = 1.0 time = 580
* CHECK dout1_0 vdout1_0ck118 = 0 time = 595
* CHECK dout1_1 vdout1_1ck118 = 1.0 time = 595
* CHECK dout1_2 vdout1_2ck118 = 0 time = 595
* CHECK dout1_3 vdout1_3ck118 = 0 time = 595
* CHECK dout1_4 vdout1_4ck118 = 0 time = 595
* CHECK dout1_5 vdout1_5ck118 = 1.0 time = 595
* CHECK dout1_6 vdout1_6ck118 = 0 time = 595
* CHECK dout1_7 vdout1_7ck118 = 0 time = 595
* CHECK dout1_8 vdout1_8ck118 = 0 time = 595
* CHECK dout1_9 vdout1_9ck118 = 0 time = 595
* CHECK dout1_10 vdout1_10ck118 = 1.0 time = 595
* CHECK dout1_11 vdout1_11ck118 = 1.0 time = 595
* CHECK dout1_12 vdout1_12ck118 = 1.0 time = 595
* CHECK dout1_13 vdout1_13ck118 = 0 time = 595
* CHECK dout1_14 vdout1_14ck118 = 1.0 time = 595
* CHECK dout1_15 vdout1_15ck118 = 0 time = 595
* CHECK dout1_16 vdout1_16ck118 = 1.0 time = 595
* CHECK dout1_17 vdout1_17ck118 = 0 time = 595
* CHECK dout1_18 vdout1_18ck118 = 0 time = 595
* CHECK dout1_19 vdout1_19ck118 = 1.0 time = 595
* CHECK dout1_20 vdout1_20ck118 = 0 time = 595
* CHECK dout1_21 vdout1_21ck118 = 0 time = 595
* CHECK dout1_22 vdout1_22ck118 = 0 time = 595
* CHECK dout1_23 vdout1_23ck118 = 1.0 time = 595
* CHECK dout1_24 vdout1_24ck118 = 0 time = 595
* CHECK dout1_25 vdout1_25ck118 = 0 time = 595
* CHECK dout1_26 vdout1_26ck118 = 1.0 time = 595
* CHECK dout1_27 vdout1_27ck118 = 0 time = 595
* CHECK dout1_28 vdout1_28ck118 = 0 time = 595
* CHECK dout1_29 vdout1_29ck118 = 1.0 time = 595
* CHECK dout1_30 vdout1_30ck118 = 1.0 time = 595
* CHECK dout1_31 vdout1_31ck118 = 0 time = 595
* CHECK dout1_32 vdout1_32ck118 = 0 time = 595
* CHECK dout1_33 vdout1_33ck118 = 1.0 time = 595
* CHECK dout1_34 vdout1_34ck118 = 0 time = 595
* CHECK dout1_35 vdout1_35ck118 = 0 time = 595
* CHECK dout1_36 vdout1_36ck118 = 0 time = 595
* CHECK dout1_37 vdout1_37ck118 = 1.0 time = 595
* CHECK dout1_38 vdout1_38ck118 = 1.0 time = 595
* CHECK dout1_39 vdout1_39ck118 = 1.0 time = 595
* CHECK dout1_40 vdout1_40ck118 = 1.0 time = 595
* CHECK dout1_41 vdout1_41ck118 = 0 time = 595
* CHECK dout1_42 vdout1_42ck118 = 1.0 time = 595
* CHECK dout1_43 vdout1_43ck118 = 1.0 time = 595
* CHECK dout1_44 vdout1_44ck118 = 1.0 time = 595
* CHECK dout1_45 vdout1_45ck118 = 1.0 time = 595
* CHECK dout1_46 vdout1_46ck118 = 0 time = 595
* CHECK dout1_47 vdout1_47ck118 = 0 time = 595
* CHECK dout1_48 vdout1_48ck118 = 0 time = 595
* CHECK dout1_49 vdout1_49ck118 = 1.0 time = 595
* CHECK dout1_50 vdout1_50ck118 = 1.0 time = 595
* CHECK dout1_51 vdout1_51ck118 = 0 time = 595
* CHECK dout1_52 vdout1_52ck118 = 1.0 time = 595
* CHECK dout1_53 vdout1_53ck118 = 0 time = 595
* CHECK dout1_54 vdout1_54ck118 = 0 time = 595
* CHECK dout1_55 vdout1_55ck118 = 1.0 time = 595
* CHECK dout1_56 vdout1_56ck118 = 0 time = 595
* CHECK dout1_57 vdout1_57ck118 = 0 time = 595
* CHECK dout1_58 vdout1_58ck118 = 1.0 time = 595
* CHECK dout1_59 vdout1_59ck118 = 1.0 time = 595
* CHECK dout1_60 vdout1_60ck118 = 1.0 time = 595
* CHECK dout1_61 vdout1_61ck118 = 1.0 time = 595
* CHECK dout1_62 vdout1_62ck118 = 0 time = 595
* CHECK dout1_63 vdout1_63ck118 = 1.0 time = 595
* CHECK dout0_0 vdout0_0ck119 = 0 time = 600
* CHECK dout0_1 vdout0_1ck119 = 0 time = 600
* CHECK dout0_2 vdout0_2ck119 = 1.0 time = 600
* CHECK dout0_3 vdout0_3ck119 = 0 time = 600
* CHECK dout0_4 vdout0_4ck119 = 1.0 time = 600
* CHECK dout0_5 vdout0_5ck119 = 0 time = 600
* CHECK dout0_6 vdout0_6ck119 = 0 time = 600
* CHECK dout0_7 vdout0_7ck119 = 0 time = 600
* CHECK dout0_8 vdout0_8ck119 = 1.0 time = 600
* CHECK dout0_9 vdout0_9ck119 = 0 time = 600
* CHECK dout0_10 vdout0_10ck119 = 1.0 time = 600
* CHECK dout0_11 vdout0_11ck119 = 1.0 time = 600
* CHECK dout0_12 vdout0_12ck119 = 0 time = 600
* CHECK dout0_13 vdout0_13ck119 = 0 time = 600
* CHECK dout0_14 vdout0_14ck119 = 0 time = 600
* CHECK dout0_15 vdout0_15ck119 = 0 time = 600
* CHECK dout0_16 vdout0_16ck119 = 0 time = 600
* CHECK dout0_17 vdout0_17ck119 = 1.0 time = 600
* CHECK dout0_18 vdout0_18ck119 = 1.0 time = 600
* CHECK dout0_19 vdout0_19ck119 = 1.0 time = 600
* CHECK dout0_20 vdout0_20ck119 = 0 time = 600
* CHECK dout0_21 vdout0_21ck119 = 0 time = 600
* CHECK dout0_22 vdout0_22ck119 = 0 time = 600
* CHECK dout0_23 vdout0_23ck119 = 1.0 time = 600
* CHECK dout0_24 vdout0_24ck119 = 0 time = 600
* CHECK dout0_25 vdout0_25ck119 = 0 time = 600
* CHECK dout0_26 vdout0_26ck119 = 1.0 time = 600
* CHECK dout0_27 vdout0_27ck119 = 0 time = 600
* CHECK dout0_28 vdout0_28ck119 = 1.0 time = 600
* CHECK dout0_29 vdout0_29ck119 = 1.0 time = 600
* CHECK dout0_30 vdout0_30ck119 = 0 time = 600
* CHECK dout0_31 vdout0_31ck119 = 1.0 time = 600
* CHECK dout0_32 vdout0_32ck119 = 0 time = 600
* CHECK dout0_33 vdout0_33ck119 = 1.0 time = 600
* CHECK dout0_34 vdout0_34ck119 = 0 time = 600
* CHECK dout0_35 vdout0_35ck119 = 1.0 time = 600
* CHECK dout0_36 vdout0_36ck119 = 1.0 time = 600
* CHECK dout0_37 vdout0_37ck119 = 0 time = 600
* CHECK dout0_38 vdout0_38ck119 = 0 time = 600
* CHECK dout0_39 vdout0_39ck119 = 1.0 time = 600
* CHECK dout0_40 vdout0_40ck119 = 0 time = 600
* CHECK dout0_41 vdout0_41ck119 = 1.0 time = 600
* CHECK dout0_42 vdout0_42ck119 = 1.0 time = 600
* CHECK dout0_43 vdout0_43ck119 = 0 time = 600
* CHECK dout0_44 vdout0_44ck119 = 1.0 time = 600
* CHECK dout0_45 vdout0_45ck119 = 1.0 time = 600
* CHECK dout0_46 vdout0_46ck119 = 0 time = 600
* CHECK dout0_47 vdout0_47ck119 = 0 time = 600
* CHECK dout0_48 vdout0_48ck119 = 0 time = 600
* CHECK dout0_49 vdout0_49ck119 = 1.0 time = 600
* CHECK dout0_50 vdout0_50ck119 = 0 time = 600
* CHECK dout0_51 vdout0_51ck119 = 0 time = 600
* CHECK dout0_52 vdout0_52ck119 = 0 time = 600
* CHECK dout0_53 vdout0_53ck119 = 1.0 time = 600
* CHECK dout0_54 vdout0_54ck119 = 0 time = 600
* CHECK dout0_55 vdout0_55ck119 = 0 time = 600
* CHECK dout0_56 vdout0_56ck119 = 1.0 time = 600
* CHECK dout0_57 vdout0_57ck119 = 1.0 time = 600
* CHECK dout0_58 vdout0_58ck119 = 0 time = 600
* CHECK dout0_59 vdout0_59ck119 = 1.0 time = 600
* CHECK dout0_60 vdout0_60ck119 = 1.0 time = 600
* CHECK dout0_61 vdout0_61ck119 = 1.0 time = 600
* CHECK dout0_62 vdout0_62ck119 = 1.0 time = 600
* CHECK dout0_63 vdout0_63ck119 = 0 time = 600
* CHECK dout1_0 vdout1_0ck119 = 0 time = 600
* CHECK dout1_1 vdout1_1ck119 = 1.0 time = 600
* CHECK dout1_2 vdout1_2ck119 = 0 time = 600
* CHECK dout1_3 vdout1_3ck119 = 1.0 time = 600
* CHECK dout1_4 vdout1_4ck119 = 0 time = 600
* CHECK dout1_5 vdout1_5ck119 = 0 time = 600
* CHECK dout1_6 vdout1_6ck119 = 1.0 time = 600
* CHECK dout1_7 vdout1_7ck119 = 0 time = 600
* CHECK dout1_8 vdout1_8ck119 = 1.0 time = 600
* CHECK dout1_9 vdout1_9ck119 = 1.0 time = 600
* CHECK dout1_10 vdout1_10ck119 = 1.0 time = 600
* CHECK dout1_11 vdout1_11ck119 = 0 time = 600
* CHECK dout1_12 vdout1_12ck119 = 1.0 time = 600
* CHECK dout1_13 vdout1_13ck119 = 1.0 time = 600
* CHECK dout1_14 vdout1_14ck119 = 0 time = 600
* CHECK dout1_15 vdout1_15ck119 = 1.0 time = 600
* CHECK dout1_16 vdout1_16ck119 = 1.0 time = 600
* CHECK dout1_17 vdout1_17ck119 = 1.0 time = 600
* CHECK dout1_18 vdout1_18ck119 = 1.0 time = 600
* CHECK dout1_19 vdout1_19ck119 = 1.0 time = 600
* CHECK dout1_20 vdout1_20ck119 = 1.0 time = 600
* CHECK dout1_21 vdout1_21ck119 = 0 time = 600
* CHECK dout1_22 vdout1_22ck119 = 0 time = 600
* CHECK dout1_23 vdout1_23ck119 = 1.0 time = 600
* CHECK dout1_24 vdout1_24ck119 = 0 time = 600
* CHECK dout1_25 vdout1_25ck119 = 0 time = 600
* CHECK dout1_26 vdout1_26ck119 = 1.0 time = 600
* CHECK dout1_27 vdout1_27ck119 = 0 time = 600
* CHECK dout1_28 vdout1_28ck119 = 0 time = 600
* CHECK dout1_29 vdout1_29ck119 = 0 time = 600
* CHECK dout1_30 vdout1_30ck119 = 0 time = 600
* CHECK dout1_31 vdout1_31ck119 = 0 time = 600
* CHECK dout1_32 vdout1_32ck119 = 1.0 time = 600
* CHECK dout1_33 vdout1_33ck119 = 1.0 time = 600
* CHECK dout1_34 vdout1_34ck119 = 0 time = 600
* CHECK dout1_35 vdout1_35ck119 = 0 time = 600
* CHECK dout1_36 vdout1_36ck119 = 1.0 time = 600
* CHECK dout1_37 vdout1_37ck119 = 1.0 time = 600
* CHECK dout1_38 vdout1_38ck119 = 1.0 time = 600
* CHECK dout1_39 vdout1_39ck119 = 0 time = 600
* CHECK dout1_40 vdout1_40ck119 = 1.0 time = 600
* CHECK dout1_41 vdout1_41ck119 = 0 time = 600
* CHECK dout1_42 vdout1_42ck119 = 0 time = 600
* CHECK dout1_43 vdout1_43ck119 = 0 time = 600
* CHECK dout1_44 vdout1_44ck119 = 1.0 time = 600
* CHECK dout1_45 vdout1_45ck119 = 1.0 time = 600
* CHECK dout1_46 vdout1_46ck119 = 0 time = 600
* CHECK dout1_47 vdout1_47ck119 = 0 time = 600
* CHECK dout1_48 vdout1_48ck119 = 0 time = 600
* CHECK dout1_49 vdout1_49ck119 = 0 time = 600
* CHECK dout1_50 vdout1_50ck119 = 1.0 time = 600
* CHECK dout1_51 vdout1_51ck119 = 1.0 time = 600
* CHECK dout1_52 vdout1_52ck119 = 0 time = 600
* CHECK dout1_53 vdout1_53ck119 = 1.0 time = 600
* CHECK dout1_54 vdout1_54ck119 = 0 time = 600
* CHECK dout1_55 vdout1_55ck119 = 0 time = 600
* CHECK dout1_56 vdout1_56ck119 = 1.0 time = 600
* CHECK dout1_57 vdout1_57ck119 = 0 time = 600
* CHECK dout1_58 vdout1_58ck119 = 0 time = 600
* CHECK dout1_59 vdout1_59ck119 = 0 time = 600
* CHECK dout1_60 vdout1_60ck119 = 1.0 time = 600
* CHECK dout1_61 vdout1_61ck119 = 1.0 time = 600
* CHECK dout1_62 vdout1_62ck119 = 0 time = 600
* CHECK dout1_63 vdout1_63ck119 = 0 time = 600
* CHECK dout1_0 vdout1_0ck120 = 1.0 time = 605
* CHECK dout1_1 vdout1_1ck120 = 1.0 time = 605
* CHECK dout1_2 vdout1_2ck120 = 1.0 time = 605
* CHECK dout1_3 vdout1_3ck120 = 1.0 time = 605
* CHECK dout1_4 vdout1_4ck120 = 1.0 time = 605
* CHECK dout1_5 vdout1_5ck120 = 0 time = 605
* CHECK dout1_6 vdout1_6ck120 = 0 time = 605
* CHECK dout1_7 vdout1_7ck120 = 1.0 time = 605
* CHECK dout1_8 vdout1_8ck120 = 1.0 time = 605
* CHECK dout1_9 vdout1_9ck120 = 0 time = 605
* CHECK dout1_10 vdout1_10ck120 = 0 time = 605
* CHECK dout1_11 vdout1_11ck120 = 1.0 time = 605
* CHECK dout1_12 vdout1_12ck120 = 1.0 time = 605
* CHECK dout1_13 vdout1_13ck120 = 0 time = 605
* CHECK dout1_14 vdout1_14ck120 = 1.0 time = 605
* CHECK dout1_15 vdout1_15ck120 = 0 time = 605
* CHECK dout1_16 vdout1_16ck120 = 1.0 time = 605
* CHECK dout1_17 vdout1_17ck120 = 0 time = 605
* CHECK dout1_18 vdout1_18ck120 = 0 time = 605
* CHECK dout1_19 vdout1_19ck120 = 1.0 time = 605
* CHECK dout1_20 vdout1_20ck120 = 0 time = 605
* CHECK dout1_21 vdout1_21ck120 = 0 time = 605
* CHECK dout1_22 vdout1_22ck120 = 0 time = 605
* CHECK dout1_23 vdout1_23ck120 = 1.0 time = 605
* CHECK dout1_24 vdout1_24ck120 = 0 time = 605
* CHECK dout1_25 vdout1_25ck120 = 0 time = 605
* CHECK dout1_26 vdout1_26ck120 = 0 time = 605
* CHECK dout1_27 vdout1_27ck120 = 0 time = 605
* CHECK dout1_28 vdout1_28ck120 = 1.0 time = 605
* CHECK dout1_29 vdout1_29ck120 = 0 time = 605
* CHECK dout1_30 vdout1_30ck120 = 1.0 time = 605
* CHECK dout1_31 vdout1_31ck120 = 0 time = 605
* CHECK dout1_32 vdout1_32ck120 = 1.0 time = 605
* CHECK dout1_33 vdout1_33ck120 = 1.0 time = 605
* CHECK dout1_34 vdout1_34ck120 = 0 time = 605
* CHECK dout1_35 vdout1_35ck120 = 1.0 time = 605
* CHECK dout1_36 vdout1_36ck120 = 1.0 time = 605
* CHECK dout1_37 vdout1_37ck120 = 1.0 time = 605
* CHECK dout1_38 vdout1_38ck120 = 1.0 time = 605
* CHECK dout1_39 vdout1_39ck120 = 1.0 time = 605
* CHECK dout1_40 vdout1_40ck120 = 1.0 time = 605
* CHECK dout1_41 vdout1_41ck120 = 1.0 time = 605
* CHECK dout1_42 vdout1_42ck120 = 0 time = 605
* CHECK dout1_43 vdout1_43ck120 = 0 time = 605
* CHECK dout1_44 vdout1_44ck120 = 1.0 time = 605
* CHECK dout1_45 vdout1_45ck120 = 1.0 time = 605
* CHECK dout1_46 vdout1_46ck120 = 0 time = 605
* CHECK dout1_47 vdout1_47ck120 = 0 time = 605
* CHECK dout1_48 vdout1_48ck120 = 1.0 time = 605
* CHECK dout1_49 vdout1_49ck120 = 0 time = 605
* CHECK dout1_50 vdout1_50ck120 = 1.0 time = 605
* CHECK dout1_51 vdout1_51ck120 = 1.0 time = 605
* CHECK dout1_52 vdout1_52ck120 = 0 time = 605
* CHECK dout1_53 vdout1_53ck120 = 1.0 time = 605
* CHECK dout1_54 vdout1_54ck120 = 1.0 time = 605
* CHECK dout1_55 vdout1_55ck120 = 1.0 time = 605
* CHECK dout1_56 vdout1_56ck120 = 0 time = 605
* CHECK dout1_57 vdout1_57ck120 = 1.0 time = 605
* CHECK dout1_58 vdout1_58ck120 = 1.0 time = 605
* CHECK dout1_59 vdout1_59ck120 = 0 time = 605
* CHECK dout1_60 vdout1_60ck120 = 0 time = 605
* CHECK dout1_61 vdout1_61ck120 = 1.0 time = 605
* CHECK dout1_62 vdout1_62ck120 = 1.0 time = 605
* CHECK dout1_63 vdout1_63ck120 = 1.0 time = 605
* CHECK dout0_0 vdout0_0ck121 = 0 time = 610
* CHECK dout0_1 vdout0_1ck121 = 1.0 time = 610
* CHECK dout0_2 vdout0_2ck121 = 0 time = 610
* CHECK dout0_3 vdout0_3ck121 = 0 time = 610
* CHECK dout0_4 vdout0_4ck121 = 0 time = 610
* CHECK dout0_5 vdout0_5ck121 = 1.0 time = 610
* CHECK dout0_6 vdout0_6ck121 = 0 time = 610
* CHECK dout0_7 vdout0_7ck121 = 0 time = 610
* CHECK dout0_8 vdout0_8ck121 = 0 time = 610
* CHECK dout0_9 vdout0_9ck121 = 0 time = 610
* CHECK dout0_10 vdout0_10ck121 = 1.0 time = 610
* CHECK dout0_11 vdout0_11ck121 = 1.0 time = 610
* CHECK dout0_12 vdout0_12ck121 = 1.0 time = 610
* CHECK dout0_13 vdout0_13ck121 = 0 time = 610
* CHECK dout0_14 vdout0_14ck121 = 1.0 time = 610
* CHECK dout0_15 vdout0_15ck121 = 0 time = 610
* CHECK dout0_16 vdout0_16ck121 = 1.0 time = 610
* CHECK dout0_17 vdout0_17ck121 = 0 time = 610
* CHECK dout0_18 vdout0_18ck121 = 0 time = 610
* CHECK dout0_19 vdout0_19ck121 = 1.0 time = 610
* CHECK dout0_20 vdout0_20ck121 = 0 time = 610
* CHECK dout0_21 vdout0_21ck121 = 0 time = 610
* CHECK dout0_22 vdout0_22ck121 = 0 time = 610
* CHECK dout0_23 vdout0_23ck121 = 1.0 time = 610
* CHECK dout0_24 vdout0_24ck121 = 0 time = 610
* CHECK dout0_25 vdout0_25ck121 = 0 time = 610
* CHECK dout0_26 vdout0_26ck121 = 1.0 time = 610
* CHECK dout0_27 vdout0_27ck121 = 0 time = 610
* CHECK dout0_28 vdout0_28ck121 = 0 time = 610
* CHECK dout0_29 vdout0_29ck121 = 1.0 time = 610
* CHECK dout0_30 vdout0_30ck121 = 1.0 time = 610
* CHECK dout0_31 vdout0_31ck121 = 0 time = 610
* CHECK dout0_32 vdout0_32ck121 = 0 time = 610
* CHECK dout0_33 vdout0_33ck121 = 1.0 time = 610
* CHECK dout0_34 vdout0_34ck121 = 0 time = 610
* CHECK dout0_35 vdout0_35ck121 = 0 time = 610
* CHECK dout0_36 vdout0_36ck121 = 0 time = 610
* CHECK dout0_37 vdout0_37ck121 = 1.0 time = 610
* CHECK dout0_38 vdout0_38ck121 = 1.0 time = 610
* CHECK dout0_39 vdout0_39ck121 = 1.0 time = 610
* CHECK dout0_40 vdout0_40ck121 = 1.0 time = 610
* CHECK dout0_41 vdout0_41ck121 = 0 time = 610
* CHECK dout0_42 vdout0_42ck121 = 1.0 time = 610
* CHECK dout0_43 vdout0_43ck121 = 1.0 time = 610
* CHECK dout0_44 vdout0_44ck121 = 1.0 time = 610
* CHECK dout0_45 vdout0_45ck121 = 1.0 time = 610
* CHECK dout0_46 vdout0_46ck121 = 0 time = 610
* CHECK dout0_47 vdout0_47ck121 = 0 time = 610
* CHECK dout0_48 vdout0_48ck121 = 0 time = 610
* CHECK dout0_49 vdout0_49ck121 = 1.0 time = 610
* CHECK dout0_50 vdout0_50ck121 = 1.0 time = 610
* CHECK dout0_51 vdout0_51ck121 = 0 time = 610
* CHECK dout0_52 vdout0_52ck121 = 1.0 time = 610
* CHECK dout0_53 vdout0_53ck121 = 0 time = 610
* CHECK dout0_54 vdout0_54ck121 = 0 time = 610
* CHECK dout0_55 vdout0_55ck121 = 1.0 time = 610
* CHECK dout0_56 vdout0_56ck121 = 0 time = 610
* CHECK dout0_57 vdout0_57ck121 = 0 time = 610
* CHECK dout0_58 vdout0_58ck121 = 1.0 time = 610
* CHECK dout0_59 vdout0_59ck121 = 1.0 time = 610
* CHECK dout0_60 vdout0_60ck121 = 1.0 time = 610
* CHECK dout0_61 vdout0_61ck121 = 1.0 time = 610
* CHECK dout0_62 vdout0_62ck121 = 0 time = 610
* CHECK dout0_63 vdout0_63ck121 = 1.0 time = 610
* CHECK dout1_0 vdout1_0ck122 = 0 time = 615
* CHECK dout1_1 vdout1_1ck122 = 0 time = 615
* CHECK dout1_2 vdout1_2ck122 = 1.0 time = 615
* CHECK dout1_3 vdout1_3ck122 = 1.0 time = 615
* CHECK dout1_4 vdout1_4ck122 = 1.0 time = 615
* CHECK dout1_5 vdout1_5ck122 = 0 time = 615
* CHECK dout1_6 vdout1_6ck122 = 0 time = 615
* CHECK dout1_7 vdout1_7ck122 = 1.0 time = 615
* CHECK dout1_8 vdout1_8ck122 = 0 time = 615
* CHECK dout1_9 vdout1_9ck122 = 1.0 time = 615
* CHECK dout1_10 vdout1_10ck122 = 0 time = 615
* CHECK dout1_11 vdout1_11ck122 = 0 time = 615
* CHECK dout1_12 vdout1_12ck122 = 0 time = 615
* CHECK dout1_13 vdout1_13ck122 = 0 time = 615
* CHECK dout1_14 vdout1_14ck122 = 1.0 time = 615
* CHECK dout1_15 vdout1_15ck122 = 1.0 time = 615
* CHECK dout1_16 vdout1_16ck122 = 0 time = 615
* CHECK dout1_17 vdout1_17ck122 = 1.0 time = 615
* CHECK dout1_18 vdout1_18ck122 = 0 time = 615
* CHECK dout1_19 vdout1_19ck122 = 0 time = 615
* CHECK dout1_20 vdout1_20ck122 = 1.0 time = 615
* CHECK dout1_21 vdout1_21ck122 = 1.0 time = 615
* CHECK dout1_22 vdout1_22ck122 = 1.0 time = 615
* CHECK dout1_23 vdout1_23ck122 = 1.0 time = 615
* CHECK dout1_24 vdout1_24ck122 = 1.0 time = 615
* CHECK dout1_25 vdout1_25ck122 = 0 time = 615
* CHECK dout1_26 vdout1_26ck122 = 1.0 time = 615
* CHECK dout1_27 vdout1_27ck122 = 1.0 time = 615
* CHECK dout1_28 vdout1_28ck122 = 0 time = 615
* CHECK dout1_29 vdout1_29ck122 = 1.0 time = 615
* CHECK dout1_30 vdout1_30ck122 = 1.0 time = 615
* CHECK dout1_31 vdout1_31ck122 = 0 time = 615
* CHECK dout1_32 vdout1_32ck122 = 0 time = 615
* CHECK dout1_33 vdout1_33ck122 = 0 time = 615
* CHECK dout1_34 vdout1_34ck122 = 0 time = 615
* CHECK dout1_35 vdout1_35ck122 = 1.0 time = 615
* CHECK dout1_36 vdout1_36ck122 = 0 time = 615
* CHECK dout1_37 vdout1_37ck122 = 1.0 time = 615
* CHECK dout1_38 vdout1_38ck122 = 0 time = 615
* CHECK dout1_39 vdout1_39ck122 = 1.0 time = 615
* CHECK dout1_40 vdout1_40ck122 = 1.0 time = 615
* CHECK dout1_41 vdout1_41ck122 = 1.0 time = 615
* CHECK dout1_42 vdout1_42ck122 = 1.0 time = 615
* CHECK dout1_43 vdout1_43ck122 = 0 time = 615
* CHECK dout1_44 vdout1_44ck122 = 0 time = 615
* CHECK dout1_45 vdout1_45ck122 = 1.0 time = 615
* CHECK dout1_46 vdout1_46ck122 = 1.0 time = 615
* CHECK dout1_47 vdout1_47ck122 = 0 time = 615
* CHECK dout1_48 vdout1_48ck122 = 1.0 time = 615
* CHECK dout1_49 vdout1_49ck122 = 1.0 time = 615
* CHECK dout1_50 vdout1_50ck122 = 0 time = 615
* CHECK dout1_51 vdout1_51ck122 = 0 time = 615
* CHECK dout1_52 vdout1_52ck122 = 1.0 time = 615
* CHECK dout1_53 vdout1_53ck122 = 0 time = 615
* CHECK dout1_54 vdout1_54ck122 = 1.0 time = 615
* CHECK dout1_55 vdout1_55ck122 = 0 time = 615
* CHECK dout1_56 vdout1_56ck122 = 1.0 time = 615
* CHECK dout1_57 vdout1_57ck122 = 1.0 time = 615
* CHECK dout1_58 vdout1_58ck122 = 0 time = 615
* CHECK dout1_59 vdout1_59ck122 = 1.0 time = 615
* CHECK dout1_60 vdout1_60ck122 = 1.0 time = 615
* CHECK dout1_61 vdout1_61ck122 = 0 time = 615
* CHECK dout1_62 vdout1_62ck122 = 0 time = 615
* CHECK dout1_63 vdout1_63ck122 = 1.0 time = 615
* CHECK dout0_0 vdout0_0ck123 = 0 time = 620
* CHECK dout0_1 vdout0_1ck123 = 1.0 time = 620
* CHECK dout0_2 vdout0_2ck123 = 0 time = 620
* CHECK dout0_3 vdout0_3ck123 = 1.0 time = 620
* CHECK dout0_4 vdout0_4ck123 = 0 time = 620
* CHECK dout0_5 vdout0_5ck123 = 0 time = 620
* CHECK dout0_6 vdout0_6ck123 = 0 time = 620
* CHECK dout0_7 vdout0_7ck123 = 1.0 time = 620
* CHECK dout0_8 vdout0_8ck123 = 1.0 time = 620
* CHECK dout0_9 vdout0_9ck123 = 0 time = 620
* CHECK dout0_10 vdout0_10ck123 = 1.0 time = 620
* CHECK dout0_11 vdout0_11ck123 = 1.0 time = 620
* CHECK dout0_12 vdout0_12ck123 = 0 time = 620
* CHECK dout0_13 vdout0_13ck123 = 1.0 time = 620
* CHECK dout0_14 vdout0_14ck123 = 0 time = 620
* CHECK dout0_15 vdout0_15ck123 = 0 time = 620
* CHECK dout0_16 vdout0_16ck123 = 0 time = 620
* CHECK dout0_17 vdout0_17ck123 = 1.0 time = 620
* CHECK dout0_18 vdout0_18ck123 = 1.0 time = 620
* CHECK dout0_19 vdout0_19ck123 = 1.0 time = 620
* CHECK dout0_20 vdout0_20ck123 = 1.0 time = 620
* CHECK dout0_21 vdout0_21ck123 = 1.0 time = 620
* CHECK dout0_22 vdout0_22ck123 = 0 time = 620
* CHECK dout0_23 vdout0_23ck123 = 1.0 time = 620
* CHECK dout0_24 vdout0_24ck123 = 0 time = 620
* CHECK dout0_25 vdout0_25ck123 = 0 time = 620
* CHECK dout0_26 vdout0_26ck123 = 0 time = 620
* CHECK dout0_27 vdout0_27ck123 = 0 time = 620
* CHECK dout0_28 vdout0_28ck123 = 0 time = 620
* CHECK dout0_29 vdout0_29ck123 = 0 time = 620
* CHECK dout0_30 vdout0_30ck123 = 1.0 time = 620
* CHECK dout0_31 vdout0_31ck123 = 1.0 time = 620
* CHECK dout0_32 vdout0_32ck123 = 1.0 time = 620
* CHECK dout0_33 vdout0_33ck123 = 0 time = 620
* CHECK dout0_34 vdout0_34ck123 = 1.0 time = 620
* CHECK dout0_35 vdout0_35ck123 = 1.0 time = 620
* CHECK dout0_36 vdout0_36ck123 = 1.0 time = 620
* CHECK dout0_37 vdout0_37ck123 = 1.0 time = 620
* CHECK dout0_38 vdout0_38ck123 = 0 time = 620
* CHECK dout0_39 vdout0_39ck123 = 0 time = 620
* CHECK dout0_40 vdout0_40ck123 = 1.0 time = 620
* CHECK dout0_41 vdout0_41ck123 = 1.0 time = 620
* CHECK dout0_42 vdout0_42ck123 = 1.0 time = 620
* CHECK dout0_43 vdout0_43ck123 = 0 time = 620
* CHECK dout0_44 vdout0_44ck123 = 0 time = 620
* CHECK dout0_45 vdout0_45ck123 = 1.0 time = 620
* CHECK dout0_46 vdout0_46ck123 = 0 time = 620
* CHECK dout0_47 vdout0_47ck123 = 0 time = 620
* CHECK dout0_48 vdout0_48ck123 = 0 time = 620
* CHECK dout0_49 vdout0_49ck123 = 0 time = 620
* CHECK dout0_50 vdout0_50ck123 = 1.0 time = 620
* CHECK dout0_51 vdout0_51ck123 = 1.0 time = 620
* CHECK dout0_52 vdout0_52ck123 = 0 time = 620
* CHECK dout0_53 vdout0_53ck123 = 1.0 time = 620
* CHECK dout0_54 vdout0_54ck123 = 1.0 time = 620
* CHECK dout0_55 vdout0_55ck123 = 0 time = 620
* CHECK dout0_56 vdout0_56ck123 = 1.0 time = 620
* CHECK dout0_57 vdout0_57ck123 = 1.0 time = 620
* CHECK dout0_58 vdout0_58ck123 = 1.0 time = 620
* CHECK dout0_59 vdout0_59ck123 = 0 time = 620
* CHECK dout0_60 vdout0_60ck123 = 0 time = 620
* CHECK dout0_61 vdout0_61ck123 = 1.0 time = 620
* CHECK dout0_62 vdout0_62ck123 = 1.0 time = 620
* CHECK dout0_63 vdout0_63ck123 = 1.0 time = 620
* CHECK dout1_0 vdout1_0ck124 = 0 time = 625
* CHECK dout1_1 vdout1_1ck124 = 0 time = 625
* CHECK dout1_2 vdout1_2ck124 = 1.0 time = 625
* CHECK dout1_3 vdout1_3ck124 = 0 time = 625
* CHECK dout1_4 vdout1_4ck124 = 1.0 time = 625
* CHECK dout1_5 vdout1_5ck124 = 0 time = 625
* CHECK dout1_6 vdout1_6ck124 = 0 time = 625
* CHECK dout1_7 vdout1_7ck124 = 0 time = 625
* CHECK dout1_8 vdout1_8ck124 = 1.0 time = 625
* CHECK dout1_9 vdout1_9ck124 = 0 time = 625
* CHECK dout1_10 vdout1_10ck124 = 1.0 time = 625
* CHECK dout1_11 vdout1_11ck124 = 1.0 time = 625
* CHECK dout1_12 vdout1_12ck124 = 0 time = 625
* CHECK dout1_13 vdout1_13ck124 = 0 time = 625
* CHECK dout1_14 vdout1_14ck124 = 0 time = 625
* CHECK dout1_15 vdout1_15ck124 = 0 time = 625
* CHECK dout1_16 vdout1_16ck124 = 0 time = 625
* CHECK dout1_17 vdout1_17ck124 = 1.0 time = 625
* CHECK dout1_18 vdout1_18ck124 = 1.0 time = 625
* CHECK dout1_19 vdout1_19ck124 = 1.0 time = 625
* CHECK dout1_20 vdout1_20ck124 = 0 time = 625
* CHECK dout1_21 vdout1_21ck124 = 0 time = 625
* CHECK dout1_22 vdout1_22ck124 = 0 time = 625
* CHECK dout1_23 vdout1_23ck124 = 1.0 time = 625
* CHECK dout1_24 vdout1_24ck124 = 0 time = 625
* CHECK dout1_25 vdout1_25ck124 = 0 time = 625
* CHECK dout1_26 vdout1_26ck124 = 1.0 time = 625
* CHECK dout1_27 vdout1_27ck124 = 0 time = 625
* CHECK dout1_28 vdout1_28ck124 = 1.0 time = 625
* CHECK dout1_29 vdout1_29ck124 = 1.0 time = 625
* CHECK dout1_30 vdout1_30ck124 = 0 time = 625
* CHECK dout1_31 vdout1_31ck124 = 1.0 time = 625
* CHECK dout1_32 vdout1_32ck124 = 0 time = 625
* CHECK dout1_33 vdout1_33ck124 = 1.0 time = 625
* CHECK dout1_34 vdout1_34ck124 = 0 time = 625
* CHECK dout1_35 vdout1_35ck124 = 1.0 time = 625
* CHECK dout1_36 vdout1_36ck124 = 1.0 time = 625
* CHECK dout1_37 vdout1_37ck124 = 0 time = 625
* CHECK dout1_38 vdout1_38ck124 = 0 time = 625
* CHECK dout1_39 vdout1_39ck124 = 1.0 time = 625
* CHECK dout1_40 vdout1_40ck124 = 0 time = 625
* CHECK dout1_41 vdout1_41ck124 = 1.0 time = 625
* CHECK dout1_42 vdout1_42ck124 = 1.0 time = 625
* CHECK dout1_43 vdout1_43ck124 = 0 time = 625
* CHECK dout1_44 vdout1_44ck124 = 1.0 time = 625
* CHECK dout1_45 vdout1_45ck124 = 1.0 time = 625
* CHECK dout1_46 vdout1_46ck124 = 0 time = 625
* CHECK dout1_47 vdout1_47ck124 = 0 time = 625
* CHECK dout1_48 vdout1_48ck124 = 0 time = 625
* CHECK dout1_49 vdout1_49ck124 = 1.0 time = 625
* CHECK dout1_50 vdout1_50ck124 = 0 time = 625
* CHECK dout1_51 vdout1_51ck124 = 0 time = 625
* CHECK dout1_52 vdout1_52ck124 = 0 time = 625
* CHECK dout1_53 vdout1_53ck124 = 1.0 time = 625
* CHECK dout1_54 vdout1_54ck124 = 0 time = 625
* CHECK dout1_55 vdout1_55ck124 = 0 time = 625
* CHECK dout1_56 vdout1_56ck124 = 1.0 time = 625
* CHECK dout1_57 vdout1_57ck124 = 1.0 time = 625
* CHECK dout1_58 vdout1_58ck124 = 0 time = 625
* CHECK dout1_59 vdout1_59ck124 = 1.0 time = 625
* CHECK dout1_60 vdout1_60ck124 = 1.0 time = 625
* CHECK dout1_61 vdout1_61ck124 = 1.0 time = 625
* CHECK dout1_62 vdout1_62ck124 = 1.0 time = 625
* CHECK dout1_63 vdout1_63ck124 = 0 time = 625
* CHECK dout0_0 vdout0_0ck125 = 0 time = 630
* CHECK dout0_1 vdout0_1ck125 = 0 time = 630
* CHECK dout0_2 vdout0_2ck125 = 1.0 time = 630
* CHECK dout0_3 vdout0_3ck125 = 0 time = 630
* CHECK dout0_4 vdout0_4ck125 = 1.0 time = 630
* CHECK dout0_5 vdout0_5ck125 = 0 time = 630
* CHECK dout0_6 vdout0_6ck125 = 0 time = 630
* CHECK dout0_7 vdout0_7ck125 = 0 time = 630
* CHECK dout0_8 vdout0_8ck125 = 1.0 time = 630
* CHECK dout0_9 vdout0_9ck125 = 0 time = 630
* CHECK dout0_10 vdout0_10ck125 = 1.0 time = 630
* CHECK dout0_11 vdout0_11ck125 = 1.0 time = 630
* CHECK dout0_12 vdout0_12ck125 = 0 time = 630
* CHECK dout0_13 vdout0_13ck125 = 0 time = 630
* CHECK dout0_14 vdout0_14ck125 = 0 time = 630
* CHECK dout0_15 vdout0_15ck125 = 0 time = 630
* CHECK dout0_16 vdout0_16ck125 = 0 time = 630
* CHECK dout0_17 vdout0_17ck125 = 1.0 time = 630
* CHECK dout0_18 vdout0_18ck125 = 1.0 time = 630
* CHECK dout0_19 vdout0_19ck125 = 1.0 time = 630
* CHECK dout0_20 vdout0_20ck125 = 0 time = 630
* CHECK dout0_21 vdout0_21ck125 = 0 time = 630
* CHECK dout0_22 vdout0_22ck125 = 0 time = 630
* CHECK dout0_23 vdout0_23ck125 = 1.0 time = 630
* CHECK dout0_24 vdout0_24ck125 = 0 time = 630
* CHECK dout0_25 vdout0_25ck125 = 0 time = 630
* CHECK dout0_26 vdout0_26ck125 = 1.0 time = 630
* CHECK dout0_27 vdout0_27ck125 = 0 time = 630
* CHECK dout0_28 vdout0_28ck125 = 1.0 time = 630
* CHECK dout0_29 vdout0_29ck125 = 1.0 time = 630
* CHECK dout0_30 vdout0_30ck125 = 0 time = 630
* CHECK dout0_31 vdout0_31ck125 = 1.0 time = 630
* CHECK dout0_32 vdout0_32ck125 = 0 time = 630
* CHECK dout0_33 vdout0_33ck125 = 1.0 time = 630
* CHECK dout0_34 vdout0_34ck125 = 0 time = 630
* CHECK dout0_35 vdout0_35ck125 = 1.0 time = 630
* CHECK dout0_36 vdout0_36ck125 = 1.0 time = 630
* CHECK dout0_37 vdout0_37ck125 = 0 time = 630
* CHECK dout0_38 vdout0_38ck125 = 0 time = 630
* CHECK dout0_39 vdout0_39ck125 = 1.0 time = 630
* CHECK dout0_40 vdout0_40ck125 = 0 time = 630
* CHECK dout0_41 vdout0_41ck125 = 1.0 time = 630
* CHECK dout0_42 vdout0_42ck125 = 1.0 time = 630
* CHECK dout0_43 vdout0_43ck125 = 0 time = 630
* CHECK dout0_44 vdout0_44ck125 = 1.0 time = 630
* CHECK dout0_45 vdout0_45ck125 = 1.0 time = 630
* CHECK dout0_46 vdout0_46ck125 = 0 time = 630
* CHECK dout0_47 vdout0_47ck125 = 0 time = 630
* CHECK dout0_48 vdout0_48ck125 = 0 time = 630
* CHECK dout0_49 vdout0_49ck125 = 1.0 time = 630
* CHECK dout0_50 vdout0_50ck125 = 0 time = 630
* CHECK dout0_51 vdout0_51ck125 = 0 time = 630
* CHECK dout0_52 vdout0_52ck125 = 0 time = 630
* CHECK dout0_53 vdout0_53ck125 = 1.0 time = 630
* CHECK dout0_54 vdout0_54ck125 = 0 time = 630
* CHECK dout0_55 vdout0_55ck125 = 0 time = 630
* CHECK dout0_56 vdout0_56ck125 = 1.0 time = 630
* CHECK dout0_57 vdout0_57ck125 = 1.0 time = 630
* CHECK dout0_58 vdout0_58ck125 = 0 time = 630
* CHECK dout0_59 vdout0_59ck125 = 1.0 time = 630
* CHECK dout0_60 vdout0_60ck125 = 1.0 time = 630
* CHECK dout0_61 vdout0_61ck125 = 1.0 time = 630
* CHECK dout0_62 vdout0_62ck125 = 1.0 time = 630
* CHECK dout0_63 vdout0_63ck125 = 0 time = 630
* CHECK dout0_0 vdout0_0ck126 = 0 time = 635
* CHECK dout0_1 vdout0_1ck126 = 1.0 time = 635
* CHECK dout0_2 vdout0_2ck126 = 1.0 time = 635
* CHECK dout0_3 vdout0_3ck126 = 1.0 time = 635
* CHECK dout0_4 vdout0_4ck126 = 0 time = 635
* CHECK dout0_5 vdout0_5ck126 = 1.0 time = 635
* CHECK dout0_6 vdout0_6ck126 = 1.0 time = 635
* CHECK dout0_7 vdout0_7ck126 = 0 time = 635
* CHECK dout0_8 vdout0_8ck126 = 0 time = 635
* CHECK dout0_9 vdout0_9ck126 = 0 time = 635
* CHECK dout0_10 vdout0_10ck126 = 1.0 time = 635
* CHECK dout0_11 vdout0_11ck126 = 1.0 time = 635
* CHECK dout0_12 vdout0_12ck126 = 0 time = 635
* CHECK dout0_13 vdout0_13ck126 = 0 time = 635
* CHECK dout0_14 vdout0_14ck126 = 0 time = 635
* CHECK dout0_15 vdout0_15ck126 = 1.0 time = 635
* CHECK dout0_16 vdout0_16ck126 = 1.0 time = 635
* CHECK dout0_17 vdout0_17ck126 = 0 time = 635
* CHECK dout0_18 vdout0_18ck126 = 0 time = 635
* CHECK dout0_19 vdout0_19ck126 = 0 time = 635
* CHECK dout0_20 vdout0_20ck126 = 0 time = 635
* CHECK dout0_21 vdout0_21ck126 = 0 time = 635
* CHECK dout0_22 vdout0_22ck126 = 1.0 time = 635
* CHECK dout0_23 vdout0_23ck126 = 0 time = 635
* CHECK dout0_24 vdout0_24ck126 = 1.0 time = 635
* CHECK dout0_25 vdout0_25ck126 = 1.0 time = 635
* CHECK dout0_26 vdout0_26ck126 = 0 time = 635
* CHECK dout0_27 vdout0_27ck126 = 0 time = 635
* CHECK dout0_28 vdout0_28ck126 = 1.0 time = 635
* CHECK dout0_29 vdout0_29ck126 = 0 time = 635
* CHECK dout0_30 vdout0_30ck126 = 1.0 time = 635
* CHECK dout0_31 vdout0_31ck126 = 0 time = 635
* CHECK dout0_32 vdout0_32ck126 = 0 time = 635
* CHECK dout0_33 vdout0_33ck126 = 1.0 time = 635
* CHECK dout0_34 vdout0_34ck126 = 1.0 time = 635
* CHECK dout0_35 vdout0_35ck126 = 1.0 time = 635
* CHECK dout0_36 vdout0_36ck126 = 1.0 time = 635
* CHECK dout0_37 vdout0_37ck126 = 1.0 time = 635
* CHECK dout0_38 vdout0_38ck126 = 0 time = 635
* CHECK dout0_39 vdout0_39ck126 = 0 time = 635
* CHECK dout0_40 vdout0_40ck126 = 1.0 time = 635
* CHECK dout0_41 vdout0_41ck126 = 1.0 time = 635
* CHECK dout0_42 vdout0_42ck126 = 0 time = 635
* CHECK dout0_43 vdout0_43ck126 = 0 time = 635
* CHECK dout0_44 vdout0_44ck126 = 1.0 time = 635
* CHECK dout0_45 vdout0_45ck126 = 1.0 time = 635
* CHECK dout0_46 vdout0_46ck126 = 1.0 time = 635
* CHECK dout0_47 vdout0_47ck126 = 0 time = 635
* CHECK dout0_48 vdout0_48ck126 = 0 time = 635
* CHECK dout0_49 vdout0_49ck126 = 0 time = 635
* CHECK dout0_50 vdout0_50ck126 = 0 time = 635
* CHECK dout0_51 vdout0_51ck126 = 0 time = 635
* CHECK dout0_52 vdout0_52ck126 = 1.0 time = 635
* CHECK dout0_53 vdout0_53ck126 = 1.0 time = 635
* CHECK dout0_54 vdout0_54ck126 = 0 time = 635
* CHECK dout0_55 vdout0_55ck126 = 0 time = 635
* CHECK dout0_56 vdout0_56ck126 = 1.0 time = 635
* CHECK dout0_57 vdout0_57ck126 = 1.0 time = 635
* CHECK dout0_58 vdout0_58ck126 = 1.0 time = 635
* CHECK dout0_59 vdout0_59ck126 = 1.0 time = 635
* CHECK dout0_60 vdout0_60ck126 = 1.0 time = 635
* CHECK dout0_61 vdout0_61ck126 = 1.0 time = 635
* CHECK dout0_62 vdout0_62ck126 = 0 time = 635
* CHECK dout0_63 vdout0_63ck126 = 0 time = 635
* CHECK dout1_0 vdout1_0ck128 = 1.0 time = 645
* CHECK dout1_1 vdout1_1ck128 = 0 time = 645
* CHECK dout1_2 vdout1_2ck128 = 0 time = 645
* CHECK dout1_3 vdout1_3ck128 = 0 time = 645
* CHECK dout1_4 vdout1_4ck128 = 0 time = 645
* CHECK dout1_5 vdout1_5ck128 = 1.0 time = 645
* CHECK dout1_6 vdout1_6ck128 = 1.0 time = 645
* CHECK dout1_7 vdout1_7ck128 = 1.0 time = 645
* CHECK dout1_8 vdout1_8ck128 = 1.0 time = 645
* CHECK dout1_9 vdout1_9ck128 = 0 time = 645
* CHECK dout1_10 vdout1_10ck128 = 1.0 time = 645
* CHECK dout1_11 vdout1_11ck128 = 1.0 time = 645
* CHECK dout1_12 vdout1_12ck128 = 0 time = 645
* CHECK dout1_13 vdout1_13ck128 = 0 time = 645
* CHECK dout1_14 vdout1_14ck128 = 0 time = 645
* CHECK dout1_15 vdout1_15ck128 = 0 time = 645
* CHECK dout1_16 vdout1_16ck128 = 0 time = 645
* CHECK dout1_17 vdout1_17ck128 = 0 time = 645
* CHECK dout1_18 vdout1_18ck128 = 0 time = 645
* CHECK dout1_19 vdout1_19ck128 = 1.0 time = 645
* CHECK dout1_20 vdout1_20ck128 = 0 time = 645
* CHECK dout1_21 vdout1_21ck128 = 1.0 time = 645
* CHECK dout1_22 vdout1_22ck128 = 1.0 time = 645
* CHECK dout1_23 vdout1_23ck128 = 0 time = 645
* CHECK dout1_24 vdout1_24ck128 = 0 time = 645
* CHECK dout1_25 vdout1_25ck128 = 0 time = 645
* CHECK dout1_26 vdout1_26ck128 = 1.0 time = 645
* CHECK dout1_27 vdout1_27ck128 = 0 time = 645
* CHECK dout1_28 vdout1_28ck128 = 0 time = 645
* CHECK dout1_29 vdout1_29ck128 = 1.0 time = 645
* CHECK dout1_30 vdout1_30ck128 = 1.0 time = 645
* CHECK dout1_31 vdout1_31ck128 = 1.0 time = 645
* CHECK dout1_32 vdout1_32ck128 = 0 time = 645
* CHECK dout1_33 vdout1_33ck128 = 0 time = 645
* CHECK dout1_34 vdout1_34ck128 = 0 time = 645
* CHECK dout1_35 vdout1_35ck128 = 0 time = 645
* CHECK dout1_36 vdout1_36ck128 = 0 time = 645
* CHECK dout1_37 vdout1_37ck128 = 0 time = 645
* CHECK dout1_38 vdout1_38ck128 = 0 time = 645
* CHECK dout1_39 vdout1_39ck128 = 0 time = 645
* CHECK dout1_40 vdout1_40ck128 = 1.0 time = 645
* CHECK dout1_41 vdout1_41ck128 = 1.0 time = 645
* CHECK dout1_42 vdout1_42ck128 = 1.0 time = 645
* CHECK dout1_43 vdout1_43ck128 = 1.0 time = 645
* CHECK dout1_44 vdout1_44ck128 = 0 time = 645
* CHECK dout1_45 vdout1_45ck128 = 0 time = 645
* CHECK dout1_46 vdout1_46ck128 = 1.0 time = 645
* CHECK dout1_47 vdout1_47ck128 = 0 time = 645
* CHECK dout1_48 vdout1_48ck128 = 0 time = 645
* CHECK dout1_49 vdout1_49ck128 = 0 time = 645
* CHECK dout1_50 vdout1_50ck128 = 1.0 time = 645
* CHECK dout1_51 vdout1_51ck128 = 0 time = 645
* CHECK dout1_52 vdout1_52ck128 = 1.0 time = 645
* CHECK dout1_53 vdout1_53ck128 = 1.0 time = 645
* CHECK dout1_54 vdout1_54ck128 = 0 time = 645
* CHECK dout1_55 vdout1_55ck128 = 1.0 time = 645
* CHECK dout1_56 vdout1_56ck128 = 0 time = 645
* CHECK dout1_57 vdout1_57ck128 = 1.0 time = 645
* CHECK dout1_58 vdout1_58ck128 = 1.0 time = 645
* CHECK dout1_59 vdout1_59ck128 = 0 time = 645
* CHECK dout1_60 vdout1_60ck128 = 0 time = 645
* CHECK dout1_61 vdout1_61ck128 = 0 time = 645
* CHECK dout1_62 vdout1_62ck128 = 1.0 time = 645
* CHECK dout1_63 vdout1_63ck128 = 0 time = 645
* CHECK dout1_0 vdout1_0ck130 = 1.0 time = 655
* CHECK dout1_1 vdout1_1ck130 = 0 time = 655
* CHECK dout1_2 vdout1_2ck130 = 1.0 time = 655
* CHECK dout1_3 vdout1_3ck130 = 0 time = 655
* CHECK dout1_4 vdout1_4ck130 = 1.0 time = 655
* CHECK dout1_5 vdout1_5ck130 = 1.0 time = 655
* CHECK dout1_6 vdout1_6ck130 = 0 time = 655
* CHECK dout1_7 vdout1_7ck130 = 1.0 time = 655
* CHECK dout1_8 vdout1_8ck130 = 1.0 time = 655
* CHECK dout1_9 vdout1_9ck130 = 0 time = 655
* CHECK dout1_10 vdout1_10ck130 = 1.0 time = 655
* CHECK dout1_11 vdout1_11ck130 = 0 time = 655
* CHECK dout1_12 vdout1_12ck130 = 1.0 time = 655
* CHECK dout1_13 vdout1_13ck130 = 0 time = 655
* CHECK dout1_14 vdout1_14ck130 = 1.0 time = 655
* CHECK dout1_15 vdout1_15ck130 = 1.0 time = 655
* CHECK dout1_16 vdout1_16ck130 = 0 time = 655
* CHECK dout1_17 vdout1_17ck130 = 1.0 time = 655
* CHECK dout1_18 vdout1_18ck130 = 1.0 time = 655
* CHECK dout1_19 vdout1_19ck130 = 1.0 time = 655
* CHECK dout1_20 vdout1_20ck130 = 1.0 time = 655
* CHECK dout1_21 vdout1_21ck130 = 0 time = 655
* CHECK dout1_22 vdout1_22ck130 = 1.0 time = 655
* CHECK dout1_23 vdout1_23ck130 = 1.0 time = 655
* CHECK dout1_24 vdout1_24ck130 = 0 time = 655
* CHECK dout1_25 vdout1_25ck130 = 1.0 time = 655
* CHECK dout1_26 vdout1_26ck130 = 1.0 time = 655
* CHECK dout1_27 vdout1_27ck130 = 1.0 time = 655
* CHECK dout1_28 vdout1_28ck130 = 1.0 time = 655
* CHECK dout1_29 vdout1_29ck130 = 0 time = 655
* CHECK dout1_30 vdout1_30ck130 = 1.0 time = 655
* CHECK dout1_31 vdout1_31ck130 = 0 time = 655
* CHECK dout1_32 vdout1_32ck130 = 0 time = 655
* CHECK dout1_33 vdout1_33ck130 = 1.0 time = 655
* CHECK dout1_34 vdout1_34ck130 = 1.0 time = 655
* CHECK dout1_35 vdout1_35ck130 = 0 time = 655
* CHECK dout1_36 vdout1_36ck130 = 1.0 time = 655
* CHECK dout1_37 vdout1_37ck130 = 1.0 time = 655
* CHECK dout1_38 vdout1_38ck130 = 0 time = 655
* CHECK dout1_39 vdout1_39ck130 = 1.0 time = 655
* CHECK dout1_40 vdout1_40ck130 = 1.0 time = 655
* CHECK dout1_41 vdout1_41ck130 = 1.0 time = 655
* CHECK dout1_42 vdout1_42ck130 = 0 time = 655
* CHECK dout1_43 vdout1_43ck130 = 0 time = 655
* CHECK dout1_44 vdout1_44ck130 = 0 time = 655
* CHECK dout1_45 vdout1_45ck130 = 1.0 time = 655
* CHECK dout1_46 vdout1_46ck130 = 0 time = 655
* CHECK dout1_47 vdout1_47ck130 = 1.0 time = 655
* CHECK dout1_48 vdout1_48ck130 = 0 time = 655
* CHECK dout1_49 vdout1_49ck130 = 0 time = 655
* CHECK dout1_50 vdout1_50ck130 = 0 time = 655
* CHECK dout1_51 vdout1_51ck130 = 1.0 time = 655
* CHECK dout1_52 vdout1_52ck130 = 0 time = 655
* CHECK dout1_53 vdout1_53ck130 = 0 time = 655
* CHECK dout1_54 vdout1_54ck130 = 0 time = 655
* CHECK dout1_55 vdout1_55ck130 = 0 time = 655
* CHECK dout1_56 vdout1_56ck130 = 1.0 time = 655
* CHECK dout1_57 vdout1_57ck130 = 1.0 time = 655
* CHECK dout1_58 vdout1_58ck130 = 0 time = 655
* CHECK dout1_59 vdout1_59ck130 = 0 time = 655
* CHECK dout1_60 vdout1_60ck130 = 0 time = 655
* CHECK dout1_61 vdout1_61ck130 = 0 time = 655
* CHECK dout1_62 vdout1_62ck130 = 1.0 time = 655
* CHECK dout1_63 vdout1_63ck130 = 0 time = 655
* CHECK dout1_0 vdout1_0ck131 = 0 time = 660
* CHECK dout1_1 vdout1_1ck131 = 1.0 time = 660
* CHECK dout1_2 vdout1_2ck131 = 0 time = 660
* CHECK dout1_3 vdout1_3ck131 = 1.0 time = 660
* CHECK dout1_4 vdout1_4ck131 = 0 time = 660
* CHECK dout1_5 vdout1_5ck131 = 0 time = 660
* CHECK dout1_6 vdout1_6ck131 = 0 time = 660
* CHECK dout1_7 vdout1_7ck131 = 1.0 time = 660
* CHECK dout1_8 vdout1_8ck131 = 1.0 time = 660
* CHECK dout1_9 vdout1_9ck131 = 0 time = 660
* CHECK dout1_10 vdout1_10ck131 = 1.0 time = 660
* CHECK dout1_11 vdout1_11ck131 = 1.0 time = 660
* CHECK dout1_12 vdout1_12ck131 = 0 time = 660
* CHECK dout1_13 vdout1_13ck131 = 1.0 time = 660
* CHECK dout1_14 vdout1_14ck131 = 0 time = 660
* CHECK dout1_15 vdout1_15ck131 = 0 time = 660
* CHECK dout1_16 vdout1_16ck131 = 0 time = 660
* CHECK dout1_17 vdout1_17ck131 = 1.0 time = 660
* CHECK dout1_18 vdout1_18ck131 = 1.0 time = 660
* CHECK dout1_19 vdout1_19ck131 = 1.0 time = 660
* CHECK dout1_20 vdout1_20ck131 = 1.0 time = 660
* CHECK dout1_21 vdout1_21ck131 = 1.0 time = 660
* CHECK dout1_22 vdout1_22ck131 = 0 time = 660
* CHECK dout1_23 vdout1_23ck131 = 1.0 time = 660
* CHECK dout1_24 vdout1_24ck131 = 0 time = 660
* CHECK dout1_25 vdout1_25ck131 = 0 time = 660
* CHECK dout1_26 vdout1_26ck131 = 0 time = 660
* CHECK dout1_27 vdout1_27ck131 = 0 time = 660
* CHECK dout1_28 vdout1_28ck131 = 0 time = 660
* CHECK dout1_29 vdout1_29ck131 = 0 time = 660
* CHECK dout1_30 vdout1_30ck131 = 1.0 time = 660
* CHECK dout1_31 vdout1_31ck131 = 1.0 time = 660
* CHECK dout1_32 vdout1_32ck131 = 1.0 time = 660
* CHECK dout1_33 vdout1_33ck131 = 0 time = 660
* CHECK dout1_34 vdout1_34ck131 = 1.0 time = 660
* CHECK dout1_35 vdout1_35ck131 = 1.0 time = 660
* CHECK dout1_36 vdout1_36ck131 = 1.0 time = 660
* CHECK dout1_37 vdout1_37ck131 = 1.0 time = 660
* CHECK dout1_38 vdout1_38ck131 = 0 time = 660
* CHECK dout1_39 vdout1_39ck131 = 0 time = 660
* CHECK dout1_40 vdout1_40ck131 = 1.0 time = 660
* CHECK dout1_41 vdout1_41ck131 = 1.0 time = 660
* CHECK dout1_42 vdout1_42ck131 = 1.0 time = 660
* CHECK dout1_43 vdout1_43ck131 = 0 time = 660
* CHECK dout1_44 vdout1_44ck131 = 0 time = 660
* CHECK dout1_45 vdout1_45ck131 = 1.0 time = 660
* CHECK dout1_46 vdout1_46ck131 = 0 time = 660
* CHECK dout1_47 vdout1_47ck131 = 0 time = 660
* CHECK dout1_48 vdout1_48ck131 = 0 time = 660
* CHECK dout1_49 vdout1_49ck131 = 0 time = 660
* CHECK dout1_50 vdout1_50ck131 = 1.0 time = 660
* CHECK dout1_51 vdout1_51ck131 = 1.0 time = 660
* CHECK dout1_52 vdout1_52ck131 = 0 time = 660
* CHECK dout1_53 vdout1_53ck131 = 1.0 time = 660
* CHECK dout1_54 vdout1_54ck131 = 1.0 time = 660
* CHECK dout1_55 vdout1_55ck131 = 0 time = 660
* CHECK dout1_56 vdout1_56ck131 = 1.0 time = 660
* CHECK dout1_57 vdout1_57ck131 = 1.0 time = 660
* CHECK dout1_58 vdout1_58ck131 = 1.0 time = 660
* CHECK dout1_59 vdout1_59ck131 = 0 time = 660
* CHECK dout1_60 vdout1_60ck131 = 0 time = 660
* CHECK dout1_61 vdout1_61ck131 = 1.0 time = 660
* CHECK dout1_62 vdout1_62ck131 = 1.0 time = 660
* CHECK dout1_63 vdout1_63ck131 = 1.0 time = 660
* CHECK dout0_0 vdout0_0ck133 = 0 time = 670
* CHECK dout0_1 vdout0_1ck133 = 1.0 time = 670
* CHECK dout0_2 vdout0_2ck133 = 1.0 time = 670
* CHECK dout0_3 vdout0_3ck133 = 1.0 time = 670
* CHECK dout0_4 vdout0_4ck133 = 0 time = 670
* CHECK dout0_5 vdout0_5ck133 = 1.0 time = 670
* CHECK dout0_6 vdout0_6ck133 = 1.0 time = 670
* CHECK dout0_7 vdout0_7ck133 = 0 time = 670
* CHECK dout0_8 vdout0_8ck133 = 0 time = 670
* CHECK dout0_9 vdout0_9ck133 = 0 time = 670
* CHECK dout0_10 vdout0_10ck133 = 1.0 time = 670
* CHECK dout0_11 vdout0_11ck133 = 1.0 time = 670
* CHECK dout0_12 vdout0_12ck133 = 0 time = 670
* CHECK dout0_13 vdout0_13ck133 = 0 time = 670
* CHECK dout0_14 vdout0_14ck133 = 0 time = 670
* CHECK dout0_15 vdout0_15ck133 = 1.0 time = 670
* CHECK dout0_16 vdout0_16ck133 = 1.0 time = 670
* CHECK dout0_17 vdout0_17ck133 = 0 time = 670
* CHECK dout0_18 vdout0_18ck133 = 0 time = 670
* CHECK dout0_19 vdout0_19ck133 = 0 time = 670
* CHECK dout0_20 vdout0_20ck133 = 0 time = 670
* CHECK dout0_21 vdout0_21ck133 = 0 time = 670
* CHECK dout0_22 vdout0_22ck133 = 1.0 time = 670
* CHECK dout0_23 vdout0_23ck133 = 0 time = 670
* CHECK dout0_24 vdout0_24ck133 = 1.0 time = 670
* CHECK dout0_25 vdout0_25ck133 = 1.0 time = 670
* CHECK dout0_26 vdout0_26ck133 = 0 time = 670
* CHECK dout0_27 vdout0_27ck133 = 0 time = 670
* CHECK dout0_28 vdout0_28ck133 = 1.0 time = 670
* CHECK dout0_29 vdout0_29ck133 = 0 time = 670
* CHECK dout0_30 vdout0_30ck133 = 1.0 time = 670
* CHECK dout0_31 vdout0_31ck133 = 0 time = 670
* CHECK dout0_32 vdout0_32ck133 = 0 time = 670
* CHECK dout0_33 vdout0_33ck133 = 1.0 time = 670
* CHECK dout0_34 vdout0_34ck133 = 1.0 time = 670
* CHECK dout0_35 vdout0_35ck133 = 1.0 time = 670
* CHECK dout0_36 vdout0_36ck133 = 1.0 time = 670
* CHECK dout0_37 vdout0_37ck133 = 1.0 time = 670
* CHECK dout0_38 vdout0_38ck133 = 0 time = 670
* CHECK dout0_39 vdout0_39ck133 = 0 time = 670
* CHECK dout0_40 vdout0_40ck133 = 1.0 time = 670
* CHECK dout0_41 vdout0_41ck133 = 1.0 time = 670
* CHECK dout0_42 vdout0_42ck133 = 0 time = 670
* CHECK dout0_43 vdout0_43ck133 = 0 time = 670
* CHECK dout0_44 vdout0_44ck133 = 1.0 time = 670
* CHECK dout0_45 vdout0_45ck133 = 1.0 time = 670
* CHECK dout0_46 vdout0_46ck133 = 1.0 time = 670
* CHECK dout0_47 vdout0_47ck133 = 0 time = 670
* CHECK dout0_48 vdout0_48ck133 = 0 time = 670
* CHECK dout0_49 vdout0_49ck133 = 0 time = 670
* CHECK dout0_50 vdout0_50ck133 = 0 time = 670
* CHECK dout0_51 vdout0_51ck133 = 0 time = 670
* CHECK dout0_52 vdout0_52ck133 = 1.0 time = 670
* CHECK dout0_53 vdout0_53ck133 = 1.0 time = 670
* CHECK dout0_54 vdout0_54ck133 = 0 time = 670
* CHECK dout0_55 vdout0_55ck133 = 0 time = 670
* CHECK dout0_56 vdout0_56ck133 = 1.0 time = 670
* CHECK dout0_57 vdout0_57ck133 = 1.0 time = 670
* CHECK dout0_58 vdout0_58ck133 = 1.0 time = 670
* CHECK dout0_59 vdout0_59ck133 = 1.0 time = 670
* CHECK dout0_60 vdout0_60ck133 = 1.0 time = 670
* CHECK dout0_61 vdout0_61ck133 = 1.0 time = 670
* CHECK dout0_62 vdout0_62ck133 = 0 time = 670
* CHECK dout0_63 vdout0_63ck133 = 0 time = 670
* CHECK dout1_0 vdout1_0ck133 = 0 time = 670
* CHECK dout1_1 vdout1_1ck133 = 0 time = 670
* CHECK dout1_2 vdout1_2ck133 = 0 time = 670
* CHECK dout1_3 vdout1_3ck133 = 1.0 time = 670
* CHECK dout1_4 vdout1_4ck133 = 0 time = 670
* CHECK dout1_5 vdout1_5ck133 = 1.0 time = 670
* CHECK dout1_6 vdout1_6ck133 = 1.0 time = 670
* CHECK dout1_7 vdout1_7ck133 = 1.0 time = 670
* CHECK dout1_8 vdout1_8ck133 = 0 time = 670
* CHECK dout1_9 vdout1_9ck133 = 1.0 time = 670
* CHECK dout1_10 vdout1_10ck133 = 0 time = 670
* CHECK dout1_11 vdout1_11ck133 = 1.0 time = 670
* CHECK dout1_12 vdout1_12ck133 = 0 time = 670
* CHECK dout1_13 vdout1_13ck133 = 0 time = 670
* CHECK dout1_14 vdout1_14ck133 = 0 time = 670
* CHECK dout1_15 vdout1_15ck133 = 1.0 time = 670
* CHECK dout1_16 vdout1_16ck133 = 1.0 time = 670
* CHECK dout1_17 vdout1_17ck133 = 1.0 time = 670
* CHECK dout1_18 vdout1_18ck133 = 0 time = 670
* CHECK dout1_19 vdout1_19ck133 = 1.0 time = 670
* CHECK dout1_20 vdout1_20ck133 = 1.0 time = 670
* CHECK dout1_21 vdout1_21ck133 = 0 time = 670
* CHECK dout1_22 vdout1_22ck133 = 1.0 time = 670
* CHECK dout1_23 vdout1_23ck133 = 1.0 time = 670
* CHECK dout1_24 vdout1_24ck133 = 1.0 time = 670
* CHECK dout1_25 vdout1_25ck133 = 0 time = 670
* CHECK dout1_26 vdout1_26ck133 = 0 time = 670
* CHECK dout1_27 vdout1_27ck133 = 0 time = 670
* CHECK dout1_28 vdout1_28ck133 = 0 time = 670
* CHECK dout1_29 vdout1_29ck133 = 0 time = 670
* CHECK dout1_30 vdout1_30ck133 = 0 time = 670
* CHECK dout1_31 vdout1_31ck133 = 0 time = 670
* CHECK dout1_32 vdout1_32ck133 = 0 time = 670
* CHECK dout1_33 vdout1_33ck133 = 1.0 time = 670
* CHECK dout1_34 vdout1_34ck133 = 0 time = 670
* CHECK dout1_35 vdout1_35ck133 = 1.0 time = 670
* CHECK dout1_36 vdout1_36ck133 = 0 time = 670
* CHECK dout1_37 vdout1_37ck133 = 1.0 time = 670
* CHECK dout1_38 vdout1_38ck133 = 1.0 time = 670
* CHECK dout1_39 vdout1_39ck133 = 0 time = 670
* CHECK dout1_40 vdout1_40ck133 = 1.0 time = 670
* CHECK dout1_41 vdout1_41ck133 = 1.0 time = 670
* CHECK dout1_42 vdout1_42ck133 = 1.0 time = 670
* CHECK dout1_43 vdout1_43ck133 = 1.0 time = 670
* CHECK dout1_44 vdout1_44ck133 = 0 time = 670
* CHECK dout1_45 vdout1_45ck133 = 1.0 time = 670
* CHECK dout1_46 vdout1_46ck133 = 0 time = 670
* CHECK dout1_47 vdout1_47ck133 = 0 time = 670
* CHECK dout1_48 vdout1_48ck133 = 1.0 time = 670
* CHECK dout1_49 vdout1_49ck133 = 1.0 time = 670
* CHECK dout1_50 vdout1_50ck133 = 1.0 time = 670
* CHECK dout1_51 vdout1_51ck133 = 0 time = 670
* CHECK dout1_52 vdout1_52ck133 = 0 time = 670
* CHECK dout1_53 vdout1_53ck133 = 0 time = 670
* CHECK dout1_54 vdout1_54ck133 = 0 time = 670
* CHECK dout1_55 vdout1_55ck133 = 0 time = 670
* CHECK dout1_56 vdout1_56ck133 = 1.0 time = 670
* CHECK dout1_57 vdout1_57ck133 = 1.0 time = 670
* CHECK dout1_58 vdout1_58ck133 = 0 time = 670
* CHECK dout1_59 vdout1_59ck133 = 0 time = 670
* CHECK dout1_60 vdout1_60ck133 = 0 time = 670
* CHECK dout1_61 vdout1_61ck133 = 0 time = 670
* CHECK dout1_62 vdout1_62ck133 = 1.0 time = 670
* CHECK dout1_63 vdout1_63ck133 = 0 time = 670
* CHECK dout0_0 vdout0_0ck135 = 0 time = 680
* CHECK dout0_1 vdout0_1ck135 = 1.0 time = 680
* CHECK dout0_2 vdout0_2ck135 = 1.0 time = 680
* CHECK dout0_3 vdout0_3ck135 = 1.0 time = 680
* CHECK dout0_4 vdout0_4ck135 = 0 time = 680
* CHECK dout0_5 vdout0_5ck135 = 1.0 time = 680
* CHECK dout0_6 vdout0_6ck135 = 1.0 time = 680
* CHECK dout0_7 vdout0_7ck135 = 0 time = 680
* CHECK dout0_8 vdout0_8ck135 = 0 time = 680
* CHECK dout0_9 vdout0_9ck135 = 0 time = 680
* CHECK dout0_10 vdout0_10ck135 = 1.0 time = 680
* CHECK dout0_11 vdout0_11ck135 = 1.0 time = 680
* CHECK dout0_12 vdout0_12ck135 = 0 time = 680
* CHECK dout0_13 vdout0_13ck135 = 0 time = 680
* CHECK dout0_14 vdout0_14ck135 = 0 time = 680
* CHECK dout0_15 vdout0_15ck135 = 1.0 time = 680
* CHECK dout0_16 vdout0_16ck135 = 1.0 time = 680
* CHECK dout0_17 vdout0_17ck135 = 0 time = 680
* CHECK dout0_18 vdout0_18ck135 = 0 time = 680
* CHECK dout0_19 vdout0_19ck135 = 0 time = 680
* CHECK dout0_20 vdout0_20ck135 = 0 time = 680
* CHECK dout0_21 vdout0_21ck135 = 0 time = 680
* CHECK dout0_22 vdout0_22ck135 = 1.0 time = 680
* CHECK dout0_23 vdout0_23ck135 = 0 time = 680
* CHECK dout0_24 vdout0_24ck135 = 1.0 time = 680
* CHECK dout0_25 vdout0_25ck135 = 1.0 time = 680
* CHECK dout0_26 vdout0_26ck135 = 0 time = 680
* CHECK dout0_27 vdout0_27ck135 = 0 time = 680
* CHECK dout0_28 vdout0_28ck135 = 1.0 time = 680
* CHECK dout0_29 vdout0_29ck135 = 0 time = 680
* CHECK dout0_30 vdout0_30ck135 = 1.0 time = 680
* CHECK dout0_31 vdout0_31ck135 = 0 time = 680
* CHECK dout0_32 vdout0_32ck135 = 0 time = 680
* CHECK dout0_33 vdout0_33ck135 = 1.0 time = 680
* CHECK dout0_34 vdout0_34ck135 = 1.0 time = 680
* CHECK dout0_35 vdout0_35ck135 = 1.0 time = 680
* CHECK dout0_36 vdout0_36ck135 = 1.0 time = 680
* CHECK dout0_37 vdout0_37ck135 = 1.0 time = 680
* CHECK dout0_38 vdout0_38ck135 = 0 time = 680
* CHECK dout0_39 vdout0_39ck135 = 0 time = 680
* CHECK dout0_40 vdout0_40ck135 = 1.0 time = 680
* CHECK dout0_41 vdout0_41ck135 = 1.0 time = 680
* CHECK dout0_42 vdout0_42ck135 = 0 time = 680
* CHECK dout0_43 vdout0_43ck135 = 0 time = 680
* CHECK dout0_44 vdout0_44ck135 = 1.0 time = 680
* CHECK dout0_45 vdout0_45ck135 = 1.0 time = 680
* CHECK dout0_46 vdout0_46ck135 = 1.0 time = 680
* CHECK dout0_47 vdout0_47ck135 = 0 time = 680
* CHECK dout0_48 vdout0_48ck135 = 0 time = 680
* CHECK dout0_49 vdout0_49ck135 = 0 time = 680
* CHECK dout0_50 vdout0_50ck135 = 0 time = 680
* CHECK dout0_51 vdout0_51ck135 = 0 time = 680
* CHECK dout0_52 vdout0_52ck135 = 1.0 time = 680
* CHECK dout0_53 vdout0_53ck135 = 1.0 time = 680
* CHECK dout0_54 vdout0_54ck135 = 0 time = 680
* CHECK dout0_55 vdout0_55ck135 = 0 time = 680
* CHECK dout0_56 vdout0_56ck135 = 1.0 time = 680
* CHECK dout0_57 vdout0_57ck135 = 1.0 time = 680
* CHECK dout0_58 vdout0_58ck135 = 1.0 time = 680
* CHECK dout0_59 vdout0_59ck135 = 1.0 time = 680
* CHECK dout0_60 vdout0_60ck135 = 1.0 time = 680
* CHECK dout0_61 vdout0_61ck135 = 1.0 time = 680
* CHECK dout0_62 vdout0_62ck135 = 0 time = 680
* CHECK dout0_63 vdout0_63ck135 = 0 time = 680
* CHECK dout1_0 vdout1_0ck135 = 0 time = 680
* CHECK dout1_1 vdout1_1ck135 = 0 time = 680
* CHECK dout1_2 vdout1_2ck135 = 0 time = 680
* CHECK dout1_3 vdout1_3ck135 = 1.0 time = 680
* CHECK dout1_4 vdout1_4ck135 = 0 time = 680
* CHECK dout1_5 vdout1_5ck135 = 0 time = 680
* CHECK dout1_6 vdout1_6ck135 = 1.0 time = 680
* CHECK dout1_7 vdout1_7ck135 = 1.0 time = 680
* CHECK dout1_8 vdout1_8ck135 = 0 time = 680
* CHECK dout1_9 vdout1_9ck135 = 1.0 time = 680
* CHECK dout1_10 vdout1_10ck135 = 1.0 time = 680
* CHECK dout1_11 vdout1_11ck135 = 0 time = 680
* CHECK dout1_12 vdout1_12ck135 = 0 time = 680
* CHECK dout1_13 vdout1_13ck135 = 0 time = 680
* CHECK dout1_14 vdout1_14ck135 = 1.0 time = 680
* CHECK dout1_15 vdout1_15ck135 = 1.0 time = 680
* CHECK dout1_16 vdout1_16ck135 = 0 time = 680
* CHECK dout1_17 vdout1_17ck135 = 1.0 time = 680
* CHECK dout1_18 vdout1_18ck135 = 0 time = 680
* CHECK dout1_19 vdout1_19ck135 = 1.0 time = 680
* CHECK dout1_20 vdout1_20ck135 = 0 time = 680
* CHECK dout1_21 vdout1_21ck135 = 0 time = 680
* CHECK dout1_22 vdout1_22ck135 = 0 time = 680
* CHECK dout1_23 vdout1_23ck135 = 1.0 time = 680
* CHECK dout1_24 vdout1_24ck135 = 1.0 time = 680
* CHECK dout1_25 vdout1_25ck135 = 1.0 time = 680
* CHECK dout1_26 vdout1_26ck135 = 1.0 time = 680
* CHECK dout1_27 vdout1_27ck135 = 1.0 time = 680
* CHECK dout1_28 vdout1_28ck135 = 1.0 time = 680
* CHECK dout1_29 vdout1_29ck135 = 0 time = 680
* CHECK dout1_30 vdout1_30ck135 = 0 time = 680
* CHECK dout1_31 vdout1_31ck135 = 0 time = 680
* CHECK dout1_32 vdout1_32ck135 = 1.0 time = 680
* CHECK dout1_33 vdout1_33ck135 = 1.0 time = 680
* CHECK dout1_34 vdout1_34ck135 = 0 time = 680
* CHECK dout1_35 vdout1_35ck135 = 0 time = 680
* CHECK dout1_36 vdout1_36ck135 = 0 time = 680
* CHECK dout1_37 vdout1_37ck135 = 0 time = 680
* CHECK dout1_38 vdout1_38ck135 = 0 time = 680
* CHECK dout1_39 vdout1_39ck135 = 1.0 time = 680
* CHECK dout1_40 vdout1_40ck135 = 1.0 time = 680
* CHECK dout1_41 vdout1_41ck135 = 1.0 time = 680
* CHECK dout1_42 vdout1_42ck135 = 0 time = 680
* CHECK dout1_43 vdout1_43ck135 = 1.0 time = 680
* CHECK dout1_44 vdout1_44ck135 = 1.0 time = 680
* CHECK dout1_45 vdout1_45ck135 = 1.0 time = 680
* CHECK dout1_46 vdout1_46ck135 = 0 time = 680
* CHECK dout1_47 vdout1_47ck135 = 1.0 time = 680
* CHECK dout1_48 vdout1_48ck135 = 0 time = 680
* CHECK dout1_49 vdout1_49ck135 = 0 time = 680
* CHECK dout1_50 vdout1_50ck135 = 1.0 time = 680
* CHECK dout1_51 vdout1_51ck135 = 0 time = 680
* CHECK dout1_52 vdout1_52ck135 = 0 time = 680
* CHECK dout1_53 vdout1_53ck135 = 1.0 time = 680
* CHECK dout1_54 vdout1_54ck135 = 1.0 time = 680
* CHECK dout1_55 vdout1_55ck135 = 0 time = 680
* CHECK dout1_56 vdout1_56ck135 = 0 time = 680
* CHECK dout1_57 vdout1_57ck135 = 0 time = 680
* CHECK dout1_58 vdout1_58ck135 = 1.0 time = 680
* CHECK dout1_59 vdout1_59ck135 = 0 time = 680
* CHECK dout1_60 vdout1_60ck135 = 1.0 time = 680
* CHECK dout1_61 vdout1_61ck135 = 1.0 time = 680
* CHECK dout1_62 vdout1_62ck135 = 1.0 time = 680
* CHECK dout1_63 vdout1_63ck135 = 1.0 time = 680
* CHECK dout0_0 vdout0_0ck136 = 1.0 time = 685
* CHECK dout0_1 vdout0_1ck136 = 0 time = 685
* CHECK dout0_2 vdout0_2ck136 = 1.0 time = 685
* CHECK dout0_3 vdout0_3ck136 = 0 time = 685
* CHECK dout0_4 vdout0_4ck136 = 0 time = 685
* CHECK dout0_5 vdout0_5ck136 = 1.0 time = 685
* CHECK dout0_6 vdout0_6ck136 = 1.0 time = 685
* CHECK dout0_7 vdout0_7ck136 = 1.0 time = 685
* CHECK dout0_8 vdout0_8ck136 = 1.0 time = 685
* CHECK dout0_9 vdout0_9ck136 = 1.0 time = 685
* CHECK dout0_10 vdout0_10ck136 = 0 time = 685
* CHECK dout0_11 vdout0_11ck136 = 1.0 time = 685
* CHECK dout0_12 vdout0_12ck136 = 1.0 time = 685
* CHECK dout0_13 vdout0_13ck136 = 0 time = 685
* CHECK dout0_14 vdout0_14ck136 = 0 time = 685
* CHECK dout0_15 vdout0_15ck136 = 0 time = 685
* CHECK dout0_16 vdout0_16ck136 = 0 time = 685
* CHECK dout0_17 vdout0_17ck136 = 1.0 time = 685
* CHECK dout0_18 vdout0_18ck136 = 1.0 time = 685
* CHECK dout0_19 vdout0_19ck136 = 0 time = 685
* CHECK dout0_20 vdout0_20ck136 = 0 time = 685
* CHECK dout0_21 vdout0_21ck136 = 0 time = 685
* CHECK dout0_22 vdout0_22ck136 = 0 time = 685
* CHECK dout0_23 vdout0_23ck136 = 0 time = 685
* CHECK dout0_24 vdout0_24ck136 = 0 time = 685
* CHECK dout0_25 vdout0_25ck136 = 0 time = 685
* CHECK dout0_26 vdout0_26ck136 = 0 time = 685
* CHECK dout0_27 vdout0_27ck136 = 0 time = 685
* CHECK dout0_28 vdout0_28ck136 = 1.0 time = 685
* CHECK dout0_29 vdout0_29ck136 = 0 time = 685
* CHECK dout0_30 vdout0_30ck136 = 0 time = 685
* CHECK dout0_31 vdout0_31ck136 = 0 time = 685
* CHECK dout0_32 vdout0_32ck136 = 1.0 time = 685
* CHECK dout0_33 vdout0_33ck136 = 0 time = 685
* CHECK dout0_34 vdout0_34ck136 = 0 time = 685
* CHECK dout0_35 vdout0_35ck136 = 0 time = 685
* CHECK dout0_36 vdout0_36ck136 = 1.0 time = 685
* CHECK dout0_37 vdout0_37ck136 = 1.0 time = 685
* CHECK dout0_38 vdout0_38ck136 = 0 time = 685
* CHECK dout0_39 vdout0_39ck136 = 0 time = 685
* CHECK dout0_40 vdout0_40ck136 = 0 time = 685
* CHECK dout0_41 vdout0_41ck136 = 0 time = 685
* CHECK dout0_42 vdout0_42ck136 = 1.0 time = 685
* CHECK dout0_43 vdout0_43ck136 = 0 time = 685
* CHECK dout0_44 vdout0_44ck136 = 0 time = 685
* CHECK dout0_45 vdout0_45ck136 = 1.0 time = 685
* CHECK dout0_46 vdout0_46ck136 = 1.0 time = 685
* CHECK dout0_47 vdout0_47ck136 = 0 time = 685
* CHECK dout0_48 vdout0_48ck136 = 1.0 time = 685
* CHECK dout0_49 vdout0_49ck136 = 0 time = 685
* CHECK dout0_50 vdout0_50ck136 = 0 time = 685
* CHECK dout0_51 vdout0_51ck136 = 0 time = 685
* CHECK dout0_52 vdout0_52ck136 = 0 time = 685
* CHECK dout0_53 vdout0_53ck136 = 1.0 time = 685
* CHECK dout0_54 vdout0_54ck136 = 0 time = 685
* CHECK dout0_55 vdout0_55ck136 = 1.0 time = 685
* CHECK dout0_56 vdout0_56ck136 = 0 time = 685
* CHECK dout0_57 vdout0_57ck136 = 1.0 time = 685
* CHECK dout0_58 vdout0_58ck136 = 1.0 time = 685
* CHECK dout0_59 vdout0_59ck136 = 0 time = 685
* CHECK dout0_60 vdout0_60ck136 = 0 time = 685
* CHECK dout0_61 vdout0_61ck136 = 1.0 time = 685
* CHECK dout0_62 vdout0_62ck136 = 0 time = 685
* CHECK dout0_63 vdout0_63ck136 = 1.0 time = 685
* CHECK dout1_0 vdout1_0ck136 = 0 time = 685
* CHECK dout1_1 vdout1_1ck136 = 0 time = 685
* CHECK dout1_2 vdout1_2ck136 = 1.0 time = 685
* CHECK dout1_3 vdout1_3ck136 = 0 time = 685
* CHECK dout1_4 vdout1_4ck136 = 1.0 time = 685
* CHECK dout1_5 vdout1_5ck136 = 0 time = 685
* CHECK dout1_6 vdout1_6ck136 = 0 time = 685
* CHECK dout1_7 vdout1_7ck136 = 0 time = 685
* CHECK dout1_8 vdout1_8ck136 = 1.0 time = 685
* CHECK dout1_9 vdout1_9ck136 = 0 time = 685
* CHECK dout1_10 vdout1_10ck136 = 1.0 time = 685
* CHECK dout1_11 vdout1_11ck136 = 1.0 time = 685
* CHECK dout1_12 vdout1_12ck136 = 0 time = 685
* CHECK dout1_13 vdout1_13ck136 = 0 time = 685
* CHECK dout1_14 vdout1_14ck136 = 0 time = 685
* CHECK dout1_15 vdout1_15ck136 = 0 time = 685
* CHECK dout1_16 vdout1_16ck136 = 0 time = 685
* CHECK dout1_17 vdout1_17ck136 = 1.0 time = 685
* CHECK dout1_18 vdout1_18ck136 = 1.0 time = 685
* CHECK dout1_19 vdout1_19ck136 = 1.0 time = 685
* CHECK dout1_20 vdout1_20ck136 = 0 time = 685
* CHECK dout1_21 vdout1_21ck136 = 0 time = 685
* CHECK dout1_22 vdout1_22ck136 = 0 time = 685
* CHECK dout1_23 vdout1_23ck136 = 1.0 time = 685
* CHECK dout1_24 vdout1_24ck136 = 0 time = 685
* CHECK dout1_25 vdout1_25ck136 = 0 time = 685
* CHECK dout1_26 vdout1_26ck136 = 1.0 time = 685
* CHECK dout1_27 vdout1_27ck136 = 0 time = 685
* CHECK dout1_28 vdout1_28ck136 = 1.0 time = 685
* CHECK dout1_29 vdout1_29ck136 = 1.0 time = 685
* CHECK dout1_30 vdout1_30ck136 = 0 time = 685
* CHECK dout1_31 vdout1_31ck136 = 1.0 time = 685
* CHECK dout1_32 vdout1_32ck136 = 0 time = 685
* CHECK dout1_33 vdout1_33ck136 = 1.0 time = 685
* CHECK dout1_34 vdout1_34ck136 = 0 time = 685
* CHECK dout1_35 vdout1_35ck136 = 1.0 time = 685
* CHECK dout1_36 vdout1_36ck136 = 1.0 time = 685
* CHECK dout1_37 vdout1_37ck136 = 0 time = 685
* CHECK dout1_38 vdout1_38ck136 = 0 time = 685
* CHECK dout1_39 vdout1_39ck136 = 1.0 time = 685
* CHECK dout1_40 vdout1_40ck136 = 0 time = 685
* CHECK dout1_41 vdout1_41ck136 = 1.0 time = 685
* CHECK dout1_42 vdout1_42ck136 = 1.0 time = 685
* CHECK dout1_43 vdout1_43ck136 = 0 time = 685
* CHECK dout1_44 vdout1_44ck136 = 1.0 time = 685
* CHECK dout1_45 vdout1_45ck136 = 1.0 time = 685
* CHECK dout1_46 vdout1_46ck136 = 0 time = 685
* CHECK dout1_47 vdout1_47ck136 = 0 time = 685
* CHECK dout1_48 vdout1_48ck136 = 0 time = 685
* CHECK dout1_49 vdout1_49ck136 = 1.0 time = 685
* CHECK dout1_50 vdout1_50ck136 = 0 time = 685
* CHECK dout1_51 vdout1_51ck136 = 0 time = 685
* CHECK dout1_52 vdout1_52ck136 = 0 time = 685
* CHECK dout1_53 vdout1_53ck136 = 1.0 time = 685
* CHECK dout1_54 vdout1_54ck136 = 0 time = 685
* CHECK dout1_55 vdout1_55ck136 = 0 time = 685
* CHECK dout1_56 vdout1_56ck136 = 1.0 time = 685
* CHECK dout1_57 vdout1_57ck136 = 1.0 time = 685
* CHECK dout1_58 vdout1_58ck136 = 0 time = 685
* CHECK dout1_59 vdout1_59ck136 = 1.0 time = 685
* CHECK dout1_60 vdout1_60ck136 = 1.0 time = 685
* CHECK dout1_61 vdout1_61ck136 = 1.0 time = 685
* CHECK dout1_62 vdout1_62ck136 = 1.0 time = 685
* CHECK dout1_63 vdout1_63ck136 = 0 time = 685
* CHECK dout0_0 vdout0_0ck137 = 1.0 time = 690
* CHECK dout0_1 vdout0_1ck137 = 0 time = 690
* CHECK dout0_2 vdout0_2ck137 = 0 time = 690
* CHECK dout0_3 vdout0_3ck137 = 1.0 time = 690
* CHECK dout0_4 vdout0_4ck137 = 0 time = 690
* CHECK dout0_5 vdout0_5ck137 = 1.0 time = 690
* CHECK dout0_6 vdout0_6ck137 = 1.0 time = 690
* CHECK dout0_7 vdout0_7ck137 = 0 time = 690
* CHECK dout0_8 vdout0_8ck137 = 1.0 time = 690
* CHECK dout0_9 vdout0_9ck137 = 1.0 time = 690
* CHECK dout0_10 vdout0_10ck137 = 0 time = 690
* CHECK dout0_11 vdout0_11ck137 = 1.0 time = 690
* CHECK dout0_12 vdout0_12ck137 = 0 time = 690
* CHECK dout0_13 vdout0_13ck137 = 1.0 time = 690
* CHECK dout0_14 vdout0_14ck137 = 1.0 time = 690
* CHECK dout0_15 vdout0_15ck137 = 0 time = 690
* CHECK dout0_16 vdout0_16ck137 = 1.0 time = 690
* CHECK dout0_17 vdout0_17ck137 = 0 time = 690
* CHECK dout0_18 vdout0_18ck137 = 0 time = 690
* CHECK dout0_19 vdout0_19ck137 = 0 time = 690
* CHECK dout0_20 vdout0_20ck137 = 1.0 time = 690
* CHECK dout0_21 vdout0_21ck137 = 0 time = 690
* CHECK dout0_22 vdout0_22ck137 = 0 time = 690
* CHECK dout0_23 vdout0_23ck137 = 0 time = 690
* CHECK dout0_24 vdout0_24ck137 = 1.0 time = 690
* CHECK dout0_25 vdout0_25ck137 = 1.0 time = 690
* CHECK dout0_26 vdout0_26ck137 = 0 time = 690
* CHECK dout0_27 vdout0_27ck137 = 1.0 time = 690
* CHECK dout0_28 vdout0_28ck137 = 1.0 time = 690
* CHECK dout0_29 vdout0_29ck137 = 1.0 time = 690
* CHECK dout0_30 vdout0_30ck137 = 1.0 time = 690
* CHECK dout0_31 vdout0_31ck137 = 1.0 time = 690
* CHECK dout0_32 vdout0_32ck137 = 1.0 time = 690
* CHECK dout0_33 vdout0_33ck137 = 0 time = 690
* CHECK dout0_34 vdout0_34ck137 = 0 time = 690
* CHECK dout0_35 vdout0_35ck137 = 0 time = 690
* CHECK dout0_36 vdout0_36ck137 = 1.0 time = 690
* CHECK dout0_37 vdout0_37ck137 = 1.0 time = 690
* CHECK dout0_38 vdout0_38ck137 = 1.0 time = 690
* CHECK dout0_39 vdout0_39ck137 = 1.0 time = 690
* CHECK dout0_40 vdout0_40ck137 = 0 time = 690
* CHECK dout0_41 vdout0_41ck137 = 0 time = 690
* CHECK dout0_42 vdout0_42ck137 = 0 time = 690
* CHECK dout0_43 vdout0_43ck137 = 1.0 time = 690
* CHECK dout0_44 vdout0_44ck137 = 1.0 time = 690
* CHECK dout0_45 vdout0_45ck137 = 0 time = 690
* CHECK dout0_46 vdout0_46ck137 = 0 time = 690
* CHECK dout0_47 vdout0_47ck137 = 1.0 time = 690
* CHECK dout0_48 vdout0_48ck137 = 1.0 time = 690
* CHECK dout0_49 vdout0_49ck137 = 1.0 time = 690
* CHECK dout0_50 vdout0_50ck137 = 0 time = 690
* CHECK dout0_51 vdout0_51ck137 = 0 time = 690
* CHECK dout0_52 vdout0_52ck137 = 1.0 time = 690
* CHECK dout0_53 vdout0_53ck137 = 0 time = 690
* CHECK dout0_54 vdout0_54ck137 = 0 time = 690
* CHECK dout0_55 vdout0_55ck137 = 0 time = 690
* CHECK dout0_56 vdout0_56ck137 = 1.0 time = 690
* CHECK dout0_57 vdout0_57ck137 = 0 time = 690
* CHECK dout0_58 vdout0_58ck137 = 0 time = 690
* CHECK dout0_59 vdout0_59ck137 = 1.0 time = 690
* CHECK dout0_60 vdout0_60ck137 = 0 time = 690
* CHECK dout0_61 vdout0_61ck137 = 0 time = 690
* CHECK dout0_62 vdout0_62ck137 = 1.0 time = 690
* CHECK dout0_63 vdout0_63ck137 = 0 time = 690
* CHECK dout1_0 vdout1_0ck137 = 1.0 time = 690
* CHECK dout1_1 vdout1_1ck137 = 0 time = 690
* CHECK dout1_2 vdout1_2ck137 = 1.0 time = 690
* CHECK dout1_3 vdout1_3ck137 = 0 time = 690
* CHECK dout1_4 vdout1_4ck137 = 0 time = 690
* CHECK dout1_5 vdout1_5ck137 = 1.0 time = 690
* CHECK dout1_6 vdout1_6ck137 = 1.0 time = 690
* CHECK dout1_7 vdout1_7ck137 = 1.0 time = 690
* CHECK dout1_8 vdout1_8ck137 = 1.0 time = 690
* CHECK dout1_9 vdout1_9ck137 = 1.0 time = 690
* CHECK dout1_10 vdout1_10ck137 = 0 time = 690
* CHECK dout1_11 vdout1_11ck137 = 1.0 time = 690
* CHECK dout1_12 vdout1_12ck137 = 1.0 time = 690
* CHECK dout1_13 vdout1_13ck137 = 0 time = 690
* CHECK dout1_14 vdout1_14ck137 = 0 time = 690
* CHECK dout1_15 vdout1_15ck137 = 0 time = 690
* CHECK dout1_16 vdout1_16ck137 = 0 time = 690
* CHECK dout1_17 vdout1_17ck137 = 1.0 time = 690
* CHECK dout1_18 vdout1_18ck137 = 1.0 time = 690
* CHECK dout1_19 vdout1_19ck137 = 0 time = 690
* CHECK dout1_20 vdout1_20ck137 = 0 time = 690
* CHECK dout1_21 vdout1_21ck137 = 0 time = 690
* CHECK dout1_22 vdout1_22ck137 = 0 time = 690
* CHECK dout1_23 vdout1_23ck137 = 0 time = 690
* CHECK dout1_24 vdout1_24ck137 = 0 time = 690
* CHECK dout1_25 vdout1_25ck137 = 0 time = 690
* CHECK dout1_26 vdout1_26ck137 = 0 time = 690
* CHECK dout1_27 vdout1_27ck137 = 0 time = 690
* CHECK dout1_28 vdout1_28ck137 = 1.0 time = 690
* CHECK dout1_29 vdout1_29ck137 = 0 time = 690
* CHECK dout1_30 vdout1_30ck137 = 0 time = 690
* CHECK dout1_31 vdout1_31ck137 = 0 time = 690
* CHECK dout1_32 vdout1_32ck137 = 1.0 time = 690
* CHECK dout1_33 vdout1_33ck137 = 0 time = 690
* CHECK dout1_34 vdout1_34ck137 = 0 time = 690
* CHECK dout1_35 vdout1_35ck137 = 0 time = 690
* CHECK dout1_36 vdout1_36ck137 = 1.0 time = 690
* CHECK dout1_37 vdout1_37ck137 = 1.0 time = 690
* CHECK dout1_38 vdout1_38ck137 = 0 time = 690
* CHECK dout1_39 vdout1_39ck137 = 0 time = 690
* CHECK dout1_40 vdout1_40ck137 = 0 time = 690
* CHECK dout1_41 vdout1_41ck137 = 0 time = 690
* CHECK dout1_42 vdout1_42ck137 = 1.0 time = 690
* CHECK dout1_43 vdout1_43ck137 = 0 time = 690
* CHECK dout1_44 vdout1_44ck137 = 0 time = 690
* CHECK dout1_45 vdout1_45ck137 = 1.0 time = 690
* CHECK dout1_46 vdout1_46ck137 = 1.0 time = 690
* CHECK dout1_47 vdout1_47ck137 = 0 time = 690
* CHECK dout1_48 vdout1_48ck137 = 1.0 time = 690
* CHECK dout1_49 vdout1_49ck137 = 0 time = 690
* CHECK dout1_50 vdout1_50ck137 = 0 time = 690
* CHECK dout1_51 vdout1_51ck137 = 0 time = 690
* CHECK dout1_52 vdout1_52ck137 = 0 time = 690
* CHECK dout1_53 vdout1_53ck137 = 1.0 time = 690
* CHECK dout1_54 vdout1_54ck137 = 0 time = 690
* CHECK dout1_55 vdout1_55ck137 = 1.0 time = 690
* CHECK dout1_56 vdout1_56ck137 = 0 time = 690
* CHECK dout1_57 vdout1_57ck137 = 1.0 time = 690
* CHECK dout1_58 vdout1_58ck137 = 1.0 time = 690
* CHECK dout1_59 vdout1_59ck137 = 0 time = 690
* CHECK dout1_60 vdout1_60ck137 = 0 time = 690
* CHECK dout1_61 vdout1_61ck137 = 1.0 time = 690
* CHECK dout1_62 vdout1_62ck137 = 0 time = 690
* CHECK dout1_63 vdout1_63ck137 = 1.0 time = 690
* CHECK dout0_0 vdout0_0ck138 = 0 time = 695
* CHECK dout0_1 vdout0_1ck138 = 1.0 time = 695
* CHECK dout0_2 vdout0_2ck138 = 0 time = 695
* CHECK dout0_3 vdout0_3ck138 = 1.0 time = 695
* CHECK dout0_4 vdout0_4ck138 = 0 time = 695
* CHECK dout0_5 vdout0_5ck138 = 0 time = 695
* CHECK dout0_6 vdout0_6ck138 = 0 time = 695
* CHECK dout0_7 vdout0_7ck138 = 1.0 time = 695
* CHECK dout0_8 vdout0_8ck138 = 1.0 time = 695
* CHECK dout0_9 vdout0_9ck138 = 0 time = 695
* CHECK dout0_10 vdout0_10ck138 = 1.0 time = 695
* CHECK dout0_11 vdout0_11ck138 = 1.0 time = 695
* CHECK dout0_12 vdout0_12ck138 = 0 time = 695
* CHECK dout0_13 vdout0_13ck138 = 1.0 time = 695
* CHECK dout0_14 vdout0_14ck138 = 0 time = 695
* CHECK dout0_15 vdout0_15ck138 = 0 time = 695
* CHECK dout0_16 vdout0_16ck138 = 0 time = 695
* CHECK dout0_17 vdout0_17ck138 = 1.0 time = 695
* CHECK dout0_18 vdout0_18ck138 = 1.0 time = 695
* CHECK dout0_19 vdout0_19ck138 = 1.0 time = 695
* CHECK dout0_20 vdout0_20ck138 = 1.0 time = 695
* CHECK dout0_21 vdout0_21ck138 = 1.0 time = 695
* CHECK dout0_22 vdout0_22ck138 = 0 time = 695
* CHECK dout0_23 vdout0_23ck138 = 1.0 time = 695
* CHECK dout0_24 vdout0_24ck138 = 0 time = 695
* CHECK dout0_25 vdout0_25ck138 = 0 time = 695
* CHECK dout0_26 vdout0_26ck138 = 0 time = 695
* CHECK dout0_27 vdout0_27ck138 = 0 time = 695
* CHECK dout0_28 vdout0_28ck138 = 0 time = 695
* CHECK dout0_29 vdout0_29ck138 = 0 time = 695
* CHECK dout0_30 vdout0_30ck138 = 1.0 time = 695
* CHECK dout0_31 vdout0_31ck138 = 1.0 time = 695
* CHECK dout0_32 vdout0_32ck138 = 1.0 time = 695
* CHECK dout0_33 vdout0_33ck138 = 0 time = 695
* CHECK dout0_34 vdout0_34ck138 = 1.0 time = 695
* CHECK dout0_35 vdout0_35ck138 = 1.0 time = 695
* CHECK dout0_36 vdout0_36ck138 = 1.0 time = 695
* CHECK dout0_37 vdout0_37ck138 = 1.0 time = 695
* CHECK dout0_38 vdout0_38ck138 = 0 time = 695
* CHECK dout0_39 vdout0_39ck138 = 0 time = 695
* CHECK dout0_40 vdout0_40ck138 = 1.0 time = 695
* CHECK dout0_41 vdout0_41ck138 = 1.0 time = 695
* CHECK dout0_42 vdout0_42ck138 = 1.0 time = 695
* CHECK dout0_43 vdout0_43ck138 = 0 time = 695
* CHECK dout0_44 vdout0_44ck138 = 0 time = 695
* CHECK dout0_45 vdout0_45ck138 = 1.0 time = 695
* CHECK dout0_46 vdout0_46ck138 = 0 time = 695
* CHECK dout0_47 vdout0_47ck138 = 0 time = 695
* CHECK dout0_48 vdout0_48ck138 = 0 time = 695
* CHECK dout0_49 vdout0_49ck138 = 0 time = 695
* CHECK dout0_50 vdout0_50ck138 = 1.0 time = 695
* CHECK dout0_51 vdout0_51ck138 = 1.0 time = 695
* CHECK dout0_52 vdout0_52ck138 = 0 time = 695
* CHECK dout0_53 vdout0_53ck138 = 1.0 time = 695
* CHECK dout0_54 vdout0_54ck138 = 1.0 time = 695
* CHECK dout0_55 vdout0_55ck138 = 0 time = 695
* CHECK dout0_56 vdout0_56ck138 = 1.0 time = 695
* CHECK dout0_57 vdout0_57ck138 = 1.0 time = 695
* CHECK dout0_58 vdout0_58ck138 = 1.0 time = 695
* CHECK dout0_59 vdout0_59ck138 = 0 time = 695
* CHECK dout0_60 vdout0_60ck138 = 0 time = 695
* CHECK dout0_61 vdout0_61ck138 = 1.0 time = 695
* CHECK dout0_62 vdout0_62ck138 = 1.0 time = 695
* CHECK dout0_63 vdout0_63ck138 = 1.0 time = 695
* CHECK dout0_0 vdout0_0ck139 = 1.0 time = 700
* CHECK dout0_1 vdout0_1ck139 = 0 time = 700
* CHECK dout0_2 vdout0_2ck139 = 1.0 time = 700
* CHECK dout0_3 vdout0_3ck139 = 0 time = 700
* CHECK dout0_4 vdout0_4ck139 = 0 time = 700
* CHECK dout0_5 vdout0_5ck139 = 1.0 time = 700
* CHECK dout0_6 vdout0_6ck139 = 1.0 time = 700
* CHECK dout0_7 vdout0_7ck139 = 1.0 time = 700
* CHECK dout0_8 vdout0_8ck139 = 1.0 time = 700
* CHECK dout0_9 vdout0_9ck139 = 1.0 time = 700
* CHECK dout0_10 vdout0_10ck139 = 0 time = 700
* CHECK dout0_11 vdout0_11ck139 = 1.0 time = 700
* CHECK dout0_12 vdout0_12ck139 = 1.0 time = 700
* CHECK dout0_13 vdout0_13ck139 = 0 time = 700
* CHECK dout0_14 vdout0_14ck139 = 0 time = 700
* CHECK dout0_15 vdout0_15ck139 = 0 time = 700
* CHECK dout0_16 vdout0_16ck139 = 0 time = 700
* CHECK dout0_17 vdout0_17ck139 = 1.0 time = 700
* CHECK dout0_18 vdout0_18ck139 = 1.0 time = 700
* CHECK dout0_19 vdout0_19ck139 = 0 time = 700
* CHECK dout0_20 vdout0_20ck139 = 0 time = 700
* CHECK dout0_21 vdout0_21ck139 = 0 time = 700
* CHECK dout0_22 vdout0_22ck139 = 0 time = 700
* CHECK dout0_23 vdout0_23ck139 = 0 time = 700
* CHECK dout0_24 vdout0_24ck139 = 0 time = 700
* CHECK dout0_25 vdout0_25ck139 = 0 time = 700
* CHECK dout0_26 vdout0_26ck139 = 0 time = 700
* CHECK dout0_27 vdout0_27ck139 = 0 time = 700
* CHECK dout0_28 vdout0_28ck139 = 1.0 time = 700
* CHECK dout0_29 vdout0_29ck139 = 0 time = 700
* CHECK dout0_30 vdout0_30ck139 = 0 time = 700
* CHECK dout0_31 vdout0_31ck139 = 0 time = 700
* CHECK dout0_32 vdout0_32ck139 = 1.0 time = 700
* CHECK dout0_33 vdout0_33ck139 = 0 time = 700
* CHECK dout0_34 vdout0_34ck139 = 0 time = 700
* CHECK dout0_35 vdout0_35ck139 = 0 time = 700
* CHECK dout0_36 vdout0_36ck139 = 1.0 time = 700
* CHECK dout0_37 vdout0_37ck139 = 1.0 time = 700
* CHECK dout0_38 vdout0_38ck139 = 0 time = 700
* CHECK dout0_39 vdout0_39ck139 = 0 time = 700
* CHECK dout0_40 vdout0_40ck139 = 0 time = 700
* CHECK dout0_41 vdout0_41ck139 = 0 time = 700
* CHECK dout0_42 vdout0_42ck139 = 1.0 time = 700
* CHECK dout0_43 vdout0_43ck139 = 0 time = 700
* CHECK dout0_44 vdout0_44ck139 = 0 time = 700
* CHECK dout0_45 vdout0_45ck139 = 1.0 time = 700
* CHECK dout0_46 vdout0_46ck139 = 1.0 time = 700
* CHECK dout0_47 vdout0_47ck139 = 0 time = 700
* CHECK dout0_48 vdout0_48ck139 = 1.0 time = 700
* CHECK dout0_49 vdout0_49ck139 = 0 time = 700
* CHECK dout0_50 vdout0_50ck139 = 0 time = 700
* CHECK dout0_51 vdout0_51ck139 = 0 time = 700
* CHECK dout0_52 vdout0_52ck139 = 0 time = 700
* CHECK dout0_53 vdout0_53ck139 = 1.0 time = 700
* CHECK dout0_54 vdout0_54ck139 = 0 time = 700
* CHECK dout0_55 vdout0_55ck139 = 1.0 time = 700
* CHECK dout0_56 vdout0_56ck139 = 0 time = 700
* CHECK dout0_57 vdout0_57ck139 = 1.0 time = 700
* CHECK dout0_58 vdout0_58ck139 = 1.0 time = 700
* CHECK dout0_59 vdout0_59ck139 = 0 time = 700
* CHECK dout0_60 vdout0_60ck139 = 0 time = 700
* CHECK dout0_61 vdout0_61ck139 = 1.0 time = 700
* CHECK dout0_62 vdout0_62ck139 = 0 time = 700
* CHECK dout0_63 vdout0_63ck139 = 1.0 time = 700
* CHECK dout1_0 vdout1_0ck139 = 1.0 time = 700
* CHECK dout1_1 vdout1_1ck139 = 1.0 time = 700
* CHECK dout1_2 vdout1_2ck139 = 1.0 time = 700
* CHECK dout1_3 vdout1_3ck139 = 1.0 time = 700
* CHECK dout1_4 vdout1_4ck139 = 1.0 time = 700
* CHECK dout1_5 vdout1_5ck139 = 0 time = 700
* CHECK dout1_6 vdout1_6ck139 = 0 time = 700
* CHECK dout1_7 vdout1_7ck139 = 1.0 time = 700
* CHECK dout1_8 vdout1_8ck139 = 1.0 time = 700
* CHECK dout1_9 vdout1_9ck139 = 0 time = 700
* CHECK dout1_10 vdout1_10ck139 = 0 time = 700
* CHECK dout1_11 vdout1_11ck139 = 1.0 time = 700
* CHECK dout1_12 vdout1_12ck139 = 1.0 time = 700
* CHECK dout1_13 vdout1_13ck139 = 0 time = 700
* CHECK dout1_14 vdout1_14ck139 = 1.0 time = 700
* CHECK dout1_15 vdout1_15ck139 = 0 time = 700
* CHECK dout1_16 vdout1_16ck139 = 1.0 time = 700
* CHECK dout1_17 vdout1_17ck139 = 0 time = 700
* CHECK dout1_18 vdout1_18ck139 = 0 time = 700
* CHECK dout1_19 vdout1_19ck139 = 1.0 time = 700
* CHECK dout1_20 vdout1_20ck139 = 0 time = 700
* CHECK dout1_21 vdout1_21ck139 = 0 time = 700
* CHECK dout1_22 vdout1_22ck139 = 0 time = 700
* CHECK dout1_23 vdout1_23ck139 = 1.0 time = 700
* CHECK dout1_24 vdout1_24ck139 = 0 time = 700
* CHECK dout1_25 vdout1_25ck139 = 0 time = 700
* CHECK dout1_26 vdout1_26ck139 = 0 time = 700
* CHECK dout1_27 vdout1_27ck139 = 0 time = 700
* CHECK dout1_28 vdout1_28ck139 = 1.0 time = 700
* CHECK dout1_29 vdout1_29ck139 = 0 time = 700
* CHECK dout1_30 vdout1_30ck139 = 1.0 time = 700
* CHECK dout1_31 vdout1_31ck139 = 0 time = 700
* CHECK dout1_32 vdout1_32ck139 = 1.0 time = 700
* CHECK dout1_33 vdout1_33ck139 = 1.0 time = 700
* CHECK dout1_34 vdout1_34ck139 = 0 time = 700
* CHECK dout1_35 vdout1_35ck139 = 1.0 time = 700
* CHECK dout1_36 vdout1_36ck139 = 1.0 time = 700
* CHECK dout1_37 vdout1_37ck139 = 1.0 time = 700
* CHECK dout1_38 vdout1_38ck139 = 1.0 time = 700
* CHECK dout1_39 vdout1_39ck139 = 1.0 time = 700
* CHECK dout1_40 vdout1_40ck139 = 1.0 time = 700
* CHECK dout1_41 vdout1_41ck139 = 1.0 time = 700
* CHECK dout1_42 vdout1_42ck139 = 0 time = 700
* CHECK dout1_43 vdout1_43ck139 = 0 time = 700
* CHECK dout1_44 vdout1_44ck139 = 1.0 time = 700
* CHECK dout1_45 vdout1_45ck139 = 1.0 time = 700
* CHECK dout1_46 vdout1_46ck139 = 0 time = 700
* CHECK dout1_47 vdout1_47ck139 = 0 time = 700
* CHECK dout1_48 vdout1_48ck139 = 1.0 time = 700
* CHECK dout1_49 vdout1_49ck139 = 0 time = 700
* CHECK dout1_50 vdout1_50ck139 = 1.0 time = 700
* CHECK dout1_51 vdout1_51ck139 = 1.0 time = 700
* CHECK dout1_52 vdout1_52ck139 = 0 time = 700
* CHECK dout1_53 vdout1_53ck139 = 1.0 time = 700
* CHECK dout1_54 vdout1_54ck139 = 1.0 time = 700
* CHECK dout1_55 vdout1_55ck139 = 1.0 time = 700
* CHECK dout1_56 vdout1_56ck139 = 0 time = 700
* CHECK dout1_57 vdout1_57ck139 = 1.0 time = 700
* CHECK dout1_58 vdout1_58ck139 = 1.0 time = 700
* CHECK dout1_59 vdout1_59ck139 = 0 time = 700
* CHECK dout1_60 vdout1_60ck139 = 0 time = 700
* CHECK dout1_61 vdout1_61ck139 = 1.0 time = 700
* CHECK dout1_62 vdout1_62ck139 = 1.0 time = 700
* CHECK dout1_63 vdout1_63ck139 = 1.0 time = 700
* CHECK dout0_0 vdout0_0ck140 = 1.0 time = 705
* CHECK dout0_1 vdout0_1ck140 = 1.0 time = 705
* CHECK dout0_2 vdout0_2ck140 = 0 time = 705
* CHECK dout0_3 vdout0_3ck140 = 0 time = 705
* CHECK dout0_4 vdout0_4ck140 = 0 time = 705
* CHECK dout0_5 vdout0_5ck140 = 1.0 time = 705
* CHECK dout0_6 vdout0_6ck140 = 0 time = 705
* CHECK dout0_7 vdout0_7ck140 = 1.0 time = 705
* CHECK dout0_8 vdout0_8ck140 = 0 time = 705
* CHECK dout0_9 vdout0_9ck140 = 1.0 time = 705
* CHECK dout0_10 vdout0_10ck140 = 0 time = 705
* CHECK dout0_11 vdout0_11ck140 = 1.0 time = 705
* CHECK dout0_12 vdout0_12ck140 = 0 time = 705
* CHECK dout0_13 vdout0_13ck140 = 1.0 time = 705
* CHECK dout0_14 vdout0_14ck140 = 0 time = 705
* CHECK dout0_15 vdout0_15ck140 = 0 time = 705
* CHECK dout0_16 vdout0_16ck140 = 1.0 time = 705
* CHECK dout0_17 vdout0_17ck140 = 1.0 time = 705
* CHECK dout0_18 vdout0_18ck140 = 0 time = 705
* CHECK dout0_19 vdout0_19ck140 = 0 time = 705
* CHECK dout0_20 vdout0_20ck140 = 1.0 time = 705
* CHECK dout0_21 vdout0_21ck140 = 0 time = 705
* CHECK dout0_22 vdout0_22ck140 = 0 time = 705
* CHECK dout0_23 vdout0_23ck140 = 0 time = 705
* CHECK dout0_24 vdout0_24ck140 = 0 time = 705
* CHECK dout0_25 vdout0_25ck140 = 0 time = 705
* CHECK dout0_26 vdout0_26ck140 = 1.0 time = 705
* CHECK dout0_27 vdout0_27ck140 = 0 time = 705
* CHECK dout0_28 vdout0_28ck140 = 1.0 time = 705
* CHECK dout0_29 vdout0_29ck140 = 1.0 time = 705
* CHECK dout0_30 vdout0_30ck140 = 1.0 time = 705
* CHECK dout0_31 vdout0_31ck140 = 0 time = 705
* CHECK dout0_32 vdout0_32ck140 = 0 time = 705
* CHECK dout0_33 vdout0_33ck140 = 1.0 time = 705
* CHECK dout0_34 vdout0_34ck140 = 1.0 time = 705
* CHECK dout0_35 vdout0_35ck140 = 0 time = 705
* CHECK dout0_36 vdout0_36ck140 = 0 time = 705
* CHECK dout0_37 vdout0_37ck140 = 0 time = 705
* CHECK dout0_38 vdout0_38ck140 = 1.0 time = 705
* CHECK dout0_39 vdout0_39ck140 = 1.0 time = 705
* CHECK dout0_40 vdout0_40ck140 = 0 time = 705
* CHECK dout0_41 vdout0_41ck140 = 0 time = 705
* CHECK dout0_42 vdout0_42ck140 = 1.0 time = 705
* CHECK dout0_43 vdout0_43ck140 = 0 time = 705
* CHECK dout0_44 vdout0_44ck140 = 0 time = 705
* CHECK dout0_45 vdout0_45ck140 = 1.0 time = 705
* CHECK dout0_46 vdout0_46ck140 = 1.0 time = 705
* CHECK dout0_47 vdout0_47ck140 = 0 time = 705
* CHECK dout0_48 vdout0_48ck140 = 1.0 time = 705
* CHECK dout0_49 vdout0_49ck140 = 0 time = 705
* CHECK dout0_50 vdout0_50ck140 = 1.0 time = 705
* CHECK dout0_51 vdout0_51ck140 = 0 time = 705
* CHECK dout0_52 vdout0_52ck140 = 0 time = 705
* CHECK dout0_53 vdout0_53ck140 = 0 time = 705
* CHECK dout0_54 vdout0_54ck140 = 0 time = 705
* CHECK dout0_55 vdout0_55ck140 = 1.0 time = 705
* CHECK dout0_56 vdout0_56ck140 = 0 time = 705
* CHECK dout0_57 vdout0_57ck140 = 0 time = 705
* CHECK dout0_58 vdout0_58ck140 = 1.0 time = 705
* CHECK dout0_59 vdout0_59ck140 = 1.0 time = 705
* CHECK dout0_60 vdout0_60ck140 = 0 time = 705
* CHECK dout0_61 vdout0_61ck140 = 0 time = 705
* CHECK dout0_62 vdout0_62ck140 = 0 time = 705
* CHECK dout0_63 vdout0_63ck140 = 1.0 time = 705
* CHECK dout1_0 vdout1_0ck140 = 1.0 time = 705
* CHECK dout1_1 vdout1_1ck140 = 1.0 time = 705
* CHECK dout1_2 vdout1_2ck140 = 1.0 time = 705
* CHECK dout1_3 vdout1_3ck140 = 1.0 time = 705
* CHECK dout1_4 vdout1_4ck140 = 1.0 time = 705
* CHECK dout1_5 vdout1_5ck140 = 0 time = 705
* CHECK dout1_6 vdout1_6ck140 = 0 time = 705
* CHECK dout1_7 vdout1_7ck140 = 1.0 time = 705
* CHECK dout1_8 vdout1_8ck140 = 1.0 time = 705
* CHECK dout1_9 vdout1_9ck140 = 0 time = 705
* CHECK dout1_10 vdout1_10ck140 = 0 time = 705
* CHECK dout1_11 vdout1_11ck140 = 1.0 time = 705
* CHECK dout1_12 vdout1_12ck140 = 1.0 time = 705
* CHECK dout1_13 vdout1_13ck140 = 0 time = 705
* CHECK dout1_14 vdout1_14ck140 = 1.0 time = 705
* CHECK dout1_15 vdout1_15ck140 = 0 time = 705
* CHECK dout1_16 vdout1_16ck140 = 1.0 time = 705
* CHECK dout1_17 vdout1_17ck140 = 0 time = 705
* CHECK dout1_18 vdout1_18ck140 = 0 time = 705
* CHECK dout1_19 vdout1_19ck140 = 1.0 time = 705
* CHECK dout1_20 vdout1_20ck140 = 0 time = 705
* CHECK dout1_21 vdout1_21ck140 = 0 time = 705
* CHECK dout1_22 vdout1_22ck140 = 0 time = 705
* CHECK dout1_23 vdout1_23ck140 = 1.0 time = 705
* CHECK dout1_24 vdout1_24ck140 = 0 time = 705
* CHECK dout1_25 vdout1_25ck140 = 0 time = 705
* CHECK dout1_26 vdout1_26ck140 = 0 time = 705
* CHECK dout1_27 vdout1_27ck140 = 0 time = 705
* CHECK dout1_28 vdout1_28ck140 = 1.0 time = 705
* CHECK dout1_29 vdout1_29ck140 = 0 time = 705
* CHECK dout1_30 vdout1_30ck140 = 1.0 time = 705
* CHECK dout1_31 vdout1_31ck140 = 0 time = 705
* CHECK dout1_32 vdout1_32ck140 = 1.0 time = 705
* CHECK dout1_33 vdout1_33ck140 = 1.0 time = 705
* CHECK dout1_34 vdout1_34ck140 = 0 time = 705
* CHECK dout1_35 vdout1_35ck140 = 1.0 time = 705
* CHECK dout1_36 vdout1_36ck140 = 1.0 time = 705
* CHECK dout1_37 vdout1_37ck140 = 1.0 time = 705
* CHECK dout1_38 vdout1_38ck140 = 1.0 time = 705
* CHECK dout1_39 vdout1_39ck140 = 1.0 time = 705
* CHECK dout1_40 vdout1_40ck140 = 1.0 time = 705
* CHECK dout1_41 vdout1_41ck140 = 1.0 time = 705
* CHECK dout1_42 vdout1_42ck140 = 0 time = 705
* CHECK dout1_43 vdout1_43ck140 = 0 time = 705
* CHECK dout1_44 vdout1_44ck140 = 1.0 time = 705
* CHECK dout1_45 vdout1_45ck140 = 1.0 time = 705
* CHECK dout1_46 vdout1_46ck140 = 0 time = 705
* CHECK dout1_47 vdout1_47ck140 = 0 time = 705
* CHECK dout1_48 vdout1_48ck140 = 1.0 time = 705
* CHECK dout1_49 vdout1_49ck140 = 0 time = 705
* CHECK dout1_50 vdout1_50ck140 = 1.0 time = 705
* CHECK dout1_51 vdout1_51ck140 = 1.0 time = 705
* CHECK dout1_52 vdout1_52ck140 = 0 time = 705
* CHECK dout1_53 vdout1_53ck140 = 1.0 time = 705
* CHECK dout1_54 vdout1_54ck140 = 1.0 time = 705
* CHECK dout1_55 vdout1_55ck140 = 1.0 time = 705
* CHECK dout1_56 vdout1_56ck140 = 0 time = 705
* CHECK dout1_57 vdout1_57ck140 = 1.0 time = 705
* CHECK dout1_58 vdout1_58ck140 = 1.0 time = 705
* CHECK dout1_59 vdout1_59ck140 = 0 time = 705
* CHECK dout1_60 vdout1_60ck140 = 0 time = 705
* CHECK dout1_61 vdout1_61ck140 = 1.0 time = 705
* CHECK dout1_62 vdout1_62ck140 = 1.0 time = 705
* CHECK dout1_63 vdout1_63ck140 = 1.0 time = 705
* CHECK dout0_0 vdout0_0ck141 = 1.0 time = 710
* CHECK dout0_1 vdout0_1ck141 = 1.0 time = 710
* CHECK dout0_2 vdout0_2ck141 = 1.0 time = 710
* CHECK dout0_3 vdout0_3ck141 = 1.0 time = 710
* CHECK dout0_4 vdout0_4ck141 = 1.0 time = 710
* CHECK dout0_5 vdout0_5ck141 = 0 time = 710
* CHECK dout0_6 vdout0_6ck141 = 0 time = 710
* CHECK dout0_7 vdout0_7ck141 = 1.0 time = 710
* CHECK dout0_8 vdout0_8ck141 = 1.0 time = 710
* CHECK dout0_9 vdout0_9ck141 = 0 time = 710
* CHECK dout0_10 vdout0_10ck141 = 0 time = 710
* CHECK dout0_11 vdout0_11ck141 = 1.0 time = 710
* CHECK dout0_12 vdout0_12ck141 = 1.0 time = 710
* CHECK dout0_13 vdout0_13ck141 = 0 time = 710
* CHECK dout0_14 vdout0_14ck141 = 1.0 time = 710
* CHECK dout0_15 vdout0_15ck141 = 0 time = 710
* CHECK dout0_16 vdout0_16ck141 = 1.0 time = 710
* CHECK dout0_17 vdout0_17ck141 = 0 time = 710
* CHECK dout0_18 vdout0_18ck141 = 0 time = 710
* CHECK dout0_19 vdout0_19ck141 = 1.0 time = 710
* CHECK dout0_20 vdout0_20ck141 = 0 time = 710
* CHECK dout0_21 vdout0_21ck141 = 0 time = 710
* CHECK dout0_22 vdout0_22ck141 = 0 time = 710
* CHECK dout0_23 vdout0_23ck141 = 1.0 time = 710
* CHECK dout0_24 vdout0_24ck141 = 0 time = 710
* CHECK dout0_25 vdout0_25ck141 = 0 time = 710
* CHECK dout0_26 vdout0_26ck141 = 0 time = 710
* CHECK dout0_27 vdout0_27ck141 = 0 time = 710
* CHECK dout0_28 vdout0_28ck141 = 1.0 time = 710
* CHECK dout0_29 vdout0_29ck141 = 0 time = 710
* CHECK dout0_30 vdout0_30ck141 = 1.0 time = 710
* CHECK dout0_31 vdout0_31ck141 = 0 time = 710
* CHECK dout0_32 vdout0_32ck141 = 1.0 time = 710
* CHECK dout0_33 vdout0_33ck141 = 1.0 time = 710
* CHECK dout0_34 vdout0_34ck141 = 0 time = 710
* CHECK dout0_35 vdout0_35ck141 = 1.0 time = 710
* CHECK dout0_36 vdout0_36ck141 = 1.0 time = 710
* CHECK dout0_37 vdout0_37ck141 = 1.0 time = 710
* CHECK dout0_38 vdout0_38ck141 = 1.0 time = 710
* CHECK dout0_39 vdout0_39ck141 = 1.0 time = 710
* CHECK dout0_40 vdout0_40ck141 = 1.0 time = 710
* CHECK dout0_41 vdout0_41ck141 = 1.0 time = 710
* CHECK dout0_42 vdout0_42ck141 = 0 time = 710
* CHECK dout0_43 vdout0_43ck141 = 0 time = 710
* CHECK dout0_44 vdout0_44ck141 = 1.0 time = 710
* CHECK dout0_45 vdout0_45ck141 = 1.0 time = 710
* CHECK dout0_46 vdout0_46ck141 = 0 time = 710
* CHECK dout0_47 vdout0_47ck141 = 0 time = 710
* CHECK dout0_48 vdout0_48ck141 = 1.0 time = 710
* CHECK dout0_49 vdout0_49ck141 = 0 time = 710
* CHECK dout0_50 vdout0_50ck141 = 1.0 time = 710
* CHECK dout0_51 vdout0_51ck141 = 1.0 time = 710
* CHECK dout0_52 vdout0_52ck141 = 0 time = 710
* CHECK dout0_53 vdout0_53ck141 = 1.0 time = 710
* CHECK dout0_54 vdout0_54ck141 = 1.0 time = 710
* CHECK dout0_55 vdout0_55ck141 = 1.0 time = 710
* CHECK dout0_56 vdout0_56ck141 = 0 time = 710
* CHECK dout0_57 vdout0_57ck141 = 1.0 time = 710
* CHECK dout0_58 vdout0_58ck141 = 1.0 time = 710
* CHECK dout0_59 vdout0_59ck141 = 0 time = 710
* CHECK dout0_60 vdout0_60ck141 = 0 time = 710
* CHECK dout0_61 vdout0_61ck141 = 1.0 time = 710
* CHECK dout0_62 vdout0_62ck141 = 1.0 time = 710
* CHECK dout0_63 vdout0_63ck141 = 1.0 time = 710
* CHECK dout1_0 vdout1_0ck141 = 0 time = 710
* CHECK dout1_1 vdout1_1ck141 = 0 time = 710
* CHECK dout1_2 vdout1_2ck141 = 1.0 time = 710
* CHECK dout1_3 vdout1_3ck141 = 0 time = 710
* CHECK dout1_4 vdout1_4ck141 = 1.0 time = 710
* CHECK dout1_5 vdout1_5ck141 = 0 time = 710
* CHECK dout1_6 vdout1_6ck141 = 0 time = 710
* CHECK dout1_7 vdout1_7ck141 = 0 time = 710
* CHECK dout1_8 vdout1_8ck141 = 1.0 time = 710
* CHECK dout1_9 vdout1_9ck141 = 0 time = 710
* CHECK dout1_10 vdout1_10ck141 = 1.0 time = 710
* CHECK dout1_11 vdout1_11ck141 = 1.0 time = 710
* CHECK dout1_12 vdout1_12ck141 = 0 time = 710
* CHECK dout1_13 vdout1_13ck141 = 0 time = 710
* CHECK dout1_14 vdout1_14ck141 = 0 time = 710
* CHECK dout1_15 vdout1_15ck141 = 0 time = 710
* CHECK dout1_16 vdout1_16ck141 = 0 time = 710
* CHECK dout1_17 vdout1_17ck141 = 1.0 time = 710
* CHECK dout1_18 vdout1_18ck141 = 1.0 time = 710
* CHECK dout1_19 vdout1_19ck141 = 1.0 time = 710
* CHECK dout1_20 vdout1_20ck141 = 0 time = 710
* CHECK dout1_21 vdout1_21ck141 = 0 time = 710
* CHECK dout1_22 vdout1_22ck141 = 0 time = 710
* CHECK dout1_23 vdout1_23ck141 = 1.0 time = 710
* CHECK dout1_24 vdout1_24ck141 = 0 time = 710
* CHECK dout1_25 vdout1_25ck141 = 0 time = 710
* CHECK dout1_26 vdout1_26ck141 = 1.0 time = 710
* CHECK dout1_27 vdout1_27ck141 = 0 time = 710
* CHECK dout1_28 vdout1_28ck141 = 1.0 time = 710
* CHECK dout1_29 vdout1_29ck141 = 1.0 time = 710
* CHECK dout1_30 vdout1_30ck141 = 0 time = 710
* CHECK dout1_31 vdout1_31ck141 = 1.0 time = 710
* CHECK dout1_32 vdout1_32ck141 = 0 time = 710
* CHECK dout1_33 vdout1_33ck141 = 1.0 time = 710
* CHECK dout1_34 vdout1_34ck141 = 0 time = 710
* CHECK dout1_35 vdout1_35ck141 = 1.0 time = 710
* CHECK dout1_36 vdout1_36ck141 = 1.0 time = 710
* CHECK dout1_37 vdout1_37ck141 = 0 time = 710
* CHECK dout1_38 vdout1_38ck141 = 0 time = 710
* CHECK dout1_39 vdout1_39ck141 = 1.0 time = 710
* CHECK dout1_40 vdout1_40ck141 = 0 time = 710
* CHECK dout1_41 vdout1_41ck141 = 1.0 time = 710
* CHECK dout1_42 vdout1_42ck141 = 1.0 time = 710
* CHECK dout1_43 vdout1_43ck141 = 0 time = 710
* CHECK dout1_44 vdout1_44ck141 = 1.0 time = 710
* CHECK dout1_45 vdout1_45ck141 = 1.0 time = 710
* CHECK dout1_46 vdout1_46ck141 = 0 time = 710
* CHECK dout1_47 vdout1_47ck141 = 0 time = 710
* CHECK dout1_48 vdout1_48ck141 = 0 time = 710
* CHECK dout1_49 vdout1_49ck141 = 1.0 time = 710
* CHECK dout1_50 vdout1_50ck141 = 0 time = 710
* CHECK dout1_51 vdout1_51ck141 = 0 time = 710
* CHECK dout1_52 vdout1_52ck141 = 0 time = 710
* CHECK dout1_53 vdout1_53ck141 = 1.0 time = 710
* CHECK dout1_54 vdout1_54ck141 = 0 time = 710
* CHECK dout1_55 vdout1_55ck141 = 0 time = 710
* CHECK dout1_56 vdout1_56ck141 = 1.0 time = 710
* CHECK dout1_57 vdout1_57ck141 = 1.0 time = 710
* CHECK dout1_58 vdout1_58ck141 = 0 time = 710
* CHECK dout1_59 vdout1_59ck141 = 1.0 time = 710
* CHECK dout1_60 vdout1_60ck141 = 1.0 time = 710
* CHECK dout1_61 vdout1_61ck141 = 1.0 time = 710
* CHECK dout1_62 vdout1_62ck141 = 1.0 time = 710
* CHECK dout1_63 vdout1_63ck141 = 0 time = 710
* CHECK dout0_0 vdout0_0ck142 = 1.0 time = 715
* CHECK dout0_1 vdout0_1ck142 = 1.0 time = 715
* CHECK dout0_2 vdout0_2ck142 = 0 time = 715
* CHECK dout0_3 vdout0_3ck142 = 0 time = 715
* CHECK dout0_4 vdout0_4ck142 = 0 time = 715
* CHECK dout0_5 vdout0_5ck142 = 0 time = 715
* CHECK dout0_6 vdout0_6ck142 = 1.0 time = 715
* CHECK dout0_7 vdout0_7ck142 = 1.0 time = 715
* CHECK dout0_8 vdout0_8ck142 = 0 time = 715
* CHECK dout0_9 vdout0_9ck142 = 1.0 time = 715
* CHECK dout0_10 vdout0_10ck142 = 0 time = 715
* CHECK dout0_11 vdout0_11ck142 = 1.0 time = 715
* CHECK dout0_12 vdout0_12ck142 = 1.0 time = 715
* CHECK dout0_13 vdout0_13ck142 = 1.0 time = 715
* CHECK dout0_14 vdout0_14ck142 = 1.0 time = 715
* CHECK dout0_15 vdout0_15ck142 = 0 time = 715
* CHECK dout0_16 vdout0_16ck142 = 0 time = 715
* CHECK dout0_17 vdout0_17ck142 = 0 time = 715
* CHECK dout0_18 vdout0_18ck142 = 1.0 time = 715
* CHECK dout0_19 vdout0_19ck142 = 1.0 time = 715
* CHECK dout0_20 vdout0_20ck142 = 1.0 time = 715
* CHECK dout0_21 vdout0_21ck142 = 1.0 time = 715
* CHECK dout0_22 vdout0_22ck142 = 0 time = 715
* CHECK dout0_23 vdout0_23ck142 = 1.0 time = 715
* CHECK dout0_24 vdout0_24ck142 = 1.0 time = 715
* CHECK dout0_25 vdout0_25ck142 = 1.0 time = 715
* CHECK dout0_26 vdout0_26ck142 = 1.0 time = 715
* CHECK dout0_27 vdout0_27ck142 = 1.0 time = 715
* CHECK dout0_28 vdout0_28ck142 = 1.0 time = 715
* CHECK dout0_29 vdout0_29ck142 = 1.0 time = 715
* CHECK dout0_30 vdout0_30ck142 = 1.0 time = 715
* CHECK dout0_31 vdout0_31ck142 = 0 time = 715
* CHECK dout0_32 vdout0_32ck142 = 0 time = 715
* CHECK dout0_33 vdout0_33ck142 = 1.0 time = 715
* CHECK dout0_34 vdout0_34ck142 = 0 time = 715
* CHECK dout0_35 vdout0_35ck142 = 1.0 time = 715
* CHECK dout0_36 vdout0_36ck142 = 0 time = 715
* CHECK dout0_37 vdout0_37ck142 = 0 time = 715
* CHECK dout0_38 vdout0_38ck142 = 0 time = 715
* CHECK dout0_39 vdout0_39ck142 = 0 time = 715
* CHECK dout0_40 vdout0_40ck142 = 0 time = 715
* CHECK dout0_41 vdout0_41ck142 = 0 time = 715
* CHECK dout0_42 vdout0_42ck142 = 1.0 time = 715
* CHECK dout0_43 vdout0_43ck142 = 1.0 time = 715
* CHECK dout0_44 vdout0_44ck142 = 1.0 time = 715
* CHECK dout0_45 vdout0_45ck142 = 1.0 time = 715
* CHECK dout0_46 vdout0_46ck142 = 0 time = 715
* CHECK dout0_47 vdout0_47ck142 = 1.0 time = 715
* CHECK dout0_48 vdout0_48ck142 = 0 time = 715
* CHECK dout0_49 vdout0_49ck142 = 1.0 time = 715
* CHECK dout0_50 vdout0_50ck142 = 1.0 time = 715
* CHECK dout0_51 vdout0_51ck142 = 0 time = 715
* CHECK dout0_52 vdout0_52ck142 = 1.0 time = 715
* CHECK dout0_53 vdout0_53ck142 = 0 time = 715
* CHECK dout0_54 vdout0_54ck142 = 1.0 time = 715
* CHECK dout0_55 vdout0_55ck142 = 1.0 time = 715
* CHECK dout0_56 vdout0_56ck142 = 0 time = 715
* CHECK dout0_57 vdout0_57ck142 = 1.0 time = 715
* CHECK dout0_58 vdout0_58ck142 = 0 time = 715
* CHECK dout0_59 vdout0_59ck142 = 0 time = 715
* CHECK dout0_60 vdout0_60ck142 = 1.0 time = 715
* CHECK dout0_61 vdout0_61ck142 = 1.0 time = 715
* CHECK dout0_62 vdout0_62ck142 = 1.0 time = 715
* CHECK dout0_63 vdout0_63ck142 = 0 time = 715
* CHECK dout0_0 vdout0_0ck143 = 1.0 time = 720
* CHECK dout0_1 vdout0_1ck143 = 1.0 time = 720
* CHECK dout0_2 vdout0_2ck143 = 0 time = 720
* CHECK dout0_3 vdout0_3ck143 = 0 time = 720
* CHECK dout0_4 vdout0_4ck143 = 0 time = 720
* CHECK dout0_5 vdout0_5ck143 = 1.0 time = 720
* CHECK dout0_6 vdout0_6ck143 = 0 time = 720
* CHECK dout0_7 vdout0_7ck143 = 1.0 time = 720
* CHECK dout0_8 vdout0_8ck143 = 0 time = 720
* CHECK dout0_9 vdout0_9ck143 = 1.0 time = 720
* CHECK dout0_10 vdout0_10ck143 = 0 time = 720
* CHECK dout0_11 vdout0_11ck143 = 1.0 time = 720
* CHECK dout0_12 vdout0_12ck143 = 0 time = 720
* CHECK dout0_13 vdout0_13ck143 = 1.0 time = 720
* CHECK dout0_14 vdout0_14ck143 = 0 time = 720
* CHECK dout0_15 vdout0_15ck143 = 0 time = 720
* CHECK dout0_16 vdout0_16ck143 = 1.0 time = 720
* CHECK dout0_17 vdout0_17ck143 = 1.0 time = 720
* CHECK dout0_18 vdout0_18ck143 = 0 time = 720
* CHECK dout0_19 vdout0_19ck143 = 0 time = 720
* CHECK dout0_20 vdout0_20ck143 = 1.0 time = 720
* CHECK dout0_21 vdout0_21ck143 = 0 time = 720
* CHECK dout0_22 vdout0_22ck143 = 0 time = 720
* CHECK dout0_23 vdout0_23ck143 = 0 time = 720
* CHECK dout0_24 vdout0_24ck143 = 0 time = 720
* CHECK dout0_25 vdout0_25ck143 = 0 time = 720
* CHECK dout0_26 vdout0_26ck143 = 1.0 time = 720
* CHECK dout0_27 vdout0_27ck143 = 0 time = 720
* CHECK dout0_28 vdout0_28ck143 = 1.0 time = 720
* CHECK dout0_29 vdout0_29ck143 = 1.0 time = 720
* CHECK dout0_30 vdout0_30ck143 = 1.0 time = 720
* CHECK dout0_31 vdout0_31ck143 = 0 time = 720
* CHECK dout0_32 vdout0_32ck143 = 0 time = 720
* CHECK dout0_33 vdout0_33ck143 = 1.0 time = 720
* CHECK dout0_34 vdout0_34ck143 = 1.0 time = 720
* CHECK dout0_35 vdout0_35ck143 = 0 time = 720
* CHECK dout0_36 vdout0_36ck143 = 0 time = 720
* CHECK dout0_37 vdout0_37ck143 = 0 time = 720
* CHECK dout0_38 vdout0_38ck143 = 1.0 time = 720
* CHECK dout0_39 vdout0_39ck143 = 1.0 time = 720
* CHECK dout0_40 vdout0_40ck143 = 0 time = 720
* CHECK dout0_41 vdout0_41ck143 = 0 time = 720
* CHECK dout0_42 vdout0_42ck143 = 1.0 time = 720
* CHECK dout0_43 vdout0_43ck143 = 0 time = 720
* CHECK dout0_44 vdout0_44ck143 = 0 time = 720
* CHECK dout0_45 vdout0_45ck143 = 1.0 time = 720
* CHECK dout0_46 vdout0_46ck143 = 1.0 time = 720
* CHECK dout0_47 vdout0_47ck143 = 0 time = 720
* CHECK dout0_48 vdout0_48ck143 = 1.0 time = 720
* CHECK dout0_49 vdout0_49ck143 = 0 time = 720
* CHECK dout0_50 vdout0_50ck143 = 1.0 time = 720
* CHECK dout0_51 vdout0_51ck143 = 0 time = 720
* CHECK dout0_52 vdout0_52ck143 = 0 time = 720
* CHECK dout0_53 vdout0_53ck143 = 0 time = 720
* CHECK dout0_54 vdout0_54ck143 = 0 time = 720
* CHECK dout0_55 vdout0_55ck143 = 1.0 time = 720
* CHECK dout0_56 vdout0_56ck143 = 0 time = 720
* CHECK dout0_57 vdout0_57ck143 = 0 time = 720
* CHECK dout0_58 vdout0_58ck143 = 1.0 time = 720
* CHECK dout0_59 vdout0_59ck143 = 1.0 time = 720
* CHECK dout0_60 vdout0_60ck143 = 0 time = 720
* CHECK dout0_61 vdout0_61ck143 = 0 time = 720
* CHECK dout0_62 vdout0_62ck143 = 0 time = 720
* CHECK dout0_63 vdout0_63ck143 = 1.0 time = 720
* CHECK dout1_0 vdout1_0ck143 = 0 time = 720
* CHECK dout1_1 vdout1_1ck143 = 1.0 time = 720
* CHECK dout1_2 vdout1_2ck143 = 1.0 time = 720
* CHECK dout1_3 vdout1_3ck143 = 1.0 time = 720
* CHECK dout1_4 vdout1_4ck143 = 0 time = 720
* CHECK dout1_5 vdout1_5ck143 = 1.0 time = 720
* CHECK dout1_6 vdout1_6ck143 = 1.0 time = 720
* CHECK dout1_7 vdout1_7ck143 = 0 time = 720
* CHECK dout1_8 vdout1_8ck143 = 0 time = 720
* CHECK dout1_9 vdout1_9ck143 = 0 time = 720
* CHECK dout1_10 vdout1_10ck143 = 1.0 time = 720
* CHECK dout1_11 vdout1_11ck143 = 1.0 time = 720
* CHECK dout1_12 vdout1_12ck143 = 0 time = 720
* CHECK dout1_13 vdout1_13ck143 = 0 time = 720
* CHECK dout1_14 vdout1_14ck143 = 0 time = 720
* CHECK dout1_15 vdout1_15ck143 = 1.0 time = 720
* CHECK dout1_16 vdout1_16ck143 = 1.0 time = 720
* CHECK dout1_17 vdout1_17ck143 = 0 time = 720
* CHECK dout1_18 vdout1_18ck143 = 0 time = 720
* CHECK dout1_19 vdout1_19ck143 = 0 time = 720
* CHECK dout1_20 vdout1_20ck143 = 0 time = 720
* CHECK dout1_21 vdout1_21ck143 = 0 time = 720
* CHECK dout1_22 vdout1_22ck143 = 1.0 time = 720
* CHECK dout1_23 vdout1_23ck143 = 0 time = 720
* CHECK dout1_24 vdout1_24ck143 = 1.0 time = 720
* CHECK dout1_25 vdout1_25ck143 = 1.0 time = 720
* CHECK dout1_26 vdout1_26ck143 = 0 time = 720
* CHECK dout1_27 vdout1_27ck143 = 0 time = 720
* CHECK dout1_28 vdout1_28ck143 = 1.0 time = 720
* CHECK dout1_29 vdout1_29ck143 = 0 time = 720
* CHECK dout1_30 vdout1_30ck143 = 1.0 time = 720
* CHECK dout1_31 vdout1_31ck143 = 0 time = 720
* CHECK dout1_32 vdout1_32ck143 = 0 time = 720
* CHECK dout1_33 vdout1_33ck143 = 1.0 time = 720
* CHECK dout1_34 vdout1_34ck143 = 1.0 time = 720
* CHECK dout1_35 vdout1_35ck143 = 1.0 time = 720
* CHECK dout1_36 vdout1_36ck143 = 1.0 time = 720
* CHECK dout1_37 vdout1_37ck143 = 1.0 time = 720
* CHECK dout1_38 vdout1_38ck143 = 0 time = 720
* CHECK dout1_39 vdout1_39ck143 = 0 time = 720
* CHECK dout1_40 vdout1_40ck143 = 1.0 time = 720
* CHECK dout1_41 vdout1_41ck143 = 1.0 time = 720
* CHECK dout1_42 vdout1_42ck143 = 0 time = 720
* CHECK dout1_43 vdout1_43ck143 = 0 time = 720
* CHECK dout1_44 vdout1_44ck143 = 1.0 time = 720
* CHECK dout1_45 vdout1_45ck143 = 1.0 time = 720
* CHECK dout1_46 vdout1_46ck143 = 1.0 time = 720
* CHECK dout1_47 vdout1_47ck143 = 0 time = 720
* CHECK dout1_48 vdout1_48ck143 = 0 time = 720
* CHECK dout1_49 vdout1_49ck143 = 0 time = 720
* CHECK dout1_50 vdout1_50ck143 = 0 time = 720
* CHECK dout1_51 vdout1_51ck143 = 0 time = 720
* CHECK dout1_52 vdout1_52ck143 = 1.0 time = 720
* CHECK dout1_53 vdout1_53ck143 = 1.0 time = 720
* CHECK dout1_54 vdout1_54ck143 = 0 time = 720
* CHECK dout1_55 vdout1_55ck143 = 0 time = 720
* CHECK dout1_56 vdout1_56ck143 = 1.0 time = 720
* CHECK dout1_57 vdout1_57ck143 = 1.0 time = 720
* CHECK dout1_58 vdout1_58ck143 = 1.0 time = 720
* CHECK dout1_59 vdout1_59ck143 = 1.0 time = 720
* CHECK dout1_60 vdout1_60ck143 = 1.0 time = 720
* CHECK dout1_61 vdout1_61ck143 = 1.0 time = 720
* CHECK dout1_62 vdout1_62ck143 = 0 time = 720
* CHECK dout1_63 vdout1_63ck143 = 0 time = 720
* CHECK dout1_0 vdout1_0ck144 = 0 time = 725
* CHECK dout1_1 vdout1_1ck144 = 0 time = 725
* CHECK dout1_2 vdout1_2ck144 = 0 time = 725
* CHECK dout1_3 vdout1_3ck144 = 1.0 time = 725
* CHECK dout1_4 vdout1_4ck144 = 0 time = 725
* CHECK dout1_5 vdout1_5ck144 = 0 time = 725
* CHECK dout1_6 vdout1_6ck144 = 1.0 time = 725
* CHECK dout1_7 vdout1_7ck144 = 1.0 time = 725
* CHECK dout1_8 vdout1_8ck144 = 0 time = 725
* CHECK dout1_9 vdout1_9ck144 = 1.0 time = 725
* CHECK dout1_10 vdout1_10ck144 = 1.0 time = 725
* CHECK dout1_11 vdout1_11ck144 = 0 time = 725
* CHECK dout1_12 vdout1_12ck144 = 0 time = 725
* CHECK dout1_13 vdout1_13ck144 = 0 time = 725
* CHECK dout1_14 vdout1_14ck144 = 1.0 time = 725
* CHECK dout1_15 vdout1_15ck144 = 1.0 time = 725
* CHECK dout1_16 vdout1_16ck144 = 0 time = 725
* CHECK dout1_17 vdout1_17ck144 = 1.0 time = 725
* CHECK dout1_18 vdout1_18ck144 = 0 time = 725
* CHECK dout1_19 vdout1_19ck144 = 1.0 time = 725
* CHECK dout1_20 vdout1_20ck144 = 0 time = 725
* CHECK dout1_21 vdout1_21ck144 = 0 time = 725
* CHECK dout1_22 vdout1_22ck144 = 0 time = 725
* CHECK dout1_23 vdout1_23ck144 = 1.0 time = 725
* CHECK dout1_24 vdout1_24ck144 = 1.0 time = 725
* CHECK dout1_25 vdout1_25ck144 = 1.0 time = 725
* CHECK dout1_26 vdout1_26ck144 = 1.0 time = 725
* CHECK dout1_27 vdout1_27ck144 = 1.0 time = 725
* CHECK dout1_28 vdout1_28ck144 = 1.0 time = 725
* CHECK dout1_29 vdout1_29ck144 = 0 time = 725
* CHECK dout1_30 vdout1_30ck144 = 0 time = 725
* CHECK dout1_31 vdout1_31ck144 = 0 time = 725
* CHECK dout1_32 vdout1_32ck144 = 1.0 time = 725
* CHECK dout1_33 vdout1_33ck144 = 1.0 time = 725
* CHECK dout1_34 vdout1_34ck144 = 0 time = 725
* CHECK dout1_35 vdout1_35ck144 = 0 time = 725
* CHECK dout1_36 vdout1_36ck144 = 0 time = 725
* CHECK dout1_37 vdout1_37ck144 = 0 time = 725
* CHECK dout1_38 vdout1_38ck144 = 0 time = 725
* CHECK dout1_39 vdout1_39ck144 = 1.0 time = 725
* CHECK dout1_40 vdout1_40ck144 = 1.0 time = 725
* CHECK dout1_41 vdout1_41ck144 = 1.0 time = 725
* CHECK dout1_42 vdout1_42ck144 = 0 time = 725
* CHECK dout1_43 vdout1_43ck144 = 1.0 time = 725
* CHECK dout1_44 vdout1_44ck144 = 1.0 time = 725
* CHECK dout1_45 vdout1_45ck144 = 1.0 time = 725
* CHECK dout1_46 vdout1_46ck144 = 0 time = 725
* CHECK dout1_47 vdout1_47ck144 = 1.0 time = 725
* CHECK dout1_48 vdout1_48ck144 = 0 time = 725
* CHECK dout1_49 vdout1_49ck144 = 0 time = 725
* CHECK dout1_50 vdout1_50ck144 = 1.0 time = 725
* CHECK dout1_51 vdout1_51ck144 = 0 time = 725
* CHECK dout1_52 vdout1_52ck144 = 0 time = 725
* CHECK dout1_53 vdout1_53ck144 = 1.0 time = 725
* CHECK dout1_54 vdout1_54ck144 = 1.0 time = 725
* CHECK dout1_55 vdout1_55ck144 = 0 time = 725
* CHECK dout1_56 vdout1_56ck144 = 0 time = 725
* CHECK dout1_57 vdout1_57ck144 = 0 time = 725
* CHECK dout1_58 vdout1_58ck144 = 1.0 time = 725
* CHECK dout1_59 vdout1_59ck144 = 0 time = 725
* CHECK dout1_60 vdout1_60ck144 = 1.0 time = 725
* CHECK dout1_61 vdout1_61ck144 = 1.0 time = 725
* CHECK dout1_62 vdout1_62ck144 = 1.0 time = 725
* CHECK dout1_63 vdout1_63ck144 = 1.0 time = 725
* CHECK dout0_0 vdout0_0ck145 = 1.0 time = 730
* CHECK dout0_1 vdout0_1ck145 = 0 time = 730
* CHECK dout0_2 vdout0_2ck145 = 1.0 time = 730
* CHECK dout0_3 vdout0_3ck145 = 0 time = 730
* CHECK dout0_4 vdout0_4ck145 = 0 time = 730
* CHECK dout0_5 vdout0_5ck145 = 1.0 time = 730
* CHECK dout0_6 vdout0_6ck145 = 1.0 time = 730
* CHECK dout0_7 vdout0_7ck145 = 1.0 time = 730
* CHECK dout0_8 vdout0_8ck145 = 1.0 time = 730
* CHECK dout0_9 vdout0_9ck145 = 1.0 time = 730
* CHECK dout0_10 vdout0_10ck145 = 0 time = 730
* CHECK dout0_11 vdout0_11ck145 = 1.0 time = 730
* CHECK dout0_12 vdout0_12ck145 = 1.0 time = 730
* CHECK dout0_13 vdout0_13ck145 = 0 time = 730
* CHECK dout0_14 vdout0_14ck145 = 0 time = 730
* CHECK dout0_15 vdout0_15ck145 = 0 time = 730
* CHECK dout0_16 vdout0_16ck145 = 0 time = 730
* CHECK dout0_17 vdout0_17ck145 = 1.0 time = 730
* CHECK dout0_18 vdout0_18ck145 = 1.0 time = 730
* CHECK dout0_19 vdout0_19ck145 = 0 time = 730
* CHECK dout0_20 vdout0_20ck145 = 0 time = 730
* CHECK dout0_21 vdout0_21ck145 = 0 time = 730
* CHECK dout0_22 vdout0_22ck145 = 0 time = 730
* CHECK dout0_23 vdout0_23ck145 = 0 time = 730
* CHECK dout0_24 vdout0_24ck145 = 0 time = 730
* CHECK dout0_25 vdout0_25ck145 = 0 time = 730
* CHECK dout0_26 vdout0_26ck145 = 0 time = 730
* CHECK dout0_27 vdout0_27ck145 = 0 time = 730
* CHECK dout0_28 vdout0_28ck145 = 1.0 time = 730
* CHECK dout0_29 vdout0_29ck145 = 0 time = 730
* CHECK dout0_30 vdout0_30ck145 = 0 time = 730
* CHECK dout0_31 vdout0_31ck145 = 0 time = 730
* CHECK dout0_32 vdout0_32ck145 = 1.0 time = 730
* CHECK dout0_33 vdout0_33ck145 = 0 time = 730
* CHECK dout0_34 vdout0_34ck145 = 0 time = 730
* CHECK dout0_35 vdout0_35ck145 = 0 time = 730
* CHECK dout0_36 vdout0_36ck145 = 1.0 time = 730
* CHECK dout0_37 vdout0_37ck145 = 1.0 time = 730
* CHECK dout0_38 vdout0_38ck145 = 0 time = 730
* CHECK dout0_39 vdout0_39ck145 = 0 time = 730
* CHECK dout0_40 vdout0_40ck145 = 0 time = 730
* CHECK dout0_41 vdout0_41ck145 = 0 time = 730
* CHECK dout0_42 vdout0_42ck145 = 1.0 time = 730
* CHECK dout0_43 vdout0_43ck145 = 0 time = 730
* CHECK dout0_44 vdout0_44ck145 = 0 time = 730
* CHECK dout0_45 vdout0_45ck145 = 1.0 time = 730
* CHECK dout0_46 vdout0_46ck145 = 1.0 time = 730
* CHECK dout0_47 vdout0_47ck145 = 0 time = 730
* CHECK dout0_48 vdout0_48ck145 = 1.0 time = 730
* CHECK dout0_49 vdout0_49ck145 = 0 time = 730
* CHECK dout0_50 vdout0_50ck145 = 0 time = 730
* CHECK dout0_51 vdout0_51ck145 = 0 time = 730
* CHECK dout0_52 vdout0_52ck145 = 0 time = 730
* CHECK dout0_53 vdout0_53ck145 = 1.0 time = 730
* CHECK dout0_54 vdout0_54ck145 = 0 time = 730
* CHECK dout0_55 vdout0_55ck145 = 1.0 time = 730
* CHECK dout0_56 vdout0_56ck145 = 0 time = 730
* CHECK dout0_57 vdout0_57ck145 = 1.0 time = 730
* CHECK dout0_58 vdout0_58ck145 = 1.0 time = 730
* CHECK dout0_59 vdout0_59ck145 = 0 time = 730
* CHECK dout0_60 vdout0_60ck145 = 0 time = 730
* CHECK dout0_61 vdout0_61ck145 = 1.0 time = 730
* CHECK dout0_62 vdout0_62ck145 = 0 time = 730
* CHECK dout0_63 vdout0_63ck145 = 1.0 time = 730
* CHECK dout1_0 vdout1_0ck145 = 1.0 time = 730
* CHECK dout1_1 vdout1_1ck145 = 0 time = 730
* CHECK dout1_2 vdout1_2ck145 = 1.0 time = 730
* CHECK dout1_3 vdout1_3ck145 = 0 time = 730
* CHECK dout1_4 vdout1_4ck145 = 0 time = 730
* CHECK dout1_5 vdout1_5ck145 = 1.0 time = 730
* CHECK dout1_6 vdout1_6ck145 = 1.0 time = 730
* CHECK dout1_7 vdout1_7ck145 = 1.0 time = 730
* CHECK dout1_8 vdout1_8ck145 = 1.0 time = 730
* CHECK dout1_9 vdout1_9ck145 = 1.0 time = 730
* CHECK dout1_10 vdout1_10ck145 = 0 time = 730
* CHECK dout1_11 vdout1_11ck145 = 1.0 time = 730
* CHECK dout1_12 vdout1_12ck145 = 1.0 time = 730
* CHECK dout1_13 vdout1_13ck145 = 0 time = 730
* CHECK dout1_14 vdout1_14ck145 = 0 time = 730
* CHECK dout1_15 vdout1_15ck145 = 0 time = 730
* CHECK dout1_16 vdout1_16ck145 = 0 time = 730
* CHECK dout1_17 vdout1_17ck145 = 1.0 time = 730
* CHECK dout1_18 vdout1_18ck145 = 1.0 time = 730
* CHECK dout1_19 vdout1_19ck145 = 0 time = 730
* CHECK dout1_20 vdout1_20ck145 = 0 time = 730
* CHECK dout1_21 vdout1_21ck145 = 0 time = 730
* CHECK dout1_22 vdout1_22ck145 = 0 time = 730
* CHECK dout1_23 vdout1_23ck145 = 0 time = 730
* CHECK dout1_24 vdout1_24ck145 = 0 time = 730
* CHECK dout1_25 vdout1_25ck145 = 0 time = 730
* CHECK dout1_26 vdout1_26ck145 = 0 time = 730
* CHECK dout1_27 vdout1_27ck145 = 0 time = 730
* CHECK dout1_28 vdout1_28ck145 = 1.0 time = 730
* CHECK dout1_29 vdout1_29ck145 = 0 time = 730
* CHECK dout1_30 vdout1_30ck145 = 0 time = 730
* CHECK dout1_31 vdout1_31ck145 = 0 time = 730
* CHECK dout1_32 vdout1_32ck145 = 1.0 time = 730
* CHECK dout1_33 vdout1_33ck145 = 0 time = 730
* CHECK dout1_34 vdout1_34ck145 = 0 time = 730
* CHECK dout1_35 vdout1_35ck145 = 0 time = 730
* CHECK dout1_36 vdout1_36ck145 = 1.0 time = 730
* CHECK dout1_37 vdout1_37ck145 = 1.0 time = 730
* CHECK dout1_38 vdout1_38ck145 = 0 time = 730
* CHECK dout1_39 vdout1_39ck145 = 0 time = 730
* CHECK dout1_40 vdout1_40ck145 = 0 time = 730
* CHECK dout1_41 vdout1_41ck145 = 0 time = 730
* CHECK dout1_42 vdout1_42ck145 = 1.0 time = 730
* CHECK dout1_43 vdout1_43ck145 = 0 time = 730
* CHECK dout1_44 vdout1_44ck145 = 0 time = 730
* CHECK dout1_45 vdout1_45ck145 = 1.0 time = 730
* CHECK dout1_46 vdout1_46ck145 = 1.0 time = 730
* CHECK dout1_47 vdout1_47ck145 = 0 time = 730
* CHECK dout1_48 vdout1_48ck145 = 1.0 time = 730
* CHECK dout1_49 vdout1_49ck145 = 0 time = 730
* CHECK dout1_50 vdout1_50ck145 = 0 time = 730
* CHECK dout1_51 vdout1_51ck145 = 0 time = 730
* CHECK dout1_52 vdout1_52ck145 = 0 time = 730
* CHECK dout1_53 vdout1_53ck145 = 1.0 time = 730
* CHECK dout1_54 vdout1_54ck145 = 0 time = 730
* CHECK dout1_55 vdout1_55ck145 = 1.0 time = 730
* CHECK dout1_56 vdout1_56ck145 = 0 time = 730
* CHECK dout1_57 vdout1_57ck145 = 1.0 time = 730
* CHECK dout1_58 vdout1_58ck145 = 1.0 time = 730
* CHECK dout1_59 vdout1_59ck145 = 0 time = 730
* CHECK dout1_60 vdout1_60ck145 = 0 time = 730
* CHECK dout1_61 vdout1_61ck145 = 1.0 time = 730
* CHECK dout1_62 vdout1_62ck145 = 0 time = 730
* CHECK dout1_63 vdout1_63ck145 = 1.0 time = 730
* CHECK dout0_0 vdout0_0ck146 = 1.0 time = 735
* CHECK dout0_1 vdout0_1ck146 = 1.0 time = 735
* CHECK dout0_2 vdout0_2ck146 = 0 time = 735
* CHECK dout0_3 vdout0_3ck146 = 0 time = 735
* CHECK dout0_4 vdout0_4ck146 = 0 time = 735
* CHECK dout0_5 vdout0_5ck146 = 0 time = 735
* CHECK dout0_6 vdout0_6ck146 = 1.0 time = 735
* CHECK dout0_7 vdout0_7ck146 = 1.0 time = 735
* CHECK dout0_8 vdout0_8ck146 = 0 time = 735
* CHECK dout0_9 vdout0_9ck146 = 1.0 time = 735
* CHECK dout0_10 vdout0_10ck146 = 0 time = 735
* CHECK dout0_11 vdout0_11ck146 = 1.0 time = 735
* CHECK dout0_12 vdout0_12ck146 = 1.0 time = 735
* CHECK dout0_13 vdout0_13ck146 = 1.0 time = 735
* CHECK dout0_14 vdout0_14ck146 = 1.0 time = 735
* CHECK dout0_15 vdout0_15ck146 = 0 time = 735
* CHECK dout0_16 vdout0_16ck146 = 0 time = 735
* CHECK dout0_17 vdout0_17ck146 = 0 time = 735
* CHECK dout0_18 vdout0_18ck146 = 1.0 time = 735
* CHECK dout0_19 vdout0_19ck146 = 1.0 time = 735
* CHECK dout0_20 vdout0_20ck146 = 1.0 time = 735
* CHECK dout0_21 vdout0_21ck146 = 1.0 time = 735
* CHECK dout0_22 vdout0_22ck146 = 0 time = 735
* CHECK dout0_23 vdout0_23ck146 = 1.0 time = 735
* CHECK dout0_24 vdout0_24ck146 = 1.0 time = 735
* CHECK dout0_25 vdout0_25ck146 = 1.0 time = 735
* CHECK dout0_26 vdout0_26ck146 = 1.0 time = 735
* CHECK dout0_27 vdout0_27ck146 = 1.0 time = 735
* CHECK dout0_28 vdout0_28ck146 = 1.0 time = 735
* CHECK dout0_29 vdout0_29ck146 = 1.0 time = 735
* CHECK dout0_30 vdout0_30ck146 = 1.0 time = 735
* CHECK dout0_31 vdout0_31ck146 = 0 time = 735
* CHECK dout0_32 vdout0_32ck146 = 0 time = 735
* CHECK dout0_33 vdout0_33ck146 = 1.0 time = 735
* CHECK dout0_34 vdout0_34ck146 = 0 time = 735
* CHECK dout0_35 vdout0_35ck146 = 1.0 time = 735
* CHECK dout0_36 vdout0_36ck146 = 0 time = 735
* CHECK dout0_37 vdout0_37ck146 = 0 time = 735
* CHECK dout0_38 vdout0_38ck146 = 0 time = 735
* CHECK dout0_39 vdout0_39ck146 = 0 time = 735
* CHECK dout0_40 vdout0_40ck146 = 0 time = 735
* CHECK dout0_41 vdout0_41ck146 = 0 time = 735
* CHECK dout0_42 vdout0_42ck146 = 1.0 time = 735
* CHECK dout0_43 vdout0_43ck146 = 1.0 time = 735
* CHECK dout0_44 vdout0_44ck146 = 1.0 time = 735
* CHECK dout0_45 vdout0_45ck146 = 1.0 time = 735
* CHECK dout0_46 vdout0_46ck146 = 0 time = 735
* CHECK dout0_47 vdout0_47ck146 = 1.0 time = 735
* CHECK dout0_48 vdout0_48ck146 = 0 time = 735
* CHECK dout0_49 vdout0_49ck146 = 1.0 time = 735
* CHECK dout0_50 vdout0_50ck146 = 1.0 time = 735
* CHECK dout0_51 vdout0_51ck146 = 0 time = 735
* CHECK dout0_52 vdout0_52ck146 = 1.0 time = 735
* CHECK dout0_53 vdout0_53ck146 = 0 time = 735
* CHECK dout0_54 vdout0_54ck146 = 1.0 time = 735
* CHECK dout0_55 vdout0_55ck146 = 1.0 time = 735
* CHECK dout0_56 vdout0_56ck146 = 0 time = 735
* CHECK dout0_57 vdout0_57ck146 = 1.0 time = 735
* CHECK dout0_58 vdout0_58ck146 = 0 time = 735
* CHECK dout0_59 vdout0_59ck146 = 0 time = 735
* CHECK dout0_60 vdout0_60ck146 = 1.0 time = 735
* CHECK dout0_61 vdout0_61ck146 = 1.0 time = 735
* CHECK dout0_62 vdout0_62ck146 = 1.0 time = 735
* CHECK dout0_63 vdout0_63ck146 = 0 time = 735
* CHECK dout0_0 vdout0_0ck147 = 1.0 time = 740
* CHECK dout0_1 vdout0_1ck147 = 0 time = 740
* CHECK dout0_2 vdout0_2ck147 = 0 time = 740
* CHECK dout0_3 vdout0_3ck147 = 1.0 time = 740
* CHECK dout0_4 vdout0_4ck147 = 0 time = 740
* CHECK dout0_5 vdout0_5ck147 = 1.0 time = 740
* CHECK dout0_6 vdout0_6ck147 = 1.0 time = 740
* CHECK dout0_7 vdout0_7ck147 = 0 time = 740
* CHECK dout0_8 vdout0_8ck147 = 1.0 time = 740
* CHECK dout0_9 vdout0_9ck147 = 1.0 time = 740
* CHECK dout0_10 vdout0_10ck147 = 0 time = 740
* CHECK dout0_11 vdout0_11ck147 = 1.0 time = 740
* CHECK dout0_12 vdout0_12ck147 = 0 time = 740
* CHECK dout0_13 vdout0_13ck147 = 1.0 time = 740
* CHECK dout0_14 vdout0_14ck147 = 1.0 time = 740
* CHECK dout0_15 vdout0_15ck147 = 0 time = 740
* CHECK dout0_16 vdout0_16ck147 = 1.0 time = 740
* CHECK dout0_17 vdout0_17ck147 = 0 time = 740
* CHECK dout0_18 vdout0_18ck147 = 0 time = 740
* CHECK dout0_19 vdout0_19ck147 = 0 time = 740
* CHECK dout0_20 vdout0_20ck147 = 1.0 time = 740
* CHECK dout0_21 vdout0_21ck147 = 0 time = 740
* CHECK dout0_22 vdout0_22ck147 = 0 time = 740
* CHECK dout0_23 vdout0_23ck147 = 0 time = 740
* CHECK dout0_24 vdout0_24ck147 = 1.0 time = 740
* CHECK dout0_25 vdout0_25ck147 = 1.0 time = 740
* CHECK dout0_26 vdout0_26ck147 = 0 time = 740
* CHECK dout0_27 vdout0_27ck147 = 1.0 time = 740
* CHECK dout0_28 vdout0_28ck147 = 1.0 time = 740
* CHECK dout0_29 vdout0_29ck147 = 1.0 time = 740
* CHECK dout0_30 vdout0_30ck147 = 1.0 time = 740
* CHECK dout0_31 vdout0_31ck147 = 1.0 time = 740
* CHECK dout0_32 vdout0_32ck147 = 1.0 time = 740
* CHECK dout0_33 vdout0_33ck147 = 0 time = 740
* CHECK dout0_34 vdout0_34ck147 = 0 time = 740
* CHECK dout0_35 vdout0_35ck147 = 0 time = 740
* CHECK dout0_36 vdout0_36ck147 = 1.0 time = 740
* CHECK dout0_37 vdout0_37ck147 = 1.0 time = 740
* CHECK dout0_38 vdout0_38ck147 = 1.0 time = 740
* CHECK dout0_39 vdout0_39ck147 = 1.0 time = 740
* CHECK dout0_40 vdout0_40ck147 = 0 time = 740
* CHECK dout0_41 vdout0_41ck147 = 0 time = 740
* CHECK dout0_42 vdout0_42ck147 = 0 time = 740
* CHECK dout0_43 vdout0_43ck147 = 1.0 time = 740
* CHECK dout0_44 vdout0_44ck147 = 1.0 time = 740
* CHECK dout0_45 vdout0_45ck147 = 0 time = 740
* CHECK dout0_46 vdout0_46ck147 = 0 time = 740
* CHECK dout0_47 vdout0_47ck147 = 1.0 time = 740
* CHECK dout0_48 vdout0_48ck147 = 1.0 time = 740
* CHECK dout0_49 vdout0_49ck147 = 1.0 time = 740
* CHECK dout0_50 vdout0_50ck147 = 0 time = 740
* CHECK dout0_51 vdout0_51ck147 = 0 time = 740
* CHECK dout0_52 vdout0_52ck147 = 1.0 time = 740
* CHECK dout0_53 vdout0_53ck147 = 0 time = 740
* CHECK dout0_54 vdout0_54ck147 = 0 time = 740
* CHECK dout0_55 vdout0_55ck147 = 0 time = 740
* CHECK dout0_56 vdout0_56ck147 = 1.0 time = 740
* CHECK dout0_57 vdout0_57ck147 = 0 time = 740
* CHECK dout0_58 vdout0_58ck147 = 0 time = 740
* CHECK dout0_59 vdout0_59ck147 = 1.0 time = 740
* CHECK dout0_60 vdout0_60ck147 = 0 time = 740
* CHECK dout0_61 vdout0_61ck147 = 0 time = 740
* CHECK dout0_62 vdout0_62ck147 = 1.0 time = 740
* CHECK dout0_63 vdout0_63ck147 = 0 time = 740
* CHECK dout0_0 vdout0_0ck149 = 0 time = 750
* CHECK dout0_1 vdout0_1ck149 = 0 time = 750
* CHECK dout0_2 vdout0_2ck149 = 1.0 time = 750
* CHECK dout0_3 vdout0_3ck149 = 0 time = 750
* CHECK dout0_4 vdout0_4ck149 = 1.0 time = 750
* CHECK dout0_5 vdout0_5ck149 = 0 time = 750
* CHECK dout0_6 vdout0_6ck149 = 0 time = 750
* CHECK dout0_7 vdout0_7ck149 = 0 time = 750
* CHECK dout0_8 vdout0_8ck149 = 1.0 time = 750
* CHECK dout0_9 vdout0_9ck149 = 0 time = 750
* CHECK dout0_10 vdout0_10ck149 = 1.0 time = 750
* CHECK dout0_11 vdout0_11ck149 = 1.0 time = 750
* CHECK dout0_12 vdout0_12ck149 = 0 time = 750
* CHECK dout0_13 vdout0_13ck149 = 0 time = 750
* CHECK dout0_14 vdout0_14ck149 = 0 time = 750
* CHECK dout0_15 vdout0_15ck149 = 0 time = 750
* CHECK dout0_16 vdout0_16ck149 = 0 time = 750
* CHECK dout0_17 vdout0_17ck149 = 1.0 time = 750
* CHECK dout0_18 vdout0_18ck149 = 1.0 time = 750
* CHECK dout0_19 vdout0_19ck149 = 1.0 time = 750
* CHECK dout0_20 vdout0_20ck149 = 0 time = 750
* CHECK dout0_21 vdout0_21ck149 = 0 time = 750
* CHECK dout0_22 vdout0_22ck149 = 0 time = 750
* CHECK dout0_23 vdout0_23ck149 = 1.0 time = 750
* CHECK dout0_24 vdout0_24ck149 = 0 time = 750
* CHECK dout0_25 vdout0_25ck149 = 0 time = 750
* CHECK dout0_26 vdout0_26ck149 = 1.0 time = 750
* CHECK dout0_27 vdout0_27ck149 = 0 time = 750
* CHECK dout0_28 vdout0_28ck149 = 1.0 time = 750
* CHECK dout0_29 vdout0_29ck149 = 1.0 time = 750
* CHECK dout0_30 vdout0_30ck149 = 0 time = 750
* CHECK dout0_31 vdout0_31ck149 = 1.0 time = 750
* CHECK dout0_32 vdout0_32ck149 = 0 time = 750
* CHECK dout0_33 vdout0_33ck149 = 1.0 time = 750
* CHECK dout0_34 vdout0_34ck149 = 0 time = 750
* CHECK dout0_35 vdout0_35ck149 = 1.0 time = 750
* CHECK dout0_36 vdout0_36ck149 = 1.0 time = 750
* CHECK dout0_37 vdout0_37ck149 = 0 time = 750
* CHECK dout0_38 vdout0_38ck149 = 0 time = 750
* CHECK dout0_39 vdout0_39ck149 = 1.0 time = 750
* CHECK dout0_40 vdout0_40ck149 = 0 time = 750
* CHECK dout0_41 vdout0_41ck149 = 1.0 time = 750
* CHECK dout0_42 vdout0_42ck149 = 1.0 time = 750
* CHECK dout0_43 vdout0_43ck149 = 0 time = 750
* CHECK dout0_44 vdout0_44ck149 = 1.0 time = 750
* CHECK dout0_45 vdout0_45ck149 = 1.0 time = 750
* CHECK dout0_46 vdout0_46ck149 = 0 time = 750
* CHECK dout0_47 vdout0_47ck149 = 0 time = 750
* CHECK dout0_48 vdout0_48ck149 = 0 time = 750
* CHECK dout0_49 vdout0_49ck149 = 1.0 time = 750
* CHECK dout0_50 vdout0_50ck149 = 0 time = 750
* CHECK dout0_51 vdout0_51ck149 = 0 time = 750
* CHECK dout0_52 vdout0_52ck149 = 0 time = 750
* CHECK dout0_53 vdout0_53ck149 = 1.0 time = 750
* CHECK dout0_54 vdout0_54ck149 = 0 time = 750
* CHECK dout0_55 vdout0_55ck149 = 0 time = 750
* CHECK dout0_56 vdout0_56ck149 = 1.0 time = 750
* CHECK dout0_57 vdout0_57ck149 = 1.0 time = 750
* CHECK dout0_58 vdout0_58ck149 = 0 time = 750
* CHECK dout0_59 vdout0_59ck149 = 1.0 time = 750
* CHECK dout0_60 vdout0_60ck149 = 1.0 time = 750
* CHECK dout0_61 vdout0_61ck149 = 1.0 time = 750
* CHECK dout0_62 vdout0_62ck149 = 1.0 time = 750
* CHECK dout0_63 vdout0_63ck149 = 0 time = 750
* CHECK dout1_0 vdout1_0ck149 = 0 time = 750
* CHECK dout1_1 vdout1_1ck149 = 0 time = 750
* CHECK dout1_2 vdout1_2ck149 = 1.0 time = 750
* CHECK dout1_3 vdout1_3ck149 = 0 time = 750
* CHECK dout1_4 vdout1_4ck149 = 1.0 time = 750
* CHECK dout1_5 vdout1_5ck149 = 0 time = 750
* CHECK dout1_6 vdout1_6ck149 = 0 time = 750
* CHECK dout1_7 vdout1_7ck149 = 0 time = 750
* CHECK dout1_8 vdout1_8ck149 = 1.0 time = 750
* CHECK dout1_9 vdout1_9ck149 = 1.0 time = 750
* CHECK dout1_10 vdout1_10ck149 = 1.0 time = 750
* CHECK dout1_11 vdout1_11ck149 = 1.0 time = 750
* CHECK dout1_12 vdout1_12ck149 = 1.0 time = 750
* CHECK dout1_13 vdout1_13ck149 = 0 time = 750
* CHECK dout1_14 vdout1_14ck149 = 0 time = 750
* CHECK dout1_15 vdout1_15ck149 = 1.0 time = 750
* CHECK dout1_16 vdout1_16ck149 = 0 time = 750
* CHECK dout1_17 vdout1_17ck149 = 1.0 time = 750
* CHECK dout1_18 vdout1_18ck149 = 1.0 time = 750
* CHECK dout1_19 vdout1_19ck149 = 1.0 time = 750
* CHECK dout1_20 vdout1_20ck149 = 1.0 time = 750
* CHECK dout1_21 vdout1_21ck149 = 0 time = 750
* CHECK dout1_22 vdout1_22ck149 = 1.0 time = 750
* CHECK dout1_23 vdout1_23ck149 = 0 time = 750
* CHECK dout1_24 vdout1_24ck149 = 0 time = 750
* CHECK dout1_25 vdout1_25ck149 = 0 time = 750
* CHECK dout1_26 vdout1_26ck149 = 1.0 time = 750
* CHECK dout1_27 vdout1_27ck149 = 1.0 time = 750
* CHECK dout1_28 vdout1_28ck149 = 1.0 time = 750
* CHECK dout1_29 vdout1_29ck149 = 0 time = 750
* CHECK dout1_30 vdout1_30ck149 = 1.0 time = 750
* CHECK dout1_31 vdout1_31ck149 = 0 time = 750
* CHECK dout1_32 vdout1_32ck149 = 0 time = 750
* CHECK dout1_33 vdout1_33ck149 = 1.0 time = 750
* CHECK dout1_34 vdout1_34ck149 = 0 time = 750
* CHECK dout1_35 vdout1_35ck149 = 0 time = 750
* CHECK dout1_36 vdout1_36ck149 = 0 time = 750
* CHECK dout1_37 vdout1_37ck149 = 1.0 time = 750
* CHECK dout1_38 vdout1_38ck149 = 1.0 time = 750
* CHECK dout1_39 vdout1_39ck149 = 0 time = 750
* CHECK dout1_40 vdout1_40ck149 = 1.0 time = 750
* CHECK dout1_41 vdout1_41ck149 = 1.0 time = 750
* CHECK dout1_42 vdout1_42ck149 = 1.0 time = 750
* CHECK dout1_43 vdout1_43ck149 = 1.0 time = 750
* CHECK dout1_44 vdout1_44ck149 = 1.0 time = 750
* CHECK dout1_45 vdout1_45ck149 = 0 time = 750
* CHECK dout1_46 vdout1_46ck149 = 1.0 time = 750
* CHECK dout1_47 vdout1_47ck149 = 0 time = 750
* CHECK dout1_48 vdout1_48ck149 = 0 time = 750
* CHECK dout1_49 vdout1_49ck149 = 1.0 time = 750
* CHECK dout1_50 vdout1_50ck149 = 1.0 time = 750
* CHECK dout1_51 vdout1_51ck149 = 0 time = 750
* CHECK dout1_52 vdout1_52ck149 = 0 time = 750
* CHECK dout1_53 vdout1_53ck149 = 0 time = 750
* CHECK dout1_54 vdout1_54ck149 = 1.0 time = 750
* CHECK dout1_55 vdout1_55ck149 = 1.0 time = 750
* CHECK dout1_56 vdout1_56ck149 = 0 time = 750
* CHECK dout1_57 vdout1_57ck149 = 1.0 time = 750
* CHECK dout1_58 vdout1_58ck149 = 0 time = 750
* CHECK dout1_59 vdout1_59ck149 = 0 time = 750
* CHECK dout1_60 vdout1_60ck149 = 1.0 time = 750
* CHECK dout1_61 vdout1_61ck149 = 1.0 time = 750
* CHECK dout1_62 vdout1_62ck149 = 1.0 time = 750
* CHECK dout1_63 vdout1_63ck149 = 0 time = 750
* CHECK dout0_0 vdout0_0ck150 = 1.0 time = 755
* CHECK dout0_1 vdout0_1ck150 = 0 time = 755
* CHECK dout0_2 vdout0_2ck150 = 0 time = 755
* CHECK dout0_3 vdout0_3ck150 = 1.0 time = 755
* CHECK dout0_4 vdout0_4ck150 = 0 time = 755
* CHECK dout0_5 vdout0_5ck150 = 1.0 time = 755
* CHECK dout0_6 vdout0_6ck150 = 1.0 time = 755
* CHECK dout0_7 vdout0_7ck150 = 0 time = 755
* CHECK dout0_8 vdout0_8ck150 = 1.0 time = 755
* CHECK dout0_9 vdout0_9ck150 = 1.0 time = 755
* CHECK dout0_10 vdout0_10ck150 = 0 time = 755
* CHECK dout0_11 vdout0_11ck150 = 1.0 time = 755
* CHECK dout0_12 vdout0_12ck150 = 0 time = 755
* CHECK dout0_13 vdout0_13ck150 = 1.0 time = 755
* CHECK dout0_14 vdout0_14ck150 = 1.0 time = 755
* CHECK dout0_15 vdout0_15ck150 = 0 time = 755
* CHECK dout0_16 vdout0_16ck150 = 1.0 time = 755
* CHECK dout0_17 vdout0_17ck150 = 0 time = 755
* CHECK dout0_18 vdout0_18ck150 = 0 time = 755
* CHECK dout0_19 vdout0_19ck150 = 0 time = 755
* CHECK dout0_20 vdout0_20ck150 = 1.0 time = 755
* CHECK dout0_21 vdout0_21ck150 = 0 time = 755
* CHECK dout0_22 vdout0_22ck150 = 0 time = 755
* CHECK dout0_23 vdout0_23ck150 = 0 time = 755
* CHECK dout0_24 vdout0_24ck150 = 1.0 time = 755
* CHECK dout0_25 vdout0_25ck150 = 1.0 time = 755
* CHECK dout0_26 vdout0_26ck150 = 0 time = 755
* CHECK dout0_27 vdout0_27ck150 = 1.0 time = 755
* CHECK dout0_28 vdout0_28ck150 = 1.0 time = 755
* CHECK dout0_29 vdout0_29ck150 = 1.0 time = 755
* CHECK dout0_30 vdout0_30ck150 = 1.0 time = 755
* CHECK dout0_31 vdout0_31ck150 = 1.0 time = 755
* CHECK dout0_32 vdout0_32ck150 = 1.0 time = 755
* CHECK dout0_33 vdout0_33ck150 = 0 time = 755
* CHECK dout0_34 vdout0_34ck150 = 0 time = 755
* CHECK dout0_35 vdout0_35ck150 = 0 time = 755
* CHECK dout0_36 vdout0_36ck150 = 1.0 time = 755
* CHECK dout0_37 vdout0_37ck150 = 1.0 time = 755
* CHECK dout0_38 vdout0_38ck150 = 1.0 time = 755
* CHECK dout0_39 vdout0_39ck150 = 1.0 time = 755
* CHECK dout0_40 vdout0_40ck150 = 0 time = 755
* CHECK dout0_41 vdout0_41ck150 = 0 time = 755
* CHECK dout0_42 vdout0_42ck150 = 0 time = 755
* CHECK dout0_43 vdout0_43ck150 = 1.0 time = 755
* CHECK dout0_44 vdout0_44ck150 = 1.0 time = 755
* CHECK dout0_45 vdout0_45ck150 = 0 time = 755
* CHECK dout0_46 vdout0_46ck150 = 0 time = 755
* CHECK dout0_47 vdout0_47ck150 = 1.0 time = 755
* CHECK dout0_48 vdout0_48ck150 = 1.0 time = 755
* CHECK dout0_49 vdout0_49ck150 = 1.0 time = 755
* CHECK dout0_50 vdout0_50ck150 = 0 time = 755
* CHECK dout0_51 vdout0_51ck150 = 0 time = 755
* CHECK dout0_52 vdout0_52ck150 = 1.0 time = 755
* CHECK dout0_53 vdout0_53ck150 = 0 time = 755
* CHECK dout0_54 vdout0_54ck150 = 0 time = 755
* CHECK dout0_55 vdout0_55ck150 = 0 time = 755
* CHECK dout0_56 vdout0_56ck150 = 1.0 time = 755
* CHECK dout0_57 vdout0_57ck150 = 0 time = 755
* CHECK dout0_58 vdout0_58ck150 = 0 time = 755
* CHECK dout0_59 vdout0_59ck150 = 1.0 time = 755
* CHECK dout0_60 vdout0_60ck150 = 0 time = 755
* CHECK dout0_61 vdout0_61ck150 = 0 time = 755
* CHECK dout0_62 vdout0_62ck150 = 1.0 time = 755
* CHECK dout0_63 vdout0_63ck150 = 0 time = 755
* CHECK dout1_0 vdout1_0ck150 = 1.0 time = 755
* CHECK dout1_1 vdout1_1ck150 = 0 time = 755
* CHECK dout1_2 vdout1_2ck150 = 0 time = 755
* CHECK dout1_3 vdout1_3ck150 = 1.0 time = 755
* CHECK dout1_4 vdout1_4ck150 = 0 time = 755
* CHECK dout1_5 vdout1_5ck150 = 1.0 time = 755
* CHECK dout1_6 vdout1_6ck150 = 1.0 time = 755
* CHECK dout1_7 vdout1_7ck150 = 0 time = 755
* CHECK dout1_8 vdout1_8ck150 = 1.0 time = 755
* CHECK dout1_9 vdout1_9ck150 = 1.0 time = 755
* CHECK dout1_10 vdout1_10ck150 = 0 time = 755
* CHECK dout1_11 vdout1_11ck150 = 1.0 time = 755
* CHECK dout1_12 vdout1_12ck150 = 0 time = 755
* CHECK dout1_13 vdout1_13ck150 = 1.0 time = 755
* CHECK dout1_14 vdout1_14ck150 = 1.0 time = 755
* CHECK dout1_15 vdout1_15ck150 = 0 time = 755
* CHECK dout1_16 vdout1_16ck150 = 1.0 time = 755
* CHECK dout1_17 vdout1_17ck150 = 0 time = 755
* CHECK dout1_18 vdout1_18ck150 = 0 time = 755
* CHECK dout1_19 vdout1_19ck150 = 0 time = 755
* CHECK dout1_20 vdout1_20ck150 = 1.0 time = 755
* CHECK dout1_21 vdout1_21ck150 = 0 time = 755
* CHECK dout1_22 vdout1_22ck150 = 0 time = 755
* CHECK dout1_23 vdout1_23ck150 = 0 time = 755
* CHECK dout1_24 vdout1_24ck150 = 1.0 time = 755
* CHECK dout1_25 vdout1_25ck150 = 1.0 time = 755
* CHECK dout1_26 vdout1_26ck150 = 0 time = 755
* CHECK dout1_27 vdout1_27ck150 = 1.0 time = 755
* CHECK dout1_28 vdout1_28ck150 = 1.0 time = 755
* CHECK dout1_29 vdout1_29ck150 = 1.0 time = 755
* CHECK dout1_30 vdout1_30ck150 = 1.0 time = 755
* CHECK dout1_31 vdout1_31ck150 = 1.0 time = 755
* CHECK dout1_32 vdout1_32ck150 = 1.0 time = 755
* CHECK dout1_33 vdout1_33ck150 = 0 time = 755
* CHECK dout1_34 vdout1_34ck150 = 0 time = 755
* CHECK dout1_35 vdout1_35ck150 = 0 time = 755
* CHECK dout1_36 vdout1_36ck150 = 1.0 time = 755
* CHECK dout1_37 vdout1_37ck150 = 1.0 time = 755
* CHECK dout1_38 vdout1_38ck150 = 1.0 time = 755
* CHECK dout1_39 vdout1_39ck150 = 1.0 time = 755
* CHECK dout1_40 vdout1_40ck150 = 0 time = 755
* CHECK dout1_41 vdout1_41ck150 = 0 time = 755
* CHECK dout1_42 vdout1_42ck150 = 0 time = 755
* CHECK dout1_43 vdout1_43ck150 = 1.0 time = 755
* CHECK dout1_44 vdout1_44ck150 = 1.0 time = 755
* CHECK dout1_45 vdout1_45ck150 = 0 time = 755
* CHECK dout1_46 vdout1_46ck150 = 0 time = 755
* CHECK dout1_47 vdout1_47ck150 = 1.0 time = 755
* CHECK dout1_48 vdout1_48ck150 = 1.0 time = 755
* CHECK dout1_49 vdout1_49ck150 = 1.0 time = 755
* CHECK dout1_50 vdout1_50ck150 = 0 time = 755
* CHECK dout1_51 vdout1_51ck150 = 0 time = 755
* CHECK dout1_52 vdout1_52ck150 = 1.0 time = 755
* CHECK dout1_53 vdout1_53ck150 = 0 time = 755
* CHECK dout1_54 vdout1_54ck150 = 0 time = 755
* CHECK dout1_55 vdout1_55ck150 = 0 time = 755
* CHECK dout1_56 vdout1_56ck150 = 1.0 time = 755
* CHECK dout1_57 vdout1_57ck150 = 0 time = 755
* CHECK dout1_58 vdout1_58ck150 = 0 time = 755
* CHECK dout1_59 vdout1_59ck150 = 1.0 time = 755
* CHECK dout1_60 vdout1_60ck150 = 0 time = 755
* CHECK dout1_61 vdout1_61ck150 = 0 time = 755
* CHECK dout1_62 vdout1_62ck150 = 1.0 time = 755
* CHECK dout1_63 vdout1_63ck150 = 0 time = 755
* CHECK dout1_0 vdout1_0ck151 = 1.0 time = 760
* CHECK dout1_1 vdout1_1ck151 = 1.0 time = 760
* CHECK dout1_2 vdout1_2ck151 = 1.0 time = 760
* CHECK dout1_3 vdout1_3ck151 = 1.0 time = 760
* CHECK dout1_4 vdout1_4ck151 = 1.0 time = 760
* CHECK dout1_5 vdout1_5ck151 = 0 time = 760
* CHECK dout1_6 vdout1_6ck151 = 0 time = 760
* CHECK dout1_7 vdout1_7ck151 = 1.0 time = 760
* CHECK dout1_8 vdout1_8ck151 = 1.0 time = 760
* CHECK dout1_9 vdout1_9ck151 = 0 time = 760
* CHECK dout1_10 vdout1_10ck151 = 0 time = 760
* CHECK dout1_11 vdout1_11ck151 = 1.0 time = 760
* CHECK dout1_12 vdout1_12ck151 = 1.0 time = 760
* CHECK dout1_13 vdout1_13ck151 = 0 time = 760
* CHECK dout1_14 vdout1_14ck151 = 1.0 time = 760
* CHECK dout1_15 vdout1_15ck151 = 0 time = 760
* CHECK dout1_16 vdout1_16ck151 = 1.0 time = 760
* CHECK dout1_17 vdout1_17ck151 = 0 time = 760
* CHECK dout1_18 vdout1_18ck151 = 0 time = 760
* CHECK dout1_19 vdout1_19ck151 = 1.0 time = 760
* CHECK dout1_20 vdout1_20ck151 = 0 time = 760
* CHECK dout1_21 vdout1_21ck151 = 0 time = 760
* CHECK dout1_22 vdout1_22ck151 = 0 time = 760
* CHECK dout1_23 vdout1_23ck151 = 1.0 time = 760
* CHECK dout1_24 vdout1_24ck151 = 0 time = 760
* CHECK dout1_25 vdout1_25ck151 = 0 time = 760
* CHECK dout1_26 vdout1_26ck151 = 0 time = 760
* CHECK dout1_27 vdout1_27ck151 = 0 time = 760
* CHECK dout1_28 vdout1_28ck151 = 1.0 time = 760
* CHECK dout1_29 vdout1_29ck151 = 0 time = 760
* CHECK dout1_30 vdout1_30ck151 = 1.0 time = 760
* CHECK dout1_31 vdout1_31ck151 = 0 time = 760
* CHECK dout1_32 vdout1_32ck151 = 1.0 time = 760
* CHECK dout1_33 vdout1_33ck151 = 1.0 time = 760
* CHECK dout1_34 vdout1_34ck151 = 0 time = 760
* CHECK dout1_35 vdout1_35ck151 = 1.0 time = 760
* CHECK dout1_36 vdout1_36ck151 = 1.0 time = 760
* CHECK dout1_37 vdout1_37ck151 = 1.0 time = 760
* CHECK dout1_38 vdout1_38ck151 = 1.0 time = 760
* CHECK dout1_39 vdout1_39ck151 = 1.0 time = 760
* CHECK dout1_40 vdout1_40ck151 = 1.0 time = 760
* CHECK dout1_41 vdout1_41ck151 = 1.0 time = 760
* CHECK dout1_42 vdout1_42ck151 = 0 time = 760
* CHECK dout1_43 vdout1_43ck151 = 0 time = 760
* CHECK dout1_44 vdout1_44ck151 = 1.0 time = 760
* CHECK dout1_45 vdout1_45ck151 = 1.0 time = 760
* CHECK dout1_46 vdout1_46ck151 = 0 time = 760
* CHECK dout1_47 vdout1_47ck151 = 0 time = 760
* CHECK dout1_48 vdout1_48ck151 = 1.0 time = 760
* CHECK dout1_49 vdout1_49ck151 = 0 time = 760
* CHECK dout1_50 vdout1_50ck151 = 1.0 time = 760
* CHECK dout1_51 vdout1_51ck151 = 1.0 time = 760
* CHECK dout1_52 vdout1_52ck151 = 0 time = 760
* CHECK dout1_53 vdout1_53ck151 = 1.0 time = 760
* CHECK dout1_54 vdout1_54ck151 = 1.0 time = 760
* CHECK dout1_55 vdout1_55ck151 = 1.0 time = 760
* CHECK dout1_56 vdout1_56ck151 = 0 time = 760
* CHECK dout1_57 vdout1_57ck151 = 1.0 time = 760
* CHECK dout1_58 vdout1_58ck151 = 1.0 time = 760
* CHECK dout1_59 vdout1_59ck151 = 0 time = 760
* CHECK dout1_60 vdout1_60ck151 = 0 time = 760
* CHECK dout1_61 vdout1_61ck151 = 1.0 time = 760
* CHECK dout1_62 vdout1_62ck151 = 1.0 time = 760
* CHECK dout1_63 vdout1_63ck151 = 1.0 time = 760
* CHECK dout0_0 vdout0_0ck152 = 1.0 time = 765
* CHECK dout0_1 vdout0_1ck152 = 0 time = 765
* CHECK dout0_2 vdout0_2ck152 = 1.0 time = 765
* CHECK dout0_3 vdout0_3ck152 = 0 time = 765
* CHECK dout0_4 vdout0_4ck152 = 1.0 time = 765
* CHECK dout0_5 vdout0_5ck152 = 1.0 time = 765
* CHECK dout0_6 vdout0_6ck152 = 0 time = 765
* CHECK dout0_7 vdout0_7ck152 = 1.0 time = 765
* CHECK dout0_8 vdout0_8ck152 = 0 time = 765
* CHECK dout0_9 vdout0_9ck152 = 0 time = 765
* CHECK dout0_10 vdout0_10ck152 = 0 time = 765
* CHECK dout0_11 vdout0_11ck152 = 1.0 time = 765
* CHECK dout0_12 vdout0_12ck152 = 1.0 time = 765
* CHECK dout0_13 vdout0_13ck152 = 0 time = 765
* CHECK dout0_14 vdout0_14ck152 = 0 time = 765
* CHECK dout0_15 vdout0_15ck152 = 0 time = 765
* CHECK dout0_16 vdout0_16ck152 = 1.0 time = 765
* CHECK dout0_17 vdout0_17ck152 = 1.0 time = 765
* CHECK dout0_18 vdout0_18ck152 = 0 time = 765
* CHECK dout0_19 vdout0_19ck152 = 1.0 time = 765
* CHECK dout0_20 vdout0_20ck152 = 0 time = 765
* CHECK dout0_21 vdout0_21ck152 = 0 time = 765
* CHECK dout0_22 vdout0_22ck152 = 1.0 time = 765
* CHECK dout0_23 vdout0_23ck152 = 0 time = 765
* CHECK dout0_24 vdout0_24ck152 = 1.0 time = 765
* CHECK dout0_25 vdout0_25ck152 = 0 time = 765
* CHECK dout0_26 vdout0_26ck152 = 0 time = 765
* CHECK dout0_27 vdout0_27ck152 = 0 time = 765
* CHECK dout0_28 vdout0_28ck152 = 1.0 time = 765
* CHECK dout0_29 vdout0_29ck152 = 0 time = 765
* CHECK dout0_30 vdout0_30ck152 = 1.0 time = 765
* CHECK dout0_31 vdout0_31ck152 = 0 time = 765
* CHECK dout0_32 vdout0_32ck152 = 1.0 time = 765
* CHECK dout0_33 vdout0_33ck152 = 1.0 time = 765
* CHECK dout0_34 vdout0_34ck152 = 0 time = 765
* CHECK dout0_35 vdout0_35ck152 = 0 time = 765
* CHECK dout0_36 vdout0_36ck152 = 1.0 time = 765
* CHECK dout0_37 vdout0_37ck152 = 0 time = 765
* CHECK dout0_38 vdout0_38ck152 = 0 time = 765
* CHECK dout0_39 vdout0_39ck152 = 1.0 time = 765
* CHECK dout0_40 vdout0_40ck152 = 0 time = 765
* CHECK dout0_41 vdout0_41ck152 = 0 time = 765
* CHECK dout0_42 vdout0_42ck152 = 0 time = 765
* CHECK dout0_43 vdout0_43ck152 = 1.0 time = 765
* CHECK dout0_44 vdout0_44ck152 = 1.0 time = 765
* CHECK dout0_45 vdout0_45ck152 = 1.0 time = 765
* CHECK dout0_46 vdout0_46ck152 = 1.0 time = 765
* CHECK dout0_47 vdout0_47ck152 = 1.0 time = 765
* CHECK dout0_48 vdout0_48ck152 = 0 time = 765
* CHECK dout0_49 vdout0_49ck152 = 1.0 time = 765
* CHECK dout0_50 vdout0_50ck152 = 1.0 time = 765
* CHECK dout0_51 vdout0_51ck152 = 0 time = 765
* CHECK dout0_52 vdout0_52ck152 = 0 time = 765
* CHECK dout0_53 vdout0_53ck152 = 0 time = 765
* CHECK dout0_54 vdout0_54ck152 = 1.0 time = 765
* CHECK dout0_55 vdout0_55ck152 = 0 time = 765
* CHECK dout0_56 vdout0_56ck152 = 0 time = 765
* CHECK dout0_57 vdout0_57ck152 = 0 time = 765
* CHECK dout0_58 vdout0_58ck152 = 0 time = 765
* CHECK dout0_59 vdout0_59ck152 = 1.0 time = 765
* CHECK dout0_60 vdout0_60ck152 = 0 time = 765
* CHECK dout0_61 vdout0_61ck152 = 1.0 time = 765
* CHECK dout0_62 vdout0_62ck152 = 1.0 time = 765
* CHECK dout0_63 vdout0_63ck152 = 0 time = 765
* CHECK dout0_0 vdout0_0ck153 = 0 time = 770
* CHECK dout0_1 vdout0_1ck153 = 0 time = 770
* CHECK dout0_2 vdout0_2ck153 = 0 time = 770
* CHECK dout0_3 vdout0_3ck153 = 1.0 time = 770
* CHECK dout0_4 vdout0_4ck153 = 0 time = 770
* CHECK dout0_5 vdout0_5ck153 = 0 time = 770
* CHECK dout0_6 vdout0_6ck153 = 1.0 time = 770
* CHECK dout0_7 vdout0_7ck153 = 1.0 time = 770
* CHECK dout0_8 vdout0_8ck153 = 0 time = 770
* CHECK dout0_9 vdout0_9ck153 = 1.0 time = 770
* CHECK dout0_10 vdout0_10ck153 = 1.0 time = 770
* CHECK dout0_11 vdout0_11ck153 = 0 time = 770
* CHECK dout0_12 vdout0_12ck153 = 0 time = 770
* CHECK dout0_13 vdout0_13ck153 = 0 time = 770
* CHECK dout0_14 vdout0_14ck153 = 1.0 time = 770
* CHECK dout0_15 vdout0_15ck153 = 1.0 time = 770
* CHECK dout0_16 vdout0_16ck153 = 0 time = 770
* CHECK dout0_17 vdout0_17ck153 = 1.0 time = 770
* CHECK dout0_18 vdout0_18ck153 = 0 time = 770
* CHECK dout0_19 vdout0_19ck153 = 1.0 time = 770
* CHECK dout0_20 vdout0_20ck153 = 0 time = 770
* CHECK dout0_21 vdout0_21ck153 = 0 time = 770
* CHECK dout0_22 vdout0_22ck153 = 0 time = 770
* CHECK dout0_23 vdout0_23ck153 = 1.0 time = 770
* CHECK dout0_24 vdout0_24ck153 = 1.0 time = 770
* CHECK dout0_25 vdout0_25ck153 = 1.0 time = 770
* CHECK dout0_26 vdout0_26ck153 = 1.0 time = 770
* CHECK dout0_27 vdout0_27ck153 = 1.0 time = 770
* CHECK dout0_28 vdout0_28ck153 = 1.0 time = 770
* CHECK dout0_29 vdout0_29ck153 = 0 time = 770
* CHECK dout0_30 vdout0_30ck153 = 0 time = 770
* CHECK dout0_31 vdout0_31ck153 = 0 time = 770
* CHECK dout0_32 vdout0_32ck153 = 1.0 time = 770
* CHECK dout0_33 vdout0_33ck153 = 1.0 time = 770
* CHECK dout0_34 vdout0_34ck153 = 0 time = 770
* CHECK dout0_35 vdout0_35ck153 = 0 time = 770
* CHECK dout0_36 vdout0_36ck153 = 0 time = 770
* CHECK dout0_37 vdout0_37ck153 = 0 time = 770
* CHECK dout0_38 vdout0_38ck153 = 0 time = 770
* CHECK dout0_39 vdout0_39ck153 = 1.0 time = 770
* CHECK dout0_40 vdout0_40ck153 = 1.0 time = 770
* CHECK dout0_41 vdout0_41ck153 = 1.0 time = 770
* CHECK dout0_42 vdout0_42ck153 = 0 time = 770
* CHECK dout0_43 vdout0_43ck153 = 1.0 time = 770
* CHECK dout0_44 vdout0_44ck153 = 1.0 time = 770
* CHECK dout0_45 vdout0_45ck153 = 1.0 time = 770
* CHECK dout0_46 vdout0_46ck153 = 0 time = 770
* CHECK dout0_47 vdout0_47ck153 = 1.0 time = 770
* CHECK dout0_48 vdout0_48ck153 = 0 time = 770
* CHECK dout0_49 vdout0_49ck153 = 0 time = 770
* CHECK dout0_50 vdout0_50ck153 = 1.0 time = 770
* CHECK dout0_51 vdout0_51ck153 = 0 time = 770
* CHECK dout0_52 vdout0_52ck153 = 0 time = 770
* CHECK dout0_53 vdout0_53ck153 = 1.0 time = 770
* CHECK dout0_54 vdout0_54ck153 = 1.0 time = 770
* CHECK dout0_55 vdout0_55ck153 = 0 time = 770
* CHECK dout0_56 vdout0_56ck153 = 0 time = 770
* CHECK dout0_57 vdout0_57ck153 = 0 time = 770
* CHECK dout0_58 vdout0_58ck153 = 1.0 time = 770
* CHECK dout0_59 vdout0_59ck153 = 0 time = 770
* CHECK dout0_60 vdout0_60ck153 = 1.0 time = 770
* CHECK dout0_61 vdout0_61ck153 = 1.0 time = 770
* CHECK dout0_62 vdout0_62ck153 = 1.0 time = 770
* CHECK dout0_63 vdout0_63ck153 = 1.0 time = 770
* CHECK dout0_0 vdout0_0ck155 = 0 time = 780
* CHECK dout0_1 vdout0_1ck155 = 0 time = 780
* CHECK dout0_2 vdout0_2ck155 = 0 time = 780
* CHECK dout0_3 vdout0_3ck155 = 1.0 time = 780
* CHECK dout0_4 vdout0_4ck155 = 0 time = 780
* CHECK dout0_5 vdout0_5ck155 = 0 time = 780
* CHECK dout0_6 vdout0_6ck155 = 1.0 time = 780
* CHECK dout0_7 vdout0_7ck155 = 1.0 time = 780
* CHECK dout0_8 vdout0_8ck155 = 0 time = 780
* CHECK dout0_9 vdout0_9ck155 = 1.0 time = 780
* CHECK dout0_10 vdout0_10ck155 = 1.0 time = 780
* CHECK dout0_11 vdout0_11ck155 = 0 time = 780
* CHECK dout0_12 vdout0_12ck155 = 0 time = 780
* CHECK dout0_13 vdout0_13ck155 = 0 time = 780
* CHECK dout0_14 vdout0_14ck155 = 1.0 time = 780
* CHECK dout0_15 vdout0_15ck155 = 1.0 time = 780
* CHECK dout0_16 vdout0_16ck155 = 0 time = 780
* CHECK dout0_17 vdout0_17ck155 = 1.0 time = 780
* CHECK dout0_18 vdout0_18ck155 = 0 time = 780
* CHECK dout0_19 vdout0_19ck155 = 1.0 time = 780
* CHECK dout0_20 vdout0_20ck155 = 0 time = 780
* CHECK dout0_21 vdout0_21ck155 = 0 time = 780
* CHECK dout0_22 vdout0_22ck155 = 0 time = 780
* CHECK dout0_23 vdout0_23ck155 = 1.0 time = 780
* CHECK dout0_24 vdout0_24ck155 = 1.0 time = 780
* CHECK dout0_25 vdout0_25ck155 = 1.0 time = 780
* CHECK dout0_26 vdout0_26ck155 = 1.0 time = 780
* CHECK dout0_27 vdout0_27ck155 = 1.0 time = 780
* CHECK dout0_28 vdout0_28ck155 = 1.0 time = 780
* CHECK dout0_29 vdout0_29ck155 = 0 time = 780
* CHECK dout0_30 vdout0_30ck155 = 0 time = 780
* CHECK dout0_31 vdout0_31ck155 = 0 time = 780
* CHECK dout0_32 vdout0_32ck155 = 1.0 time = 780
* CHECK dout0_33 vdout0_33ck155 = 1.0 time = 780
* CHECK dout0_34 vdout0_34ck155 = 0 time = 780
* CHECK dout0_35 vdout0_35ck155 = 0 time = 780
* CHECK dout0_36 vdout0_36ck155 = 0 time = 780
* CHECK dout0_37 vdout0_37ck155 = 0 time = 780
* CHECK dout0_38 vdout0_38ck155 = 0 time = 780
* CHECK dout0_39 vdout0_39ck155 = 1.0 time = 780
* CHECK dout0_40 vdout0_40ck155 = 1.0 time = 780
* CHECK dout0_41 vdout0_41ck155 = 1.0 time = 780
* CHECK dout0_42 vdout0_42ck155 = 0 time = 780
* CHECK dout0_43 vdout0_43ck155 = 1.0 time = 780
* CHECK dout0_44 vdout0_44ck155 = 1.0 time = 780
* CHECK dout0_45 vdout0_45ck155 = 1.0 time = 780
* CHECK dout0_46 vdout0_46ck155 = 0 time = 780
* CHECK dout0_47 vdout0_47ck155 = 1.0 time = 780
* CHECK dout0_48 vdout0_48ck155 = 0 time = 780
* CHECK dout0_49 vdout0_49ck155 = 0 time = 780
* CHECK dout0_50 vdout0_50ck155 = 1.0 time = 780
* CHECK dout0_51 vdout0_51ck155 = 0 time = 780
* CHECK dout0_52 vdout0_52ck155 = 0 time = 780
* CHECK dout0_53 vdout0_53ck155 = 1.0 time = 780
* CHECK dout0_54 vdout0_54ck155 = 1.0 time = 780
* CHECK dout0_55 vdout0_55ck155 = 0 time = 780
* CHECK dout0_56 vdout0_56ck155 = 0 time = 780
* CHECK dout0_57 vdout0_57ck155 = 0 time = 780
* CHECK dout0_58 vdout0_58ck155 = 1.0 time = 780
* CHECK dout0_59 vdout0_59ck155 = 0 time = 780
* CHECK dout0_60 vdout0_60ck155 = 1.0 time = 780
* CHECK dout0_61 vdout0_61ck155 = 1.0 time = 780
* CHECK dout0_62 vdout0_62ck155 = 1.0 time = 780
* CHECK dout0_63 vdout0_63ck155 = 1.0 time = 780
* CHECK dout1_0 vdout1_0ck155 = 1.0 time = 780
* CHECK dout1_1 vdout1_1ck155 = 1.0 time = 780
* CHECK dout1_2 vdout1_2ck155 = 1.0 time = 780
* CHECK dout1_3 vdout1_3ck155 = 1.0 time = 780
* CHECK dout1_4 vdout1_4ck155 = 1.0 time = 780
* CHECK dout1_5 vdout1_5ck155 = 0 time = 780
* CHECK dout1_6 vdout1_6ck155 = 0 time = 780
* CHECK dout1_7 vdout1_7ck155 = 1.0 time = 780
* CHECK dout1_8 vdout1_8ck155 = 1.0 time = 780
* CHECK dout1_9 vdout1_9ck155 = 0 time = 780
* CHECK dout1_10 vdout1_10ck155 = 0 time = 780
* CHECK dout1_11 vdout1_11ck155 = 1.0 time = 780
* CHECK dout1_12 vdout1_12ck155 = 1.0 time = 780
* CHECK dout1_13 vdout1_13ck155 = 0 time = 780
* CHECK dout1_14 vdout1_14ck155 = 1.0 time = 780
* CHECK dout1_15 vdout1_15ck155 = 0 time = 780
* CHECK dout1_16 vdout1_16ck155 = 1.0 time = 780
* CHECK dout1_17 vdout1_17ck155 = 0 time = 780
* CHECK dout1_18 vdout1_18ck155 = 0 time = 780
* CHECK dout1_19 vdout1_19ck155 = 1.0 time = 780
* CHECK dout1_20 vdout1_20ck155 = 0 time = 780
* CHECK dout1_21 vdout1_21ck155 = 0 time = 780
* CHECK dout1_22 vdout1_22ck155 = 0 time = 780
* CHECK dout1_23 vdout1_23ck155 = 1.0 time = 780
* CHECK dout1_24 vdout1_24ck155 = 0 time = 780
* CHECK dout1_25 vdout1_25ck155 = 0 time = 780
* CHECK dout1_26 vdout1_26ck155 = 0 time = 780
* CHECK dout1_27 vdout1_27ck155 = 0 time = 780
* CHECK dout1_28 vdout1_28ck155 = 1.0 time = 780
* CHECK dout1_29 vdout1_29ck155 = 0 time = 780
* CHECK dout1_30 vdout1_30ck155 = 1.0 time = 780
* CHECK dout1_31 vdout1_31ck155 = 0 time = 780
* CHECK dout1_32 vdout1_32ck155 = 1.0 time = 780
* CHECK dout1_33 vdout1_33ck155 = 1.0 time = 780
* CHECK dout1_34 vdout1_34ck155 = 0 time = 780
* CHECK dout1_35 vdout1_35ck155 = 1.0 time = 780
* CHECK dout1_36 vdout1_36ck155 = 1.0 time = 780
* CHECK dout1_37 vdout1_37ck155 = 1.0 time = 780
* CHECK dout1_38 vdout1_38ck155 = 1.0 time = 780
* CHECK dout1_39 vdout1_39ck155 = 1.0 time = 780
* CHECK dout1_40 vdout1_40ck155 = 1.0 time = 780
* CHECK dout1_41 vdout1_41ck155 = 1.0 time = 780
* CHECK dout1_42 vdout1_42ck155 = 0 time = 780
* CHECK dout1_43 vdout1_43ck155 = 0 time = 780
* CHECK dout1_44 vdout1_44ck155 = 1.0 time = 780
* CHECK dout1_45 vdout1_45ck155 = 1.0 time = 780
* CHECK dout1_46 vdout1_46ck155 = 0 time = 780
* CHECK dout1_47 vdout1_47ck155 = 0 time = 780
* CHECK dout1_48 vdout1_48ck155 = 1.0 time = 780
* CHECK dout1_49 vdout1_49ck155 = 0 time = 780
* CHECK dout1_50 vdout1_50ck155 = 1.0 time = 780
* CHECK dout1_51 vdout1_51ck155 = 1.0 time = 780
* CHECK dout1_52 vdout1_52ck155 = 0 time = 780
* CHECK dout1_53 vdout1_53ck155 = 1.0 time = 780
* CHECK dout1_54 vdout1_54ck155 = 1.0 time = 780
* CHECK dout1_55 vdout1_55ck155 = 1.0 time = 780
* CHECK dout1_56 vdout1_56ck155 = 0 time = 780
* CHECK dout1_57 vdout1_57ck155 = 1.0 time = 780
* CHECK dout1_58 vdout1_58ck155 = 1.0 time = 780
* CHECK dout1_59 vdout1_59ck155 = 0 time = 780
* CHECK dout1_60 vdout1_60ck155 = 0 time = 780
* CHECK dout1_61 vdout1_61ck155 = 1.0 time = 780
* CHECK dout1_62 vdout1_62ck155 = 1.0 time = 780
* CHECK dout1_63 vdout1_63ck155 = 1.0 time = 780
* CHECK dout0_0 vdout0_0ck157 = 0 time = 790
* CHECK dout0_1 vdout0_1ck157 = 0 time = 790
* CHECK dout0_2 vdout0_2ck157 = 1.0 time = 790
* CHECK dout0_3 vdout0_3ck157 = 1.0 time = 790
* CHECK dout0_4 vdout0_4ck157 = 0 time = 790
* CHECK dout0_5 vdout0_5ck157 = 0 time = 790
* CHECK dout0_6 vdout0_6ck157 = 0 time = 790
* CHECK dout0_7 vdout0_7ck157 = 1.0 time = 790
* CHECK dout0_8 vdout0_8ck157 = 1.0 time = 790
* CHECK dout0_9 vdout0_9ck157 = 0 time = 790
* CHECK dout0_10 vdout0_10ck157 = 0 time = 790
* CHECK dout0_11 vdout0_11ck157 = 1.0 time = 790
* CHECK dout0_12 vdout0_12ck157 = 0 time = 790
* CHECK dout0_13 vdout0_13ck157 = 0 time = 790
* CHECK dout0_14 vdout0_14ck157 = 1.0 time = 790
* CHECK dout0_15 vdout0_15ck157 = 1.0 time = 790
* CHECK dout0_16 vdout0_16ck157 = 1.0 time = 790
* CHECK dout0_17 vdout0_17ck157 = 1.0 time = 790
* CHECK dout0_18 vdout0_18ck157 = 1.0 time = 790
* CHECK dout0_19 vdout0_19ck157 = 1.0 time = 790
* CHECK dout0_20 vdout0_20ck157 = 0 time = 790
* CHECK dout0_21 vdout0_21ck157 = 0 time = 790
* CHECK dout0_22 vdout0_22ck157 = 1.0 time = 790
* CHECK dout0_23 vdout0_23ck157 = 0 time = 790
* CHECK dout0_24 vdout0_24ck157 = 0 time = 790
* CHECK dout0_25 vdout0_25ck157 = 1.0 time = 790
* CHECK dout0_26 vdout0_26ck157 = 0 time = 790
* CHECK dout0_27 vdout0_27ck157 = 0 time = 790
* CHECK dout0_28 vdout0_28ck157 = 0 time = 790
* CHECK dout0_29 vdout0_29ck157 = 0 time = 790
* CHECK dout0_30 vdout0_30ck157 = 0 time = 790
* CHECK dout0_31 vdout0_31ck157 = 0 time = 790
* CHECK dout0_32 vdout0_32ck157 = 1.0 time = 790
* CHECK dout0_33 vdout0_33ck157 = 1.0 time = 790
* CHECK dout0_34 vdout0_34ck157 = 1.0 time = 790
* CHECK dout0_35 vdout0_35ck157 = 1.0 time = 790
* CHECK dout0_36 vdout0_36ck157 = 0 time = 790
* CHECK dout0_37 vdout0_37ck157 = 0 time = 790
* CHECK dout0_38 vdout0_38ck157 = 0 time = 790
* CHECK dout0_39 vdout0_39ck157 = 0 time = 790
* CHECK dout0_40 vdout0_40ck157 = 1.0 time = 790
* CHECK dout0_41 vdout0_41ck157 = 0 time = 790
* CHECK dout0_42 vdout0_42ck157 = 0 time = 790
* CHECK dout0_43 vdout0_43ck157 = 0 time = 790
* CHECK dout0_44 vdout0_44ck157 = 0 time = 790
* CHECK dout0_45 vdout0_45ck157 = 1.0 time = 790
* CHECK dout0_46 vdout0_46ck157 = 1.0 time = 790
* CHECK dout0_47 vdout0_47ck157 = 0 time = 790
* CHECK dout0_48 vdout0_48ck157 = 0 time = 790
* CHECK dout0_49 vdout0_49ck157 = 0 time = 790
* CHECK dout0_50 vdout0_50ck157 = 0 time = 790
* CHECK dout0_51 vdout0_51ck157 = 0 time = 790
* CHECK dout0_52 vdout0_52ck157 = 1.0 time = 790
* CHECK dout0_53 vdout0_53ck157 = 0 time = 790
* CHECK dout0_54 vdout0_54ck157 = 1.0 time = 790
* CHECK dout0_55 vdout0_55ck157 = 1.0 time = 790
* CHECK dout0_56 vdout0_56ck157 = 1.0 time = 790
* CHECK dout0_57 vdout0_57ck157 = 0 time = 790
* CHECK dout0_58 vdout0_58ck157 = 1.0 time = 790
* CHECK dout0_59 vdout0_59ck157 = 1.0 time = 790
* CHECK dout0_60 vdout0_60ck157 = 0 time = 790
* CHECK dout0_61 vdout0_61ck157 = 1.0 time = 790
* CHECK dout0_62 vdout0_62ck157 = 1.0 time = 790
* CHECK dout0_63 vdout0_63ck157 = 1.0 time = 790
* CHECK dout0_0 vdout0_0ck158 = 1.0 time = 795
* CHECK dout0_1 vdout0_1ck158 = 1.0 time = 795
* CHECK dout0_2 vdout0_2ck158 = 1.0 time = 795
* CHECK dout0_3 vdout0_3ck158 = 1.0 time = 795
* CHECK dout0_4 vdout0_4ck158 = 1.0 time = 795
* CHECK dout0_5 vdout0_5ck158 = 0 time = 795
* CHECK dout0_6 vdout0_6ck158 = 0 time = 795
* CHECK dout0_7 vdout0_7ck158 = 1.0 time = 795
* CHECK dout0_8 vdout0_8ck158 = 1.0 time = 795
* CHECK dout0_9 vdout0_9ck158 = 0 time = 795
* CHECK dout0_10 vdout0_10ck158 = 0 time = 795
* CHECK dout0_11 vdout0_11ck158 = 1.0 time = 795
* CHECK dout0_12 vdout0_12ck158 = 1.0 time = 795
* CHECK dout0_13 vdout0_13ck158 = 0 time = 795
* CHECK dout0_14 vdout0_14ck158 = 1.0 time = 795
* CHECK dout0_15 vdout0_15ck158 = 0 time = 795
* CHECK dout0_16 vdout0_16ck158 = 1.0 time = 795
* CHECK dout0_17 vdout0_17ck158 = 0 time = 795
* CHECK dout0_18 vdout0_18ck158 = 0 time = 795
* CHECK dout0_19 vdout0_19ck158 = 1.0 time = 795
* CHECK dout0_20 vdout0_20ck158 = 0 time = 795
* CHECK dout0_21 vdout0_21ck158 = 0 time = 795
* CHECK dout0_22 vdout0_22ck158 = 0 time = 795
* CHECK dout0_23 vdout0_23ck158 = 1.0 time = 795
* CHECK dout0_24 vdout0_24ck158 = 0 time = 795
* CHECK dout0_25 vdout0_25ck158 = 0 time = 795
* CHECK dout0_26 vdout0_26ck158 = 0 time = 795
* CHECK dout0_27 vdout0_27ck158 = 0 time = 795
* CHECK dout0_28 vdout0_28ck158 = 1.0 time = 795
* CHECK dout0_29 vdout0_29ck158 = 0 time = 795
* CHECK dout0_30 vdout0_30ck158 = 1.0 time = 795
* CHECK dout0_31 vdout0_31ck158 = 0 time = 795
* CHECK dout0_32 vdout0_32ck158 = 1.0 time = 795
* CHECK dout0_33 vdout0_33ck158 = 1.0 time = 795
* CHECK dout0_34 vdout0_34ck158 = 0 time = 795
* CHECK dout0_35 vdout0_35ck158 = 1.0 time = 795
* CHECK dout0_36 vdout0_36ck158 = 1.0 time = 795
* CHECK dout0_37 vdout0_37ck158 = 1.0 time = 795
* CHECK dout0_38 vdout0_38ck158 = 1.0 time = 795
* CHECK dout0_39 vdout0_39ck158 = 1.0 time = 795
* CHECK dout0_40 vdout0_40ck158 = 1.0 time = 795
* CHECK dout0_41 vdout0_41ck158 = 1.0 time = 795
* CHECK dout0_42 vdout0_42ck158 = 0 time = 795
* CHECK dout0_43 vdout0_43ck158 = 0 time = 795
* CHECK dout0_44 vdout0_44ck158 = 1.0 time = 795
* CHECK dout0_45 vdout0_45ck158 = 1.0 time = 795
* CHECK dout0_46 vdout0_46ck158 = 0 time = 795
* CHECK dout0_47 vdout0_47ck158 = 0 time = 795
* CHECK dout0_48 vdout0_48ck158 = 1.0 time = 795
* CHECK dout0_49 vdout0_49ck158 = 0 time = 795
* CHECK dout0_50 vdout0_50ck158 = 1.0 time = 795
* CHECK dout0_51 vdout0_51ck158 = 1.0 time = 795
* CHECK dout0_52 vdout0_52ck158 = 0 time = 795
* CHECK dout0_53 vdout0_53ck158 = 1.0 time = 795
* CHECK dout0_54 vdout0_54ck158 = 1.0 time = 795
* CHECK dout0_55 vdout0_55ck158 = 1.0 time = 795
* CHECK dout0_56 vdout0_56ck158 = 0 time = 795
* CHECK dout0_57 vdout0_57ck158 = 1.0 time = 795
* CHECK dout0_58 vdout0_58ck158 = 1.0 time = 795
* CHECK dout0_59 vdout0_59ck158 = 0 time = 795
* CHECK dout0_60 vdout0_60ck158 = 0 time = 795
* CHECK dout0_61 vdout0_61ck158 = 1.0 time = 795
* CHECK dout0_62 vdout0_62ck158 = 1.0 time = 795
* CHECK dout0_63 vdout0_63ck158 = 1.0 time = 795
* CHECK dout0_0 vdout0_0ck159 = 0 time = 800
* CHECK dout0_1 vdout0_1ck159 = 1.0 time = 800
* CHECK dout0_2 vdout0_2ck159 = 1.0 time = 800
* CHECK dout0_3 vdout0_3ck159 = 1.0 time = 800
* CHECK dout0_4 vdout0_4ck159 = 1.0 time = 800
* CHECK dout0_5 vdout0_5ck159 = 1.0 time = 800
* CHECK dout0_6 vdout0_6ck159 = 0 time = 800
* CHECK dout0_7 vdout0_7ck159 = 1.0 time = 800
* CHECK dout0_8 vdout0_8ck159 = 0 time = 800
* CHECK dout0_9 vdout0_9ck159 = 1.0 time = 800
* CHECK dout0_10 vdout0_10ck159 = 1.0 time = 800
* CHECK dout0_11 vdout0_11ck159 = 0 time = 800
* CHECK dout0_12 vdout0_12ck159 = 1.0 time = 800
* CHECK dout0_13 vdout0_13ck159 = 1.0 time = 800
* CHECK dout0_14 vdout0_14ck159 = 0 time = 800
* CHECK dout0_15 vdout0_15ck159 = 1.0 time = 800
* CHECK dout0_16 vdout0_16ck159 = 1.0 time = 800
* CHECK dout0_17 vdout0_17ck159 = 1.0 time = 800
* CHECK dout0_18 vdout0_18ck159 = 1.0 time = 800
* CHECK dout0_19 vdout0_19ck159 = 0 time = 800
* CHECK dout0_20 vdout0_20ck159 = 0 time = 800
* CHECK dout0_21 vdout0_21ck159 = 0 time = 800
* CHECK dout0_22 vdout0_22ck159 = 1.0 time = 800
* CHECK dout0_23 vdout0_23ck159 = 0 time = 800
* CHECK dout0_24 vdout0_24ck159 = 0 time = 800
* CHECK dout0_25 vdout0_25ck159 = 0 time = 800
* CHECK dout0_26 vdout0_26ck159 = 0 time = 800
* CHECK dout0_27 vdout0_27ck159 = 0 time = 800
* CHECK dout0_28 vdout0_28ck159 = 1.0 time = 800
* CHECK dout0_29 vdout0_29ck159 = 1.0 time = 800
* CHECK dout0_30 vdout0_30ck159 = 1.0 time = 800
* CHECK dout0_31 vdout0_31ck159 = 0 time = 800
* CHECK dout0_32 vdout0_32ck159 = 0 time = 800
* CHECK dout0_33 vdout0_33ck159 = 0 time = 800
* CHECK dout0_34 vdout0_34ck159 = 1.0 time = 800
* CHECK dout0_35 vdout0_35ck159 = 1.0 time = 800
* CHECK dout0_36 vdout0_36ck159 = 1.0 time = 800
* CHECK dout0_37 vdout0_37ck159 = 1.0 time = 800
* CHECK dout0_38 vdout0_38ck159 = 0 time = 800
* CHECK dout0_39 vdout0_39ck159 = 0 time = 800
* CHECK dout0_40 vdout0_40ck159 = 1.0 time = 800
* CHECK dout0_41 vdout0_41ck159 = 1.0 time = 800
* CHECK dout0_42 vdout0_42ck159 = 0 time = 800
* CHECK dout0_43 vdout0_43ck159 = 0 time = 800
* CHECK dout0_44 vdout0_44ck159 = 0 time = 800
* CHECK dout0_45 vdout0_45ck159 = 1.0 time = 800
* CHECK dout0_46 vdout0_46ck159 = 1.0 time = 800
* CHECK dout0_47 vdout0_47ck159 = 0 time = 800
* CHECK dout0_48 vdout0_48ck159 = 1.0 time = 800
* CHECK dout0_49 vdout0_49ck159 = 1.0 time = 800
* CHECK dout0_50 vdout0_50ck159 = 1.0 time = 800
* CHECK dout0_51 vdout0_51ck159 = 1.0 time = 800
* CHECK dout0_52 vdout0_52ck159 = 1.0 time = 800
* CHECK dout0_53 vdout0_53ck159 = 1.0 time = 800
* CHECK dout0_54 vdout0_54ck159 = 0 time = 800
* CHECK dout0_55 vdout0_55ck159 = 0 time = 800
* CHECK dout0_56 vdout0_56ck159 = 1.0 time = 800
* CHECK dout0_57 vdout0_57ck159 = 1.0 time = 800
* CHECK dout0_58 vdout0_58ck159 = 0 time = 800
* CHECK dout0_59 vdout0_59ck159 = 0 time = 800
* CHECK dout0_60 vdout0_60ck159 = 1.0 time = 800
* CHECK dout0_61 vdout0_61ck159 = 1.0 time = 800
* CHECK dout0_62 vdout0_62ck159 = 1.0 time = 800
* CHECK dout0_63 vdout0_63ck159 = 0 time = 800
* CHECK dout1_0 vdout1_0ck160 = 1.0 time = 805
* CHECK dout1_1 vdout1_1ck160 = 0 time = 805
* CHECK dout1_2 vdout1_2ck160 = 1.0 time = 805
* CHECK dout1_3 vdout1_3ck160 = 1.0 time = 805
* CHECK dout1_4 vdout1_4ck160 = 0 time = 805
* CHECK dout1_5 vdout1_5ck160 = 1.0 time = 805
* CHECK dout1_6 vdout1_6ck160 = 1.0 time = 805
* CHECK dout1_7 vdout1_7ck160 = 1.0 time = 805
* CHECK dout1_8 vdout1_8ck160 = 1.0 time = 805
* CHECK dout1_9 vdout1_9ck160 = 1.0 time = 805
* CHECK dout1_10 vdout1_10ck160 = 0 time = 805
* CHECK dout1_11 vdout1_11ck160 = 1.0 time = 805
* CHECK dout1_12 vdout1_12ck160 = 0 time = 805
* CHECK dout1_13 vdout1_13ck160 = 0 time = 805
* CHECK dout1_14 vdout1_14ck160 = 0 time = 805
* CHECK dout1_15 vdout1_15ck160 = 0 time = 805
* CHECK dout1_16 vdout1_16ck160 = 0 time = 805
* CHECK dout1_17 vdout1_17ck160 = 0 time = 805
* CHECK dout1_18 vdout1_18ck160 = 1.0 time = 805
* CHECK dout1_19 vdout1_19ck160 = 1.0 time = 805
* CHECK dout1_20 vdout1_20ck160 = 1.0 time = 805
* CHECK dout1_21 vdout1_21ck160 = 0 time = 805
* CHECK dout1_22 vdout1_22ck160 = 0 time = 805
* CHECK dout1_23 vdout1_23ck160 = 1.0 time = 805
* CHECK dout1_24 vdout1_24ck160 = 1.0 time = 805
* CHECK dout1_25 vdout1_25ck160 = 0 time = 805
* CHECK dout1_26 vdout1_26ck160 = 1.0 time = 805
* CHECK dout1_27 vdout1_27ck160 = 1.0 time = 805
* CHECK dout1_28 vdout1_28ck160 = 0 time = 805
* CHECK dout1_29 vdout1_29ck160 = 0 time = 805
* CHECK dout1_30 vdout1_30ck160 = 0 time = 805
* CHECK dout1_31 vdout1_31ck160 = 0 time = 805
* CHECK dout1_32 vdout1_32ck160 = 1.0 time = 805
* CHECK dout1_33 vdout1_33ck160 = 0 time = 805
* CHECK dout1_34 vdout1_34ck160 = 0 time = 805
* CHECK dout1_35 vdout1_35ck160 = 1.0 time = 805
* CHECK dout1_36 vdout1_36ck160 = 1.0 time = 805
* CHECK dout1_37 vdout1_37ck160 = 0 time = 805
* CHECK dout1_38 vdout1_38ck160 = 0 time = 805
* CHECK dout1_39 vdout1_39ck160 = 0 time = 805
* CHECK dout1_40 vdout1_40ck160 = 1.0 time = 805
* CHECK dout1_41 vdout1_41ck160 = 0 time = 805
* CHECK dout1_42 vdout1_42ck160 = 0 time = 805
* CHECK dout1_43 vdout1_43ck160 = 0 time = 805
* CHECK dout1_44 vdout1_44ck160 = 0 time = 805
* CHECK dout1_45 vdout1_45ck160 = 1.0 time = 805
* CHECK dout1_46 vdout1_46ck160 = 0 time = 805
* CHECK dout1_47 vdout1_47ck160 = 0 time = 805
* CHECK dout1_48 vdout1_48ck160 = 0 time = 805
* CHECK dout1_49 vdout1_49ck160 = 0 time = 805
* CHECK dout1_50 vdout1_50ck160 = 1.0 time = 805
* CHECK dout1_51 vdout1_51ck160 = 1.0 time = 805
* CHECK dout1_52 vdout1_52ck160 = 0 time = 805
* CHECK dout1_53 vdout1_53ck160 = 0 time = 805
* CHECK dout1_54 vdout1_54ck160 = 0 time = 805
* CHECK dout1_55 vdout1_55ck160 = 1.0 time = 805
* CHECK dout1_56 vdout1_56ck160 = 0 time = 805
* CHECK dout1_57 vdout1_57ck160 = 0 time = 805
* CHECK dout1_58 vdout1_58ck160 = 0 time = 805
* CHECK dout1_59 vdout1_59ck160 = 0 time = 805
* CHECK dout1_60 vdout1_60ck160 = 0 time = 805
* CHECK dout1_61 vdout1_61ck160 = 1.0 time = 805
* CHECK dout1_62 vdout1_62ck160 = 0 time = 805
* CHECK dout1_63 vdout1_63ck160 = 0 time = 805
* CHECK dout1_0 vdout1_0ck161 = 1.0 time = 810
* CHECK dout1_1 vdout1_1ck161 = 0 time = 810
* CHECK dout1_2 vdout1_2ck161 = 0 time = 810
* CHECK dout1_3 vdout1_3ck161 = 0 time = 810
* CHECK dout1_4 vdout1_4ck161 = 1.0 time = 810
* CHECK dout1_5 vdout1_5ck161 = 0 time = 810
* CHECK dout1_6 vdout1_6ck161 = 1.0 time = 810
* CHECK dout1_7 vdout1_7ck161 = 1.0 time = 810
* CHECK dout1_8 vdout1_8ck161 = 0 time = 810
* CHECK dout1_9 vdout1_9ck161 = 0 time = 810
* CHECK dout1_10 vdout1_10ck161 = 0 time = 810
* CHECK dout1_11 vdout1_11ck161 = 0 time = 810
* CHECK dout1_12 vdout1_12ck161 = 1.0 time = 810
* CHECK dout1_13 vdout1_13ck161 = 0 time = 810
* CHECK dout1_14 vdout1_14ck161 = 0 time = 810
* CHECK dout1_15 vdout1_15ck161 = 1.0 time = 810
* CHECK dout1_16 vdout1_16ck161 = 0 time = 810
* CHECK dout1_17 vdout1_17ck161 = 0 time = 810
* CHECK dout1_18 vdout1_18ck161 = 1.0 time = 810
* CHECK dout1_19 vdout1_19ck161 = 1.0 time = 810
* CHECK dout1_20 vdout1_20ck161 = 0 time = 810
* CHECK dout1_21 vdout1_21ck161 = 1.0 time = 810
* CHECK dout1_22 vdout1_22ck161 = 0 time = 810
* CHECK dout1_23 vdout1_23ck161 = 0 time = 810
* CHECK dout1_24 vdout1_24ck161 = 0 time = 810
* CHECK dout1_25 vdout1_25ck161 = 1.0 time = 810
* CHECK dout1_26 vdout1_26ck161 = 0 time = 810
* CHECK dout1_27 vdout1_27ck161 = 0 time = 810
* CHECK dout1_28 vdout1_28ck161 = 1.0 time = 810
* CHECK dout1_29 vdout1_29ck161 = 1.0 time = 810
* CHECK dout1_30 vdout1_30ck161 = 1.0 time = 810
* CHECK dout1_31 vdout1_31ck161 = 1.0 time = 810
* CHECK dout1_32 vdout1_32ck161 = 1.0 time = 810
* CHECK dout1_33 vdout1_33ck161 = 1.0 time = 810
* CHECK dout1_34 vdout1_34ck161 = 0 time = 810
* CHECK dout1_35 vdout1_35ck161 = 0 time = 810
* CHECK dout1_36 vdout1_36ck161 = 1.0 time = 810
* CHECK dout1_37 vdout1_37ck161 = 0 time = 810
* CHECK dout1_38 vdout1_38ck161 = 1.0 time = 810
* CHECK dout1_39 vdout1_39ck161 = 1.0 time = 810
* CHECK dout1_40 vdout1_40ck161 = 1.0 time = 810
* CHECK dout1_41 vdout1_41ck161 = 1.0 time = 810
* CHECK dout1_42 vdout1_42ck161 = 1.0 time = 810
* CHECK dout1_43 vdout1_43ck161 = 1.0 time = 810
* CHECK dout1_44 vdout1_44ck161 = 0 time = 810
* CHECK dout1_45 vdout1_45ck161 = 1.0 time = 810
* CHECK dout1_46 vdout1_46ck161 = 1.0 time = 810
* CHECK dout1_47 vdout1_47ck161 = 0 time = 810
* CHECK dout1_48 vdout1_48ck161 = 1.0 time = 810
* CHECK dout1_49 vdout1_49ck161 = 0 time = 810
* CHECK dout1_50 vdout1_50ck161 = 0 time = 810
* CHECK dout1_51 vdout1_51ck161 = 0 time = 810
* CHECK dout1_52 vdout1_52ck161 = 1.0 time = 810
* CHECK dout1_53 vdout1_53ck161 = 0 time = 810
* CHECK dout1_54 vdout1_54ck161 = 1.0 time = 810
* CHECK dout1_55 vdout1_55ck161 = 0 time = 810
* CHECK dout1_56 vdout1_56ck161 = 1.0 time = 810
* CHECK dout1_57 vdout1_57ck161 = 0 time = 810
* CHECK dout1_58 vdout1_58ck161 = 0 time = 810
* CHECK dout1_59 vdout1_59ck161 = 0 time = 810
* CHECK dout1_60 vdout1_60ck161 = 1.0 time = 810
* CHECK dout1_61 vdout1_61ck161 = 1.0 time = 810
* CHECK dout1_62 vdout1_62ck161 = 1.0 time = 810
* CHECK dout1_63 vdout1_63ck161 = 1.0 time = 810
* CHECK dout0_0 vdout0_0ck163 = 0 time = 820
* CHECK dout0_1 vdout0_1ck163 = 0 time = 820
* CHECK dout0_2 vdout0_2ck163 = 0 time = 820
* CHECK dout0_3 vdout0_3ck163 = 1.0 time = 820
* CHECK dout0_4 vdout0_4ck163 = 0 time = 820
* CHECK dout0_5 vdout0_5ck163 = 0 time = 820
* CHECK dout0_6 vdout0_6ck163 = 0 time = 820
* CHECK dout0_7 vdout0_7ck163 = 0 time = 820
* CHECK dout0_8 vdout0_8ck163 = 0 time = 820
* CHECK dout0_9 vdout0_9ck163 = 0 time = 820
* CHECK dout0_10 vdout0_10ck163 = 1.0 time = 820
* CHECK dout0_11 vdout0_11ck163 = 0 time = 820
* CHECK dout0_12 vdout0_12ck163 = 0 time = 820
* CHECK dout0_13 vdout0_13ck163 = 1.0 time = 820
* CHECK dout0_14 vdout0_14ck163 = 0 time = 820
* CHECK dout0_15 vdout0_15ck163 = 1.0 time = 820
* CHECK dout0_16 vdout0_16ck163 = 0 time = 820
* CHECK dout0_17 vdout0_17ck163 = 1.0 time = 820
* CHECK dout0_18 vdout0_18ck163 = 0 time = 820
* CHECK dout0_19 vdout0_19ck163 = 1.0 time = 820
* CHECK dout0_20 vdout0_20ck163 = 1.0 time = 820
* CHECK dout0_21 vdout0_21ck163 = 1.0 time = 820
* CHECK dout0_22 vdout0_22ck163 = 0 time = 820
* CHECK dout0_23 vdout0_23ck163 = 1.0 time = 820
* CHECK dout0_24 vdout0_24ck163 = 0 time = 820
* CHECK dout0_25 vdout0_25ck163 = 0 time = 820
* CHECK dout0_26 vdout0_26ck163 = 1.0 time = 820
* CHECK dout0_27 vdout0_27ck163 = 1.0 time = 820
* CHECK dout0_28 vdout0_28ck163 = 1.0 time = 820
* CHECK dout0_29 vdout0_29ck163 = 1.0 time = 820
* CHECK dout0_30 vdout0_30ck163 = 0 time = 820
* CHECK dout0_31 vdout0_31ck163 = 0 time = 820
* CHECK dout0_32 vdout0_32ck163 = 1.0 time = 820
* CHECK dout0_33 vdout0_33ck163 = 0 time = 820
* CHECK dout0_34 vdout0_34ck163 = 0 time = 820
* CHECK dout0_35 vdout0_35ck163 = 1.0 time = 820
* CHECK dout0_36 vdout0_36ck163 = 0 time = 820
* CHECK dout0_37 vdout0_37ck163 = 1.0 time = 820
* CHECK dout0_38 vdout0_38ck163 = 0 time = 820
* CHECK dout0_39 vdout0_39ck163 = 0 time = 820
* CHECK dout0_40 vdout0_40ck163 = 0 time = 820
* CHECK dout0_41 vdout0_41ck163 = 0 time = 820
* CHECK dout0_42 vdout0_42ck163 = 0 time = 820
* CHECK dout0_43 vdout0_43ck163 = 0 time = 820
* CHECK dout0_44 vdout0_44ck163 = 0 time = 820
* CHECK dout0_45 vdout0_45ck163 = 0 time = 820
* CHECK dout0_46 vdout0_46ck163 = 1.0 time = 820
* CHECK dout0_47 vdout0_47ck163 = 1.0 time = 820
* CHECK dout0_48 vdout0_48ck163 = 1.0 time = 820
* CHECK dout0_49 vdout0_49ck163 = 0 time = 820
* CHECK dout0_50 vdout0_50ck163 = 0 time = 820
* CHECK dout0_51 vdout0_51ck163 = 1.0 time = 820
* CHECK dout0_52 vdout0_52ck163 = 1.0 time = 820
* CHECK dout0_53 vdout0_53ck163 = 1.0 time = 820
* CHECK dout0_54 vdout0_54ck163 = 1.0 time = 820
* CHECK dout0_55 vdout0_55ck163 = 0 time = 820
* CHECK dout0_56 vdout0_56ck163 = 0 time = 820
* CHECK dout0_57 vdout0_57ck163 = 0 time = 820
* CHECK dout0_58 vdout0_58ck163 = 0 time = 820
* CHECK dout0_59 vdout0_59ck163 = 1.0 time = 820
* CHECK dout0_60 vdout0_60ck163 = 1.0 time = 820
* CHECK dout0_61 vdout0_61ck163 = 0 time = 820
* CHECK dout0_62 vdout0_62ck163 = 1.0 time = 820
* CHECK dout0_63 vdout0_63ck163 = 1.0 time = 820
* CHECK dout0_0 vdout0_0ck164 = 1.0 time = 825
* CHECK dout0_1 vdout0_1ck164 = 0 time = 825
* CHECK dout0_2 vdout0_2ck164 = 1.0 time = 825
* CHECK dout0_3 vdout0_3ck164 = 1.0 time = 825
* CHECK dout0_4 vdout0_4ck164 = 0 time = 825
* CHECK dout0_5 vdout0_5ck164 = 1.0 time = 825
* CHECK dout0_6 vdout0_6ck164 = 1.0 time = 825
* CHECK dout0_7 vdout0_7ck164 = 1.0 time = 825
* CHECK dout0_8 vdout0_8ck164 = 1.0 time = 825
* CHECK dout0_9 vdout0_9ck164 = 1.0 time = 825
* CHECK dout0_10 vdout0_10ck164 = 0 time = 825
* CHECK dout0_11 vdout0_11ck164 = 1.0 time = 825
* CHECK dout0_12 vdout0_12ck164 = 0 time = 825
* CHECK dout0_13 vdout0_13ck164 = 0 time = 825
* CHECK dout0_14 vdout0_14ck164 = 0 time = 825
* CHECK dout0_15 vdout0_15ck164 = 0 time = 825
* CHECK dout0_16 vdout0_16ck164 = 0 time = 825
* CHECK dout0_17 vdout0_17ck164 = 0 time = 825
* CHECK dout0_18 vdout0_18ck164 = 1.0 time = 825
* CHECK dout0_19 vdout0_19ck164 = 1.0 time = 825
* CHECK dout0_20 vdout0_20ck164 = 1.0 time = 825
* CHECK dout0_21 vdout0_21ck164 = 0 time = 825
* CHECK dout0_22 vdout0_22ck164 = 0 time = 825
* CHECK dout0_23 vdout0_23ck164 = 1.0 time = 825
* CHECK dout0_24 vdout0_24ck164 = 1.0 time = 825
* CHECK dout0_25 vdout0_25ck164 = 0 time = 825
* CHECK dout0_26 vdout0_26ck164 = 1.0 time = 825
* CHECK dout0_27 vdout0_27ck164 = 1.0 time = 825
* CHECK dout0_28 vdout0_28ck164 = 0 time = 825
* CHECK dout0_29 vdout0_29ck164 = 0 time = 825
* CHECK dout0_30 vdout0_30ck164 = 0 time = 825
* CHECK dout0_31 vdout0_31ck164 = 0 time = 825
* CHECK dout0_32 vdout0_32ck164 = 1.0 time = 825
* CHECK dout0_33 vdout0_33ck164 = 0 time = 825
* CHECK dout0_34 vdout0_34ck164 = 0 time = 825
* CHECK dout0_35 vdout0_35ck164 = 1.0 time = 825
* CHECK dout0_36 vdout0_36ck164 = 1.0 time = 825
* CHECK dout0_37 vdout0_37ck164 = 0 time = 825
* CHECK dout0_38 vdout0_38ck164 = 0 time = 825
* CHECK dout0_39 vdout0_39ck164 = 0 time = 825
* CHECK dout0_40 vdout0_40ck164 = 1.0 time = 825
* CHECK dout0_41 vdout0_41ck164 = 0 time = 825
* CHECK dout0_42 vdout0_42ck164 = 0 time = 825
* CHECK dout0_43 vdout0_43ck164 = 0 time = 825
* CHECK dout0_44 vdout0_44ck164 = 0 time = 825
* CHECK dout0_45 vdout0_45ck164 = 1.0 time = 825
* CHECK dout0_46 vdout0_46ck164 = 0 time = 825
* CHECK dout0_47 vdout0_47ck164 = 0 time = 825
* CHECK dout0_48 vdout0_48ck164 = 0 time = 825
* CHECK dout0_49 vdout0_49ck164 = 0 time = 825
* CHECK dout0_50 vdout0_50ck164 = 1.0 time = 825
* CHECK dout0_51 vdout0_51ck164 = 1.0 time = 825
* CHECK dout0_52 vdout0_52ck164 = 0 time = 825
* CHECK dout0_53 vdout0_53ck164 = 0 time = 825
* CHECK dout0_54 vdout0_54ck164 = 0 time = 825
* CHECK dout0_55 vdout0_55ck164 = 1.0 time = 825
* CHECK dout0_56 vdout0_56ck164 = 0 time = 825
* CHECK dout0_57 vdout0_57ck164 = 0 time = 825
* CHECK dout0_58 vdout0_58ck164 = 0 time = 825
* CHECK dout0_59 vdout0_59ck164 = 0 time = 825
* CHECK dout0_60 vdout0_60ck164 = 0 time = 825
* CHECK dout0_61 vdout0_61ck164 = 1.0 time = 825
* CHECK dout0_62 vdout0_62ck164 = 0 time = 825
* CHECK dout0_63 vdout0_63ck164 = 0 time = 825
* CHECK dout1_0 vdout1_0ck164 = 0 time = 825
* CHECK dout1_1 vdout1_1ck164 = 0 time = 825
* CHECK dout1_2 vdout1_2ck164 = 0 time = 825
* CHECK dout1_3 vdout1_3ck164 = 1.0 time = 825
* CHECK dout1_4 vdout1_4ck164 = 0 time = 825
* CHECK dout1_5 vdout1_5ck164 = 0 time = 825
* CHECK dout1_6 vdout1_6ck164 = 1.0 time = 825
* CHECK dout1_7 vdout1_7ck164 = 1.0 time = 825
* CHECK dout1_8 vdout1_8ck164 = 0 time = 825
* CHECK dout1_9 vdout1_9ck164 = 1.0 time = 825
* CHECK dout1_10 vdout1_10ck164 = 1.0 time = 825
* CHECK dout1_11 vdout1_11ck164 = 0 time = 825
* CHECK dout1_12 vdout1_12ck164 = 0 time = 825
* CHECK dout1_13 vdout1_13ck164 = 0 time = 825
* CHECK dout1_14 vdout1_14ck164 = 1.0 time = 825
* CHECK dout1_15 vdout1_15ck164 = 1.0 time = 825
* CHECK dout1_16 vdout1_16ck164 = 0 time = 825
* CHECK dout1_17 vdout1_17ck164 = 1.0 time = 825
* CHECK dout1_18 vdout1_18ck164 = 0 time = 825
* CHECK dout1_19 vdout1_19ck164 = 1.0 time = 825
* CHECK dout1_20 vdout1_20ck164 = 0 time = 825
* CHECK dout1_21 vdout1_21ck164 = 0 time = 825
* CHECK dout1_22 vdout1_22ck164 = 0 time = 825
* CHECK dout1_23 vdout1_23ck164 = 1.0 time = 825
* CHECK dout1_24 vdout1_24ck164 = 1.0 time = 825
* CHECK dout1_25 vdout1_25ck164 = 1.0 time = 825
* CHECK dout1_26 vdout1_26ck164 = 1.0 time = 825
* CHECK dout1_27 vdout1_27ck164 = 1.0 time = 825
* CHECK dout1_28 vdout1_28ck164 = 1.0 time = 825
* CHECK dout1_29 vdout1_29ck164 = 0 time = 825
* CHECK dout1_30 vdout1_30ck164 = 0 time = 825
* CHECK dout1_31 vdout1_31ck164 = 0 time = 825
* CHECK dout1_32 vdout1_32ck164 = 1.0 time = 825
* CHECK dout1_33 vdout1_33ck164 = 1.0 time = 825
* CHECK dout1_34 vdout1_34ck164 = 0 time = 825
* CHECK dout1_35 vdout1_35ck164 = 0 time = 825
* CHECK dout1_36 vdout1_36ck164 = 0 time = 825
* CHECK dout1_37 vdout1_37ck164 = 0 time = 825
* CHECK dout1_38 vdout1_38ck164 = 0 time = 825
* CHECK dout1_39 vdout1_39ck164 = 1.0 time = 825
* CHECK dout1_40 vdout1_40ck164 = 1.0 time = 825
* CHECK dout1_41 vdout1_41ck164 = 1.0 time = 825
* CHECK dout1_42 vdout1_42ck164 = 0 time = 825
* CHECK dout1_43 vdout1_43ck164 = 1.0 time = 825
* CHECK dout1_44 vdout1_44ck164 = 1.0 time = 825
* CHECK dout1_45 vdout1_45ck164 = 1.0 time = 825
* CHECK dout1_46 vdout1_46ck164 = 0 time = 825
* CHECK dout1_47 vdout1_47ck164 = 1.0 time = 825
* CHECK dout1_48 vdout1_48ck164 = 0 time = 825
* CHECK dout1_49 vdout1_49ck164 = 0 time = 825
* CHECK dout1_50 vdout1_50ck164 = 1.0 time = 825
* CHECK dout1_51 vdout1_51ck164 = 0 time = 825
* CHECK dout1_52 vdout1_52ck164 = 0 time = 825
* CHECK dout1_53 vdout1_53ck164 = 1.0 time = 825
* CHECK dout1_54 vdout1_54ck164 = 1.0 time = 825
* CHECK dout1_55 vdout1_55ck164 = 0 time = 825
* CHECK dout1_56 vdout1_56ck164 = 0 time = 825
* CHECK dout1_57 vdout1_57ck164 = 0 time = 825
* CHECK dout1_58 vdout1_58ck164 = 1.0 time = 825
* CHECK dout1_59 vdout1_59ck164 = 0 time = 825
* CHECK dout1_60 vdout1_60ck164 = 1.0 time = 825
* CHECK dout1_61 vdout1_61ck164 = 1.0 time = 825
* CHECK dout1_62 vdout1_62ck164 = 1.0 time = 825
* CHECK dout1_63 vdout1_63ck164 = 1.0 time = 825
* CHECK dout0_0 vdout0_0ck165 = 0 time = 830
* CHECK dout0_1 vdout0_1ck165 = 0 time = 830
* CHECK dout0_2 vdout0_2ck165 = 0 time = 830
* CHECK dout0_3 vdout0_3ck165 = 0 time = 830
* CHECK dout0_4 vdout0_4ck165 = 1.0 time = 830
* CHECK dout0_5 vdout0_5ck165 = 0 time = 830
* CHECK dout0_6 vdout0_6ck165 = 0 time = 830
* CHECK dout0_7 vdout0_7ck165 = 0 time = 830
* CHECK dout0_8 vdout0_8ck165 = 1.0 time = 830
* CHECK dout0_9 vdout0_9ck165 = 0 time = 830
* CHECK dout0_10 vdout0_10ck165 = 0 time = 830
* CHECK dout0_11 vdout0_11ck165 = 0 time = 830
* CHECK dout0_12 vdout0_12ck165 = 1.0 time = 830
* CHECK dout0_13 vdout0_13ck165 = 0 time = 830
* CHECK dout0_14 vdout0_14ck165 = 1.0 time = 830
* CHECK dout0_15 vdout0_15ck165 = 0 time = 830
* CHECK dout0_16 vdout0_16ck165 = 1.0 time = 830
* CHECK dout0_17 vdout0_17ck165 = 1.0 time = 830
* CHECK dout0_18 vdout0_18ck165 = 1.0 time = 830
* CHECK dout0_19 vdout0_19ck165 = 1.0 time = 830
* CHECK dout0_20 vdout0_20ck165 = 1.0 time = 830
* CHECK dout0_21 vdout0_21ck165 = 1.0 time = 830
* CHECK dout0_22 vdout0_22ck165 = 1.0 time = 830
* CHECK dout0_23 vdout0_23ck165 = 0 time = 830
* CHECK dout0_24 vdout0_24ck165 = 0 time = 830
* CHECK dout0_25 vdout0_25ck165 = 1.0 time = 830
* CHECK dout0_26 vdout0_26ck165 = 1.0 time = 830
* CHECK dout0_27 vdout0_27ck165 = 0 time = 830
* CHECK dout0_28 vdout0_28ck165 = 1.0 time = 830
* CHECK dout0_29 vdout0_29ck165 = 1.0 time = 830
* CHECK dout0_30 vdout0_30ck165 = 0 time = 830
* CHECK dout0_31 vdout0_31ck165 = 1.0 time = 830
* CHECK dout0_32 vdout0_32ck165 = 0 time = 830
* CHECK dout0_33 vdout0_33ck165 = 1.0 time = 830
* CHECK dout0_34 vdout0_34ck165 = 0 time = 830
* CHECK dout0_35 vdout0_35ck165 = 1.0 time = 830
* CHECK dout0_36 vdout0_36ck165 = 1.0 time = 830
* CHECK dout0_37 vdout0_37ck165 = 1.0 time = 830
* CHECK dout0_38 vdout0_38ck165 = 0 time = 830
* CHECK dout0_39 vdout0_39ck165 = 1.0 time = 830
* CHECK dout0_40 vdout0_40ck165 = 1.0 time = 830
* CHECK dout0_41 vdout0_41ck165 = 0 time = 830
* CHECK dout0_42 vdout0_42ck165 = 0 time = 830
* CHECK dout0_43 vdout0_43ck165 = 1.0 time = 830
* CHECK dout0_44 vdout0_44ck165 = 1.0 time = 830
* CHECK dout0_45 vdout0_45ck165 = 1.0 time = 830
* CHECK dout0_46 vdout0_46ck165 = 0 time = 830
* CHECK dout0_47 vdout0_47ck165 = 0 time = 830
* CHECK dout0_48 vdout0_48ck165 = 1.0 time = 830
* CHECK dout0_49 vdout0_49ck165 = 0 time = 830
* CHECK dout0_50 vdout0_50ck165 = 1.0 time = 830
* CHECK dout0_51 vdout0_51ck165 = 1.0 time = 830
* CHECK dout0_52 vdout0_52ck165 = 1.0 time = 830
* CHECK dout0_53 vdout0_53ck165 = 1.0 time = 830
* CHECK dout0_54 vdout0_54ck165 = 1.0 time = 830
* CHECK dout0_55 vdout0_55ck165 = 0 time = 830
* CHECK dout0_56 vdout0_56ck165 = 1.0 time = 830
* CHECK dout0_57 vdout0_57ck165 = 0 time = 830
* CHECK dout0_58 vdout0_58ck165 = 0 time = 830
* CHECK dout0_59 vdout0_59ck165 = 0 time = 830
* CHECK dout0_60 vdout0_60ck165 = 1.0 time = 830
* CHECK dout0_61 vdout0_61ck165 = 1.0 time = 830
* CHECK dout0_62 vdout0_62ck165 = 1.0 time = 830
* CHECK dout0_63 vdout0_63ck165 = 0 time = 830
* CHECK dout0_0 vdout0_0ck166 = 1.0 time = 835
* CHECK dout0_1 vdout0_1ck166 = 0 time = 835
* CHECK dout0_2 vdout0_2ck166 = 0 time = 835
* CHECK dout0_3 vdout0_3ck166 = 0 time = 835
* CHECK dout0_4 vdout0_4ck166 = 1.0 time = 835
* CHECK dout0_5 vdout0_5ck166 = 0 time = 835
* CHECK dout0_6 vdout0_6ck166 = 1.0 time = 835
* CHECK dout0_7 vdout0_7ck166 = 1.0 time = 835
* CHECK dout0_8 vdout0_8ck166 = 0 time = 835
* CHECK dout0_9 vdout0_9ck166 = 0 time = 835
* CHECK dout0_10 vdout0_10ck166 = 0 time = 835
* CHECK dout0_11 vdout0_11ck166 = 0 time = 835
* CHECK dout0_12 vdout0_12ck166 = 1.0 time = 835
* CHECK dout0_13 vdout0_13ck166 = 0 time = 835
* CHECK dout0_14 vdout0_14ck166 = 0 time = 835
* CHECK dout0_15 vdout0_15ck166 = 1.0 time = 835
* CHECK dout0_16 vdout0_16ck166 = 0 time = 835
* CHECK dout0_17 vdout0_17ck166 = 0 time = 835
* CHECK dout0_18 vdout0_18ck166 = 1.0 time = 835
* CHECK dout0_19 vdout0_19ck166 = 1.0 time = 835
* CHECK dout0_20 vdout0_20ck166 = 0 time = 835
* CHECK dout0_21 vdout0_21ck166 = 1.0 time = 835
* CHECK dout0_22 vdout0_22ck166 = 0 time = 835
* CHECK dout0_23 vdout0_23ck166 = 0 time = 835
* CHECK dout0_24 vdout0_24ck166 = 0 time = 835
* CHECK dout0_25 vdout0_25ck166 = 1.0 time = 835
* CHECK dout0_26 vdout0_26ck166 = 0 time = 835
* CHECK dout0_27 vdout0_27ck166 = 0 time = 835
* CHECK dout0_28 vdout0_28ck166 = 1.0 time = 835
* CHECK dout0_29 vdout0_29ck166 = 1.0 time = 835
* CHECK dout0_30 vdout0_30ck166 = 1.0 time = 835
* CHECK dout0_31 vdout0_31ck166 = 1.0 time = 835
* CHECK dout0_32 vdout0_32ck166 = 1.0 time = 835
* CHECK dout0_33 vdout0_33ck166 = 1.0 time = 835
* CHECK dout0_34 vdout0_34ck166 = 0 time = 835
* CHECK dout0_35 vdout0_35ck166 = 0 time = 835
* CHECK dout0_36 vdout0_36ck166 = 1.0 time = 835
* CHECK dout0_37 vdout0_37ck166 = 0 time = 835
* CHECK dout0_38 vdout0_38ck166 = 1.0 time = 835
* CHECK dout0_39 vdout0_39ck166 = 1.0 time = 835
* CHECK dout0_40 vdout0_40ck166 = 1.0 time = 835
* CHECK dout0_41 vdout0_41ck166 = 1.0 time = 835
* CHECK dout0_42 vdout0_42ck166 = 1.0 time = 835
* CHECK dout0_43 vdout0_43ck166 = 1.0 time = 835
* CHECK dout0_44 vdout0_44ck166 = 0 time = 835
* CHECK dout0_45 vdout0_45ck166 = 1.0 time = 835
* CHECK dout0_46 vdout0_46ck166 = 1.0 time = 835
* CHECK dout0_47 vdout0_47ck166 = 0 time = 835
* CHECK dout0_48 vdout0_48ck166 = 1.0 time = 835
* CHECK dout0_49 vdout0_49ck166 = 0 time = 835
* CHECK dout0_50 vdout0_50ck166 = 0 time = 835
* CHECK dout0_51 vdout0_51ck166 = 0 time = 835
* CHECK dout0_52 vdout0_52ck166 = 1.0 time = 835
* CHECK dout0_53 vdout0_53ck166 = 0 time = 835
* CHECK dout0_54 vdout0_54ck166 = 1.0 time = 835
* CHECK dout0_55 vdout0_55ck166 = 0 time = 835
* CHECK dout0_56 vdout0_56ck166 = 1.0 time = 835
* CHECK dout0_57 vdout0_57ck166 = 0 time = 835
* CHECK dout0_58 vdout0_58ck166 = 0 time = 835
* CHECK dout0_59 vdout0_59ck166 = 0 time = 835
* CHECK dout0_60 vdout0_60ck166 = 1.0 time = 835
* CHECK dout0_61 vdout0_61ck166 = 1.0 time = 835
* CHECK dout0_62 vdout0_62ck166 = 1.0 time = 835
* CHECK dout0_63 vdout0_63ck166 = 1.0 time = 835
* CHECK dout0_0 vdout0_0ck167 = 0 time = 840
* CHECK dout0_1 vdout0_1ck167 = 0 time = 840
* CHECK dout0_2 vdout0_2ck167 = 1.0 time = 840
* CHECK dout0_3 vdout0_3ck167 = 1.0 time = 840
* CHECK dout0_4 vdout0_4ck167 = 0 time = 840
* CHECK dout0_5 vdout0_5ck167 = 0 time = 840
* CHECK dout0_6 vdout0_6ck167 = 1.0 time = 840
* CHECK dout0_7 vdout0_7ck167 = 1.0 time = 840
* CHECK dout0_8 vdout0_8ck167 = 1.0 time = 840
* CHECK dout0_9 vdout0_9ck167 = 0 time = 840
* CHECK dout0_10 vdout0_10ck167 = 1.0 time = 840
* CHECK dout0_11 vdout0_11ck167 = 1.0 time = 840
* CHECK dout0_12 vdout0_12ck167 = 1.0 time = 840
* CHECK dout0_13 vdout0_13ck167 = 0 time = 840
* CHECK dout0_14 vdout0_14ck167 = 1.0 time = 840
* CHECK dout0_15 vdout0_15ck167 = 0 time = 840
* CHECK dout0_16 vdout0_16ck167 = 0 time = 840
* CHECK dout0_17 vdout0_17ck167 = 1.0 time = 840
* CHECK dout0_18 vdout0_18ck167 = 0 time = 840
* CHECK dout0_19 vdout0_19ck167 = 0 time = 840
* CHECK dout0_20 vdout0_20ck167 = 1.0 time = 840
* CHECK dout0_21 vdout0_21ck167 = 1.0 time = 840
* CHECK dout0_22 vdout0_22ck167 = 0 time = 840
* CHECK dout0_23 vdout0_23ck167 = 0 time = 840
* CHECK dout0_24 vdout0_24ck167 = 0 time = 840
* CHECK dout0_25 vdout0_25ck167 = 1.0 time = 840
* CHECK dout0_26 vdout0_26ck167 = 0 time = 840
* CHECK dout0_27 vdout0_27ck167 = 0 time = 840
* CHECK dout0_28 vdout0_28ck167 = 0 time = 840
* CHECK dout0_29 vdout0_29ck167 = 0 time = 840
* CHECK dout0_30 vdout0_30ck167 = 0 time = 840
* CHECK dout0_31 vdout0_31ck167 = 0 time = 840
* CHECK dout0_32 vdout0_32ck167 = 1.0 time = 840
* CHECK dout0_33 vdout0_33ck167 = 1.0 time = 840
* CHECK dout0_34 vdout0_34ck167 = 0 time = 840
* CHECK dout0_35 vdout0_35ck167 = 0 time = 840
* CHECK dout0_36 vdout0_36ck167 = 1.0 time = 840
* CHECK dout0_37 vdout0_37ck167 = 0 time = 840
* CHECK dout0_38 vdout0_38ck167 = 1.0 time = 840
* CHECK dout0_39 vdout0_39ck167 = 0 time = 840
* CHECK dout0_40 vdout0_40ck167 = 1.0 time = 840
* CHECK dout0_41 vdout0_41ck167 = 1.0 time = 840
* CHECK dout0_42 vdout0_42ck167 = 1.0 time = 840
* CHECK dout0_43 vdout0_43ck167 = 0 time = 840
* CHECK dout0_44 vdout0_44ck167 = 0 time = 840
* CHECK dout0_45 vdout0_45ck167 = 0 time = 840
* CHECK dout0_46 vdout0_46ck167 = 1.0 time = 840
* CHECK dout0_47 vdout0_47ck167 = 0 time = 840
* CHECK dout0_48 vdout0_48ck167 = 0 time = 840
* CHECK dout0_49 vdout0_49ck167 = 1.0 time = 840
* CHECK dout0_50 vdout0_50ck167 = 1.0 time = 840
* CHECK dout0_51 vdout0_51ck167 = 1.0 time = 840
* CHECK dout0_52 vdout0_52ck167 = 0 time = 840
* CHECK dout0_53 vdout0_53ck167 = 1.0 time = 840
* CHECK dout0_54 vdout0_54ck167 = 1.0 time = 840
* CHECK dout0_55 vdout0_55ck167 = 1.0 time = 840
* CHECK dout0_56 vdout0_56ck167 = 0 time = 840
* CHECK dout0_57 vdout0_57ck167 = 1.0 time = 840
* CHECK dout0_58 vdout0_58ck167 = 0 time = 840
* CHECK dout0_59 vdout0_59ck167 = 1.0 time = 840
* CHECK dout0_60 vdout0_60ck167 = 0 time = 840
* CHECK dout0_61 vdout0_61ck167 = 1.0 time = 840
* CHECK dout0_62 vdout0_62ck167 = 1.0 time = 840
* CHECK dout0_63 vdout0_63ck167 = 0 time = 840
* CHECK dout1_0 vdout1_0ck167 = 1.0 time = 840
* CHECK dout1_1 vdout1_1ck167 = 0 time = 840
* CHECK dout1_2 vdout1_2ck167 = 0 time = 840
* CHECK dout1_3 vdout1_3ck167 = 0 time = 840
* CHECK dout1_4 vdout1_4ck167 = 1.0 time = 840
* CHECK dout1_5 vdout1_5ck167 = 0 time = 840
* CHECK dout1_6 vdout1_6ck167 = 1.0 time = 840
* CHECK dout1_7 vdout1_7ck167 = 1.0 time = 840
* CHECK dout1_8 vdout1_8ck167 = 0 time = 840
* CHECK dout1_9 vdout1_9ck167 = 0 time = 840
* CHECK dout1_10 vdout1_10ck167 = 0 time = 840
* CHECK dout1_11 vdout1_11ck167 = 0 time = 840
* CHECK dout1_12 vdout1_12ck167 = 1.0 time = 840
* CHECK dout1_13 vdout1_13ck167 = 0 time = 840
* CHECK dout1_14 vdout1_14ck167 = 0 time = 840
* CHECK dout1_15 vdout1_15ck167 = 1.0 time = 840
* CHECK dout1_16 vdout1_16ck167 = 0 time = 840
* CHECK dout1_17 vdout1_17ck167 = 0 time = 840
* CHECK dout1_18 vdout1_18ck167 = 1.0 time = 840
* CHECK dout1_19 vdout1_19ck167 = 1.0 time = 840
* CHECK dout1_20 vdout1_20ck167 = 0 time = 840
* CHECK dout1_21 vdout1_21ck167 = 1.0 time = 840
* CHECK dout1_22 vdout1_22ck167 = 0 time = 840
* CHECK dout1_23 vdout1_23ck167 = 0 time = 840
* CHECK dout1_24 vdout1_24ck167 = 0 time = 840
* CHECK dout1_25 vdout1_25ck167 = 1.0 time = 840
* CHECK dout1_26 vdout1_26ck167 = 0 time = 840
* CHECK dout1_27 vdout1_27ck167 = 0 time = 840
* CHECK dout1_28 vdout1_28ck167 = 1.0 time = 840
* CHECK dout1_29 vdout1_29ck167 = 1.0 time = 840
* CHECK dout1_30 vdout1_30ck167 = 1.0 time = 840
* CHECK dout1_31 vdout1_31ck167 = 1.0 time = 840
* CHECK dout1_32 vdout1_32ck167 = 1.0 time = 840
* CHECK dout1_33 vdout1_33ck167 = 1.0 time = 840
* CHECK dout1_34 vdout1_34ck167 = 0 time = 840
* CHECK dout1_35 vdout1_35ck167 = 0 time = 840
* CHECK dout1_36 vdout1_36ck167 = 1.0 time = 840
* CHECK dout1_37 vdout1_37ck167 = 0 time = 840
* CHECK dout1_38 vdout1_38ck167 = 1.0 time = 840
* CHECK dout1_39 vdout1_39ck167 = 1.0 time = 840
* CHECK dout1_40 vdout1_40ck167 = 1.0 time = 840
* CHECK dout1_41 vdout1_41ck167 = 1.0 time = 840
* CHECK dout1_42 vdout1_42ck167 = 1.0 time = 840
* CHECK dout1_43 vdout1_43ck167 = 1.0 time = 840
* CHECK dout1_44 vdout1_44ck167 = 0 time = 840
* CHECK dout1_45 vdout1_45ck167 = 1.0 time = 840
* CHECK dout1_46 vdout1_46ck167 = 1.0 time = 840
* CHECK dout1_47 vdout1_47ck167 = 0 time = 840
* CHECK dout1_48 vdout1_48ck167 = 1.0 time = 840
* CHECK dout1_49 vdout1_49ck167 = 0 time = 840
* CHECK dout1_50 vdout1_50ck167 = 0 time = 840
* CHECK dout1_51 vdout1_51ck167 = 0 time = 840
* CHECK dout1_52 vdout1_52ck167 = 1.0 time = 840
* CHECK dout1_53 vdout1_53ck167 = 0 time = 840
* CHECK dout1_54 vdout1_54ck167 = 1.0 time = 840
* CHECK dout1_55 vdout1_55ck167 = 0 time = 840
* CHECK dout1_56 vdout1_56ck167 = 1.0 time = 840
* CHECK dout1_57 vdout1_57ck167 = 0 time = 840
* CHECK dout1_58 vdout1_58ck167 = 0 time = 840
* CHECK dout1_59 vdout1_59ck167 = 0 time = 840
* CHECK dout1_60 vdout1_60ck167 = 1.0 time = 840
* CHECK dout1_61 vdout1_61ck167 = 1.0 time = 840
* CHECK dout1_62 vdout1_62ck167 = 1.0 time = 840
* CHECK dout1_63 vdout1_63ck167 = 1.0 time = 840
* CHECK dout1_0 vdout1_0ck168 = 1.0 time = 845
* CHECK dout1_1 vdout1_1ck168 = 1.0 time = 845
* CHECK dout1_2 vdout1_2ck168 = 1.0 time = 845
* CHECK dout1_3 vdout1_3ck168 = 1.0 time = 845
* CHECK dout1_4 vdout1_4ck168 = 1.0 time = 845
* CHECK dout1_5 vdout1_5ck168 = 0 time = 845
* CHECK dout1_6 vdout1_6ck168 = 0 time = 845
* CHECK dout1_7 vdout1_7ck168 = 1.0 time = 845
* CHECK dout1_8 vdout1_8ck168 = 1.0 time = 845
* CHECK dout1_9 vdout1_9ck168 = 0 time = 845
* CHECK dout1_10 vdout1_10ck168 = 0 time = 845
* CHECK dout1_11 vdout1_11ck168 = 1.0 time = 845
* CHECK dout1_12 vdout1_12ck168 = 1.0 time = 845
* CHECK dout1_13 vdout1_13ck168 = 0 time = 845
* CHECK dout1_14 vdout1_14ck168 = 1.0 time = 845
* CHECK dout1_15 vdout1_15ck168 = 0 time = 845
* CHECK dout1_16 vdout1_16ck168 = 1.0 time = 845
* CHECK dout1_17 vdout1_17ck168 = 0 time = 845
* CHECK dout1_18 vdout1_18ck168 = 0 time = 845
* CHECK dout1_19 vdout1_19ck168 = 1.0 time = 845
* CHECK dout1_20 vdout1_20ck168 = 0 time = 845
* CHECK dout1_21 vdout1_21ck168 = 0 time = 845
* CHECK dout1_22 vdout1_22ck168 = 0 time = 845
* CHECK dout1_23 vdout1_23ck168 = 1.0 time = 845
* CHECK dout1_24 vdout1_24ck168 = 0 time = 845
* CHECK dout1_25 vdout1_25ck168 = 0 time = 845
* CHECK dout1_26 vdout1_26ck168 = 0 time = 845
* CHECK dout1_27 vdout1_27ck168 = 0 time = 845
* CHECK dout1_28 vdout1_28ck168 = 1.0 time = 845
* CHECK dout1_29 vdout1_29ck168 = 0 time = 845
* CHECK dout1_30 vdout1_30ck168 = 1.0 time = 845
* CHECK dout1_31 vdout1_31ck168 = 0 time = 845
* CHECK dout1_32 vdout1_32ck168 = 1.0 time = 845
* CHECK dout1_33 vdout1_33ck168 = 1.0 time = 845
* CHECK dout1_34 vdout1_34ck168 = 0 time = 845
* CHECK dout1_35 vdout1_35ck168 = 1.0 time = 845
* CHECK dout1_36 vdout1_36ck168 = 1.0 time = 845
* CHECK dout1_37 vdout1_37ck168 = 1.0 time = 845
* CHECK dout1_38 vdout1_38ck168 = 1.0 time = 845
* CHECK dout1_39 vdout1_39ck168 = 1.0 time = 845
* CHECK dout1_40 vdout1_40ck168 = 1.0 time = 845
* CHECK dout1_41 vdout1_41ck168 = 1.0 time = 845
* CHECK dout1_42 vdout1_42ck168 = 0 time = 845
* CHECK dout1_43 vdout1_43ck168 = 0 time = 845
* CHECK dout1_44 vdout1_44ck168 = 1.0 time = 845
* CHECK dout1_45 vdout1_45ck168 = 1.0 time = 845
* CHECK dout1_46 vdout1_46ck168 = 0 time = 845
* CHECK dout1_47 vdout1_47ck168 = 0 time = 845
* CHECK dout1_48 vdout1_48ck168 = 1.0 time = 845
* CHECK dout1_49 vdout1_49ck168 = 0 time = 845
* CHECK dout1_50 vdout1_50ck168 = 1.0 time = 845
* CHECK dout1_51 vdout1_51ck168 = 1.0 time = 845
* CHECK dout1_52 vdout1_52ck168 = 0 time = 845
* CHECK dout1_53 vdout1_53ck168 = 1.0 time = 845
* CHECK dout1_54 vdout1_54ck168 = 1.0 time = 845
* CHECK dout1_55 vdout1_55ck168 = 1.0 time = 845
* CHECK dout1_56 vdout1_56ck168 = 0 time = 845
* CHECK dout1_57 vdout1_57ck168 = 1.0 time = 845
* CHECK dout1_58 vdout1_58ck168 = 1.0 time = 845
* CHECK dout1_59 vdout1_59ck168 = 0 time = 845
* CHECK dout1_60 vdout1_60ck168 = 0 time = 845
* CHECK dout1_61 vdout1_61ck168 = 1.0 time = 845
* CHECK dout1_62 vdout1_62ck168 = 1.0 time = 845
* CHECK dout1_63 vdout1_63ck168 = 1.0 time = 845
* CHECK dout1_0 vdout1_0ck169 = 0 time = 850
* CHECK dout1_1 vdout1_1ck169 = 0 time = 850
* CHECK dout1_2 vdout1_2ck169 = 0 time = 850
* CHECK dout1_3 vdout1_3ck169 = 1.0 time = 850
* CHECK dout1_4 vdout1_4ck169 = 0 time = 850
* CHECK dout1_5 vdout1_5ck169 = 0 time = 850
* CHECK dout1_6 vdout1_6ck169 = 0 time = 850
* CHECK dout1_7 vdout1_7ck169 = 0 time = 850
* CHECK dout1_8 vdout1_8ck169 = 0 time = 850
* CHECK dout1_9 vdout1_9ck169 = 0 time = 850
* CHECK dout1_10 vdout1_10ck169 = 1.0 time = 850
* CHECK dout1_11 vdout1_11ck169 = 0 time = 850
* CHECK dout1_12 vdout1_12ck169 = 0 time = 850
* CHECK dout1_13 vdout1_13ck169 = 1.0 time = 850
* CHECK dout1_14 vdout1_14ck169 = 0 time = 850
* CHECK dout1_15 vdout1_15ck169 = 1.0 time = 850
* CHECK dout1_16 vdout1_16ck169 = 0 time = 850
* CHECK dout1_17 vdout1_17ck169 = 1.0 time = 850
* CHECK dout1_18 vdout1_18ck169 = 0 time = 850
* CHECK dout1_19 vdout1_19ck169 = 1.0 time = 850
* CHECK dout1_20 vdout1_20ck169 = 1.0 time = 850
* CHECK dout1_21 vdout1_21ck169 = 1.0 time = 850
* CHECK dout1_22 vdout1_22ck169 = 0 time = 850
* CHECK dout1_23 vdout1_23ck169 = 1.0 time = 850
* CHECK dout1_24 vdout1_24ck169 = 0 time = 850
* CHECK dout1_25 vdout1_25ck169 = 0 time = 850
* CHECK dout1_26 vdout1_26ck169 = 1.0 time = 850
* CHECK dout1_27 vdout1_27ck169 = 1.0 time = 850
* CHECK dout1_28 vdout1_28ck169 = 1.0 time = 850
* CHECK dout1_29 vdout1_29ck169 = 1.0 time = 850
* CHECK dout1_30 vdout1_30ck169 = 0 time = 850
* CHECK dout1_31 vdout1_31ck169 = 0 time = 850
* CHECK dout1_32 vdout1_32ck169 = 1.0 time = 850
* CHECK dout1_33 vdout1_33ck169 = 0 time = 850
* CHECK dout1_34 vdout1_34ck169 = 0 time = 850
* CHECK dout1_35 vdout1_35ck169 = 1.0 time = 850
* CHECK dout1_36 vdout1_36ck169 = 0 time = 850
* CHECK dout1_37 vdout1_37ck169 = 1.0 time = 850
* CHECK dout1_38 vdout1_38ck169 = 0 time = 850
* CHECK dout1_39 vdout1_39ck169 = 0 time = 850
* CHECK dout1_40 vdout1_40ck169 = 0 time = 850
* CHECK dout1_41 vdout1_41ck169 = 0 time = 850
* CHECK dout1_42 vdout1_42ck169 = 0 time = 850
* CHECK dout1_43 vdout1_43ck169 = 0 time = 850
* CHECK dout1_44 vdout1_44ck169 = 0 time = 850
* CHECK dout1_45 vdout1_45ck169 = 0 time = 850
* CHECK dout1_46 vdout1_46ck169 = 1.0 time = 850
* CHECK dout1_47 vdout1_47ck169 = 1.0 time = 850
* CHECK dout1_48 vdout1_48ck169 = 1.0 time = 850
* CHECK dout1_49 vdout1_49ck169 = 0 time = 850
* CHECK dout1_50 vdout1_50ck169 = 0 time = 850
* CHECK dout1_51 vdout1_51ck169 = 1.0 time = 850
* CHECK dout1_52 vdout1_52ck169 = 1.0 time = 850
* CHECK dout1_53 vdout1_53ck169 = 1.0 time = 850
* CHECK dout1_54 vdout1_54ck169 = 1.0 time = 850
* CHECK dout1_55 vdout1_55ck169 = 0 time = 850
* CHECK dout1_56 vdout1_56ck169 = 0 time = 850
* CHECK dout1_57 vdout1_57ck169 = 0 time = 850
* CHECK dout1_58 vdout1_58ck169 = 0 time = 850
* CHECK dout1_59 vdout1_59ck169 = 1.0 time = 850
* CHECK dout1_60 vdout1_60ck169 = 1.0 time = 850
* CHECK dout1_61 vdout1_61ck169 = 0 time = 850
* CHECK dout1_62 vdout1_62ck169 = 1.0 time = 850
* CHECK dout1_63 vdout1_63ck169 = 1.0 time = 850
* CHECK dout1_0 vdout1_0ck170 = 1.0 time = 855
* CHECK dout1_1 vdout1_1ck170 = 1.0 time = 855
* CHECK dout1_2 vdout1_2ck170 = 1.0 time = 855
* CHECK dout1_3 vdout1_3ck170 = 1.0 time = 855
* CHECK dout1_4 vdout1_4ck170 = 1.0 time = 855
* CHECK dout1_5 vdout1_5ck170 = 0 time = 855
* CHECK dout1_6 vdout1_6ck170 = 0 time = 855
* CHECK dout1_7 vdout1_7ck170 = 1.0 time = 855
* CHECK dout1_8 vdout1_8ck170 = 1.0 time = 855
* CHECK dout1_9 vdout1_9ck170 = 0 time = 855
* CHECK dout1_10 vdout1_10ck170 = 0 time = 855
* CHECK dout1_11 vdout1_11ck170 = 1.0 time = 855
* CHECK dout1_12 vdout1_12ck170 = 1.0 time = 855
* CHECK dout1_13 vdout1_13ck170 = 0 time = 855
* CHECK dout1_14 vdout1_14ck170 = 1.0 time = 855
* CHECK dout1_15 vdout1_15ck170 = 0 time = 855
* CHECK dout1_16 vdout1_16ck170 = 1.0 time = 855
* CHECK dout1_17 vdout1_17ck170 = 0 time = 855
* CHECK dout1_18 vdout1_18ck170 = 0 time = 855
* CHECK dout1_19 vdout1_19ck170 = 1.0 time = 855
* CHECK dout1_20 vdout1_20ck170 = 0 time = 855
* CHECK dout1_21 vdout1_21ck170 = 0 time = 855
* CHECK dout1_22 vdout1_22ck170 = 0 time = 855
* CHECK dout1_23 vdout1_23ck170 = 1.0 time = 855
* CHECK dout1_24 vdout1_24ck170 = 0 time = 855
* CHECK dout1_25 vdout1_25ck170 = 0 time = 855
* CHECK dout1_26 vdout1_26ck170 = 0 time = 855
* CHECK dout1_27 vdout1_27ck170 = 0 time = 855
* CHECK dout1_28 vdout1_28ck170 = 1.0 time = 855
* CHECK dout1_29 vdout1_29ck170 = 0 time = 855
* CHECK dout1_30 vdout1_30ck170 = 1.0 time = 855
* CHECK dout1_31 vdout1_31ck170 = 0 time = 855
* CHECK dout1_32 vdout1_32ck170 = 1.0 time = 855
* CHECK dout1_33 vdout1_33ck170 = 1.0 time = 855
* CHECK dout1_34 vdout1_34ck170 = 0 time = 855
* CHECK dout1_35 vdout1_35ck170 = 1.0 time = 855
* CHECK dout1_36 vdout1_36ck170 = 1.0 time = 855
* CHECK dout1_37 vdout1_37ck170 = 1.0 time = 855
* CHECK dout1_38 vdout1_38ck170 = 1.0 time = 855
* CHECK dout1_39 vdout1_39ck170 = 1.0 time = 855
* CHECK dout1_40 vdout1_40ck170 = 1.0 time = 855
* CHECK dout1_41 vdout1_41ck170 = 1.0 time = 855
* CHECK dout1_42 vdout1_42ck170 = 0 time = 855
* CHECK dout1_43 vdout1_43ck170 = 0 time = 855
* CHECK dout1_44 vdout1_44ck170 = 1.0 time = 855
* CHECK dout1_45 vdout1_45ck170 = 1.0 time = 855
* CHECK dout1_46 vdout1_46ck170 = 0 time = 855
* CHECK dout1_47 vdout1_47ck170 = 0 time = 855
* CHECK dout1_48 vdout1_48ck170 = 1.0 time = 855
* CHECK dout1_49 vdout1_49ck170 = 0 time = 855
* CHECK dout1_50 vdout1_50ck170 = 1.0 time = 855
* CHECK dout1_51 vdout1_51ck170 = 1.0 time = 855
* CHECK dout1_52 vdout1_52ck170 = 0 time = 855
* CHECK dout1_53 vdout1_53ck170 = 1.0 time = 855
* CHECK dout1_54 vdout1_54ck170 = 1.0 time = 855
* CHECK dout1_55 vdout1_55ck170 = 1.0 time = 855
* CHECK dout1_56 vdout1_56ck170 = 0 time = 855
* CHECK dout1_57 vdout1_57ck170 = 1.0 time = 855
* CHECK dout1_58 vdout1_58ck170 = 1.0 time = 855
* CHECK dout1_59 vdout1_59ck170 = 0 time = 855
* CHECK dout1_60 vdout1_60ck170 = 0 time = 855
* CHECK dout1_61 vdout1_61ck170 = 1.0 time = 855
* CHECK dout1_62 vdout1_62ck170 = 1.0 time = 855
* CHECK dout1_63 vdout1_63ck170 = 1.0 time = 855
* CHECK dout1_0 vdout1_0ck171 = 1.0 time = 860
* CHECK dout1_1 vdout1_1ck171 = 1.0 time = 860
* CHECK dout1_2 vdout1_2ck171 = 1.0 time = 860
* CHECK dout1_3 vdout1_3ck171 = 1.0 time = 860
* CHECK dout1_4 vdout1_4ck171 = 1.0 time = 860
* CHECK dout1_5 vdout1_5ck171 = 0 time = 860
* CHECK dout1_6 vdout1_6ck171 = 1.0 time = 860
* CHECK dout1_7 vdout1_7ck171 = 1.0 time = 860
* CHECK dout1_8 vdout1_8ck171 = 0 time = 860
* CHECK dout1_9 vdout1_9ck171 = 0 time = 860
* CHECK dout1_10 vdout1_10ck171 = 1.0 time = 860
* CHECK dout1_11 vdout1_11ck171 = 0 time = 860
* CHECK dout1_12 vdout1_12ck171 = 1.0 time = 860
* CHECK dout1_13 vdout1_13ck171 = 0 time = 860
* CHECK dout1_14 vdout1_14ck171 = 0 time = 860
* CHECK dout1_15 vdout1_15ck171 = 1.0 time = 860
* CHECK dout1_16 vdout1_16ck171 = 1.0 time = 860
* CHECK dout1_17 vdout1_17ck171 = 0 time = 860
* CHECK dout1_18 vdout1_18ck171 = 1.0 time = 860
* CHECK dout1_19 vdout1_19ck171 = 0 time = 860
* CHECK dout1_20 vdout1_20ck171 = 0 time = 860
* CHECK dout1_21 vdout1_21ck171 = 0 time = 860
* CHECK dout1_22 vdout1_22ck171 = 1.0 time = 860
* CHECK dout1_23 vdout1_23ck171 = 1.0 time = 860
* CHECK dout1_24 vdout1_24ck171 = 1.0 time = 860
* CHECK dout1_25 vdout1_25ck171 = 1.0 time = 860
* CHECK dout1_26 vdout1_26ck171 = 0 time = 860
* CHECK dout1_27 vdout1_27ck171 = 0 time = 860
* CHECK dout1_28 vdout1_28ck171 = 0 time = 860
* CHECK dout1_29 vdout1_29ck171 = 0 time = 860
* CHECK dout1_30 vdout1_30ck171 = 0 time = 860
* CHECK dout1_31 vdout1_31ck171 = 1.0 time = 860
* CHECK dout1_32 vdout1_32ck171 = 0 time = 860
* CHECK dout1_33 vdout1_33ck171 = 1.0 time = 860
* CHECK dout1_34 vdout1_34ck171 = 0 time = 860
* CHECK dout1_35 vdout1_35ck171 = 1.0 time = 860
* CHECK dout1_36 vdout1_36ck171 = 1.0 time = 860
* CHECK dout1_37 vdout1_37ck171 = 1.0 time = 860
* CHECK dout1_38 vdout1_38ck171 = 0 time = 860
* CHECK dout1_39 vdout1_39ck171 = 0 time = 860
* CHECK dout1_40 vdout1_40ck171 = 1.0 time = 860
* CHECK dout1_41 vdout1_41ck171 = 0 time = 860
* CHECK dout1_42 vdout1_42ck171 = 0 time = 860
* CHECK dout1_43 vdout1_43ck171 = 0 time = 860
* CHECK dout1_44 vdout1_44ck171 = 0 time = 860
* CHECK dout1_45 vdout1_45ck171 = 0 time = 860
* CHECK dout1_46 vdout1_46ck171 = 1.0 time = 860
* CHECK dout1_47 vdout1_47ck171 = 1.0 time = 860
* CHECK dout1_48 vdout1_48ck171 = 0 time = 860
* CHECK dout1_49 vdout1_49ck171 = 0 time = 860
* CHECK dout1_50 vdout1_50ck171 = 1.0 time = 860
* CHECK dout1_51 vdout1_51ck171 = 1.0 time = 860
* CHECK dout1_52 vdout1_52ck171 = 0 time = 860
* CHECK dout1_53 vdout1_53ck171 = 1.0 time = 860
* CHECK dout1_54 vdout1_54ck171 = 1.0 time = 860
* CHECK dout1_55 vdout1_55ck171 = 0 time = 860
* CHECK dout1_56 vdout1_56ck171 = 0 time = 860
* CHECK dout1_57 vdout1_57ck171 = 1.0 time = 860
* CHECK dout1_58 vdout1_58ck171 = 0 time = 860
* CHECK dout1_59 vdout1_59ck171 = 1.0 time = 860
* CHECK dout1_60 vdout1_60ck171 = 1.0 time = 860
* CHECK dout1_61 vdout1_61ck171 = 0 time = 860
* CHECK dout1_62 vdout1_62ck171 = 1.0 time = 860
* CHECK dout1_63 vdout1_63ck171 = 1.0 time = 860
* CHECK dout0_0 vdout0_0ck172 = 0 time = 865
* CHECK dout0_1 vdout0_1ck172 = 0 time = 865
* CHECK dout0_2 vdout0_2ck172 = 0 time = 865
* CHECK dout0_3 vdout0_3ck172 = 1.0 time = 865
* CHECK dout0_4 vdout0_4ck172 = 0 time = 865
* CHECK dout0_5 vdout0_5ck172 = 0 time = 865
* CHECK dout0_6 vdout0_6ck172 = 1.0 time = 865
* CHECK dout0_7 vdout0_7ck172 = 1.0 time = 865
* CHECK dout0_8 vdout0_8ck172 = 0 time = 865
* CHECK dout0_9 vdout0_9ck172 = 1.0 time = 865
* CHECK dout0_10 vdout0_10ck172 = 1.0 time = 865
* CHECK dout0_11 vdout0_11ck172 = 0 time = 865
* CHECK dout0_12 vdout0_12ck172 = 0 time = 865
* CHECK dout0_13 vdout0_13ck172 = 0 time = 865
* CHECK dout0_14 vdout0_14ck172 = 1.0 time = 865
* CHECK dout0_15 vdout0_15ck172 = 1.0 time = 865
* CHECK dout0_16 vdout0_16ck172 = 0 time = 865
* CHECK dout0_17 vdout0_17ck172 = 1.0 time = 865
* CHECK dout0_18 vdout0_18ck172 = 0 time = 865
* CHECK dout0_19 vdout0_19ck172 = 1.0 time = 865
* CHECK dout0_20 vdout0_20ck172 = 0 time = 865
* CHECK dout0_21 vdout0_21ck172 = 0 time = 865
* CHECK dout0_22 vdout0_22ck172 = 0 time = 865
* CHECK dout0_23 vdout0_23ck172 = 1.0 time = 865
* CHECK dout0_24 vdout0_24ck172 = 1.0 time = 865
* CHECK dout0_25 vdout0_25ck172 = 1.0 time = 865
* CHECK dout0_26 vdout0_26ck172 = 1.0 time = 865
* CHECK dout0_27 vdout0_27ck172 = 1.0 time = 865
* CHECK dout0_28 vdout0_28ck172 = 1.0 time = 865
* CHECK dout0_29 vdout0_29ck172 = 0 time = 865
* CHECK dout0_30 vdout0_30ck172 = 0 time = 865
* CHECK dout0_31 vdout0_31ck172 = 0 time = 865
* CHECK dout0_32 vdout0_32ck172 = 1.0 time = 865
* CHECK dout0_33 vdout0_33ck172 = 1.0 time = 865
* CHECK dout0_34 vdout0_34ck172 = 0 time = 865
* CHECK dout0_35 vdout0_35ck172 = 0 time = 865
* CHECK dout0_36 vdout0_36ck172 = 0 time = 865
* CHECK dout0_37 vdout0_37ck172 = 0 time = 865
* CHECK dout0_38 vdout0_38ck172 = 0 time = 865
* CHECK dout0_39 vdout0_39ck172 = 1.0 time = 865
* CHECK dout0_40 vdout0_40ck172 = 1.0 time = 865
* CHECK dout0_41 vdout0_41ck172 = 1.0 time = 865
* CHECK dout0_42 vdout0_42ck172 = 0 time = 865
* CHECK dout0_43 vdout0_43ck172 = 1.0 time = 865
* CHECK dout0_44 vdout0_44ck172 = 1.0 time = 865
* CHECK dout0_45 vdout0_45ck172 = 1.0 time = 865
* CHECK dout0_46 vdout0_46ck172 = 0 time = 865
* CHECK dout0_47 vdout0_47ck172 = 1.0 time = 865
* CHECK dout0_48 vdout0_48ck172 = 0 time = 865
* CHECK dout0_49 vdout0_49ck172 = 0 time = 865
* CHECK dout0_50 vdout0_50ck172 = 1.0 time = 865
* CHECK dout0_51 vdout0_51ck172 = 0 time = 865
* CHECK dout0_52 vdout0_52ck172 = 0 time = 865
* CHECK dout0_53 vdout0_53ck172 = 1.0 time = 865
* CHECK dout0_54 vdout0_54ck172 = 1.0 time = 865
* CHECK dout0_55 vdout0_55ck172 = 0 time = 865
* CHECK dout0_56 vdout0_56ck172 = 0 time = 865
* CHECK dout0_57 vdout0_57ck172 = 0 time = 865
* CHECK dout0_58 vdout0_58ck172 = 1.0 time = 865
* CHECK dout0_59 vdout0_59ck172 = 0 time = 865
* CHECK dout0_60 vdout0_60ck172 = 1.0 time = 865
* CHECK dout0_61 vdout0_61ck172 = 1.0 time = 865
* CHECK dout0_62 vdout0_62ck172 = 1.0 time = 865
* CHECK dout0_63 vdout0_63ck172 = 1.0 time = 865
* CHECK dout1_0 vdout1_0ck174 = 0 time = 875
* CHECK dout1_1 vdout1_1ck174 = 0 time = 875
* CHECK dout1_2 vdout1_2ck174 = 0 time = 875
* CHECK dout1_3 vdout1_3ck174 = 0 time = 875
* CHECK dout1_4 vdout1_4ck174 = 1.0 time = 875
* CHECK dout1_5 vdout1_5ck174 = 1.0 time = 875
* CHECK dout1_6 vdout1_6ck174 = 0 time = 875
* CHECK dout1_7 vdout1_7ck174 = 0 time = 875
* CHECK dout1_8 vdout1_8ck174 = 0 time = 875
* CHECK dout1_9 vdout1_9ck174 = 0 time = 875
* CHECK dout1_10 vdout1_10ck174 = 1.0 time = 875
* CHECK dout1_11 vdout1_11ck174 = 1.0 time = 875
* CHECK dout1_12 vdout1_12ck174 = 1.0 time = 875
* CHECK dout1_13 vdout1_13ck174 = 0 time = 875
* CHECK dout1_14 vdout1_14ck174 = 0 time = 875
* CHECK dout1_15 vdout1_15ck174 = 0 time = 875
* CHECK dout1_16 vdout1_16ck174 = 1.0 time = 875
* CHECK dout1_17 vdout1_17ck174 = 0 time = 875
* CHECK dout1_18 vdout1_18ck174 = 1.0 time = 875
* CHECK dout1_19 vdout1_19ck174 = 1.0 time = 875
* CHECK dout1_20 vdout1_20ck174 = 0 time = 875
* CHECK dout1_21 vdout1_21ck174 = 1.0 time = 875
* CHECK dout1_22 vdout1_22ck174 = 0 time = 875
* CHECK dout1_23 vdout1_23ck174 = 1.0 time = 875
* CHECK dout1_24 vdout1_24ck174 = 1.0 time = 875
* CHECK dout1_25 vdout1_25ck174 = 0 time = 875
* CHECK dout1_26 vdout1_26ck174 = 1.0 time = 875
* CHECK dout1_27 vdout1_27ck174 = 1.0 time = 875
* CHECK dout1_28 vdout1_28ck174 = 1.0 time = 875
* CHECK dout1_29 vdout1_29ck174 = 0 time = 875
* CHECK dout1_30 vdout1_30ck174 = 1.0 time = 875
* CHECK dout1_31 vdout1_31ck174 = 0 time = 875
* CHECK dout1_32 vdout1_32ck174 = 1.0 time = 875
* CHECK dout1_33 vdout1_33ck174 = 0 time = 875
* CHECK dout1_34 vdout1_34ck174 = 1.0 time = 875
* CHECK dout1_35 vdout1_35ck174 = 1.0 time = 875
* CHECK dout1_36 vdout1_36ck174 = 1.0 time = 875
* CHECK dout1_37 vdout1_37ck174 = 0 time = 875
* CHECK dout1_38 vdout1_38ck174 = 1.0 time = 875
* CHECK dout1_39 vdout1_39ck174 = 0 time = 875
* CHECK dout1_40 vdout1_40ck174 = 1.0 time = 875
* CHECK dout1_41 vdout1_41ck174 = 0 time = 875
* CHECK dout1_42 vdout1_42ck174 = 1.0 time = 875
* CHECK dout1_43 vdout1_43ck174 = 0 time = 875
* CHECK dout1_44 vdout1_44ck174 = 1.0 time = 875
* CHECK dout1_45 vdout1_45ck174 = 1.0 time = 875
* CHECK dout1_46 vdout1_46ck174 = 1.0 time = 875
* CHECK dout1_47 vdout1_47ck174 = 1.0 time = 875
* CHECK dout1_48 vdout1_48ck174 = 1.0 time = 875
* CHECK dout1_49 vdout1_49ck174 = 1.0 time = 875
* CHECK dout1_50 vdout1_50ck174 = 1.0 time = 875
* CHECK dout1_51 vdout1_51ck174 = 1.0 time = 875
* CHECK dout1_52 vdout1_52ck174 = 1.0 time = 875
* CHECK dout1_53 vdout1_53ck174 = 1.0 time = 875
* CHECK dout1_54 vdout1_54ck174 = 0 time = 875
* CHECK dout1_55 vdout1_55ck174 = 1.0 time = 875
* CHECK dout1_56 vdout1_56ck174 = 1.0 time = 875
* CHECK dout1_57 vdout1_57ck174 = 0 time = 875
* CHECK dout1_58 vdout1_58ck174 = 1.0 time = 875
* CHECK dout1_59 vdout1_59ck174 = 1.0 time = 875
* CHECK dout1_60 vdout1_60ck174 = 1.0 time = 875
* CHECK dout1_61 vdout1_61ck174 = 1.0 time = 875
* CHECK dout1_62 vdout1_62ck174 = 1.0 time = 875
* CHECK dout1_63 vdout1_63ck174 = 0 time = 875
* CHECK dout0_0 vdout0_0ck175 = 0 time = 880
* CHECK dout0_1 vdout0_1ck175 = 0 time = 880
* CHECK dout0_2 vdout0_2ck175 = 0 time = 880
* CHECK dout0_3 vdout0_3ck175 = 0 time = 880
* CHECK dout0_4 vdout0_4ck175 = 1.0 time = 880
* CHECK dout0_5 vdout0_5ck175 = 0 time = 880
* CHECK dout0_6 vdout0_6ck175 = 0 time = 880
* CHECK dout0_7 vdout0_7ck175 = 0 time = 880
* CHECK dout0_8 vdout0_8ck175 = 1.0 time = 880
* CHECK dout0_9 vdout0_9ck175 = 0 time = 880
* CHECK dout0_10 vdout0_10ck175 = 0 time = 880
* CHECK dout0_11 vdout0_11ck175 = 0 time = 880
* CHECK dout0_12 vdout0_12ck175 = 1.0 time = 880
* CHECK dout0_13 vdout0_13ck175 = 0 time = 880
* CHECK dout0_14 vdout0_14ck175 = 1.0 time = 880
* CHECK dout0_15 vdout0_15ck175 = 0 time = 880
* CHECK dout0_16 vdout0_16ck175 = 1.0 time = 880
* CHECK dout0_17 vdout0_17ck175 = 1.0 time = 880
* CHECK dout0_18 vdout0_18ck175 = 1.0 time = 880
* CHECK dout0_19 vdout0_19ck175 = 1.0 time = 880
* CHECK dout0_20 vdout0_20ck175 = 1.0 time = 880
* CHECK dout0_21 vdout0_21ck175 = 1.0 time = 880
* CHECK dout0_22 vdout0_22ck175 = 1.0 time = 880
* CHECK dout0_23 vdout0_23ck175 = 0 time = 880
* CHECK dout0_24 vdout0_24ck175 = 0 time = 880
* CHECK dout0_25 vdout0_25ck175 = 1.0 time = 880
* CHECK dout0_26 vdout0_26ck175 = 1.0 time = 880
* CHECK dout0_27 vdout0_27ck175 = 0 time = 880
* CHECK dout0_28 vdout0_28ck175 = 1.0 time = 880
* CHECK dout0_29 vdout0_29ck175 = 1.0 time = 880
* CHECK dout0_30 vdout0_30ck175 = 0 time = 880
* CHECK dout0_31 vdout0_31ck175 = 1.0 time = 880
* CHECK dout0_32 vdout0_32ck175 = 0 time = 880
* CHECK dout0_33 vdout0_33ck175 = 1.0 time = 880
* CHECK dout0_34 vdout0_34ck175 = 0 time = 880
* CHECK dout0_35 vdout0_35ck175 = 1.0 time = 880
* CHECK dout0_36 vdout0_36ck175 = 1.0 time = 880
* CHECK dout0_37 vdout0_37ck175 = 1.0 time = 880
* CHECK dout0_38 vdout0_38ck175 = 0 time = 880
* CHECK dout0_39 vdout0_39ck175 = 1.0 time = 880
* CHECK dout0_40 vdout0_40ck175 = 1.0 time = 880
* CHECK dout0_41 vdout0_41ck175 = 0 time = 880
* CHECK dout0_42 vdout0_42ck175 = 0 time = 880
* CHECK dout0_43 vdout0_43ck175 = 1.0 time = 880
* CHECK dout0_44 vdout0_44ck175 = 1.0 time = 880
* CHECK dout0_45 vdout0_45ck175 = 1.0 time = 880
* CHECK dout0_46 vdout0_46ck175 = 0 time = 880
* CHECK dout0_47 vdout0_47ck175 = 0 time = 880
* CHECK dout0_48 vdout0_48ck175 = 1.0 time = 880
* CHECK dout0_49 vdout0_49ck175 = 0 time = 880
* CHECK dout0_50 vdout0_50ck175 = 1.0 time = 880
* CHECK dout0_51 vdout0_51ck175 = 1.0 time = 880
* CHECK dout0_52 vdout0_52ck175 = 1.0 time = 880
* CHECK dout0_53 vdout0_53ck175 = 1.0 time = 880
* CHECK dout0_54 vdout0_54ck175 = 1.0 time = 880
* CHECK dout0_55 vdout0_55ck175 = 0 time = 880
* CHECK dout0_56 vdout0_56ck175 = 1.0 time = 880
* CHECK dout0_57 vdout0_57ck175 = 0 time = 880
* CHECK dout0_58 vdout0_58ck175 = 0 time = 880
* CHECK dout0_59 vdout0_59ck175 = 0 time = 880
* CHECK dout0_60 vdout0_60ck175 = 1.0 time = 880
* CHECK dout0_61 vdout0_61ck175 = 1.0 time = 880
* CHECK dout0_62 vdout0_62ck175 = 1.0 time = 880
* CHECK dout0_63 vdout0_63ck175 = 0 time = 880
* CHECK dout1_0 vdout1_0ck175 = 1.0 time = 880
* CHECK dout1_1 vdout1_1ck175 = 0 time = 880
* CHECK dout1_2 vdout1_2ck175 = 0 time = 880
* CHECK dout1_3 vdout1_3ck175 = 0 time = 880
* CHECK dout1_4 vdout1_4ck175 = 1.0 time = 880
* CHECK dout1_5 vdout1_5ck175 = 0 time = 880
* CHECK dout1_6 vdout1_6ck175 = 1.0 time = 880
* CHECK dout1_7 vdout1_7ck175 = 1.0 time = 880
* CHECK dout1_8 vdout1_8ck175 = 0 time = 880
* CHECK dout1_9 vdout1_9ck175 = 0 time = 880
* CHECK dout1_10 vdout1_10ck175 = 0 time = 880
* CHECK dout1_11 vdout1_11ck175 = 0 time = 880
* CHECK dout1_12 vdout1_12ck175 = 1.0 time = 880
* CHECK dout1_13 vdout1_13ck175 = 0 time = 880
* CHECK dout1_14 vdout1_14ck175 = 0 time = 880
* CHECK dout1_15 vdout1_15ck175 = 1.0 time = 880
* CHECK dout1_16 vdout1_16ck175 = 0 time = 880
* CHECK dout1_17 vdout1_17ck175 = 0 time = 880
* CHECK dout1_18 vdout1_18ck175 = 1.0 time = 880
* CHECK dout1_19 vdout1_19ck175 = 1.0 time = 880
* CHECK dout1_20 vdout1_20ck175 = 0 time = 880
* CHECK dout1_21 vdout1_21ck175 = 1.0 time = 880
* CHECK dout1_22 vdout1_22ck175 = 0 time = 880
* CHECK dout1_23 vdout1_23ck175 = 0 time = 880
* CHECK dout1_24 vdout1_24ck175 = 0 time = 880
* CHECK dout1_25 vdout1_25ck175 = 1.0 time = 880
* CHECK dout1_26 vdout1_26ck175 = 0 time = 880
* CHECK dout1_27 vdout1_27ck175 = 0 time = 880
* CHECK dout1_28 vdout1_28ck175 = 1.0 time = 880
* CHECK dout1_29 vdout1_29ck175 = 1.0 time = 880
* CHECK dout1_30 vdout1_30ck175 = 1.0 time = 880
* CHECK dout1_31 vdout1_31ck175 = 1.0 time = 880
* CHECK dout1_32 vdout1_32ck175 = 1.0 time = 880
* CHECK dout1_33 vdout1_33ck175 = 1.0 time = 880
* CHECK dout1_34 vdout1_34ck175 = 0 time = 880
* CHECK dout1_35 vdout1_35ck175 = 0 time = 880
* CHECK dout1_36 vdout1_36ck175 = 1.0 time = 880
* CHECK dout1_37 vdout1_37ck175 = 0 time = 880
* CHECK dout1_38 vdout1_38ck175 = 1.0 time = 880
* CHECK dout1_39 vdout1_39ck175 = 1.0 time = 880
* CHECK dout1_40 vdout1_40ck175 = 1.0 time = 880
* CHECK dout1_41 vdout1_41ck175 = 1.0 time = 880
* CHECK dout1_42 vdout1_42ck175 = 1.0 time = 880
* CHECK dout1_43 vdout1_43ck175 = 1.0 time = 880
* CHECK dout1_44 vdout1_44ck175 = 0 time = 880
* CHECK dout1_45 vdout1_45ck175 = 1.0 time = 880
* CHECK dout1_46 vdout1_46ck175 = 1.0 time = 880
* CHECK dout1_47 vdout1_47ck175 = 0 time = 880
* CHECK dout1_48 vdout1_48ck175 = 1.0 time = 880
* CHECK dout1_49 vdout1_49ck175 = 0 time = 880
* CHECK dout1_50 vdout1_50ck175 = 0 time = 880
* CHECK dout1_51 vdout1_51ck175 = 0 time = 880
* CHECK dout1_52 vdout1_52ck175 = 1.0 time = 880
* CHECK dout1_53 vdout1_53ck175 = 0 time = 880
* CHECK dout1_54 vdout1_54ck175 = 1.0 time = 880
* CHECK dout1_55 vdout1_55ck175 = 0 time = 880
* CHECK dout1_56 vdout1_56ck175 = 1.0 time = 880
* CHECK dout1_57 vdout1_57ck175 = 0 time = 880
* CHECK dout1_58 vdout1_58ck175 = 0 time = 880
* CHECK dout1_59 vdout1_59ck175 = 0 time = 880
* CHECK dout1_60 vdout1_60ck175 = 1.0 time = 880
* CHECK dout1_61 vdout1_61ck175 = 1.0 time = 880
* CHECK dout1_62 vdout1_62ck175 = 1.0 time = 880
* CHECK dout1_63 vdout1_63ck175 = 1.0 time = 880
* CHECK dout0_0 vdout0_0ck176 = 0 time = 885
* CHECK dout0_1 vdout0_1ck176 = 1.0 time = 885
* CHECK dout0_2 vdout0_2ck176 = 0 time = 885
* CHECK dout0_3 vdout0_3ck176 = 0 time = 885
* CHECK dout0_4 vdout0_4ck176 = 0 time = 885
* CHECK dout0_5 vdout0_5ck176 = 1.0 time = 885
* CHECK dout0_6 vdout0_6ck176 = 1.0 time = 885
* CHECK dout0_7 vdout0_7ck176 = 0 time = 885
* CHECK dout0_8 vdout0_8ck176 = 0 time = 885
* CHECK dout0_9 vdout0_9ck176 = 0 time = 885
* CHECK dout0_10 vdout0_10ck176 = 0 time = 885
* CHECK dout0_11 vdout0_11ck176 = 0 time = 885
* CHECK dout0_12 vdout0_12ck176 = 0 time = 885
* CHECK dout0_13 vdout0_13ck176 = 1.0 time = 885
* CHECK dout0_14 vdout0_14ck176 = 0 time = 885
* CHECK dout0_15 vdout0_15ck176 = 0 time = 885
* CHECK dout0_16 vdout0_16ck176 = 0 time = 885
* CHECK dout0_17 vdout0_17ck176 = 0 time = 885
* CHECK dout0_18 vdout0_18ck176 = 1.0 time = 885
* CHECK dout0_19 vdout0_19ck176 = 0 time = 885
* CHECK dout0_20 vdout0_20ck176 = 0 time = 885
* CHECK dout0_21 vdout0_21ck176 = 0 time = 885
* CHECK dout0_22 vdout0_22ck176 = 0 time = 885
* CHECK dout0_23 vdout0_23ck176 = 0 time = 885
* CHECK dout0_24 vdout0_24ck176 = 0 time = 885
* CHECK dout0_25 vdout0_25ck176 = 1.0 time = 885
* CHECK dout0_26 vdout0_26ck176 = 0 time = 885
* CHECK dout0_27 vdout0_27ck176 = 0 time = 885
* CHECK dout0_28 vdout0_28ck176 = 1.0 time = 885
* CHECK dout0_29 vdout0_29ck176 = 1.0 time = 885
* CHECK dout0_30 vdout0_30ck176 = 1.0 time = 885
* CHECK dout0_31 vdout0_31ck176 = 1.0 time = 885
* CHECK dout0_32 vdout0_32ck176 = 0 time = 885
* CHECK dout0_33 vdout0_33ck176 = 0 time = 885
* CHECK dout0_34 vdout0_34ck176 = 1.0 time = 885
* CHECK dout0_35 vdout0_35ck176 = 1.0 time = 885
* CHECK dout0_36 vdout0_36ck176 = 1.0 time = 885
* CHECK dout0_37 vdout0_37ck176 = 1.0 time = 885
* CHECK dout0_38 vdout0_38ck176 = 1.0 time = 885
* CHECK dout0_39 vdout0_39ck176 = 1.0 time = 885
* CHECK dout0_40 vdout0_40ck176 = 1.0 time = 885
* CHECK dout0_41 vdout0_41ck176 = 1.0 time = 885
* CHECK dout0_42 vdout0_42ck176 = 1.0 time = 885
* CHECK dout0_43 vdout0_43ck176 = 1.0 time = 885
* CHECK dout0_44 vdout0_44ck176 = 0 time = 885
* CHECK dout0_45 vdout0_45ck176 = 1.0 time = 885
* CHECK dout0_46 vdout0_46ck176 = 0 time = 885
* CHECK dout0_47 vdout0_47ck176 = 0 time = 885
* CHECK dout0_48 vdout0_48ck176 = 1.0 time = 885
* CHECK dout0_49 vdout0_49ck176 = 1.0 time = 885
* CHECK dout0_50 vdout0_50ck176 = 1.0 time = 885
* CHECK dout0_51 vdout0_51ck176 = 0 time = 885
* CHECK dout0_52 vdout0_52ck176 = 1.0 time = 885
* CHECK dout0_53 vdout0_53ck176 = 1.0 time = 885
* CHECK dout0_54 vdout0_54ck176 = 1.0 time = 885
* CHECK dout0_55 vdout0_55ck176 = 0 time = 885
* CHECK dout0_56 vdout0_56ck176 = 0 time = 885
* CHECK dout0_57 vdout0_57ck176 = 1.0 time = 885
* CHECK dout0_58 vdout0_58ck176 = 1.0 time = 885
* CHECK dout0_59 vdout0_59ck176 = 1.0 time = 885
* CHECK dout0_60 vdout0_60ck176 = 1.0 time = 885
* CHECK dout0_61 vdout0_61ck176 = 1.0 time = 885
* CHECK dout0_62 vdout0_62ck176 = 1.0 time = 885
* CHECK dout0_63 vdout0_63ck176 = 0 time = 885
* CHECK dout0_0 vdout0_0ck177 = 1.0 time = 890
* CHECK dout0_1 vdout0_1ck177 = 1.0 time = 890
* CHECK dout0_2 vdout0_2ck177 = 1.0 time = 890
* CHECK dout0_3 vdout0_3ck177 = 1.0 time = 890
* CHECK dout0_4 vdout0_4ck177 = 1.0 time = 890
* CHECK dout0_5 vdout0_5ck177 = 0 time = 890
* CHECK dout0_6 vdout0_6ck177 = 0 time = 890
* CHECK dout0_7 vdout0_7ck177 = 1.0 time = 890
* CHECK dout0_8 vdout0_8ck177 = 1.0 time = 890
* CHECK dout0_9 vdout0_9ck177 = 0 time = 890
* CHECK dout0_10 vdout0_10ck177 = 0 time = 890
* CHECK dout0_11 vdout0_11ck177 = 1.0 time = 890
* CHECK dout0_12 vdout0_12ck177 = 1.0 time = 890
* CHECK dout0_13 vdout0_13ck177 = 0 time = 890
* CHECK dout0_14 vdout0_14ck177 = 1.0 time = 890
* CHECK dout0_15 vdout0_15ck177 = 0 time = 890
* CHECK dout0_16 vdout0_16ck177 = 1.0 time = 890
* CHECK dout0_17 vdout0_17ck177 = 0 time = 890
* CHECK dout0_18 vdout0_18ck177 = 0 time = 890
* CHECK dout0_19 vdout0_19ck177 = 1.0 time = 890
* CHECK dout0_20 vdout0_20ck177 = 0 time = 890
* CHECK dout0_21 vdout0_21ck177 = 0 time = 890
* CHECK dout0_22 vdout0_22ck177 = 0 time = 890
* CHECK dout0_23 vdout0_23ck177 = 1.0 time = 890
* CHECK dout0_24 vdout0_24ck177 = 0 time = 890
* CHECK dout0_25 vdout0_25ck177 = 0 time = 890
* CHECK dout0_26 vdout0_26ck177 = 0 time = 890
* CHECK dout0_27 vdout0_27ck177 = 0 time = 890
* CHECK dout0_28 vdout0_28ck177 = 1.0 time = 890
* CHECK dout0_29 vdout0_29ck177 = 0 time = 890
* CHECK dout0_30 vdout0_30ck177 = 1.0 time = 890
* CHECK dout0_31 vdout0_31ck177 = 0 time = 890
* CHECK dout0_32 vdout0_32ck177 = 1.0 time = 890
* CHECK dout0_33 vdout0_33ck177 = 1.0 time = 890
* CHECK dout0_34 vdout0_34ck177 = 0 time = 890
* CHECK dout0_35 vdout0_35ck177 = 1.0 time = 890
* CHECK dout0_36 vdout0_36ck177 = 1.0 time = 890
* CHECK dout0_37 vdout0_37ck177 = 1.0 time = 890
* CHECK dout0_38 vdout0_38ck177 = 1.0 time = 890
* CHECK dout0_39 vdout0_39ck177 = 1.0 time = 890
* CHECK dout0_40 vdout0_40ck177 = 1.0 time = 890
* CHECK dout0_41 vdout0_41ck177 = 1.0 time = 890
* CHECK dout0_42 vdout0_42ck177 = 0 time = 890
* CHECK dout0_43 vdout0_43ck177 = 0 time = 890
* CHECK dout0_44 vdout0_44ck177 = 1.0 time = 890
* CHECK dout0_45 vdout0_45ck177 = 1.0 time = 890
* CHECK dout0_46 vdout0_46ck177 = 0 time = 890
* CHECK dout0_47 vdout0_47ck177 = 0 time = 890
* CHECK dout0_48 vdout0_48ck177 = 1.0 time = 890
* CHECK dout0_49 vdout0_49ck177 = 0 time = 890
* CHECK dout0_50 vdout0_50ck177 = 1.0 time = 890
* CHECK dout0_51 vdout0_51ck177 = 1.0 time = 890
* CHECK dout0_52 vdout0_52ck177 = 0 time = 890
* CHECK dout0_53 vdout0_53ck177 = 1.0 time = 890
* CHECK dout0_54 vdout0_54ck177 = 1.0 time = 890
* CHECK dout0_55 vdout0_55ck177 = 1.0 time = 890
* CHECK dout0_56 vdout0_56ck177 = 0 time = 890
* CHECK dout0_57 vdout0_57ck177 = 1.0 time = 890
* CHECK dout0_58 vdout0_58ck177 = 1.0 time = 890
* CHECK dout0_59 vdout0_59ck177 = 0 time = 890
* CHECK dout0_60 vdout0_60ck177 = 0 time = 890
* CHECK dout0_61 vdout0_61ck177 = 1.0 time = 890
* CHECK dout0_62 vdout0_62ck177 = 1.0 time = 890
* CHECK dout0_63 vdout0_63ck177 = 1.0 time = 890
* CHECK dout0_0 vdout0_0ck178 = 0 time = 895
* CHECK dout0_1 vdout0_1ck178 = 0 time = 895
* CHECK dout0_2 vdout0_2ck178 = 0 time = 895
* CHECK dout0_3 vdout0_3ck178 = 0 time = 895
* CHECK dout0_4 vdout0_4ck178 = 1.0 time = 895
* CHECK dout0_5 vdout0_5ck178 = 1.0 time = 895
* CHECK dout0_6 vdout0_6ck178 = 0 time = 895
* CHECK dout0_7 vdout0_7ck178 = 0 time = 895
* CHECK dout0_8 vdout0_8ck178 = 0 time = 895
* CHECK dout0_9 vdout0_9ck178 = 0 time = 895
* CHECK dout0_10 vdout0_10ck178 = 1.0 time = 895
* CHECK dout0_11 vdout0_11ck178 = 1.0 time = 895
* CHECK dout0_12 vdout0_12ck178 = 1.0 time = 895
* CHECK dout0_13 vdout0_13ck178 = 0 time = 895
* CHECK dout0_14 vdout0_14ck178 = 0 time = 895
* CHECK dout0_15 vdout0_15ck178 = 0 time = 895
* CHECK dout0_16 vdout0_16ck178 = 1.0 time = 895
* CHECK dout0_17 vdout0_17ck178 = 0 time = 895
* CHECK dout0_18 vdout0_18ck178 = 1.0 time = 895
* CHECK dout0_19 vdout0_19ck178 = 1.0 time = 895
* CHECK dout0_20 vdout0_20ck178 = 0 time = 895
* CHECK dout0_21 vdout0_21ck178 = 1.0 time = 895
* CHECK dout0_22 vdout0_22ck178 = 0 time = 895
* CHECK dout0_23 vdout0_23ck178 = 1.0 time = 895
* CHECK dout0_24 vdout0_24ck178 = 1.0 time = 895
* CHECK dout0_25 vdout0_25ck178 = 0 time = 895
* CHECK dout0_26 vdout0_26ck178 = 1.0 time = 895
* CHECK dout0_27 vdout0_27ck178 = 1.0 time = 895
* CHECK dout0_28 vdout0_28ck178 = 1.0 time = 895
* CHECK dout0_29 vdout0_29ck178 = 0 time = 895
* CHECK dout0_30 vdout0_30ck178 = 1.0 time = 895
* CHECK dout0_31 vdout0_31ck178 = 0 time = 895
* CHECK dout0_32 vdout0_32ck178 = 1.0 time = 895
* CHECK dout0_33 vdout0_33ck178 = 0 time = 895
* CHECK dout0_34 vdout0_34ck178 = 1.0 time = 895
* CHECK dout0_35 vdout0_35ck178 = 1.0 time = 895
* CHECK dout0_36 vdout0_36ck178 = 1.0 time = 895
* CHECK dout0_37 vdout0_37ck178 = 0 time = 895
* CHECK dout0_38 vdout0_38ck178 = 1.0 time = 895
* CHECK dout0_39 vdout0_39ck178 = 0 time = 895
* CHECK dout0_40 vdout0_40ck178 = 1.0 time = 895
* CHECK dout0_41 vdout0_41ck178 = 0 time = 895
* CHECK dout0_42 vdout0_42ck178 = 1.0 time = 895
* CHECK dout0_43 vdout0_43ck178 = 0 time = 895
* CHECK dout0_44 vdout0_44ck178 = 1.0 time = 895
* CHECK dout0_45 vdout0_45ck178 = 1.0 time = 895
* CHECK dout0_46 vdout0_46ck178 = 1.0 time = 895
* CHECK dout0_47 vdout0_47ck178 = 1.0 time = 895
* CHECK dout0_48 vdout0_48ck178 = 1.0 time = 895
* CHECK dout0_49 vdout0_49ck178 = 1.0 time = 895
* CHECK dout0_50 vdout0_50ck178 = 1.0 time = 895
* CHECK dout0_51 vdout0_51ck178 = 1.0 time = 895
* CHECK dout0_52 vdout0_52ck178 = 1.0 time = 895
* CHECK dout0_53 vdout0_53ck178 = 1.0 time = 895
* CHECK dout0_54 vdout0_54ck178 = 0 time = 895
* CHECK dout0_55 vdout0_55ck178 = 1.0 time = 895
* CHECK dout0_56 vdout0_56ck178 = 1.0 time = 895
* CHECK dout0_57 vdout0_57ck178 = 0 time = 895
* CHECK dout0_58 vdout0_58ck178 = 1.0 time = 895
* CHECK dout0_59 vdout0_59ck178 = 1.0 time = 895
* CHECK dout0_60 vdout0_60ck178 = 1.0 time = 895
* CHECK dout0_61 vdout0_61ck178 = 1.0 time = 895
* CHECK dout0_62 vdout0_62ck178 = 1.0 time = 895
* CHECK dout0_63 vdout0_63ck178 = 0 time = 895
* CHECK dout1_0 vdout1_0ck178 = 0 time = 895
* CHECK dout1_1 vdout1_1ck178 = 0 time = 895
* CHECK dout1_2 vdout1_2ck178 = 0 time = 895
* CHECK dout1_3 vdout1_3ck178 = 1.0 time = 895
* CHECK dout1_4 vdout1_4ck178 = 1.0 time = 895
* CHECK dout1_5 vdout1_5ck178 = 1.0 time = 895
* CHECK dout1_6 vdout1_6ck178 = 0 time = 895
* CHECK dout1_7 vdout1_7ck178 = 0 time = 895
* CHECK dout1_8 vdout1_8ck178 = 0 time = 895
* CHECK dout1_9 vdout1_9ck178 = 1.0 time = 895
* CHECK dout1_10 vdout1_10ck178 = 0 time = 895
* CHECK dout1_11 vdout1_11ck178 = 0 time = 895
* CHECK dout1_12 vdout1_12ck178 = 1.0 time = 895
* CHECK dout1_13 vdout1_13ck178 = 1.0 time = 895
* CHECK dout1_14 vdout1_14ck178 = 0 time = 895
* CHECK dout1_15 vdout1_15ck178 = 1.0 time = 895
* CHECK dout1_16 vdout1_16ck178 = 1.0 time = 895
* CHECK dout1_17 vdout1_17ck178 = 0 time = 895
* CHECK dout1_18 vdout1_18ck178 = 1.0 time = 895
* CHECK dout1_19 vdout1_19ck178 = 0 time = 895
* CHECK dout1_20 vdout1_20ck178 = 1.0 time = 895
* CHECK dout1_21 vdout1_21ck178 = 1.0 time = 895
* CHECK dout1_22 vdout1_22ck178 = 0 time = 895
* CHECK dout1_23 vdout1_23ck178 = 0 time = 895
* CHECK dout1_24 vdout1_24ck178 = 0 time = 895
* CHECK dout1_25 vdout1_25ck178 = 0 time = 895
* CHECK dout1_26 vdout1_26ck178 = 0 time = 895
* CHECK dout1_27 vdout1_27ck178 = 0 time = 895
* CHECK dout1_28 vdout1_28ck178 = 0 time = 895
* CHECK dout1_29 vdout1_29ck178 = 1.0 time = 895
* CHECK dout1_30 vdout1_30ck178 = 0 time = 895
* CHECK dout1_31 vdout1_31ck178 = 0 time = 895
* CHECK dout1_32 vdout1_32ck178 = 0 time = 895
* CHECK dout1_33 vdout1_33ck178 = 0 time = 895
* CHECK dout1_34 vdout1_34ck178 = 1.0 time = 895
* CHECK dout1_35 vdout1_35ck178 = 1.0 time = 895
* CHECK dout1_36 vdout1_36ck178 = 1.0 time = 895
* CHECK dout1_37 vdout1_37ck178 = 0 time = 895
* CHECK dout1_38 vdout1_38ck178 = 0 time = 895
* CHECK dout1_39 vdout1_39ck178 = 0 time = 895
* CHECK dout1_40 vdout1_40ck178 = 1.0 time = 895
* CHECK dout1_41 vdout1_41ck178 = 1.0 time = 895
* CHECK dout1_42 vdout1_42ck178 = 0 time = 895
* CHECK dout1_43 vdout1_43ck178 = 0 time = 895
* CHECK dout1_44 vdout1_44ck178 = 1.0 time = 895
* CHECK dout1_45 vdout1_45ck178 = 0 time = 895
* CHECK dout1_46 vdout1_46ck178 = 1.0 time = 895
* CHECK dout1_47 vdout1_47ck178 = 0 time = 895
* CHECK dout1_48 vdout1_48ck178 = 0 time = 895
* CHECK dout1_49 vdout1_49ck178 = 1.0 time = 895
* CHECK dout1_50 vdout1_50ck178 = 1.0 time = 895
* CHECK dout1_51 vdout1_51ck178 = 0 time = 895
* CHECK dout1_52 vdout1_52ck178 = 1.0 time = 895
* CHECK dout1_53 vdout1_53ck178 = 0 time = 895
* CHECK dout1_54 vdout1_54ck178 = 0 time = 895
* CHECK dout1_55 vdout1_55ck178 = 1.0 time = 895
* CHECK dout1_56 vdout1_56ck178 = 1.0 time = 895
* CHECK dout1_57 vdout1_57ck178 = 0 time = 895
* CHECK dout1_58 vdout1_58ck178 = 0 time = 895
* CHECK dout1_59 vdout1_59ck178 = 1.0 time = 895
* CHECK dout1_60 vdout1_60ck178 = 0 time = 895
* CHECK dout1_61 vdout1_61ck178 = 0 time = 895
* CHECK dout1_62 vdout1_62ck178 = 0 time = 895
* CHECK dout1_63 vdout1_63ck178 = 1.0 time = 895
* CHECK dout0_0 vdout0_0ck179 = 1.0 time = 900
* CHECK dout0_1 vdout0_1ck179 = 0 time = 900
* CHECK dout0_2 vdout0_2ck179 = 1.0 time = 900
* CHECK dout0_3 vdout0_3ck179 = 1.0 time = 900
* CHECK dout0_4 vdout0_4ck179 = 0 time = 900
* CHECK dout0_5 vdout0_5ck179 = 1.0 time = 900
* CHECK dout0_6 vdout0_6ck179 = 1.0 time = 900
* CHECK dout0_7 vdout0_7ck179 = 1.0 time = 900
* CHECK dout0_8 vdout0_8ck179 = 1.0 time = 900
* CHECK dout0_9 vdout0_9ck179 = 1.0 time = 900
* CHECK dout0_10 vdout0_10ck179 = 0 time = 900
* CHECK dout0_11 vdout0_11ck179 = 1.0 time = 900
* CHECK dout0_12 vdout0_12ck179 = 0 time = 900
* CHECK dout0_13 vdout0_13ck179 = 0 time = 900
* CHECK dout0_14 vdout0_14ck179 = 0 time = 900
* CHECK dout0_15 vdout0_15ck179 = 0 time = 900
* CHECK dout0_16 vdout0_16ck179 = 0 time = 900
* CHECK dout0_17 vdout0_17ck179 = 0 time = 900
* CHECK dout0_18 vdout0_18ck179 = 1.0 time = 900
* CHECK dout0_19 vdout0_19ck179 = 1.0 time = 900
* CHECK dout0_20 vdout0_20ck179 = 1.0 time = 900
* CHECK dout0_21 vdout0_21ck179 = 0 time = 900
* CHECK dout0_22 vdout0_22ck179 = 0 time = 900
* CHECK dout0_23 vdout0_23ck179 = 1.0 time = 900
* CHECK dout0_24 vdout0_24ck179 = 1.0 time = 900
* CHECK dout0_25 vdout0_25ck179 = 0 time = 900
* CHECK dout0_26 vdout0_26ck179 = 1.0 time = 900
* CHECK dout0_27 vdout0_27ck179 = 1.0 time = 900
* CHECK dout0_28 vdout0_28ck179 = 0 time = 900
* CHECK dout0_29 vdout0_29ck179 = 0 time = 900
* CHECK dout0_30 vdout0_30ck179 = 0 time = 900
* CHECK dout0_31 vdout0_31ck179 = 0 time = 900
* CHECK dout0_32 vdout0_32ck179 = 1.0 time = 900
* CHECK dout0_33 vdout0_33ck179 = 0 time = 900
* CHECK dout0_34 vdout0_34ck179 = 0 time = 900
* CHECK dout0_35 vdout0_35ck179 = 1.0 time = 900
* CHECK dout0_36 vdout0_36ck179 = 1.0 time = 900
* CHECK dout0_37 vdout0_37ck179 = 0 time = 900
* CHECK dout0_38 vdout0_38ck179 = 0 time = 900
* CHECK dout0_39 vdout0_39ck179 = 0 time = 900
* CHECK dout0_40 vdout0_40ck179 = 1.0 time = 900
* CHECK dout0_41 vdout0_41ck179 = 0 time = 900
* CHECK dout0_42 vdout0_42ck179 = 0 time = 900
* CHECK dout0_43 vdout0_43ck179 = 0 time = 900
* CHECK dout0_44 vdout0_44ck179 = 0 time = 900
* CHECK dout0_45 vdout0_45ck179 = 1.0 time = 900
* CHECK dout0_46 vdout0_46ck179 = 0 time = 900
* CHECK dout0_47 vdout0_47ck179 = 0 time = 900
* CHECK dout0_48 vdout0_48ck179 = 0 time = 900
* CHECK dout0_49 vdout0_49ck179 = 0 time = 900
* CHECK dout0_50 vdout0_50ck179 = 1.0 time = 900
* CHECK dout0_51 vdout0_51ck179 = 1.0 time = 900
* CHECK dout0_52 vdout0_52ck179 = 0 time = 900
* CHECK dout0_53 vdout0_53ck179 = 0 time = 900
* CHECK dout0_54 vdout0_54ck179 = 0 time = 900
* CHECK dout0_55 vdout0_55ck179 = 1.0 time = 900
* CHECK dout0_56 vdout0_56ck179 = 0 time = 900
* CHECK dout0_57 vdout0_57ck179 = 0 time = 900
* CHECK dout0_58 vdout0_58ck179 = 0 time = 900
* CHECK dout0_59 vdout0_59ck179 = 0 time = 900
* CHECK dout0_60 vdout0_60ck179 = 0 time = 900
* CHECK dout0_61 vdout0_61ck179 = 1.0 time = 900
* CHECK dout0_62 vdout0_62ck179 = 0 time = 900
* CHECK dout0_63 vdout0_63ck179 = 0 time = 900
* CHECK dout1_0 vdout1_0ck179 = 0 time = 900
* CHECK dout1_1 vdout1_1ck179 = 0 time = 900
* CHECK dout1_2 vdout1_2ck179 = 0 time = 900
* CHECK dout1_3 vdout1_3ck179 = 1.0 time = 900
* CHECK dout1_4 vdout1_4ck179 = 1.0 time = 900
* CHECK dout1_5 vdout1_5ck179 = 0 time = 900
* CHECK dout1_6 vdout1_6ck179 = 0 time = 900
* CHECK dout1_7 vdout1_7ck179 = 0 time = 900
* CHECK dout1_8 vdout1_8ck179 = 0 time = 900
* CHECK dout1_9 vdout1_9ck179 = 0 time = 900
* CHECK dout1_10 vdout1_10ck179 = 0 time = 900
* CHECK dout1_11 vdout1_11ck179 = 0 time = 900
* CHECK dout1_12 vdout1_12ck179 = 1.0 time = 900
* CHECK dout1_13 vdout1_13ck179 = 0 time = 900
* CHECK dout1_14 vdout1_14ck179 = 1.0 time = 900
* CHECK dout1_15 vdout1_15ck179 = 1.0 time = 900
* CHECK dout1_16 vdout1_16ck179 = 0 time = 900
* CHECK dout1_17 vdout1_17ck179 = 1.0 time = 900
* CHECK dout1_18 vdout1_18ck179 = 0 time = 900
* CHECK dout1_19 vdout1_19ck179 = 1.0 time = 900
* CHECK dout1_20 vdout1_20ck179 = 1.0 time = 900
* CHECK dout1_21 vdout1_21ck179 = 0 time = 900
* CHECK dout1_22 vdout1_22ck179 = 1.0 time = 900
* CHECK dout1_23 vdout1_23ck179 = 1.0 time = 900
* CHECK dout1_24 vdout1_24ck179 = 0 time = 900
* CHECK dout1_25 vdout1_25ck179 = 1.0 time = 900
* CHECK dout1_26 vdout1_26ck179 = 1.0 time = 900
* CHECK dout1_27 vdout1_27ck179 = 1.0 time = 900
* CHECK dout1_28 vdout1_28ck179 = 0 time = 900
* CHECK dout1_29 vdout1_29ck179 = 0 time = 900
* CHECK dout1_30 vdout1_30ck179 = 0 time = 900
* CHECK dout1_31 vdout1_31ck179 = 1.0 time = 900
* CHECK dout1_32 vdout1_32ck179 = 0 time = 900
* CHECK dout1_33 vdout1_33ck179 = 1.0 time = 900
* CHECK dout1_34 vdout1_34ck179 = 1.0 time = 900
* CHECK dout1_35 vdout1_35ck179 = 0 time = 900
* CHECK dout1_36 vdout1_36ck179 = 0 time = 900
* CHECK dout1_37 vdout1_37ck179 = 0 time = 900
* CHECK dout1_38 vdout1_38ck179 = 0 time = 900
* CHECK dout1_39 vdout1_39ck179 = 1.0 time = 900
* CHECK dout1_40 vdout1_40ck179 = 0 time = 900
* CHECK dout1_41 vdout1_41ck179 = 0 time = 900
* CHECK dout1_42 vdout1_42ck179 = 0 time = 900
* CHECK dout1_43 vdout1_43ck179 = 0 time = 900
* CHECK dout1_44 vdout1_44ck179 = 1.0 time = 900
* CHECK dout1_45 vdout1_45ck179 = 1.0 time = 900
* CHECK dout1_46 vdout1_46ck179 = 1.0 time = 900
* CHECK dout1_47 vdout1_47ck179 = 0 time = 900
* CHECK dout1_48 vdout1_48ck179 = 1.0 time = 900
* CHECK dout1_49 vdout1_49ck179 = 0 time = 900
* CHECK dout1_50 vdout1_50ck179 = 1.0 time = 900
* CHECK dout1_51 vdout1_51ck179 = 0 time = 900
* CHECK dout1_52 vdout1_52ck179 = 0 time = 900
* CHECK dout1_53 vdout1_53ck179 = 1.0 time = 900
* CHECK dout1_54 vdout1_54ck179 = 0 time = 900
* CHECK dout1_55 vdout1_55ck179 = 1.0 time = 900
* CHECK dout1_56 vdout1_56ck179 = 0 time = 900
* CHECK dout1_57 vdout1_57ck179 = 1.0 time = 900
* CHECK dout1_58 vdout1_58ck179 = 1.0 time = 900
* CHECK dout1_59 vdout1_59ck179 = 1.0 time = 900
* CHECK dout1_60 vdout1_60ck179 = 0 time = 900
* CHECK dout1_61 vdout1_61ck179 = 0 time = 900
* CHECK dout1_62 vdout1_62ck179 = 0 time = 900
* CHECK dout1_63 vdout1_63ck179 = 0 time = 900
* CHECK dout0_0 vdout0_0ck180 = 1.0 time = 905
* CHECK dout0_1 vdout0_1ck180 = 0 time = 905
* CHECK dout0_2 vdout0_2ck180 = 0 time = 905
* CHECK dout0_3 vdout0_3ck180 = 0 time = 905
* CHECK dout0_4 vdout0_4ck180 = 1.0 time = 905
* CHECK dout0_5 vdout0_5ck180 = 0 time = 905
* CHECK dout0_6 vdout0_6ck180 = 1.0 time = 905
* CHECK dout0_7 vdout0_7ck180 = 1.0 time = 905
* CHECK dout0_8 vdout0_8ck180 = 0 time = 905
* CHECK dout0_9 vdout0_9ck180 = 0 time = 905
* CHECK dout0_10 vdout0_10ck180 = 0 time = 905
* CHECK dout0_11 vdout0_11ck180 = 0 time = 905
* CHECK dout0_12 vdout0_12ck180 = 1.0 time = 905
* CHECK dout0_13 vdout0_13ck180 = 0 time = 905
* CHECK dout0_14 vdout0_14ck180 = 0 time = 905
* CHECK dout0_15 vdout0_15ck180 = 1.0 time = 905
* CHECK dout0_16 vdout0_16ck180 = 0 time = 905
* CHECK dout0_17 vdout0_17ck180 = 0 time = 905
* CHECK dout0_18 vdout0_18ck180 = 1.0 time = 905
* CHECK dout0_19 vdout0_19ck180 = 1.0 time = 905
* CHECK dout0_20 vdout0_20ck180 = 0 time = 905
* CHECK dout0_21 vdout0_21ck180 = 1.0 time = 905
* CHECK dout0_22 vdout0_22ck180 = 0 time = 905
* CHECK dout0_23 vdout0_23ck180 = 0 time = 905
* CHECK dout0_24 vdout0_24ck180 = 0 time = 905
* CHECK dout0_25 vdout0_25ck180 = 1.0 time = 905
* CHECK dout0_26 vdout0_26ck180 = 0 time = 905
* CHECK dout0_27 vdout0_27ck180 = 0 time = 905
* CHECK dout0_28 vdout0_28ck180 = 1.0 time = 905
* CHECK dout0_29 vdout0_29ck180 = 1.0 time = 905
* CHECK dout0_30 vdout0_30ck180 = 1.0 time = 905
* CHECK dout0_31 vdout0_31ck180 = 1.0 time = 905
* CHECK dout0_32 vdout0_32ck180 = 1.0 time = 905
* CHECK dout0_33 vdout0_33ck180 = 1.0 time = 905
* CHECK dout0_34 vdout0_34ck180 = 0 time = 905
* CHECK dout0_35 vdout0_35ck180 = 0 time = 905
* CHECK dout0_36 vdout0_36ck180 = 1.0 time = 905
* CHECK dout0_37 vdout0_37ck180 = 0 time = 905
* CHECK dout0_38 vdout0_38ck180 = 1.0 time = 905
* CHECK dout0_39 vdout0_39ck180 = 1.0 time = 905
* CHECK dout0_40 vdout0_40ck180 = 1.0 time = 905
* CHECK dout0_41 vdout0_41ck180 = 1.0 time = 905
* CHECK dout0_42 vdout0_42ck180 = 1.0 time = 905
* CHECK dout0_43 vdout0_43ck180 = 1.0 time = 905
* CHECK dout0_44 vdout0_44ck180 = 0 time = 905
* CHECK dout0_45 vdout0_45ck180 = 1.0 time = 905
* CHECK dout0_46 vdout0_46ck180 = 1.0 time = 905
* CHECK dout0_47 vdout0_47ck180 = 0 time = 905
* CHECK dout0_48 vdout0_48ck180 = 1.0 time = 905
* CHECK dout0_49 vdout0_49ck180 = 0 time = 905
* CHECK dout0_50 vdout0_50ck180 = 0 time = 905
* CHECK dout0_51 vdout0_51ck180 = 0 time = 905
* CHECK dout0_52 vdout0_52ck180 = 1.0 time = 905
* CHECK dout0_53 vdout0_53ck180 = 0 time = 905
* CHECK dout0_54 vdout0_54ck180 = 1.0 time = 905
* CHECK dout0_55 vdout0_55ck180 = 0 time = 905
* CHECK dout0_56 vdout0_56ck180 = 1.0 time = 905
* CHECK dout0_57 vdout0_57ck180 = 0 time = 905
* CHECK dout0_58 vdout0_58ck180 = 0 time = 905
* CHECK dout0_59 vdout0_59ck180 = 0 time = 905
* CHECK dout0_60 vdout0_60ck180 = 1.0 time = 905
* CHECK dout0_61 vdout0_61ck180 = 1.0 time = 905
* CHECK dout0_62 vdout0_62ck180 = 1.0 time = 905
* CHECK dout0_63 vdout0_63ck180 = 1.0 time = 905
* CHECK dout0_0 vdout0_0ck181 = 1.0 time = 910
* CHECK dout0_1 vdout0_1ck181 = 1.0 time = 910
* CHECK dout0_2 vdout0_2ck181 = 1.0 time = 910
* CHECK dout0_3 vdout0_3ck181 = 1.0 time = 910
* CHECK dout0_4 vdout0_4ck181 = 1.0 time = 910
* CHECK dout0_5 vdout0_5ck181 = 0 time = 910
* CHECK dout0_6 vdout0_6ck181 = 0 time = 910
* CHECK dout0_7 vdout0_7ck181 = 1.0 time = 910
* CHECK dout0_8 vdout0_8ck181 = 1.0 time = 910
* CHECK dout0_9 vdout0_9ck181 = 0 time = 910
* CHECK dout0_10 vdout0_10ck181 = 0 time = 910
* CHECK dout0_11 vdout0_11ck181 = 1.0 time = 910
* CHECK dout0_12 vdout0_12ck181 = 1.0 time = 910
* CHECK dout0_13 vdout0_13ck181 = 0 time = 910
* CHECK dout0_14 vdout0_14ck181 = 1.0 time = 910
* CHECK dout0_15 vdout0_15ck181 = 0 time = 910
* CHECK dout0_16 vdout0_16ck181 = 1.0 time = 910
* CHECK dout0_17 vdout0_17ck181 = 0 time = 910
* CHECK dout0_18 vdout0_18ck181 = 0 time = 910
* CHECK dout0_19 vdout0_19ck181 = 1.0 time = 910
* CHECK dout0_20 vdout0_20ck181 = 0 time = 910
* CHECK dout0_21 vdout0_21ck181 = 0 time = 910
* CHECK dout0_22 vdout0_22ck181 = 0 time = 910
* CHECK dout0_23 vdout0_23ck181 = 1.0 time = 910
* CHECK dout0_24 vdout0_24ck181 = 0 time = 910
* CHECK dout0_25 vdout0_25ck181 = 0 time = 910
* CHECK dout0_26 vdout0_26ck181 = 0 time = 910
* CHECK dout0_27 vdout0_27ck181 = 0 time = 910
* CHECK dout0_28 vdout0_28ck181 = 1.0 time = 910
* CHECK dout0_29 vdout0_29ck181 = 0 time = 910
* CHECK dout0_30 vdout0_30ck181 = 1.0 time = 910
* CHECK dout0_31 vdout0_31ck181 = 0 time = 910
* CHECK dout0_32 vdout0_32ck181 = 1.0 time = 910
* CHECK dout0_33 vdout0_33ck181 = 1.0 time = 910
* CHECK dout0_34 vdout0_34ck181 = 0 time = 910
* CHECK dout0_35 vdout0_35ck181 = 1.0 time = 910
* CHECK dout0_36 vdout0_36ck181 = 1.0 time = 910
* CHECK dout0_37 vdout0_37ck181 = 1.0 time = 910
* CHECK dout0_38 vdout0_38ck181 = 1.0 time = 910
* CHECK dout0_39 vdout0_39ck181 = 1.0 time = 910
* CHECK dout0_40 vdout0_40ck181 = 1.0 time = 910
* CHECK dout0_41 vdout0_41ck181 = 1.0 time = 910
* CHECK dout0_42 vdout0_42ck181 = 0 time = 910
* CHECK dout0_43 vdout0_43ck181 = 0 time = 910
* CHECK dout0_44 vdout0_44ck181 = 1.0 time = 910
* CHECK dout0_45 vdout0_45ck181 = 1.0 time = 910
* CHECK dout0_46 vdout0_46ck181 = 0 time = 910
* CHECK dout0_47 vdout0_47ck181 = 0 time = 910
* CHECK dout0_48 vdout0_48ck181 = 1.0 time = 910
* CHECK dout0_49 vdout0_49ck181 = 0 time = 910
* CHECK dout0_50 vdout0_50ck181 = 1.0 time = 910
* CHECK dout0_51 vdout0_51ck181 = 1.0 time = 910
* CHECK dout0_52 vdout0_52ck181 = 0 time = 910
* CHECK dout0_53 vdout0_53ck181 = 1.0 time = 910
* CHECK dout0_54 vdout0_54ck181 = 1.0 time = 910
* CHECK dout0_55 vdout0_55ck181 = 1.0 time = 910
* CHECK dout0_56 vdout0_56ck181 = 0 time = 910
* CHECK dout0_57 vdout0_57ck181 = 1.0 time = 910
* CHECK dout0_58 vdout0_58ck181 = 1.0 time = 910
* CHECK dout0_59 vdout0_59ck181 = 0 time = 910
* CHECK dout0_60 vdout0_60ck181 = 0 time = 910
* CHECK dout0_61 vdout0_61ck181 = 1.0 time = 910
* CHECK dout0_62 vdout0_62ck181 = 1.0 time = 910
* CHECK dout0_63 vdout0_63ck181 = 1.0 time = 910
* CHECK dout1_0 vdout1_0ck183 = 1.0 time = 920
* CHECK dout1_1 vdout1_1ck183 = 1.0 time = 920
* CHECK dout1_2 vdout1_2ck183 = 1.0 time = 920
* CHECK dout1_3 vdout1_3ck183 = 1.0 time = 920
* CHECK dout1_4 vdout1_4ck183 = 0 time = 920
* CHECK dout1_5 vdout1_5ck183 = 1.0 time = 920
* CHECK dout1_6 vdout1_6ck183 = 0 time = 920
* CHECK dout1_7 vdout1_7ck183 = 0 time = 920
* CHECK dout1_8 vdout1_8ck183 = 0 time = 920
* CHECK dout1_9 vdout1_9ck183 = 0 time = 920
* CHECK dout1_10 vdout1_10ck183 = 1.0 time = 920
* CHECK dout1_11 vdout1_11ck183 = 1.0 time = 920
* CHECK dout1_12 vdout1_12ck183 = 0 time = 920
* CHECK dout1_13 vdout1_13ck183 = 0 time = 920
* CHECK dout1_14 vdout1_14ck183 = 1.0 time = 920
* CHECK dout1_15 vdout1_15ck183 = 1.0 time = 920
* CHECK dout1_16 vdout1_16ck183 = 0 time = 920
* CHECK dout1_17 vdout1_17ck183 = 1.0 time = 920
* CHECK dout1_18 vdout1_18ck183 = 0 time = 920
* CHECK dout1_19 vdout1_19ck183 = 1.0 time = 920
* CHECK dout1_20 vdout1_20ck183 = 0 time = 920
* CHECK dout1_21 vdout1_21ck183 = 1.0 time = 920
* CHECK dout1_22 vdout1_22ck183 = 1.0 time = 920
* CHECK dout1_23 vdout1_23ck183 = 1.0 time = 920
* CHECK dout1_24 vdout1_24ck183 = 0 time = 920
* CHECK dout1_25 vdout1_25ck183 = 0 time = 920
* CHECK dout1_26 vdout1_26ck183 = 0 time = 920
* CHECK dout1_27 vdout1_27ck183 = 0 time = 920
* CHECK dout1_28 vdout1_28ck183 = 1.0 time = 920
* CHECK dout1_29 vdout1_29ck183 = 0 time = 920
* CHECK dout1_30 vdout1_30ck183 = 1.0 time = 920
* CHECK dout1_31 vdout1_31ck183 = 1.0 time = 920
* CHECK dout1_32 vdout1_32ck183 = 1.0 time = 920
* CHECK dout1_33 vdout1_33ck183 = 0 time = 920
* CHECK dout1_34 vdout1_34ck183 = 1.0 time = 920
* CHECK dout1_35 vdout1_35ck183 = 0 time = 920
* CHECK dout1_36 vdout1_36ck183 = 0 time = 920
* CHECK dout1_37 vdout1_37ck183 = 1.0 time = 920
* CHECK dout1_38 vdout1_38ck183 = 1.0 time = 920
* CHECK dout1_39 vdout1_39ck183 = 1.0 time = 920
* CHECK dout1_40 vdout1_40ck183 = 0 time = 920
* CHECK dout1_41 vdout1_41ck183 = 1.0 time = 920
* CHECK dout1_42 vdout1_42ck183 = 1.0 time = 920
* CHECK dout1_43 vdout1_43ck183 = 0 time = 920
* CHECK dout1_44 vdout1_44ck183 = 0 time = 920
* CHECK dout1_45 vdout1_45ck183 = 1.0 time = 920
* CHECK dout1_46 vdout1_46ck183 = 0 time = 920
* CHECK dout1_47 vdout1_47ck183 = 1.0 time = 920
* CHECK dout1_48 vdout1_48ck183 = 0 time = 920
* CHECK dout1_49 vdout1_49ck183 = 0 time = 920
* CHECK dout1_50 vdout1_50ck183 = 1.0 time = 920
* CHECK dout1_51 vdout1_51ck183 = 1.0 time = 920
* CHECK dout1_52 vdout1_52ck183 = 1.0 time = 920
* CHECK dout1_53 vdout1_53ck183 = 1.0 time = 920
* CHECK dout1_54 vdout1_54ck183 = 0 time = 920
* CHECK dout1_55 vdout1_55ck183 = 1.0 time = 920
* CHECK dout1_56 vdout1_56ck183 = 1.0 time = 920
* CHECK dout1_57 vdout1_57ck183 = 0 time = 920
* CHECK dout1_58 vdout1_58ck183 = 1.0 time = 920
* CHECK dout1_59 vdout1_59ck183 = 1.0 time = 920
* CHECK dout1_60 vdout1_60ck183 = 0 time = 920
* CHECK dout1_61 vdout1_61ck183 = 1.0 time = 920
* CHECK dout1_62 vdout1_62ck183 = 1.0 time = 920
* CHECK dout1_63 vdout1_63ck183 = 0 time = 920
* CHECK dout1_0 vdout1_0ck184 = 1.0 time = 925
* CHECK dout1_1 vdout1_1ck184 = 1.0 time = 925
* CHECK dout1_2 vdout1_2ck184 = 0 time = 925
* CHECK dout1_3 vdout1_3ck184 = 0 time = 925
* CHECK dout1_4 vdout1_4ck184 = 1.0 time = 925
* CHECK dout1_5 vdout1_5ck184 = 1.0 time = 925
* CHECK dout1_6 vdout1_6ck184 = 1.0 time = 925
* CHECK dout1_7 vdout1_7ck184 = 0 time = 925
* CHECK dout1_8 vdout1_8ck184 = 1.0 time = 925
* CHECK dout1_9 vdout1_9ck184 = 0 time = 925
* CHECK dout1_10 vdout1_10ck184 = 1.0 time = 925
* CHECK dout1_11 vdout1_11ck184 = 1.0 time = 925
* CHECK dout1_12 vdout1_12ck184 = 1.0 time = 925
* CHECK dout1_13 vdout1_13ck184 = 1.0 time = 925
* CHECK dout1_14 vdout1_14ck184 = 1.0 time = 925
* CHECK dout1_15 vdout1_15ck184 = 1.0 time = 925
* CHECK dout1_16 vdout1_16ck184 = 1.0 time = 925
* CHECK dout1_17 vdout1_17ck184 = 0 time = 925
* CHECK dout1_18 vdout1_18ck184 = 1.0 time = 925
* CHECK dout1_19 vdout1_19ck184 = 0 time = 925
* CHECK dout1_20 vdout1_20ck184 = 0 time = 925
* CHECK dout1_21 vdout1_21ck184 = 0 time = 925
* CHECK dout1_22 vdout1_22ck184 = 0 time = 925
* CHECK dout1_23 vdout1_23ck184 = 0 time = 925
* CHECK dout1_24 vdout1_24ck184 = 0 time = 925
* CHECK dout1_25 vdout1_25ck184 = 1.0 time = 925
* CHECK dout1_26 vdout1_26ck184 = 0 time = 925
* CHECK dout1_27 vdout1_27ck184 = 1.0 time = 925
* CHECK dout1_28 vdout1_28ck184 = 0 time = 925
* CHECK dout1_29 vdout1_29ck184 = 0 time = 925
* CHECK dout1_30 vdout1_30ck184 = 0 time = 925
* CHECK dout1_31 vdout1_31ck184 = 1.0 time = 925
* CHECK dout1_32 vdout1_32ck184 = 0 time = 925
* CHECK dout1_33 vdout1_33ck184 = 1.0 time = 925
* CHECK dout1_34 vdout1_34ck184 = 1.0 time = 925
* CHECK dout1_35 vdout1_35ck184 = 0 time = 925
* CHECK dout1_36 vdout1_36ck184 = 1.0 time = 925
* CHECK dout1_37 vdout1_37ck184 = 1.0 time = 925
* CHECK dout1_38 vdout1_38ck184 = 0 time = 925
* CHECK dout1_39 vdout1_39ck184 = 0 time = 925
* CHECK dout1_40 vdout1_40ck184 = 1.0 time = 925
* CHECK dout1_41 vdout1_41ck184 = 0 time = 925
* CHECK dout1_42 vdout1_42ck184 = 1.0 time = 925
* CHECK dout1_43 vdout1_43ck184 = 1.0 time = 925
* CHECK dout1_44 vdout1_44ck184 = 0 time = 925
* CHECK dout1_45 vdout1_45ck184 = 0 time = 925
* CHECK dout1_46 vdout1_46ck184 = 1.0 time = 925
* CHECK dout1_47 vdout1_47ck184 = 0 time = 925
* CHECK dout1_48 vdout1_48ck184 = 0 time = 925
* CHECK dout1_49 vdout1_49ck184 = 0 time = 925
* CHECK dout1_50 vdout1_50ck184 = 0 time = 925
* CHECK dout1_51 vdout1_51ck184 = 1.0 time = 925
* CHECK dout1_52 vdout1_52ck184 = 1.0 time = 925
* CHECK dout1_53 vdout1_53ck184 = 0 time = 925
* CHECK dout1_54 vdout1_54ck184 = 0 time = 925
* CHECK dout1_55 vdout1_55ck184 = 1.0 time = 925
* CHECK dout1_56 vdout1_56ck184 = 1.0 time = 925
* CHECK dout1_57 vdout1_57ck184 = 1.0 time = 925
* CHECK dout1_58 vdout1_58ck184 = 0 time = 925
* CHECK dout1_59 vdout1_59ck184 = 1.0 time = 925
* CHECK dout1_60 vdout1_60ck184 = 1.0 time = 925
* CHECK dout1_61 vdout1_61ck184 = 1.0 time = 925
* CHECK dout1_62 vdout1_62ck184 = 1.0 time = 925
* CHECK dout1_63 vdout1_63ck184 = 1.0 time = 925
* CHECK dout0_0 vdout0_0ck185 = 1.0 time = 930
* CHECK dout0_1 vdout0_1ck185 = 0 time = 930
* CHECK dout0_2 vdout0_2ck185 = 0 time = 930
* CHECK dout0_3 vdout0_3ck185 = 0 time = 930
* CHECK dout0_4 vdout0_4ck185 = 1.0 time = 930
* CHECK dout0_5 vdout0_5ck185 = 0 time = 930
* CHECK dout0_6 vdout0_6ck185 = 1.0 time = 930
* CHECK dout0_7 vdout0_7ck185 = 1.0 time = 930
* CHECK dout0_8 vdout0_8ck185 = 0 time = 930
* CHECK dout0_9 vdout0_9ck185 = 0 time = 930
* CHECK dout0_10 vdout0_10ck185 = 0 time = 930
* CHECK dout0_11 vdout0_11ck185 = 0 time = 930
* CHECK dout0_12 vdout0_12ck185 = 1.0 time = 930
* CHECK dout0_13 vdout0_13ck185 = 0 time = 930
* CHECK dout0_14 vdout0_14ck185 = 0 time = 930
* CHECK dout0_15 vdout0_15ck185 = 1.0 time = 930
* CHECK dout0_16 vdout0_16ck185 = 0 time = 930
* CHECK dout0_17 vdout0_17ck185 = 0 time = 930
* CHECK dout0_18 vdout0_18ck185 = 1.0 time = 930
* CHECK dout0_19 vdout0_19ck185 = 1.0 time = 930
* CHECK dout0_20 vdout0_20ck185 = 0 time = 930
* CHECK dout0_21 vdout0_21ck185 = 1.0 time = 930
* CHECK dout0_22 vdout0_22ck185 = 0 time = 930
* CHECK dout0_23 vdout0_23ck185 = 0 time = 930
* CHECK dout0_24 vdout0_24ck185 = 0 time = 930
* CHECK dout0_25 vdout0_25ck185 = 1.0 time = 930
* CHECK dout0_26 vdout0_26ck185 = 0 time = 930
* CHECK dout0_27 vdout0_27ck185 = 0 time = 930
* CHECK dout0_28 vdout0_28ck185 = 1.0 time = 930
* CHECK dout0_29 vdout0_29ck185 = 1.0 time = 930
* CHECK dout0_30 vdout0_30ck185 = 1.0 time = 930
* CHECK dout0_31 vdout0_31ck185 = 1.0 time = 930
* CHECK dout0_32 vdout0_32ck185 = 1.0 time = 930
* CHECK dout0_33 vdout0_33ck185 = 1.0 time = 930
* CHECK dout0_34 vdout0_34ck185 = 0 time = 930
* CHECK dout0_35 vdout0_35ck185 = 0 time = 930
* CHECK dout0_36 vdout0_36ck185 = 1.0 time = 930
* CHECK dout0_37 vdout0_37ck185 = 0 time = 930
* CHECK dout0_38 vdout0_38ck185 = 1.0 time = 930
* CHECK dout0_39 vdout0_39ck185 = 1.0 time = 930
* CHECK dout0_40 vdout0_40ck185 = 1.0 time = 930
* CHECK dout0_41 vdout0_41ck185 = 1.0 time = 930
* CHECK dout0_42 vdout0_42ck185 = 1.0 time = 930
* CHECK dout0_43 vdout0_43ck185 = 1.0 time = 930
* CHECK dout0_44 vdout0_44ck185 = 0 time = 930
* CHECK dout0_45 vdout0_45ck185 = 1.0 time = 930
* CHECK dout0_46 vdout0_46ck185 = 1.0 time = 930
* CHECK dout0_47 vdout0_47ck185 = 0 time = 930
* CHECK dout0_48 vdout0_48ck185 = 1.0 time = 930
* CHECK dout0_49 vdout0_49ck185 = 0 time = 930
* CHECK dout0_50 vdout0_50ck185 = 0 time = 930
* CHECK dout0_51 vdout0_51ck185 = 0 time = 930
* CHECK dout0_52 vdout0_52ck185 = 1.0 time = 930
* CHECK dout0_53 vdout0_53ck185 = 0 time = 930
* CHECK dout0_54 vdout0_54ck185 = 1.0 time = 930
* CHECK dout0_55 vdout0_55ck185 = 0 time = 930
* CHECK dout0_56 vdout0_56ck185 = 1.0 time = 930
* CHECK dout0_57 vdout0_57ck185 = 0 time = 930
* CHECK dout0_58 vdout0_58ck185 = 0 time = 930
* CHECK dout0_59 vdout0_59ck185 = 0 time = 930
* CHECK dout0_60 vdout0_60ck185 = 1.0 time = 930
* CHECK dout0_61 vdout0_61ck185 = 1.0 time = 930
* CHECK dout0_62 vdout0_62ck185 = 1.0 time = 930
* CHECK dout0_63 vdout0_63ck185 = 1.0 time = 930
* CHECK dout0_0 vdout0_0ck188 = 1.0 time = 945
* CHECK dout0_1 vdout0_1ck188 = 1.0 time = 945
* CHECK dout0_2 vdout0_2ck188 = 0 time = 945
* CHECK dout0_3 vdout0_3ck188 = 1.0 time = 945
* CHECK dout0_4 vdout0_4ck188 = 0 time = 945
* CHECK dout0_5 vdout0_5ck188 = 1.0 time = 945
* CHECK dout0_6 vdout0_6ck188 = 0 time = 945
* CHECK dout0_7 vdout0_7ck188 = 1.0 time = 945
* CHECK dout0_8 vdout0_8ck188 = 1.0 time = 945
* CHECK dout0_9 vdout0_9ck188 = 1.0 time = 945
* CHECK dout0_10 vdout0_10ck188 = 1.0 time = 945
* CHECK dout0_11 vdout0_11ck188 = 1.0 time = 945
* CHECK dout0_12 vdout0_12ck188 = 0 time = 945
* CHECK dout0_13 vdout0_13ck188 = 1.0 time = 945
* CHECK dout0_14 vdout0_14ck188 = 0 time = 945
* CHECK dout0_15 vdout0_15ck188 = 1.0 time = 945
* CHECK dout0_16 vdout0_16ck188 = 1.0 time = 945
* CHECK dout0_17 vdout0_17ck188 = 1.0 time = 945
* CHECK dout0_18 vdout0_18ck188 = 1.0 time = 945
* CHECK dout0_19 vdout0_19ck188 = 1.0 time = 945
* CHECK dout0_20 vdout0_20ck188 = 0 time = 945
* CHECK dout0_21 vdout0_21ck188 = 1.0 time = 945
* CHECK dout0_22 vdout0_22ck188 = 0 time = 945
* CHECK dout0_23 vdout0_23ck188 = 1.0 time = 945
* CHECK dout0_24 vdout0_24ck188 = 1.0 time = 945
* CHECK dout0_25 vdout0_25ck188 = 0 time = 945
* CHECK dout0_26 vdout0_26ck188 = 0 time = 945
* CHECK dout0_27 vdout0_27ck188 = 1.0 time = 945
* CHECK dout0_28 vdout0_28ck188 = 0 time = 945
* CHECK dout0_29 vdout0_29ck188 = 1.0 time = 945
* CHECK dout0_30 vdout0_30ck188 = 1.0 time = 945
* CHECK dout0_31 vdout0_31ck188 = 1.0 time = 945
* CHECK dout0_32 vdout0_32ck188 = 0 time = 945
* CHECK dout0_33 vdout0_33ck188 = 0 time = 945
* CHECK dout0_34 vdout0_34ck188 = 1.0 time = 945
* CHECK dout0_35 vdout0_35ck188 = 0 time = 945
* CHECK dout0_36 vdout0_36ck188 = 0 time = 945
* CHECK dout0_37 vdout0_37ck188 = 1.0 time = 945
* CHECK dout0_38 vdout0_38ck188 = 1.0 time = 945
* CHECK dout0_39 vdout0_39ck188 = 0 time = 945
* CHECK dout0_40 vdout0_40ck188 = 1.0 time = 945
* CHECK dout0_41 vdout0_41ck188 = 1.0 time = 945
* CHECK dout0_42 vdout0_42ck188 = 1.0 time = 945
* CHECK dout0_43 vdout0_43ck188 = 1.0 time = 945
* CHECK dout0_44 vdout0_44ck188 = 0 time = 945
* CHECK dout0_45 vdout0_45ck188 = 0 time = 945
* CHECK dout0_46 vdout0_46ck188 = 1.0 time = 945
* CHECK dout0_47 vdout0_47ck188 = 1.0 time = 945
* CHECK dout0_48 vdout0_48ck188 = 1.0 time = 945
* CHECK dout0_49 vdout0_49ck188 = 1.0 time = 945
* CHECK dout0_50 vdout0_50ck188 = 1.0 time = 945
* CHECK dout0_51 vdout0_51ck188 = 0 time = 945
* CHECK dout0_52 vdout0_52ck188 = 0 time = 945
* CHECK dout0_53 vdout0_53ck188 = 0 time = 945
* CHECK dout0_54 vdout0_54ck188 = 0 time = 945
* CHECK dout0_55 vdout0_55ck188 = 0 time = 945
* CHECK dout0_56 vdout0_56ck188 = 1.0 time = 945
* CHECK dout0_57 vdout0_57ck188 = 0 time = 945
* CHECK dout0_58 vdout0_58ck188 = 0 time = 945
* CHECK dout0_59 vdout0_59ck188 = 1.0 time = 945
* CHECK dout0_60 vdout0_60ck188 = 1.0 time = 945
* CHECK dout0_61 vdout0_61ck188 = 0 time = 945
* CHECK dout0_62 vdout0_62ck188 = 0 time = 945
* CHECK dout0_63 vdout0_63ck188 = 1.0 time = 945
* CHECK dout1_0 vdout1_0ck188 = 0 time = 945
* CHECK dout1_1 vdout1_1ck188 = 1.0 time = 945
* CHECK dout1_2 vdout1_2ck188 = 0 time = 945
* CHECK dout1_3 vdout1_3ck188 = 0 time = 945
* CHECK dout1_4 vdout1_4ck188 = 0 time = 945
* CHECK dout1_5 vdout1_5ck188 = 1.0 time = 945
* CHECK dout1_6 vdout1_6ck188 = 1.0 time = 945
* CHECK dout1_7 vdout1_7ck188 = 0 time = 945
* CHECK dout1_8 vdout1_8ck188 = 0 time = 945
* CHECK dout1_9 vdout1_9ck188 = 0 time = 945
* CHECK dout1_10 vdout1_10ck188 = 0 time = 945
* CHECK dout1_11 vdout1_11ck188 = 0 time = 945
* CHECK dout1_12 vdout1_12ck188 = 0 time = 945
* CHECK dout1_13 vdout1_13ck188 = 1.0 time = 945
* CHECK dout1_14 vdout1_14ck188 = 0 time = 945
* CHECK dout1_15 vdout1_15ck188 = 0 time = 945
* CHECK dout1_16 vdout1_16ck188 = 0 time = 945
* CHECK dout1_17 vdout1_17ck188 = 0 time = 945
* CHECK dout1_18 vdout1_18ck188 = 1.0 time = 945
* CHECK dout1_19 vdout1_19ck188 = 0 time = 945
* CHECK dout1_20 vdout1_20ck188 = 0 time = 945
* CHECK dout1_21 vdout1_21ck188 = 0 time = 945
* CHECK dout1_22 vdout1_22ck188 = 0 time = 945
* CHECK dout1_23 vdout1_23ck188 = 0 time = 945
* CHECK dout1_24 vdout1_24ck188 = 0 time = 945
* CHECK dout1_25 vdout1_25ck188 = 1.0 time = 945
* CHECK dout1_26 vdout1_26ck188 = 0 time = 945
* CHECK dout1_27 vdout1_27ck188 = 0 time = 945
* CHECK dout1_28 vdout1_28ck188 = 1.0 time = 945
* CHECK dout1_29 vdout1_29ck188 = 1.0 time = 945
* CHECK dout1_30 vdout1_30ck188 = 1.0 time = 945
* CHECK dout1_31 vdout1_31ck188 = 1.0 time = 945
* CHECK dout1_32 vdout1_32ck188 = 0 time = 945
* CHECK dout1_33 vdout1_33ck188 = 0 time = 945
* CHECK dout1_34 vdout1_34ck188 = 1.0 time = 945
* CHECK dout1_35 vdout1_35ck188 = 1.0 time = 945
* CHECK dout1_36 vdout1_36ck188 = 1.0 time = 945
* CHECK dout1_37 vdout1_37ck188 = 1.0 time = 945
* CHECK dout1_38 vdout1_38ck188 = 1.0 time = 945
* CHECK dout1_39 vdout1_39ck188 = 1.0 time = 945
* CHECK dout1_40 vdout1_40ck188 = 1.0 time = 945
* CHECK dout1_41 vdout1_41ck188 = 1.0 time = 945
* CHECK dout1_42 vdout1_42ck188 = 1.0 time = 945
* CHECK dout1_43 vdout1_43ck188 = 1.0 time = 945
* CHECK dout1_44 vdout1_44ck188 = 0 time = 945
* CHECK dout1_45 vdout1_45ck188 = 1.0 time = 945
* CHECK dout1_46 vdout1_46ck188 = 0 time = 945
* CHECK dout1_47 vdout1_47ck188 = 0 time = 945
* CHECK dout1_48 vdout1_48ck188 = 1.0 time = 945
* CHECK dout1_49 vdout1_49ck188 = 1.0 time = 945
* CHECK dout1_50 vdout1_50ck188 = 1.0 time = 945
* CHECK dout1_51 vdout1_51ck188 = 0 time = 945
* CHECK dout1_52 vdout1_52ck188 = 1.0 time = 945
* CHECK dout1_53 vdout1_53ck188 = 1.0 time = 945
* CHECK dout1_54 vdout1_54ck188 = 1.0 time = 945
* CHECK dout1_55 vdout1_55ck188 = 0 time = 945
* CHECK dout1_56 vdout1_56ck188 = 0 time = 945
* CHECK dout1_57 vdout1_57ck188 = 1.0 time = 945
* CHECK dout1_58 vdout1_58ck188 = 1.0 time = 945
* CHECK dout1_59 vdout1_59ck188 = 1.0 time = 945
* CHECK dout1_60 vdout1_60ck188 = 1.0 time = 945
* CHECK dout1_61 vdout1_61ck188 = 1.0 time = 945
* CHECK dout1_62 vdout1_62ck188 = 1.0 time = 945
* CHECK dout1_63 vdout1_63ck188 = 0 time = 945
* CHECK dout0_0 vdout0_0ck189 = 1.0 time = 950
* CHECK dout0_1 vdout0_1ck189 = 1.0 time = 950
* CHECK dout0_2 vdout0_2ck189 = 0 time = 950
* CHECK dout0_3 vdout0_3ck189 = 0 time = 950
* CHECK dout0_4 vdout0_4ck189 = 1.0 time = 950
* CHECK dout0_5 vdout0_5ck189 = 1.0 time = 950
* CHECK dout0_6 vdout0_6ck189 = 1.0 time = 950
* CHECK dout0_7 vdout0_7ck189 = 0 time = 950
* CHECK dout0_8 vdout0_8ck189 = 1.0 time = 950
* CHECK dout0_9 vdout0_9ck189 = 0 time = 950
* CHECK dout0_10 vdout0_10ck189 = 1.0 time = 950
* CHECK dout0_11 vdout0_11ck189 = 1.0 time = 950
* CHECK dout0_12 vdout0_12ck189 = 1.0 time = 950
* CHECK dout0_13 vdout0_13ck189 = 1.0 time = 950
* CHECK dout0_14 vdout0_14ck189 = 1.0 time = 950
* CHECK dout0_15 vdout0_15ck189 = 1.0 time = 950
* CHECK dout0_16 vdout0_16ck189 = 1.0 time = 950
* CHECK dout0_17 vdout0_17ck189 = 0 time = 950
* CHECK dout0_18 vdout0_18ck189 = 1.0 time = 950
* CHECK dout0_19 vdout0_19ck189 = 0 time = 950
* CHECK dout0_20 vdout0_20ck189 = 0 time = 950
* CHECK dout0_21 vdout0_21ck189 = 0 time = 950
* CHECK dout0_22 vdout0_22ck189 = 0 time = 950
* CHECK dout0_23 vdout0_23ck189 = 0 time = 950
* CHECK dout0_24 vdout0_24ck189 = 0 time = 950
* CHECK dout0_25 vdout0_25ck189 = 1.0 time = 950
* CHECK dout0_26 vdout0_26ck189 = 0 time = 950
* CHECK dout0_27 vdout0_27ck189 = 1.0 time = 950
* CHECK dout0_28 vdout0_28ck189 = 0 time = 950
* CHECK dout0_29 vdout0_29ck189 = 0 time = 950
* CHECK dout0_30 vdout0_30ck189 = 0 time = 950
* CHECK dout0_31 vdout0_31ck189 = 1.0 time = 950
* CHECK dout0_32 vdout0_32ck189 = 0 time = 950
* CHECK dout0_33 vdout0_33ck189 = 1.0 time = 950
* CHECK dout0_34 vdout0_34ck189 = 1.0 time = 950
* CHECK dout0_35 vdout0_35ck189 = 0 time = 950
* CHECK dout0_36 vdout0_36ck189 = 1.0 time = 950
* CHECK dout0_37 vdout0_37ck189 = 1.0 time = 950
* CHECK dout0_38 vdout0_38ck189 = 0 time = 950
* CHECK dout0_39 vdout0_39ck189 = 0 time = 950
* CHECK dout0_40 vdout0_40ck189 = 1.0 time = 950
* CHECK dout0_41 vdout0_41ck189 = 0 time = 950
* CHECK dout0_42 vdout0_42ck189 = 1.0 time = 950
* CHECK dout0_43 vdout0_43ck189 = 1.0 time = 950
* CHECK dout0_44 vdout0_44ck189 = 0 time = 950
* CHECK dout0_45 vdout0_45ck189 = 0 time = 950
* CHECK dout0_46 vdout0_46ck189 = 1.0 time = 950
* CHECK dout0_47 vdout0_47ck189 = 0 time = 950
* CHECK dout0_48 vdout0_48ck189 = 0 time = 950
* CHECK dout0_49 vdout0_49ck189 = 0 time = 950
* CHECK dout0_50 vdout0_50ck189 = 0 time = 950
* CHECK dout0_51 vdout0_51ck189 = 1.0 time = 950
* CHECK dout0_52 vdout0_52ck189 = 1.0 time = 950
* CHECK dout0_53 vdout0_53ck189 = 0 time = 950
* CHECK dout0_54 vdout0_54ck189 = 0 time = 950
* CHECK dout0_55 vdout0_55ck189 = 1.0 time = 950
* CHECK dout0_56 vdout0_56ck189 = 1.0 time = 950
* CHECK dout0_57 vdout0_57ck189 = 1.0 time = 950
* CHECK dout0_58 vdout0_58ck189 = 0 time = 950
* CHECK dout0_59 vdout0_59ck189 = 1.0 time = 950
* CHECK dout0_60 vdout0_60ck189 = 1.0 time = 950
* CHECK dout0_61 vdout0_61ck189 = 1.0 time = 950
* CHECK dout0_62 vdout0_62ck189 = 1.0 time = 950
* CHECK dout0_63 vdout0_63ck189 = 1.0 time = 950
* CHECK dout1_0 vdout1_0ck190 = 1.0 time = 955
* CHECK dout1_1 vdout1_1ck190 = 0 time = 955
* CHECK dout1_2 vdout1_2ck190 = 0 time = 955
* CHECK dout1_3 vdout1_3ck190 = 0 time = 955
* CHECK dout1_4 vdout1_4ck190 = 1.0 time = 955
* CHECK dout1_5 vdout1_5ck190 = 0 time = 955
* CHECK dout1_6 vdout1_6ck190 = 1.0 time = 955
* CHECK dout1_7 vdout1_7ck190 = 1.0 time = 955
* CHECK dout1_8 vdout1_8ck190 = 0 time = 955
* CHECK dout1_9 vdout1_9ck190 = 0 time = 955
* CHECK dout1_10 vdout1_10ck190 = 0 time = 955
* CHECK dout1_11 vdout1_11ck190 = 0 time = 955
* CHECK dout1_12 vdout1_12ck190 = 1.0 time = 955
* CHECK dout1_13 vdout1_13ck190 = 0 time = 955
* CHECK dout1_14 vdout1_14ck190 = 0 time = 955
* CHECK dout1_15 vdout1_15ck190 = 1.0 time = 955
* CHECK dout1_16 vdout1_16ck190 = 0 time = 955
* CHECK dout1_17 vdout1_17ck190 = 0 time = 955
* CHECK dout1_18 vdout1_18ck190 = 1.0 time = 955
* CHECK dout1_19 vdout1_19ck190 = 1.0 time = 955
* CHECK dout1_20 vdout1_20ck190 = 0 time = 955
* CHECK dout1_21 vdout1_21ck190 = 1.0 time = 955
* CHECK dout1_22 vdout1_22ck190 = 0 time = 955
* CHECK dout1_23 vdout1_23ck190 = 0 time = 955
* CHECK dout1_24 vdout1_24ck190 = 0 time = 955
* CHECK dout1_25 vdout1_25ck190 = 1.0 time = 955
* CHECK dout1_26 vdout1_26ck190 = 0 time = 955
* CHECK dout1_27 vdout1_27ck190 = 0 time = 955
* CHECK dout1_28 vdout1_28ck190 = 1.0 time = 955
* CHECK dout1_29 vdout1_29ck190 = 1.0 time = 955
* CHECK dout1_30 vdout1_30ck190 = 1.0 time = 955
* CHECK dout1_31 vdout1_31ck190 = 1.0 time = 955
* CHECK dout1_32 vdout1_32ck190 = 1.0 time = 955
* CHECK dout1_33 vdout1_33ck190 = 1.0 time = 955
* CHECK dout1_34 vdout1_34ck190 = 0 time = 955
* CHECK dout1_35 vdout1_35ck190 = 0 time = 955
* CHECK dout1_36 vdout1_36ck190 = 1.0 time = 955
* CHECK dout1_37 vdout1_37ck190 = 0 time = 955
* CHECK dout1_38 vdout1_38ck190 = 1.0 time = 955
* CHECK dout1_39 vdout1_39ck190 = 1.0 time = 955
* CHECK dout1_40 vdout1_40ck190 = 1.0 time = 955
* CHECK dout1_41 vdout1_41ck190 = 1.0 time = 955
* CHECK dout1_42 vdout1_42ck190 = 1.0 time = 955
* CHECK dout1_43 vdout1_43ck190 = 1.0 time = 955
* CHECK dout1_44 vdout1_44ck190 = 0 time = 955
* CHECK dout1_45 vdout1_45ck190 = 1.0 time = 955
* CHECK dout1_46 vdout1_46ck190 = 1.0 time = 955
* CHECK dout1_47 vdout1_47ck190 = 0 time = 955
* CHECK dout1_48 vdout1_48ck190 = 1.0 time = 955
* CHECK dout1_49 vdout1_49ck190 = 0 time = 955
* CHECK dout1_50 vdout1_50ck190 = 0 time = 955
* CHECK dout1_51 vdout1_51ck190 = 0 time = 955
* CHECK dout1_52 vdout1_52ck190 = 1.0 time = 955
* CHECK dout1_53 vdout1_53ck190 = 0 time = 955
* CHECK dout1_54 vdout1_54ck190 = 1.0 time = 955
* CHECK dout1_55 vdout1_55ck190 = 0 time = 955
* CHECK dout1_56 vdout1_56ck190 = 1.0 time = 955
* CHECK dout1_57 vdout1_57ck190 = 0 time = 955
* CHECK dout1_58 vdout1_58ck190 = 0 time = 955
* CHECK dout1_59 vdout1_59ck190 = 0 time = 955
* CHECK dout1_60 vdout1_60ck190 = 1.0 time = 955
* CHECK dout1_61 vdout1_61ck190 = 1.0 time = 955
* CHECK dout1_62 vdout1_62ck190 = 1.0 time = 955
* CHECK dout1_63 vdout1_63ck190 = 1.0 time = 955
* CHECK dout0_0 vdout0_0ck191 = 0 time = 960
* CHECK dout0_1 vdout0_1ck191 = 0 time = 960
* CHECK dout0_2 vdout0_2ck191 = 0 time = 960
* CHECK dout0_3 vdout0_3ck191 = 1.0 time = 960
* CHECK dout0_4 vdout0_4ck191 = 0 time = 960
* CHECK dout0_5 vdout0_5ck191 = 0 time = 960
* CHECK dout0_6 vdout0_6ck191 = 0 time = 960
* CHECK dout0_7 vdout0_7ck191 = 1.0 time = 960
* CHECK dout0_8 vdout0_8ck191 = 0 time = 960
* CHECK dout0_9 vdout0_9ck191 = 0 time = 960
* CHECK dout0_10 vdout0_10ck191 = 1.0 time = 960
* CHECK dout0_11 vdout0_11ck191 = 1.0 time = 960
* CHECK dout0_12 vdout0_12ck191 = 1.0 time = 960
* CHECK dout0_13 vdout0_13ck191 = 1.0 time = 960
* CHECK dout0_14 vdout0_14ck191 = 1.0 time = 960
* CHECK dout0_15 vdout0_15ck191 = 0 time = 960
* CHECK dout0_16 vdout0_16ck191 = 0 time = 960
* CHECK dout0_17 vdout0_17ck191 = 1.0 time = 960
* CHECK dout0_18 vdout0_18ck191 = 1.0 time = 960
* CHECK dout0_19 vdout0_19ck191 = 0 time = 960
* CHECK dout0_20 vdout0_20ck191 = 1.0 time = 960
* CHECK dout0_21 vdout0_21ck191 = 0 time = 960
* CHECK dout0_22 vdout0_22ck191 = 1.0 time = 960
* CHECK dout0_23 vdout0_23ck191 = 0 time = 960
* CHECK dout0_24 vdout0_24ck191 = 0 time = 960
* CHECK dout0_25 vdout0_25ck191 = 1.0 time = 960
* CHECK dout0_26 vdout0_26ck191 = 1.0 time = 960
* CHECK dout0_27 vdout0_27ck191 = 1.0 time = 960
* CHECK dout0_28 vdout0_28ck191 = 1.0 time = 960
* CHECK dout0_29 vdout0_29ck191 = 1.0 time = 960
* CHECK dout0_30 vdout0_30ck191 = 0 time = 960
* CHECK dout0_31 vdout0_31ck191 = 1.0 time = 960
* CHECK dout0_32 vdout0_32ck191 = 0 time = 960
* CHECK dout0_33 vdout0_33ck191 = 0 time = 960
* CHECK dout0_34 vdout0_34ck191 = 1.0 time = 960
* CHECK dout0_35 vdout0_35ck191 = 0 time = 960
* CHECK dout0_36 vdout0_36ck191 = 0 time = 960
* CHECK dout0_37 vdout0_37ck191 = 1.0 time = 960
* CHECK dout0_38 vdout0_38ck191 = 0 time = 960
* CHECK dout0_39 vdout0_39ck191 = 0 time = 960
* CHECK dout0_40 vdout0_40ck191 = 0 time = 960
* CHECK dout0_41 vdout0_41ck191 = 1.0 time = 960
* CHECK dout0_42 vdout0_42ck191 = 1.0 time = 960
* CHECK dout0_43 vdout0_43ck191 = 1.0 time = 960
* CHECK dout0_44 vdout0_44ck191 = 0 time = 960
* CHECK dout0_45 vdout0_45ck191 = 1.0 time = 960
* CHECK dout0_46 vdout0_46ck191 = 1.0 time = 960
* CHECK dout0_47 vdout0_47ck191 = 0 time = 960
* CHECK dout0_48 vdout0_48ck191 = 1.0 time = 960
* CHECK dout0_49 vdout0_49ck191 = 1.0 time = 960
* CHECK dout0_50 vdout0_50ck191 = 0 time = 960
* CHECK dout0_51 vdout0_51ck191 = 0 time = 960
* CHECK dout0_52 vdout0_52ck191 = 1.0 time = 960
* CHECK dout0_53 vdout0_53ck191 = 0 time = 960
* CHECK dout0_54 vdout0_54ck191 = 1.0 time = 960
* CHECK dout0_55 vdout0_55ck191 = 1.0 time = 960
* CHECK dout0_56 vdout0_56ck191 = 1.0 time = 960
* CHECK dout0_57 vdout0_57ck191 = 1.0 time = 960
* CHECK dout0_58 vdout0_58ck191 = 0 time = 960
* CHECK dout0_59 vdout0_59ck191 = 0 time = 960
* CHECK dout0_60 vdout0_60ck191 = 1.0 time = 960
* CHECK dout0_61 vdout0_61ck191 = 1.0 time = 960
* CHECK dout0_62 vdout0_62ck191 = 1.0 time = 960
* CHECK dout0_63 vdout0_63ck191 = 1.0 time = 960
* CHECK dout1_0 vdout1_0ck192 = 1.0 time = 965
* CHECK dout1_1 vdout1_1ck192 = 1.0 time = 965
* CHECK dout1_2 vdout1_2ck192 = 0 time = 965
* CHECK dout1_3 vdout1_3ck192 = 1.0 time = 965
* CHECK dout1_4 vdout1_4ck192 = 1.0 time = 965
* CHECK dout1_5 vdout1_5ck192 = 0 time = 965
* CHECK dout1_6 vdout1_6ck192 = 1.0 time = 965
* CHECK dout1_7 vdout1_7ck192 = 1.0 time = 965
* CHECK dout1_8 vdout1_8ck192 = 1.0 time = 965
* CHECK dout1_9 vdout1_9ck192 = 0 time = 965
* CHECK dout1_10 vdout1_10ck192 = 0 time = 965
* CHECK dout1_11 vdout1_11ck192 = 1.0 time = 965
* CHECK dout1_12 vdout1_12ck192 = 1.0 time = 965
* CHECK dout1_13 vdout1_13ck192 = 0 time = 965
* CHECK dout1_14 vdout1_14ck192 = 0 time = 965
* CHECK dout1_15 vdout1_15ck192 = 0 time = 965
* CHECK dout1_16 vdout1_16ck192 = 0 time = 965
* CHECK dout1_17 vdout1_17ck192 = 1.0 time = 965
* CHECK dout1_18 vdout1_18ck192 = 0 time = 965
* CHECK dout1_19 vdout1_19ck192 = 0 time = 965
* CHECK dout1_20 vdout1_20ck192 = 0 time = 965
* CHECK dout1_21 vdout1_21ck192 = 0 time = 965
* CHECK dout1_22 vdout1_22ck192 = 0 time = 965
* CHECK dout1_23 vdout1_23ck192 = 0 time = 965
* CHECK dout1_24 vdout1_24ck192 = 1.0 time = 965
* CHECK dout1_25 vdout1_25ck192 = 0 time = 965
* CHECK dout1_26 vdout1_26ck192 = 0 time = 965
* CHECK dout1_27 vdout1_27ck192 = 1.0 time = 965
* CHECK dout1_28 vdout1_28ck192 = 0 time = 965
* CHECK dout1_29 vdout1_29ck192 = 1.0 time = 965
* CHECK dout1_30 vdout1_30ck192 = 0 time = 965
* CHECK dout1_31 vdout1_31ck192 = 0 time = 965
* CHECK dout1_32 vdout1_32ck192 = 1.0 time = 965
* CHECK dout1_33 vdout1_33ck192 = 1.0 time = 965
* CHECK dout1_34 vdout1_34ck192 = 1.0 time = 965
* CHECK dout1_35 vdout1_35ck192 = 0 time = 965
* CHECK dout1_36 vdout1_36ck192 = 1.0 time = 965
* CHECK dout1_37 vdout1_37ck192 = 1.0 time = 965
* CHECK dout1_38 vdout1_38ck192 = 1.0 time = 965
* CHECK dout1_39 vdout1_39ck192 = 1.0 time = 965
* CHECK dout1_40 vdout1_40ck192 = 1.0 time = 965
* CHECK dout1_41 vdout1_41ck192 = 1.0 time = 965
* CHECK dout1_42 vdout1_42ck192 = 1.0 time = 965
* CHECK dout1_43 vdout1_43ck192 = 0 time = 965
* CHECK dout1_44 vdout1_44ck192 = 0 time = 965
* CHECK dout1_45 vdout1_45ck192 = 0 time = 965
* CHECK dout1_46 vdout1_46ck192 = 0 time = 965
* CHECK dout1_47 vdout1_47ck192 = 0 time = 965
* CHECK dout1_48 vdout1_48ck192 = 1.0 time = 965
* CHECK dout1_49 vdout1_49ck192 = 1.0 time = 965
* CHECK dout1_50 vdout1_50ck192 = 1.0 time = 965
* CHECK dout1_51 vdout1_51ck192 = 0 time = 965
* CHECK dout1_52 vdout1_52ck192 = 0 time = 965
* CHECK dout1_53 vdout1_53ck192 = 1.0 time = 965
* CHECK dout1_54 vdout1_54ck192 = 0 time = 965
* CHECK dout1_55 vdout1_55ck192 = 0 time = 965
* CHECK dout1_56 vdout1_56ck192 = 1.0 time = 965
* CHECK dout1_57 vdout1_57ck192 = 1.0 time = 965
* CHECK dout1_58 vdout1_58ck192 = 1.0 time = 965
* CHECK dout1_59 vdout1_59ck192 = 1.0 time = 965
* CHECK dout1_60 vdout1_60ck192 = 1.0 time = 965
* CHECK dout1_61 vdout1_61ck192 = 1.0 time = 965
* CHECK dout1_62 vdout1_62ck192 = 1.0 time = 965
* CHECK dout1_63 vdout1_63ck192 = 0 time = 965
* CHECK dout1_0 vdout1_0ck193 = 1.0 time = 970
* CHECK dout1_1 vdout1_1ck193 = 1.0 time = 970
* CHECK dout1_2 vdout1_2ck193 = 0 time = 970
* CHECK dout1_3 vdout1_3ck193 = 0 time = 970
* CHECK dout1_4 vdout1_4ck193 = 1.0 time = 970
* CHECK dout1_5 vdout1_5ck193 = 1.0 time = 970
* CHECK dout1_6 vdout1_6ck193 = 1.0 time = 970
* CHECK dout1_7 vdout1_7ck193 = 0 time = 970
* CHECK dout1_8 vdout1_8ck193 = 1.0 time = 970
* CHECK dout1_9 vdout1_9ck193 = 0 time = 970
* CHECK dout1_10 vdout1_10ck193 = 1.0 time = 970
* CHECK dout1_11 vdout1_11ck193 = 1.0 time = 970
* CHECK dout1_12 vdout1_12ck193 = 1.0 time = 970
* CHECK dout1_13 vdout1_13ck193 = 1.0 time = 970
* CHECK dout1_14 vdout1_14ck193 = 1.0 time = 970
* CHECK dout1_15 vdout1_15ck193 = 1.0 time = 970
* CHECK dout1_16 vdout1_16ck193 = 1.0 time = 970
* CHECK dout1_17 vdout1_17ck193 = 0 time = 970
* CHECK dout1_18 vdout1_18ck193 = 1.0 time = 970
* CHECK dout1_19 vdout1_19ck193 = 0 time = 970
* CHECK dout1_20 vdout1_20ck193 = 0 time = 970
* CHECK dout1_21 vdout1_21ck193 = 0 time = 970
* CHECK dout1_22 vdout1_22ck193 = 0 time = 970
* CHECK dout1_23 vdout1_23ck193 = 0 time = 970
* CHECK dout1_24 vdout1_24ck193 = 0 time = 970
* CHECK dout1_25 vdout1_25ck193 = 1.0 time = 970
* CHECK dout1_26 vdout1_26ck193 = 0 time = 970
* CHECK dout1_27 vdout1_27ck193 = 1.0 time = 970
* CHECK dout1_28 vdout1_28ck193 = 0 time = 970
* CHECK dout1_29 vdout1_29ck193 = 0 time = 970
* CHECK dout1_30 vdout1_30ck193 = 0 time = 970
* CHECK dout1_31 vdout1_31ck193 = 1.0 time = 970
* CHECK dout1_32 vdout1_32ck193 = 0 time = 970
* CHECK dout1_33 vdout1_33ck193 = 1.0 time = 970
* CHECK dout1_34 vdout1_34ck193 = 1.0 time = 970
* CHECK dout1_35 vdout1_35ck193 = 0 time = 970
* CHECK dout1_36 vdout1_36ck193 = 1.0 time = 970
* CHECK dout1_37 vdout1_37ck193 = 1.0 time = 970
* CHECK dout1_38 vdout1_38ck193 = 0 time = 970
* CHECK dout1_39 vdout1_39ck193 = 0 time = 970
* CHECK dout1_40 vdout1_40ck193 = 1.0 time = 970
* CHECK dout1_41 vdout1_41ck193 = 0 time = 970
* CHECK dout1_42 vdout1_42ck193 = 1.0 time = 970
* CHECK dout1_43 vdout1_43ck193 = 1.0 time = 970
* CHECK dout1_44 vdout1_44ck193 = 0 time = 970
* CHECK dout1_45 vdout1_45ck193 = 0 time = 970
* CHECK dout1_46 vdout1_46ck193 = 1.0 time = 970
* CHECK dout1_47 vdout1_47ck193 = 0 time = 970
* CHECK dout1_48 vdout1_48ck193 = 0 time = 970
* CHECK dout1_49 vdout1_49ck193 = 0 time = 970
* CHECK dout1_50 vdout1_50ck193 = 0 time = 970
* CHECK dout1_51 vdout1_51ck193 = 1.0 time = 970
* CHECK dout1_52 vdout1_52ck193 = 1.0 time = 970
* CHECK dout1_53 vdout1_53ck193 = 0 time = 970
* CHECK dout1_54 vdout1_54ck193 = 0 time = 970
* CHECK dout1_55 vdout1_55ck193 = 1.0 time = 970
* CHECK dout1_56 vdout1_56ck193 = 1.0 time = 970
* CHECK dout1_57 vdout1_57ck193 = 1.0 time = 970
* CHECK dout1_58 vdout1_58ck193 = 0 time = 970
* CHECK dout1_59 vdout1_59ck193 = 1.0 time = 970
* CHECK dout1_60 vdout1_60ck193 = 1.0 time = 970
* CHECK dout1_61 vdout1_61ck193 = 1.0 time = 970
* CHECK dout1_62 vdout1_62ck193 = 1.0 time = 970
* CHECK dout1_63 vdout1_63ck193 = 1.0 time = 970
* CHECK dout0_0 vdout0_0ck194 = 1.0 time = 975
* CHECK dout0_1 vdout0_1ck194 = 0 time = 975
* CHECK dout0_2 vdout0_2ck194 = 1.0 time = 975
* CHECK dout0_3 vdout0_3ck194 = 1.0 time = 975
* CHECK dout0_4 vdout0_4ck194 = 0 time = 975
* CHECK dout0_5 vdout0_5ck194 = 1.0 time = 975
* CHECK dout0_6 vdout0_6ck194 = 1.0 time = 975
* CHECK dout0_7 vdout0_7ck194 = 1.0 time = 975
* CHECK dout0_8 vdout0_8ck194 = 1.0 time = 975
* CHECK dout0_9 vdout0_9ck194 = 1.0 time = 975
* CHECK dout0_10 vdout0_10ck194 = 0 time = 975
* CHECK dout0_11 vdout0_11ck194 = 1.0 time = 975
* CHECK dout0_12 vdout0_12ck194 = 0 time = 975
* CHECK dout0_13 vdout0_13ck194 = 0 time = 975
* CHECK dout0_14 vdout0_14ck194 = 0 time = 975
* CHECK dout0_15 vdout0_15ck194 = 0 time = 975
* CHECK dout0_16 vdout0_16ck194 = 0 time = 975
* CHECK dout0_17 vdout0_17ck194 = 0 time = 975
* CHECK dout0_18 vdout0_18ck194 = 1.0 time = 975
* CHECK dout0_19 vdout0_19ck194 = 1.0 time = 975
* CHECK dout0_20 vdout0_20ck194 = 1.0 time = 975
* CHECK dout0_21 vdout0_21ck194 = 0 time = 975
* CHECK dout0_22 vdout0_22ck194 = 0 time = 975
* CHECK dout0_23 vdout0_23ck194 = 1.0 time = 975
* CHECK dout0_24 vdout0_24ck194 = 1.0 time = 975
* CHECK dout0_25 vdout0_25ck194 = 0 time = 975
* CHECK dout0_26 vdout0_26ck194 = 1.0 time = 975
* CHECK dout0_27 vdout0_27ck194 = 1.0 time = 975
* CHECK dout0_28 vdout0_28ck194 = 0 time = 975
* CHECK dout0_29 vdout0_29ck194 = 0 time = 975
* CHECK dout0_30 vdout0_30ck194 = 0 time = 975
* CHECK dout0_31 vdout0_31ck194 = 0 time = 975
* CHECK dout0_32 vdout0_32ck194 = 1.0 time = 975
* CHECK dout0_33 vdout0_33ck194 = 0 time = 975
* CHECK dout0_34 vdout0_34ck194 = 0 time = 975
* CHECK dout0_35 vdout0_35ck194 = 1.0 time = 975
* CHECK dout0_36 vdout0_36ck194 = 1.0 time = 975
* CHECK dout0_37 vdout0_37ck194 = 0 time = 975
* CHECK dout0_38 vdout0_38ck194 = 0 time = 975
* CHECK dout0_39 vdout0_39ck194 = 0 time = 975
* CHECK dout0_40 vdout0_40ck194 = 1.0 time = 975
* CHECK dout0_41 vdout0_41ck194 = 0 time = 975
* CHECK dout0_42 vdout0_42ck194 = 0 time = 975
* CHECK dout0_43 vdout0_43ck194 = 0 time = 975
* CHECK dout0_44 vdout0_44ck194 = 0 time = 975
* CHECK dout0_45 vdout0_45ck194 = 1.0 time = 975
* CHECK dout0_46 vdout0_46ck194 = 0 time = 975
* CHECK dout0_47 vdout0_47ck194 = 0 time = 975
* CHECK dout0_48 vdout0_48ck194 = 0 time = 975
* CHECK dout0_49 vdout0_49ck194 = 0 time = 975
* CHECK dout0_50 vdout0_50ck194 = 1.0 time = 975
* CHECK dout0_51 vdout0_51ck194 = 1.0 time = 975
* CHECK dout0_52 vdout0_52ck194 = 0 time = 975
* CHECK dout0_53 vdout0_53ck194 = 0 time = 975
* CHECK dout0_54 vdout0_54ck194 = 0 time = 975
* CHECK dout0_55 vdout0_55ck194 = 1.0 time = 975
* CHECK dout0_56 vdout0_56ck194 = 0 time = 975
* CHECK dout0_57 vdout0_57ck194 = 0 time = 975
* CHECK dout0_58 vdout0_58ck194 = 0 time = 975
* CHECK dout0_59 vdout0_59ck194 = 0 time = 975
* CHECK dout0_60 vdout0_60ck194 = 0 time = 975
* CHECK dout0_61 vdout0_61ck194 = 1.0 time = 975
* CHECK dout0_62 vdout0_62ck194 = 0 time = 975
* CHECK dout0_63 vdout0_63ck194 = 0 time = 975
* CHECK dout1_0 vdout1_0ck194 = 1.0 time = 975
* CHECK dout1_1 vdout1_1ck194 = 1.0 time = 975
* CHECK dout1_2 vdout1_2ck194 = 1.0 time = 975
* CHECK dout1_3 vdout1_3ck194 = 0 time = 975
* CHECK dout1_4 vdout1_4ck194 = 0 time = 975
* CHECK dout1_5 vdout1_5ck194 = 0 time = 975
* CHECK dout1_6 vdout1_6ck194 = 1.0 time = 975
* CHECK dout1_7 vdout1_7ck194 = 0 time = 975
* CHECK dout1_8 vdout1_8ck194 = 1.0 time = 975
* CHECK dout1_9 vdout1_9ck194 = 1.0 time = 975
* CHECK dout1_10 vdout1_10ck194 = 1.0 time = 975
* CHECK dout1_11 vdout1_11ck194 = 0 time = 975
* CHECK dout1_12 vdout1_12ck194 = 1.0 time = 975
* CHECK dout1_13 vdout1_13ck194 = 1.0 time = 975
* CHECK dout1_14 vdout1_14ck194 = 1.0 time = 975
* CHECK dout1_15 vdout1_15ck194 = 0 time = 975
* CHECK dout1_16 vdout1_16ck194 = 0 time = 975
* CHECK dout1_17 vdout1_17ck194 = 0 time = 975
* CHECK dout1_18 vdout1_18ck194 = 0 time = 975
* CHECK dout1_19 vdout1_19ck194 = 0 time = 975
* CHECK dout1_20 vdout1_20ck194 = 0 time = 975
* CHECK dout1_21 vdout1_21ck194 = 0 time = 975
* CHECK dout1_22 vdout1_22ck194 = 1.0 time = 975
* CHECK dout1_23 vdout1_23ck194 = 0 time = 975
* CHECK dout1_24 vdout1_24ck194 = 0 time = 975
* CHECK dout1_25 vdout1_25ck194 = 0 time = 975
* CHECK dout1_26 vdout1_26ck194 = 0 time = 975
* CHECK dout1_27 vdout1_27ck194 = 1.0 time = 975
* CHECK dout1_28 vdout1_28ck194 = 0 time = 975
* CHECK dout1_29 vdout1_29ck194 = 0 time = 975
* CHECK dout1_30 vdout1_30ck194 = 1.0 time = 975
* CHECK dout1_31 vdout1_31ck194 = 0 time = 975
* CHECK dout1_32 vdout1_32ck194 = 0 time = 975
* CHECK dout1_33 vdout1_33ck194 = 0 time = 975
* CHECK dout1_34 vdout1_34ck194 = 0 time = 975
* CHECK dout1_35 vdout1_35ck194 = 0 time = 975
* CHECK dout1_36 vdout1_36ck194 = 0 time = 975
* CHECK dout1_37 vdout1_37ck194 = 0 time = 975
* CHECK dout1_38 vdout1_38ck194 = 0 time = 975
* CHECK dout1_39 vdout1_39ck194 = 1.0 time = 975
* CHECK dout1_40 vdout1_40ck194 = 0 time = 975
* CHECK dout1_41 vdout1_41ck194 = 1.0 time = 975
* CHECK dout1_42 vdout1_42ck194 = 1.0 time = 975
* CHECK dout1_43 vdout1_43ck194 = 0 time = 975
* CHECK dout1_44 vdout1_44ck194 = 1.0 time = 975
* CHECK dout1_45 vdout1_45ck194 = 0 time = 975
* CHECK dout1_46 vdout1_46ck194 = 1.0 time = 975
* CHECK dout1_47 vdout1_47ck194 = 1.0 time = 975
* CHECK dout1_48 vdout1_48ck194 = 0 time = 975
* CHECK dout1_49 vdout1_49ck194 = 0 time = 975
* CHECK dout1_50 vdout1_50ck194 = 1.0 time = 975
* CHECK dout1_51 vdout1_51ck194 = 0 time = 975
* CHECK dout1_52 vdout1_52ck194 = 1.0 time = 975
* CHECK dout1_53 vdout1_53ck194 = 0 time = 975
* CHECK dout1_54 vdout1_54ck194 = 0 time = 975
* CHECK dout1_55 vdout1_55ck194 = 1.0 time = 975
* CHECK dout1_56 vdout1_56ck194 = 1.0 time = 975
* CHECK dout1_57 vdout1_57ck194 = 0 time = 975
* CHECK dout1_58 vdout1_58ck194 = 1.0 time = 975
* CHECK dout1_59 vdout1_59ck194 = 1.0 time = 975
* CHECK dout1_60 vdout1_60ck194 = 0 time = 975
* CHECK dout1_61 vdout1_61ck194 = 1.0 time = 975
* CHECK dout1_62 vdout1_62ck194 = 1.0 time = 975
* CHECK dout1_63 vdout1_63ck194 = 1.0 time = 975
* CHECK dout0_0 vdout0_0ck195 = 1.0 time = 980
* CHECK dout0_1 vdout0_1ck195 = 1.0 time = 980
* CHECK dout0_2 vdout0_2ck195 = 0 time = 980
* CHECK dout0_3 vdout0_3ck195 = 1.0 time = 980
* CHECK dout0_4 vdout0_4ck195 = 0 time = 980
* CHECK dout0_5 vdout0_5ck195 = 1.0 time = 980
* CHECK dout0_6 vdout0_6ck195 = 0 time = 980
* CHECK dout0_7 vdout0_7ck195 = 1.0 time = 980
* CHECK dout0_8 vdout0_8ck195 = 1.0 time = 980
* CHECK dout0_9 vdout0_9ck195 = 1.0 time = 980
* CHECK dout0_10 vdout0_10ck195 = 1.0 time = 980
* CHECK dout0_11 vdout0_11ck195 = 1.0 time = 980
* CHECK dout0_12 vdout0_12ck195 = 0 time = 980
* CHECK dout0_13 vdout0_13ck195 = 1.0 time = 980
* CHECK dout0_14 vdout0_14ck195 = 0 time = 980
* CHECK dout0_15 vdout0_15ck195 = 1.0 time = 980
* CHECK dout0_16 vdout0_16ck195 = 1.0 time = 980
* CHECK dout0_17 vdout0_17ck195 = 1.0 time = 980
* CHECK dout0_18 vdout0_18ck195 = 1.0 time = 980
* CHECK dout0_19 vdout0_19ck195 = 1.0 time = 980
* CHECK dout0_20 vdout0_20ck195 = 0 time = 980
* CHECK dout0_21 vdout0_21ck195 = 1.0 time = 980
* CHECK dout0_22 vdout0_22ck195 = 0 time = 980
* CHECK dout0_23 vdout0_23ck195 = 1.0 time = 980
* CHECK dout0_24 vdout0_24ck195 = 1.0 time = 980
* CHECK dout0_25 vdout0_25ck195 = 0 time = 980
* CHECK dout0_26 vdout0_26ck195 = 0 time = 980
* CHECK dout0_27 vdout0_27ck195 = 1.0 time = 980
* CHECK dout0_28 vdout0_28ck195 = 0 time = 980
* CHECK dout0_29 vdout0_29ck195 = 1.0 time = 980
* CHECK dout0_30 vdout0_30ck195 = 1.0 time = 980
* CHECK dout0_31 vdout0_31ck195 = 1.0 time = 980
* CHECK dout0_32 vdout0_32ck195 = 0 time = 980
* CHECK dout0_33 vdout0_33ck195 = 0 time = 980
* CHECK dout0_34 vdout0_34ck195 = 1.0 time = 980
* CHECK dout0_35 vdout0_35ck195 = 0 time = 980
* CHECK dout0_36 vdout0_36ck195 = 0 time = 980
* CHECK dout0_37 vdout0_37ck195 = 1.0 time = 980
* CHECK dout0_38 vdout0_38ck195 = 1.0 time = 980
* CHECK dout0_39 vdout0_39ck195 = 0 time = 980
* CHECK dout0_40 vdout0_40ck195 = 1.0 time = 980
* CHECK dout0_41 vdout0_41ck195 = 1.0 time = 980
* CHECK dout0_42 vdout0_42ck195 = 1.0 time = 980
* CHECK dout0_43 vdout0_43ck195 = 1.0 time = 980
* CHECK dout0_44 vdout0_44ck195 = 0 time = 980
* CHECK dout0_45 vdout0_45ck195 = 0 time = 980
* CHECK dout0_46 vdout0_46ck195 = 1.0 time = 980
* CHECK dout0_47 vdout0_47ck195 = 1.0 time = 980
* CHECK dout0_48 vdout0_48ck195 = 1.0 time = 980
* CHECK dout0_49 vdout0_49ck195 = 1.0 time = 980
* CHECK dout0_50 vdout0_50ck195 = 1.0 time = 980
* CHECK dout0_51 vdout0_51ck195 = 0 time = 980
* CHECK dout0_52 vdout0_52ck195 = 0 time = 980
* CHECK dout0_53 vdout0_53ck195 = 0 time = 980
* CHECK dout0_54 vdout0_54ck195 = 0 time = 980
* CHECK dout0_55 vdout0_55ck195 = 0 time = 980
* CHECK dout0_56 vdout0_56ck195 = 1.0 time = 980
* CHECK dout0_57 vdout0_57ck195 = 0 time = 980
* CHECK dout0_58 vdout0_58ck195 = 0 time = 980
* CHECK dout0_59 vdout0_59ck195 = 1.0 time = 980
* CHECK dout0_60 vdout0_60ck195 = 1.0 time = 980
* CHECK dout0_61 vdout0_61ck195 = 0 time = 980
* CHECK dout0_62 vdout0_62ck195 = 0 time = 980
* CHECK dout0_63 vdout0_63ck195 = 1.0 time = 980
* CHECK dout0_0 vdout0_0ck196 = 1.0 time = 985
* CHECK dout0_1 vdout0_1ck196 = 1.0 time = 985
* CHECK dout0_2 vdout0_2ck196 = 0 time = 985
* CHECK dout0_3 vdout0_3ck196 = 1.0 time = 985
* CHECK dout0_4 vdout0_4ck196 = 0 time = 985
* CHECK dout0_5 vdout0_5ck196 = 1.0 time = 985
* CHECK dout0_6 vdout0_6ck196 = 0 time = 985
* CHECK dout0_7 vdout0_7ck196 = 1.0 time = 985
* CHECK dout0_8 vdout0_8ck196 = 1.0 time = 985
* CHECK dout0_9 vdout0_9ck196 = 1.0 time = 985
* CHECK dout0_10 vdout0_10ck196 = 1.0 time = 985
* CHECK dout0_11 vdout0_11ck196 = 1.0 time = 985
* CHECK dout0_12 vdout0_12ck196 = 0 time = 985
* CHECK dout0_13 vdout0_13ck196 = 1.0 time = 985
* CHECK dout0_14 vdout0_14ck196 = 0 time = 985
* CHECK dout0_15 vdout0_15ck196 = 1.0 time = 985
* CHECK dout0_16 vdout0_16ck196 = 1.0 time = 985
* CHECK dout0_17 vdout0_17ck196 = 1.0 time = 985
* CHECK dout0_18 vdout0_18ck196 = 1.0 time = 985
* CHECK dout0_19 vdout0_19ck196 = 1.0 time = 985
* CHECK dout0_20 vdout0_20ck196 = 0 time = 985
* CHECK dout0_21 vdout0_21ck196 = 1.0 time = 985
* CHECK dout0_22 vdout0_22ck196 = 0 time = 985
* CHECK dout0_23 vdout0_23ck196 = 1.0 time = 985
* CHECK dout0_24 vdout0_24ck196 = 1.0 time = 985
* CHECK dout0_25 vdout0_25ck196 = 0 time = 985
* CHECK dout0_26 vdout0_26ck196 = 0 time = 985
* CHECK dout0_27 vdout0_27ck196 = 1.0 time = 985
* CHECK dout0_28 vdout0_28ck196 = 0 time = 985
* CHECK dout0_29 vdout0_29ck196 = 1.0 time = 985
* CHECK dout0_30 vdout0_30ck196 = 1.0 time = 985
* CHECK dout0_31 vdout0_31ck196 = 1.0 time = 985
* CHECK dout0_32 vdout0_32ck196 = 0 time = 985
* CHECK dout0_33 vdout0_33ck196 = 0 time = 985
* CHECK dout0_34 vdout0_34ck196 = 1.0 time = 985
* CHECK dout0_35 vdout0_35ck196 = 0 time = 985
* CHECK dout0_36 vdout0_36ck196 = 0 time = 985
* CHECK dout0_37 vdout0_37ck196 = 1.0 time = 985
* CHECK dout0_38 vdout0_38ck196 = 1.0 time = 985
* CHECK dout0_39 vdout0_39ck196 = 0 time = 985
* CHECK dout0_40 vdout0_40ck196 = 1.0 time = 985
* CHECK dout0_41 vdout0_41ck196 = 1.0 time = 985
* CHECK dout0_42 vdout0_42ck196 = 1.0 time = 985
* CHECK dout0_43 vdout0_43ck196 = 1.0 time = 985
* CHECK dout0_44 vdout0_44ck196 = 0 time = 985
* CHECK dout0_45 vdout0_45ck196 = 0 time = 985
* CHECK dout0_46 vdout0_46ck196 = 1.0 time = 985
* CHECK dout0_47 vdout0_47ck196 = 1.0 time = 985
* CHECK dout0_48 vdout0_48ck196 = 1.0 time = 985
* CHECK dout0_49 vdout0_49ck196 = 1.0 time = 985
* CHECK dout0_50 vdout0_50ck196 = 1.0 time = 985
* CHECK dout0_51 vdout0_51ck196 = 0 time = 985
* CHECK dout0_52 vdout0_52ck196 = 0 time = 985
* CHECK dout0_53 vdout0_53ck196 = 0 time = 985
* CHECK dout0_54 vdout0_54ck196 = 0 time = 985
* CHECK dout0_55 vdout0_55ck196 = 0 time = 985
* CHECK dout0_56 vdout0_56ck196 = 1.0 time = 985
* CHECK dout0_57 vdout0_57ck196 = 0 time = 985
* CHECK dout0_58 vdout0_58ck196 = 0 time = 985
* CHECK dout0_59 vdout0_59ck196 = 1.0 time = 985
* CHECK dout0_60 vdout0_60ck196 = 1.0 time = 985
* CHECK dout0_61 vdout0_61ck196 = 0 time = 985
* CHECK dout0_62 vdout0_62ck196 = 0 time = 985
* CHECK dout0_63 vdout0_63ck196 = 1.0 time = 985
* CHECK dout0_0 vdout0_0ck197 = 1.0 time = 990
* CHECK dout0_1 vdout0_1ck197 = 1.0 time = 990
* CHECK dout0_2 vdout0_2ck197 = 0 time = 990
* CHECK dout0_3 vdout0_3ck197 = 1.0 time = 990
* CHECK dout0_4 vdout0_4ck197 = 0 time = 990
* CHECK dout0_5 vdout0_5ck197 = 1.0 time = 990
* CHECK dout0_6 vdout0_6ck197 = 0 time = 990
* CHECK dout0_7 vdout0_7ck197 = 1.0 time = 990
* CHECK dout0_8 vdout0_8ck197 = 1.0 time = 990
* CHECK dout0_9 vdout0_9ck197 = 1.0 time = 990
* CHECK dout0_10 vdout0_10ck197 = 1.0 time = 990
* CHECK dout0_11 vdout0_11ck197 = 1.0 time = 990
* CHECK dout0_12 vdout0_12ck197 = 0 time = 990
* CHECK dout0_13 vdout0_13ck197 = 1.0 time = 990
* CHECK dout0_14 vdout0_14ck197 = 0 time = 990
* CHECK dout0_15 vdout0_15ck197 = 1.0 time = 990
* CHECK dout0_16 vdout0_16ck197 = 1.0 time = 990
* CHECK dout0_17 vdout0_17ck197 = 1.0 time = 990
* CHECK dout0_18 vdout0_18ck197 = 1.0 time = 990
* CHECK dout0_19 vdout0_19ck197 = 1.0 time = 990
* CHECK dout0_20 vdout0_20ck197 = 0 time = 990
* CHECK dout0_21 vdout0_21ck197 = 1.0 time = 990
* CHECK dout0_22 vdout0_22ck197 = 0 time = 990
* CHECK dout0_23 vdout0_23ck197 = 1.0 time = 990
* CHECK dout0_24 vdout0_24ck197 = 1.0 time = 990
* CHECK dout0_25 vdout0_25ck197 = 0 time = 990
* CHECK dout0_26 vdout0_26ck197 = 0 time = 990
* CHECK dout0_27 vdout0_27ck197 = 1.0 time = 990
* CHECK dout0_28 vdout0_28ck197 = 0 time = 990
* CHECK dout0_29 vdout0_29ck197 = 1.0 time = 990
* CHECK dout0_30 vdout0_30ck197 = 1.0 time = 990
* CHECK dout0_31 vdout0_31ck197 = 1.0 time = 990
* CHECK dout0_32 vdout0_32ck197 = 0 time = 990
* CHECK dout0_33 vdout0_33ck197 = 0 time = 990
* CHECK dout0_34 vdout0_34ck197 = 1.0 time = 990
* CHECK dout0_35 vdout0_35ck197 = 0 time = 990
* CHECK dout0_36 vdout0_36ck197 = 0 time = 990
* CHECK dout0_37 vdout0_37ck197 = 1.0 time = 990
* CHECK dout0_38 vdout0_38ck197 = 1.0 time = 990
* CHECK dout0_39 vdout0_39ck197 = 0 time = 990
* CHECK dout0_40 vdout0_40ck197 = 1.0 time = 990
* CHECK dout0_41 vdout0_41ck197 = 1.0 time = 990
* CHECK dout0_42 vdout0_42ck197 = 1.0 time = 990
* CHECK dout0_43 vdout0_43ck197 = 1.0 time = 990
* CHECK dout0_44 vdout0_44ck197 = 0 time = 990
* CHECK dout0_45 vdout0_45ck197 = 0 time = 990
* CHECK dout0_46 vdout0_46ck197 = 1.0 time = 990
* CHECK dout0_47 vdout0_47ck197 = 1.0 time = 990
* CHECK dout0_48 vdout0_48ck197 = 1.0 time = 990
* CHECK dout0_49 vdout0_49ck197 = 1.0 time = 990
* CHECK dout0_50 vdout0_50ck197 = 1.0 time = 990
* CHECK dout0_51 vdout0_51ck197 = 0 time = 990
* CHECK dout0_52 vdout0_52ck197 = 0 time = 990
* CHECK dout0_53 vdout0_53ck197 = 0 time = 990
* CHECK dout0_54 vdout0_54ck197 = 0 time = 990
* CHECK dout0_55 vdout0_55ck197 = 0 time = 990
* CHECK dout0_56 vdout0_56ck197 = 1.0 time = 990
* CHECK dout0_57 vdout0_57ck197 = 0 time = 990
* CHECK dout0_58 vdout0_58ck197 = 0 time = 990
* CHECK dout0_59 vdout0_59ck197 = 1.0 time = 990
* CHECK dout0_60 vdout0_60ck197 = 1.0 time = 990
* CHECK dout0_61 vdout0_61ck197 = 0 time = 990
* CHECK dout0_62 vdout0_62ck197 = 0 time = 990
* CHECK dout0_63 vdout0_63ck197 = 1.0 time = 990
* CHECK dout1_0 vdout1_0ck197 = 1.0 time = 990
* CHECK dout1_1 vdout1_1ck197 = 1.0 time = 990
* CHECK dout1_2 vdout1_2ck197 = 1.0 time = 990
* CHECK dout1_3 vdout1_3ck197 = 0 time = 990
* CHECK dout1_4 vdout1_4ck197 = 0 time = 990
* CHECK dout1_5 vdout1_5ck197 = 0 time = 990
* CHECK dout1_6 vdout1_6ck197 = 1.0 time = 990
* CHECK dout1_7 vdout1_7ck197 = 0 time = 990
* CHECK dout1_8 vdout1_8ck197 = 1.0 time = 990
* CHECK dout1_9 vdout1_9ck197 = 1.0 time = 990
* CHECK dout1_10 vdout1_10ck197 = 1.0 time = 990
* CHECK dout1_11 vdout1_11ck197 = 0 time = 990
* CHECK dout1_12 vdout1_12ck197 = 1.0 time = 990
* CHECK dout1_13 vdout1_13ck197 = 1.0 time = 990
* CHECK dout1_14 vdout1_14ck197 = 1.0 time = 990
* CHECK dout1_15 vdout1_15ck197 = 0 time = 990
* CHECK dout1_16 vdout1_16ck197 = 0 time = 990
* CHECK dout1_17 vdout1_17ck197 = 0 time = 990
* CHECK dout1_18 vdout1_18ck197 = 0 time = 990
* CHECK dout1_19 vdout1_19ck197 = 0 time = 990
* CHECK dout1_20 vdout1_20ck197 = 0 time = 990
* CHECK dout1_21 vdout1_21ck197 = 0 time = 990
* CHECK dout1_22 vdout1_22ck197 = 1.0 time = 990
* CHECK dout1_23 vdout1_23ck197 = 0 time = 990
* CHECK dout1_24 vdout1_24ck197 = 0 time = 990
* CHECK dout1_25 vdout1_25ck197 = 0 time = 990
* CHECK dout1_26 vdout1_26ck197 = 0 time = 990
* CHECK dout1_27 vdout1_27ck197 = 1.0 time = 990
* CHECK dout1_28 vdout1_28ck197 = 0 time = 990
* CHECK dout1_29 vdout1_29ck197 = 0 time = 990
* CHECK dout1_30 vdout1_30ck197 = 1.0 time = 990
* CHECK dout1_31 vdout1_31ck197 = 0 time = 990
* CHECK dout1_32 vdout1_32ck197 = 0 time = 990
* CHECK dout1_33 vdout1_33ck197 = 0 time = 990
* CHECK dout1_34 vdout1_34ck197 = 0 time = 990
* CHECK dout1_35 vdout1_35ck197 = 0 time = 990
* CHECK dout1_36 vdout1_36ck197 = 0 time = 990
* CHECK dout1_37 vdout1_37ck197 = 0 time = 990
* CHECK dout1_38 vdout1_38ck197 = 0 time = 990
* CHECK dout1_39 vdout1_39ck197 = 1.0 time = 990
* CHECK dout1_40 vdout1_40ck197 = 0 time = 990
* CHECK dout1_41 vdout1_41ck197 = 1.0 time = 990
* CHECK dout1_42 vdout1_42ck197 = 1.0 time = 990
* CHECK dout1_43 vdout1_43ck197 = 0 time = 990
* CHECK dout1_44 vdout1_44ck197 = 1.0 time = 990
* CHECK dout1_45 vdout1_45ck197 = 0 time = 990
* CHECK dout1_46 vdout1_46ck197 = 1.0 time = 990
* CHECK dout1_47 vdout1_47ck197 = 1.0 time = 990
* CHECK dout1_48 vdout1_48ck197 = 0 time = 990
* CHECK dout1_49 vdout1_49ck197 = 0 time = 990
* CHECK dout1_50 vdout1_50ck197 = 1.0 time = 990
* CHECK dout1_51 vdout1_51ck197 = 0 time = 990
* CHECK dout1_52 vdout1_52ck197 = 1.0 time = 990
* CHECK dout1_53 vdout1_53ck197 = 0 time = 990
* CHECK dout1_54 vdout1_54ck197 = 0 time = 990
* CHECK dout1_55 vdout1_55ck197 = 1.0 time = 990
* CHECK dout1_56 vdout1_56ck197 = 1.0 time = 990
* CHECK dout1_57 vdout1_57ck197 = 0 time = 990
* CHECK dout1_58 vdout1_58ck197 = 1.0 time = 990
* CHECK dout1_59 vdout1_59ck197 = 1.0 time = 990
* CHECK dout1_60 vdout1_60ck197 = 0 time = 990
* CHECK dout1_61 vdout1_61ck197 = 1.0 time = 990
* CHECK dout1_62 vdout1_62ck197 = 1.0 time = 990
* CHECK dout1_63 vdout1_63ck197 = 1.0 time = 990
* CHECK dout1_0 vdout1_0ck198 = 1.0 time = 995
* CHECK dout1_1 vdout1_1ck198 = 1.0 time = 995
* CHECK dout1_2 vdout1_2ck198 = 0 time = 995
* CHECK dout1_3 vdout1_3ck198 = 1.0 time = 995
* CHECK dout1_4 vdout1_4ck198 = 0 time = 995
* CHECK dout1_5 vdout1_5ck198 = 1.0 time = 995
* CHECK dout1_6 vdout1_6ck198 = 0 time = 995
* CHECK dout1_7 vdout1_7ck198 = 1.0 time = 995
* CHECK dout1_8 vdout1_8ck198 = 1.0 time = 995
* CHECK dout1_9 vdout1_9ck198 = 1.0 time = 995
* CHECK dout1_10 vdout1_10ck198 = 1.0 time = 995
* CHECK dout1_11 vdout1_11ck198 = 1.0 time = 995
* CHECK dout1_12 vdout1_12ck198 = 0 time = 995
* CHECK dout1_13 vdout1_13ck198 = 1.0 time = 995
* CHECK dout1_14 vdout1_14ck198 = 0 time = 995
* CHECK dout1_15 vdout1_15ck198 = 1.0 time = 995
* CHECK dout1_16 vdout1_16ck198 = 1.0 time = 995
* CHECK dout1_17 vdout1_17ck198 = 1.0 time = 995
* CHECK dout1_18 vdout1_18ck198 = 1.0 time = 995
* CHECK dout1_19 vdout1_19ck198 = 1.0 time = 995
* CHECK dout1_20 vdout1_20ck198 = 0 time = 995
* CHECK dout1_21 vdout1_21ck198 = 1.0 time = 995
* CHECK dout1_22 vdout1_22ck198 = 0 time = 995
* CHECK dout1_23 vdout1_23ck198 = 1.0 time = 995
* CHECK dout1_24 vdout1_24ck198 = 1.0 time = 995
* CHECK dout1_25 vdout1_25ck198 = 0 time = 995
* CHECK dout1_26 vdout1_26ck198 = 0 time = 995
* CHECK dout1_27 vdout1_27ck198 = 1.0 time = 995
* CHECK dout1_28 vdout1_28ck198 = 0 time = 995
* CHECK dout1_29 vdout1_29ck198 = 1.0 time = 995
* CHECK dout1_30 vdout1_30ck198 = 1.0 time = 995
* CHECK dout1_31 vdout1_31ck198 = 1.0 time = 995
* CHECK dout1_32 vdout1_32ck198 = 0 time = 995
* CHECK dout1_33 vdout1_33ck198 = 0 time = 995
* CHECK dout1_34 vdout1_34ck198 = 1.0 time = 995
* CHECK dout1_35 vdout1_35ck198 = 0 time = 995
* CHECK dout1_36 vdout1_36ck198 = 0 time = 995
* CHECK dout1_37 vdout1_37ck198 = 1.0 time = 995
* CHECK dout1_38 vdout1_38ck198 = 1.0 time = 995
* CHECK dout1_39 vdout1_39ck198 = 0 time = 995
* CHECK dout1_40 vdout1_40ck198 = 1.0 time = 995
* CHECK dout1_41 vdout1_41ck198 = 1.0 time = 995
* CHECK dout1_42 vdout1_42ck198 = 1.0 time = 995
* CHECK dout1_43 vdout1_43ck198 = 1.0 time = 995
* CHECK dout1_44 vdout1_44ck198 = 0 time = 995
* CHECK dout1_45 vdout1_45ck198 = 0 time = 995
* CHECK dout1_46 vdout1_46ck198 = 1.0 time = 995
* CHECK dout1_47 vdout1_47ck198 = 1.0 time = 995
* CHECK dout1_48 vdout1_48ck198 = 1.0 time = 995
* CHECK dout1_49 vdout1_49ck198 = 1.0 time = 995
* CHECK dout1_50 vdout1_50ck198 = 1.0 time = 995
* CHECK dout1_51 vdout1_51ck198 = 0 time = 995
* CHECK dout1_52 vdout1_52ck198 = 0 time = 995
* CHECK dout1_53 vdout1_53ck198 = 0 time = 995
* CHECK dout1_54 vdout1_54ck198 = 0 time = 995
* CHECK dout1_55 vdout1_55ck198 = 0 time = 995
* CHECK dout1_56 vdout1_56ck198 = 1.0 time = 995
* CHECK dout1_57 vdout1_57ck198 = 0 time = 995
* CHECK dout1_58 vdout1_58ck198 = 0 time = 995
* CHECK dout1_59 vdout1_59ck198 = 1.0 time = 995
* CHECK dout1_60 vdout1_60ck198 = 1.0 time = 995
* CHECK dout1_61 vdout1_61ck198 = 0 time = 995
* CHECK dout1_62 vdout1_62ck198 = 0 time = 995
* CHECK dout1_63 vdout1_63ck198 = 1.0 time = 995
* CHECK dout1_0 vdout1_0ck199 = 1.0 time = 1000
* CHECK dout1_1 vdout1_1ck199 = 0 time = 1000
* CHECK dout1_2 vdout1_2ck199 = 0 time = 1000
* CHECK dout1_3 vdout1_3ck199 = 0 time = 1000
* CHECK dout1_4 vdout1_4ck199 = 1.0 time = 1000
* CHECK dout1_5 vdout1_5ck199 = 0 time = 1000
* CHECK dout1_6 vdout1_6ck199 = 1.0 time = 1000
* CHECK dout1_7 vdout1_7ck199 = 1.0 time = 1000
* CHECK dout1_8 vdout1_8ck199 = 0 time = 1000
* CHECK dout1_9 vdout1_9ck199 = 0 time = 1000
* CHECK dout1_10 vdout1_10ck199 = 0 time = 1000
* CHECK dout1_11 vdout1_11ck199 = 0 time = 1000
* CHECK dout1_12 vdout1_12ck199 = 1.0 time = 1000
* CHECK dout1_13 vdout1_13ck199 = 0 time = 1000
* CHECK dout1_14 vdout1_14ck199 = 0 time = 1000
* CHECK dout1_15 vdout1_15ck199 = 1.0 time = 1000
* CHECK dout1_16 vdout1_16ck199 = 0 time = 1000
* CHECK dout1_17 vdout1_17ck199 = 0 time = 1000
* CHECK dout1_18 vdout1_18ck199 = 1.0 time = 1000
* CHECK dout1_19 vdout1_19ck199 = 1.0 time = 1000
* CHECK dout1_20 vdout1_20ck199 = 0 time = 1000
* CHECK dout1_21 vdout1_21ck199 = 1.0 time = 1000
* CHECK dout1_22 vdout1_22ck199 = 0 time = 1000
* CHECK dout1_23 vdout1_23ck199 = 0 time = 1000
* CHECK dout1_24 vdout1_24ck199 = 0 time = 1000
* CHECK dout1_25 vdout1_25ck199 = 1.0 time = 1000
* CHECK dout1_26 vdout1_26ck199 = 0 time = 1000
* CHECK dout1_27 vdout1_27ck199 = 0 time = 1000
* CHECK dout1_28 vdout1_28ck199 = 1.0 time = 1000
* CHECK dout1_29 vdout1_29ck199 = 1.0 time = 1000
* CHECK dout1_30 vdout1_30ck199 = 1.0 time = 1000
* CHECK dout1_31 vdout1_31ck199 = 1.0 time = 1000
* CHECK dout1_32 vdout1_32ck199 = 1.0 time = 1000
* CHECK dout1_33 vdout1_33ck199 = 1.0 time = 1000
* CHECK dout1_34 vdout1_34ck199 = 0 time = 1000
* CHECK dout1_35 vdout1_35ck199 = 0 time = 1000
* CHECK dout1_36 vdout1_36ck199 = 1.0 time = 1000
* CHECK dout1_37 vdout1_37ck199 = 0 time = 1000
* CHECK dout1_38 vdout1_38ck199 = 1.0 time = 1000
* CHECK dout1_39 vdout1_39ck199 = 1.0 time = 1000
* CHECK dout1_40 vdout1_40ck199 = 1.0 time = 1000
* CHECK dout1_41 vdout1_41ck199 = 1.0 time = 1000
* CHECK dout1_42 vdout1_42ck199 = 1.0 time = 1000
* CHECK dout1_43 vdout1_43ck199 = 1.0 time = 1000
* CHECK dout1_44 vdout1_44ck199 = 0 time = 1000
* CHECK dout1_45 vdout1_45ck199 = 1.0 time = 1000
* CHECK dout1_46 vdout1_46ck199 = 1.0 time = 1000
* CHECK dout1_47 vdout1_47ck199 = 0 time = 1000
* CHECK dout1_48 vdout1_48ck199 = 1.0 time = 1000
* CHECK dout1_49 vdout1_49ck199 = 0 time = 1000
* CHECK dout1_50 vdout1_50ck199 = 0 time = 1000
* CHECK dout1_51 vdout1_51ck199 = 0 time = 1000
* CHECK dout1_52 vdout1_52ck199 = 1.0 time = 1000
* CHECK dout1_53 vdout1_53ck199 = 0 time = 1000
* CHECK dout1_54 vdout1_54ck199 = 1.0 time = 1000
* CHECK dout1_55 vdout1_55ck199 = 0 time = 1000
* CHECK dout1_56 vdout1_56ck199 = 1.0 time = 1000
* CHECK dout1_57 vdout1_57ck199 = 0 time = 1000
* CHECK dout1_58 vdout1_58ck199 = 0 time = 1000
* CHECK dout1_59 vdout1_59ck199 = 0 time = 1000
* CHECK dout1_60 vdout1_60ck199 = 1.0 time = 1000
* CHECK dout1_61 vdout1_61ck199 = 1.0 time = 1000
* CHECK dout1_62 vdout1_62ck199 = 1.0 time = 1000
* CHECK dout1_63 vdout1_63ck199 = 1.0 time = 1000
* CHECK dout0_0 vdout0_0ck200 = 0 time = 1005
* CHECK dout0_1 vdout0_1ck200 = 0 time = 1005
* CHECK dout0_2 vdout0_2ck200 = 0 time = 1005
* CHECK dout0_3 vdout0_3ck200 = 1.0 time = 1005
* CHECK dout0_4 vdout0_4ck200 = 0 time = 1005
* CHECK dout0_5 vdout0_5ck200 = 0 time = 1005
* CHECK dout0_6 vdout0_6ck200 = 0 time = 1005
* CHECK dout0_7 vdout0_7ck200 = 1.0 time = 1005
* CHECK dout0_8 vdout0_8ck200 = 0 time = 1005
* CHECK dout0_9 vdout0_9ck200 = 0 time = 1005
* CHECK dout0_10 vdout0_10ck200 = 1.0 time = 1005
* CHECK dout0_11 vdout0_11ck200 = 1.0 time = 1005
* CHECK dout0_12 vdout0_12ck200 = 1.0 time = 1005
* CHECK dout0_13 vdout0_13ck200 = 1.0 time = 1005
* CHECK dout0_14 vdout0_14ck200 = 1.0 time = 1005
* CHECK dout0_15 vdout0_15ck200 = 0 time = 1005
* CHECK dout0_16 vdout0_16ck200 = 0 time = 1005
* CHECK dout0_17 vdout0_17ck200 = 1.0 time = 1005
* CHECK dout0_18 vdout0_18ck200 = 1.0 time = 1005
* CHECK dout0_19 vdout0_19ck200 = 0 time = 1005
* CHECK dout0_20 vdout0_20ck200 = 1.0 time = 1005
* CHECK dout0_21 vdout0_21ck200 = 0 time = 1005
* CHECK dout0_22 vdout0_22ck200 = 1.0 time = 1005
* CHECK dout0_23 vdout0_23ck200 = 0 time = 1005
* CHECK dout0_24 vdout0_24ck200 = 0 time = 1005
* CHECK dout0_25 vdout0_25ck200 = 1.0 time = 1005
* CHECK dout0_26 vdout0_26ck200 = 1.0 time = 1005
* CHECK dout0_27 vdout0_27ck200 = 1.0 time = 1005
* CHECK dout0_28 vdout0_28ck200 = 1.0 time = 1005
* CHECK dout0_29 vdout0_29ck200 = 1.0 time = 1005
* CHECK dout0_30 vdout0_30ck200 = 0 time = 1005
* CHECK dout0_31 vdout0_31ck200 = 1.0 time = 1005
* CHECK dout0_32 vdout0_32ck200 = 0 time = 1005
* CHECK dout0_33 vdout0_33ck200 = 0 time = 1005
* CHECK dout0_34 vdout0_34ck200 = 1.0 time = 1005
* CHECK dout0_35 vdout0_35ck200 = 0 time = 1005
* CHECK dout0_36 vdout0_36ck200 = 0 time = 1005
* CHECK dout0_37 vdout0_37ck200 = 1.0 time = 1005
* CHECK dout0_38 vdout0_38ck200 = 0 time = 1005
* CHECK dout0_39 vdout0_39ck200 = 0 time = 1005
* CHECK dout0_40 vdout0_40ck200 = 0 time = 1005
* CHECK dout0_41 vdout0_41ck200 = 1.0 time = 1005
* CHECK dout0_42 vdout0_42ck200 = 1.0 time = 1005
* CHECK dout0_43 vdout0_43ck200 = 1.0 time = 1005
* CHECK dout0_44 vdout0_44ck200 = 0 time = 1005
* CHECK dout0_45 vdout0_45ck200 = 1.0 time = 1005
* CHECK dout0_46 vdout0_46ck200 = 1.0 time = 1005
* CHECK dout0_47 vdout0_47ck200 = 0 time = 1005
* CHECK dout0_48 vdout0_48ck200 = 1.0 time = 1005
* CHECK dout0_49 vdout0_49ck200 = 1.0 time = 1005
* CHECK dout0_50 vdout0_50ck200 = 0 time = 1005
* CHECK dout0_51 vdout0_51ck200 = 0 time = 1005
* CHECK dout0_52 vdout0_52ck200 = 1.0 time = 1005
* CHECK dout0_53 vdout0_53ck200 = 0 time = 1005
* CHECK dout0_54 vdout0_54ck200 = 1.0 time = 1005
* CHECK dout0_55 vdout0_55ck200 = 1.0 time = 1005
* CHECK dout0_56 vdout0_56ck200 = 1.0 time = 1005
* CHECK dout0_57 vdout0_57ck200 = 1.0 time = 1005
* CHECK dout0_58 vdout0_58ck200 = 0 time = 1005
* CHECK dout0_59 vdout0_59ck200 = 0 time = 1005
* CHECK dout0_60 vdout0_60ck200 = 1.0 time = 1005
* CHECK dout0_61 vdout0_61ck200 = 1.0 time = 1005
* CHECK dout0_62 vdout0_62ck200 = 1.0 time = 1005
* CHECK dout0_63 vdout0_63ck200 = 1.0 time = 1005
* CHECK dout0_0 vdout0_0ck201 = 1.0 time = 1010
* CHECK dout0_1 vdout0_1ck201 = 0 time = 1010
* CHECK dout0_2 vdout0_2ck201 = 1.0 time = 1010
* CHECK dout0_3 vdout0_3ck201 = 1.0 time = 1010
* CHECK dout0_4 vdout0_4ck201 = 0 time = 1010
* CHECK dout0_5 vdout0_5ck201 = 1.0 time = 1010
* CHECK dout0_6 vdout0_6ck201 = 0 time = 1010
* CHECK dout0_7 vdout0_7ck201 = 0 time = 1010
* CHECK dout0_8 vdout0_8ck201 = 1.0 time = 1010
* CHECK dout0_9 vdout0_9ck201 = 1.0 time = 1010
* CHECK dout0_10 vdout0_10ck201 = 1.0 time = 1010
* CHECK dout0_11 vdout0_11ck201 = 0 time = 1010
* CHECK dout0_12 vdout0_12ck201 = 1.0 time = 1010
* CHECK dout0_13 vdout0_13ck201 = 1.0 time = 1010
* CHECK dout0_14 vdout0_14ck201 = 0 time = 1010
* CHECK dout0_15 vdout0_15ck201 = 1.0 time = 1010
* CHECK dout0_16 vdout0_16ck201 = 0 time = 1010
* CHECK dout0_17 vdout0_17ck201 = 1.0 time = 1010
* CHECK dout0_18 vdout0_18ck201 = 1.0 time = 1010
* CHECK dout0_19 vdout0_19ck201 = 0 time = 1010
* CHECK dout0_20 vdout0_20ck201 = 1.0 time = 1010
* CHECK dout0_21 vdout0_21ck201 = 0 time = 1010
* CHECK dout0_22 vdout0_22ck201 = 0 time = 1010
* CHECK dout0_23 vdout0_23ck201 = 0 time = 1010
* CHECK dout0_24 vdout0_24ck201 = 1.0 time = 1010
* CHECK dout0_25 vdout0_25ck201 = 0 time = 1010
* CHECK dout0_26 vdout0_26ck201 = 1.0 time = 1010
* CHECK dout0_27 vdout0_27ck201 = 1.0 time = 1010
* CHECK dout0_28 vdout0_28ck201 = 1.0 time = 1010
* CHECK dout0_29 vdout0_29ck201 = 0 time = 1010
* CHECK dout0_30 vdout0_30ck201 = 0 time = 1010
* CHECK dout0_31 vdout0_31ck201 = 1.0 time = 1010
* CHECK dout0_32 vdout0_32ck201 = 1.0 time = 1010
* CHECK dout0_33 vdout0_33ck201 = 0 time = 1010
* CHECK dout0_34 vdout0_34ck201 = 0 time = 1010
* CHECK dout0_35 vdout0_35ck201 = 0 time = 1010
* CHECK dout0_36 vdout0_36ck201 = 1.0 time = 1010
* CHECK dout0_37 vdout0_37ck201 = 1.0 time = 1010
* CHECK dout0_38 vdout0_38ck201 = 1.0 time = 1010
* CHECK dout0_39 vdout0_39ck201 = 1.0 time = 1010
* CHECK dout0_40 vdout0_40ck201 = 1.0 time = 1010
* CHECK dout0_41 vdout0_41ck201 = 0 time = 1010
* CHECK dout0_42 vdout0_42ck201 = 0 time = 1010
* CHECK dout0_43 vdout0_43ck201 = 1.0 time = 1010
* CHECK dout0_44 vdout0_44ck201 = 1.0 time = 1010
* CHECK dout0_45 vdout0_45ck201 = 1.0 time = 1010
* CHECK dout0_46 vdout0_46ck201 = 0 time = 1010
* CHECK dout0_47 vdout0_47ck201 = 1.0 time = 1010
* CHECK dout0_48 vdout0_48ck201 = 0 time = 1010
* CHECK dout0_49 vdout0_49ck201 = 1.0 time = 1010
* CHECK dout0_50 vdout0_50ck201 = 1.0 time = 1010
* CHECK dout0_51 vdout0_51ck201 = 0 time = 1010
* CHECK dout0_52 vdout0_52ck201 = 1.0 time = 1010
* CHECK dout0_53 vdout0_53ck201 = 0 time = 1010
* CHECK dout0_54 vdout0_54ck201 = 1.0 time = 1010
* CHECK dout0_55 vdout0_55ck201 = 1.0 time = 1010
* CHECK dout0_56 vdout0_56ck201 = 1.0 time = 1010
* CHECK dout0_57 vdout0_57ck201 = 1.0 time = 1010
* CHECK dout0_58 vdout0_58ck201 = 0 time = 1010
* CHECK dout0_59 vdout0_59ck201 = 0 time = 1010
* CHECK dout0_60 vdout0_60ck201 = 1.0 time = 1010
* CHECK dout0_61 vdout0_61ck201 = 1.0 time = 1010
* CHECK dout0_62 vdout0_62ck201 = 1.0 time = 1010
* CHECK dout0_63 vdout0_63ck201 = 1.0 time = 1010
* CHECK dout0_0 vdout0_0ck203 = 1.0 time = 1020
* CHECK dout0_1 vdout0_1ck203 = 0 time = 1020
* CHECK dout0_2 vdout0_2ck203 = 0 time = 1020
* CHECK dout0_3 vdout0_3ck203 = 1.0 time = 1020
* CHECK dout0_4 vdout0_4ck203 = 1.0 time = 1020
* CHECK dout0_5 vdout0_5ck203 = 1.0 time = 1020
* CHECK dout0_6 vdout0_6ck203 = 1.0 time = 1020
* CHECK dout0_7 vdout0_7ck203 = 1.0 time = 1020
* CHECK dout0_8 vdout0_8ck203 = 1.0 time = 1020
* CHECK dout0_9 vdout0_9ck203 = 0 time = 1020
* CHECK dout0_10 vdout0_10ck203 = 1.0 time = 1020
* CHECK dout0_11 vdout0_11ck203 = 0 time = 1020
* CHECK dout0_12 vdout0_12ck203 = 1.0 time = 1020
* CHECK dout0_13 vdout0_13ck203 = 0 time = 1020
* CHECK dout0_14 vdout0_14ck203 = 0 time = 1020
* CHECK dout0_15 vdout0_15ck203 = 0 time = 1020
* CHECK dout0_16 vdout0_16ck203 = 1.0 time = 1020
* CHECK dout0_17 vdout0_17ck203 = 1.0 time = 1020
* CHECK dout0_18 vdout0_18ck203 = 1.0 time = 1020
* CHECK dout0_19 vdout0_19ck203 = 0 time = 1020
* CHECK dout0_20 vdout0_20ck203 = 1.0 time = 1020
* CHECK dout0_21 vdout0_21ck203 = 1.0 time = 1020
* CHECK dout0_22 vdout0_22ck203 = 0 time = 1020
* CHECK dout0_23 vdout0_23ck203 = 1.0 time = 1020
* CHECK dout0_24 vdout0_24ck203 = 0 time = 1020
* CHECK dout0_25 vdout0_25ck203 = 1.0 time = 1020
* CHECK dout0_26 vdout0_26ck203 = 0 time = 1020
* CHECK dout0_27 vdout0_27ck203 = 0 time = 1020
* CHECK dout0_28 vdout0_28ck203 = 1.0 time = 1020
* CHECK dout0_29 vdout0_29ck203 = 0 time = 1020
* CHECK dout0_30 vdout0_30ck203 = 1.0 time = 1020
* CHECK dout0_31 vdout0_31ck203 = 0 time = 1020
* CHECK dout0_32 vdout0_32ck203 = 1.0 time = 1020
* CHECK dout0_33 vdout0_33ck203 = 0 time = 1020
* CHECK dout0_34 vdout0_34ck203 = 0 time = 1020
* CHECK dout0_35 vdout0_35ck203 = 1.0 time = 1020
* CHECK dout0_36 vdout0_36ck203 = 0 time = 1020
* CHECK dout0_37 vdout0_37ck203 = 1.0 time = 1020
* CHECK dout0_38 vdout0_38ck203 = 0 time = 1020
* CHECK dout0_39 vdout0_39ck203 = 0 time = 1020
* CHECK dout0_40 vdout0_40ck203 = 1.0 time = 1020
* CHECK dout0_41 vdout0_41ck203 = 0 time = 1020
* CHECK dout0_42 vdout0_42ck203 = 1.0 time = 1020
* CHECK dout0_43 vdout0_43ck203 = 1.0 time = 1020
* CHECK dout0_44 vdout0_44ck203 = 0 time = 1020
* CHECK dout0_45 vdout0_45ck203 = 1.0 time = 1020
* CHECK dout0_46 vdout0_46ck203 = 0 time = 1020
* CHECK dout0_47 vdout0_47ck203 = 1.0 time = 1020
* CHECK dout0_48 vdout0_48ck203 = 0 time = 1020
* CHECK dout0_49 vdout0_49ck203 = 0 time = 1020
* CHECK dout0_50 vdout0_50ck203 = 1.0 time = 1020
* CHECK dout0_51 vdout0_51ck203 = 1.0 time = 1020
* CHECK dout0_52 vdout0_52ck203 = 1.0 time = 1020
* CHECK dout0_53 vdout0_53ck203 = 1.0 time = 1020
* CHECK dout0_54 vdout0_54ck203 = 1.0 time = 1020
* CHECK dout0_55 vdout0_55ck203 = 1.0 time = 1020
* CHECK dout0_56 vdout0_56ck203 = 1.0 time = 1020
* CHECK dout0_57 vdout0_57ck203 = 1.0 time = 1020
* CHECK dout0_58 vdout0_58ck203 = 1.0 time = 1020
* CHECK dout0_59 vdout0_59ck203 = 1.0 time = 1020
* CHECK dout0_60 vdout0_60ck203 = 0 time = 1020
* CHECK dout0_61 vdout0_61ck203 = 1.0 time = 1020
* CHECK dout0_62 vdout0_62ck203 = 0 time = 1020
* CHECK dout0_63 vdout0_63ck203 = 0 time = 1020
* CHECK dout1_0 vdout1_0ck203 = 0 time = 1020
* CHECK dout1_1 vdout1_1ck203 = 0 time = 1020
* CHECK dout1_2 vdout1_2ck203 = 0 time = 1020
* CHECK dout1_3 vdout1_3ck203 = 1.0 time = 1020
* CHECK dout1_4 vdout1_4ck203 = 0 time = 1020
* CHECK dout1_5 vdout1_5ck203 = 0 time = 1020
* CHECK dout1_6 vdout1_6ck203 = 0 time = 1020
* CHECK dout1_7 vdout1_7ck203 = 1.0 time = 1020
* CHECK dout1_8 vdout1_8ck203 = 0 time = 1020
* CHECK dout1_9 vdout1_9ck203 = 0 time = 1020
* CHECK dout1_10 vdout1_10ck203 = 1.0 time = 1020
* CHECK dout1_11 vdout1_11ck203 = 1.0 time = 1020
* CHECK dout1_12 vdout1_12ck203 = 1.0 time = 1020
* CHECK dout1_13 vdout1_13ck203 = 1.0 time = 1020
* CHECK dout1_14 vdout1_14ck203 = 1.0 time = 1020
* CHECK dout1_15 vdout1_15ck203 = 0 time = 1020
* CHECK dout1_16 vdout1_16ck203 = 0 time = 1020
* CHECK dout1_17 vdout1_17ck203 = 1.0 time = 1020
* CHECK dout1_18 vdout1_18ck203 = 1.0 time = 1020
* CHECK dout1_19 vdout1_19ck203 = 0 time = 1020
* CHECK dout1_20 vdout1_20ck203 = 1.0 time = 1020
* CHECK dout1_21 vdout1_21ck203 = 0 time = 1020
* CHECK dout1_22 vdout1_22ck203 = 1.0 time = 1020
* CHECK dout1_23 vdout1_23ck203 = 0 time = 1020
* CHECK dout1_24 vdout1_24ck203 = 0 time = 1020
* CHECK dout1_25 vdout1_25ck203 = 1.0 time = 1020
* CHECK dout1_26 vdout1_26ck203 = 1.0 time = 1020
* CHECK dout1_27 vdout1_27ck203 = 1.0 time = 1020
* CHECK dout1_28 vdout1_28ck203 = 1.0 time = 1020
* CHECK dout1_29 vdout1_29ck203 = 1.0 time = 1020
* CHECK dout1_30 vdout1_30ck203 = 0 time = 1020
* CHECK dout1_31 vdout1_31ck203 = 1.0 time = 1020
* CHECK dout1_32 vdout1_32ck203 = 0 time = 1020
* CHECK dout1_33 vdout1_33ck203 = 0 time = 1020
* CHECK dout1_34 vdout1_34ck203 = 1.0 time = 1020
* CHECK dout1_35 vdout1_35ck203 = 0 time = 1020
* CHECK dout1_36 vdout1_36ck203 = 0 time = 1020
* CHECK dout1_37 vdout1_37ck203 = 1.0 time = 1020
* CHECK dout1_38 vdout1_38ck203 = 0 time = 1020
* CHECK dout1_39 vdout1_39ck203 = 0 time = 1020
* CHECK dout1_40 vdout1_40ck203 = 0 time = 1020
* CHECK dout1_41 vdout1_41ck203 = 1.0 time = 1020
* CHECK dout1_42 vdout1_42ck203 = 1.0 time = 1020
* CHECK dout1_43 vdout1_43ck203 = 1.0 time = 1020
* CHECK dout1_44 vdout1_44ck203 = 0 time = 1020
* CHECK dout1_45 vdout1_45ck203 = 1.0 time = 1020
* CHECK dout1_46 vdout1_46ck203 = 1.0 time = 1020
* CHECK dout1_47 vdout1_47ck203 = 0 time = 1020
* CHECK dout1_48 vdout1_48ck203 = 1.0 time = 1020
* CHECK dout1_49 vdout1_49ck203 = 1.0 time = 1020
* CHECK dout1_50 vdout1_50ck203 = 0 time = 1020
* CHECK dout1_51 vdout1_51ck203 = 0 time = 1020
* CHECK dout1_52 vdout1_52ck203 = 1.0 time = 1020
* CHECK dout1_53 vdout1_53ck203 = 0 time = 1020
* CHECK dout1_54 vdout1_54ck203 = 1.0 time = 1020
* CHECK dout1_55 vdout1_55ck203 = 1.0 time = 1020
* CHECK dout1_56 vdout1_56ck203 = 1.0 time = 1020
* CHECK dout1_57 vdout1_57ck203 = 1.0 time = 1020
* CHECK dout1_58 vdout1_58ck203 = 0 time = 1020
* CHECK dout1_59 vdout1_59ck203 = 0 time = 1020
* CHECK dout1_60 vdout1_60ck203 = 1.0 time = 1020
* CHECK dout1_61 vdout1_61ck203 = 1.0 time = 1020
* CHECK dout1_62 vdout1_62ck203 = 1.0 time = 1020
* CHECK dout1_63 vdout1_63ck203 = 1.0 time = 1020
.include /home/ihs24/OpenRAM/openram_outputs/fp32_SRAM_MACROS/functional_meas.sp
* probe is used for hspice/xa, while plot is used in ngspice
*.probe V(*)
*.plot V(*)
.end
