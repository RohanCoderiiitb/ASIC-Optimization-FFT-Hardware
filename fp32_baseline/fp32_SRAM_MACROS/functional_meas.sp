.meas tran vdout0_0ck40 FIND v(dout0_0) AT=25.025n

.meas tran vdout0_1ck40 FIND v(dout0_1) AT=25.025n

.meas tran vdout0_2ck40 FIND v(dout0_2) AT=25.025n

.meas tran vdout0_3ck40 FIND v(dout0_3) AT=25.025n

.meas tran vdout0_4ck40 FIND v(dout0_4) AT=25.025n

.meas tran vdout0_5ck40 FIND v(dout0_5) AT=25.025n

.meas tran vdout0_6ck40 FIND v(dout0_6) AT=25.025n

.meas tran vdout0_7ck40 FIND v(dout0_7) AT=25.025n

.meas tran vdout0_8ck40 FIND v(dout0_8) AT=25.025n

.meas tran vdout0_9ck40 FIND v(dout0_9) AT=25.025n

.meas tran vdout0_10ck40 FIND v(dout0_10) AT=25.025n

.meas tran vdout0_11ck40 FIND v(dout0_11) AT=25.025n

.meas tran vdout0_12ck40 FIND v(dout0_12) AT=25.025n

.meas tran vdout0_13ck40 FIND v(dout0_13) AT=25.025n

.meas tran vdout0_14ck40 FIND v(dout0_14) AT=25.025n

.meas tran vdout0_15ck40 FIND v(dout0_15) AT=25.025n

.meas tran vdout0_16ck40 FIND v(dout0_16) AT=25.025n

.meas tran vdout0_17ck40 FIND v(dout0_17) AT=25.025n

.meas tran vdout0_18ck40 FIND v(dout0_18) AT=25.025n

.meas tran vdout0_19ck40 FIND v(dout0_19) AT=25.025n

.meas tran vdout0_20ck40 FIND v(dout0_20) AT=25.025n

.meas tran vdout0_21ck40 FIND v(dout0_21) AT=25.025n

.meas tran vdout0_22ck40 FIND v(dout0_22) AT=25.025n

.meas tran vdout0_23ck40 FIND v(dout0_23) AT=25.025n

.meas tran vdout0_24ck40 FIND v(dout0_24) AT=25.025n

.meas tran vdout0_25ck40 FIND v(dout0_25) AT=25.025n

.meas tran vdout0_26ck40 FIND v(dout0_26) AT=25.025n

.meas tran vdout0_27ck40 FIND v(dout0_27) AT=25.025n

.meas tran vdout0_28ck40 FIND v(dout0_28) AT=25.025n

.meas tran vdout0_29ck40 FIND v(dout0_29) AT=25.025n

.meas tran vdout0_30ck40 FIND v(dout0_30) AT=25.025n

.meas tran vdout0_31ck40 FIND v(dout0_31) AT=25.025n

.meas tran vdout0_32ck40 FIND v(dout0_32) AT=25.025n

.meas tran vdout0_33ck40 FIND v(dout0_33) AT=25.025n

.meas tran vdout0_34ck40 FIND v(dout0_34) AT=25.025n

.meas tran vdout0_35ck40 FIND v(dout0_35) AT=25.025n

.meas tran vdout0_36ck40 FIND v(dout0_36) AT=25.025n

.meas tran vdout0_37ck40 FIND v(dout0_37) AT=25.025n

.meas tran vdout0_38ck40 FIND v(dout0_38) AT=25.025n

.meas tran vdout0_39ck40 FIND v(dout0_39) AT=25.025n

.meas tran vdout0_40ck40 FIND v(dout0_40) AT=25.025n

.meas tran vdout0_41ck40 FIND v(dout0_41) AT=25.025n

.meas tran vdout0_42ck40 FIND v(dout0_42) AT=25.025n

.meas tran vdout0_43ck40 FIND v(dout0_43) AT=25.025n

.meas tran vdout0_44ck40 FIND v(dout0_44) AT=25.025n

.meas tran vdout0_45ck40 FIND v(dout0_45) AT=25.025n

.meas tran vdout0_46ck40 FIND v(dout0_46) AT=25.025n

.meas tran vdout0_47ck40 FIND v(dout0_47) AT=25.025n

.meas tran vdout0_48ck40 FIND v(dout0_48) AT=25.025n

.meas tran vdout0_49ck40 FIND v(dout0_49) AT=25.025n

.meas tran vdout0_50ck40 FIND v(dout0_50) AT=25.025n

.meas tran vdout0_51ck40 FIND v(dout0_51) AT=25.025n

.meas tran vdout0_52ck40 FIND v(dout0_52) AT=25.025n

.meas tran vdout0_53ck40 FIND v(dout0_53) AT=25.025n

.meas tran vdout0_54ck40 FIND v(dout0_54) AT=25.025n

.meas tran vdout0_55ck40 FIND v(dout0_55) AT=25.025n

.meas tran vdout0_56ck40 FIND v(dout0_56) AT=25.025n

.meas tran vdout0_57ck40 FIND v(dout0_57) AT=25.025n

.meas tran vdout0_58ck40 FIND v(dout0_58) AT=25.025n

.meas tran vdout0_59ck40 FIND v(dout0_59) AT=25.025n

.meas tran vdout0_60ck40 FIND v(dout0_60) AT=25.025n

.meas tran vdout0_61ck40 FIND v(dout0_61) AT=25.025n

.meas tran vdout0_62ck40 FIND v(dout0_62) AT=25.025n

.meas tran vdout0_63ck40 FIND v(dout0_63) AT=25.025n

.meas tran vdout1_0ck40 FIND v(dout1_0) AT=25.025n

.meas tran vdout1_1ck40 FIND v(dout1_1) AT=25.025n

.meas tran vdout1_2ck40 FIND v(dout1_2) AT=25.025n

.meas tran vdout1_3ck40 FIND v(dout1_3) AT=25.025n

.meas tran vdout1_4ck40 FIND v(dout1_4) AT=25.025n

.meas tran vdout1_5ck40 FIND v(dout1_5) AT=25.025n

.meas tran vdout1_6ck40 FIND v(dout1_6) AT=25.025n

.meas tran vdout1_7ck40 FIND v(dout1_7) AT=25.025n

.meas tran vdout1_8ck40 FIND v(dout1_8) AT=25.025n

.meas tran vdout1_9ck40 FIND v(dout1_9) AT=25.025n

.meas tran vdout1_10ck40 FIND v(dout1_10) AT=25.025n

.meas tran vdout1_11ck40 FIND v(dout1_11) AT=25.025n

.meas tran vdout1_12ck40 FIND v(dout1_12) AT=25.025n

.meas tran vdout1_13ck40 FIND v(dout1_13) AT=25.025n

.meas tran vdout1_14ck40 FIND v(dout1_14) AT=25.025n

.meas tran vdout1_15ck40 FIND v(dout1_15) AT=25.025n

.meas tran vdout1_16ck40 FIND v(dout1_16) AT=25.025n

.meas tran vdout1_17ck40 FIND v(dout1_17) AT=25.025n

.meas tran vdout1_18ck40 FIND v(dout1_18) AT=25.025n

.meas tran vdout1_19ck40 FIND v(dout1_19) AT=25.025n

.meas tran vdout1_20ck40 FIND v(dout1_20) AT=25.025n

.meas tran vdout1_21ck40 FIND v(dout1_21) AT=25.025n

.meas tran vdout1_22ck40 FIND v(dout1_22) AT=25.025n

.meas tran vdout1_23ck40 FIND v(dout1_23) AT=25.025n

.meas tran vdout1_24ck40 FIND v(dout1_24) AT=25.025n

.meas tran vdout1_25ck40 FIND v(dout1_25) AT=25.025n

.meas tran vdout1_26ck40 FIND v(dout1_26) AT=25.025n

.meas tran vdout1_27ck40 FIND v(dout1_27) AT=25.025n

.meas tran vdout1_28ck40 FIND v(dout1_28) AT=25.025n

.meas tran vdout1_29ck40 FIND v(dout1_29) AT=25.025n

.meas tran vdout1_30ck40 FIND v(dout1_30) AT=25.025n

.meas tran vdout1_31ck40 FIND v(dout1_31) AT=25.025n

.meas tran vdout1_32ck40 FIND v(dout1_32) AT=25.025n

.meas tran vdout1_33ck40 FIND v(dout1_33) AT=25.025n

.meas tran vdout1_34ck40 FIND v(dout1_34) AT=25.025n

.meas tran vdout1_35ck40 FIND v(dout1_35) AT=25.025n

.meas tran vdout1_36ck40 FIND v(dout1_36) AT=25.025n

.meas tran vdout1_37ck40 FIND v(dout1_37) AT=25.025n

.meas tran vdout1_38ck40 FIND v(dout1_38) AT=25.025n

.meas tran vdout1_39ck40 FIND v(dout1_39) AT=25.025n

.meas tran vdout1_40ck40 FIND v(dout1_40) AT=25.025n

.meas tran vdout1_41ck40 FIND v(dout1_41) AT=25.025n

.meas tran vdout1_42ck40 FIND v(dout1_42) AT=25.025n

.meas tran vdout1_43ck40 FIND v(dout1_43) AT=25.025n

.meas tran vdout1_44ck40 FIND v(dout1_44) AT=25.025n

.meas tran vdout1_45ck40 FIND v(dout1_45) AT=25.025n

.meas tran vdout1_46ck40 FIND v(dout1_46) AT=25.025n

.meas tran vdout1_47ck40 FIND v(dout1_47) AT=25.025n

.meas tran vdout1_48ck40 FIND v(dout1_48) AT=25.025n

.meas tran vdout1_49ck40 FIND v(dout1_49) AT=25.025n

.meas tran vdout1_50ck40 FIND v(dout1_50) AT=25.025n

.meas tran vdout1_51ck40 FIND v(dout1_51) AT=25.025n

.meas tran vdout1_52ck40 FIND v(dout1_52) AT=25.025n

.meas tran vdout1_53ck40 FIND v(dout1_53) AT=25.025n

.meas tran vdout1_54ck40 FIND v(dout1_54) AT=25.025n

.meas tran vdout1_55ck40 FIND v(dout1_55) AT=25.025n

.meas tran vdout1_56ck40 FIND v(dout1_56) AT=25.025n

.meas tran vdout1_57ck40 FIND v(dout1_57) AT=25.025n

.meas tran vdout1_58ck40 FIND v(dout1_58) AT=25.025n

.meas tran vdout1_59ck40 FIND v(dout1_59) AT=25.025n

.meas tran vdout1_60ck40 FIND v(dout1_60) AT=25.025n

.meas tran vdout1_61ck40 FIND v(dout1_61) AT=25.025n

.meas tran vdout1_62ck40 FIND v(dout1_62) AT=25.025n

.meas tran vdout1_63ck40 FIND v(dout1_63) AT=25.025n

.meas tran vdout0_0ck50 FIND v(dout0_0) AT=30.025n

.meas tran vdout0_1ck50 FIND v(dout0_1) AT=30.025n

.meas tran vdout0_2ck50 FIND v(dout0_2) AT=30.025n

.meas tran vdout0_3ck50 FIND v(dout0_3) AT=30.025n

.meas tran vdout0_4ck50 FIND v(dout0_4) AT=30.025n

.meas tran vdout0_5ck50 FIND v(dout0_5) AT=30.025n

.meas tran vdout0_6ck50 FIND v(dout0_6) AT=30.025n

.meas tran vdout0_7ck50 FIND v(dout0_7) AT=30.025n

.meas tran vdout0_8ck50 FIND v(dout0_8) AT=30.025n

.meas tran vdout0_9ck50 FIND v(dout0_9) AT=30.025n

.meas tran vdout0_10ck50 FIND v(dout0_10) AT=30.025n

.meas tran vdout0_11ck50 FIND v(dout0_11) AT=30.025n

.meas tran vdout0_12ck50 FIND v(dout0_12) AT=30.025n

.meas tran vdout0_13ck50 FIND v(dout0_13) AT=30.025n

.meas tran vdout0_14ck50 FIND v(dout0_14) AT=30.025n

.meas tran vdout0_15ck50 FIND v(dout0_15) AT=30.025n

.meas tran vdout0_16ck50 FIND v(dout0_16) AT=30.025n

.meas tran vdout0_17ck50 FIND v(dout0_17) AT=30.025n

.meas tran vdout0_18ck50 FIND v(dout0_18) AT=30.025n

.meas tran vdout0_19ck50 FIND v(dout0_19) AT=30.025n

.meas tran vdout0_20ck50 FIND v(dout0_20) AT=30.025n

.meas tran vdout0_21ck50 FIND v(dout0_21) AT=30.025n

.meas tran vdout0_22ck50 FIND v(dout0_22) AT=30.025n

.meas tran vdout0_23ck50 FIND v(dout0_23) AT=30.025n

.meas tran vdout0_24ck50 FIND v(dout0_24) AT=30.025n

.meas tran vdout0_25ck50 FIND v(dout0_25) AT=30.025n

.meas tran vdout0_26ck50 FIND v(dout0_26) AT=30.025n

.meas tran vdout0_27ck50 FIND v(dout0_27) AT=30.025n

.meas tran vdout0_28ck50 FIND v(dout0_28) AT=30.025n

.meas tran vdout0_29ck50 FIND v(dout0_29) AT=30.025n

.meas tran vdout0_30ck50 FIND v(dout0_30) AT=30.025n

.meas tran vdout0_31ck50 FIND v(dout0_31) AT=30.025n

.meas tran vdout0_32ck50 FIND v(dout0_32) AT=30.025n

.meas tran vdout0_33ck50 FIND v(dout0_33) AT=30.025n

.meas tran vdout0_34ck50 FIND v(dout0_34) AT=30.025n

.meas tran vdout0_35ck50 FIND v(dout0_35) AT=30.025n

.meas tran vdout0_36ck50 FIND v(dout0_36) AT=30.025n

.meas tran vdout0_37ck50 FIND v(dout0_37) AT=30.025n

.meas tran vdout0_38ck50 FIND v(dout0_38) AT=30.025n

.meas tran vdout0_39ck50 FIND v(dout0_39) AT=30.025n

.meas tran vdout0_40ck50 FIND v(dout0_40) AT=30.025n

.meas tran vdout0_41ck50 FIND v(dout0_41) AT=30.025n

.meas tran vdout0_42ck50 FIND v(dout0_42) AT=30.025n

.meas tran vdout0_43ck50 FIND v(dout0_43) AT=30.025n

.meas tran vdout0_44ck50 FIND v(dout0_44) AT=30.025n

.meas tran vdout0_45ck50 FIND v(dout0_45) AT=30.025n

.meas tran vdout0_46ck50 FIND v(dout0_46) AT=30.025n

.meas tran vdout0_47ck50 FIND v(dout0_47) AT=30.025n

.meas tran vdout0_48ck50 FIND v(dout0_48) AT=30.025n

.meas tran vdout0_49ck50 FIND v(dout0_49) AT=30.025n

.meas tran vdout0_50ck50 FIND v(dout0_50) AT=30.025n

.meas tran vdout0_51ck50 FIND v(dout0_51) AT=30.025n

.meas tran vdout0_52ck50 FIND v(dout0_52) AT=30.025n

.meas tran vdout0_53ck50 FIND v(dout0_53) AT=30.025n

.meas tran vdout0_54ck50 FIND v(dout0_54) AT=30.025n

.meas tran vdout0_55ck50 FIND v(dout0_55) AT=30.025n

.meas tran vdout0_56ck50 FIND v(dout0_56) AT=30.025n

.meas tran vdout0_57ck50 FIND v(dout0_57) AT=30.025n

.meas tran vdout0_58ck50 FIND v(dout0_58) AT=30.025n

.meas tran vdout0_59ck50 FIND v(dout0_59) AT=30.025n

.meas tran vdout0_60ck50 FIND v(dout0_60) AT=30.025n

.meas tran vdout0_61ck50 FIND v(dout0_61) AT=30.025n

.meas tran vdout0_62ck50 FIND v(dout0_62) AT=30.025n

.meas tran vdout0_63ck50 FIND v(dout0_63) AT=30.025n

.meas tran vdout1_0ck50 FIND v(dout1_0) AT=30.025n

.meas tran vdout1_1ck50 FIND v(dout1_1) AT=30.025n

.meas tran vdout1_2ck50 FIND v(dout1_2) AT=30.025n

.meas tran vdout1_3ck50 FIND v(dout1_3) AT=30.025n

.meas tran vdout1_4ck50 FIND v(dout1_4) AT=30.025n

.meas tran vdout1_5ck50 FIND v(dout1_5) AT=30.025n

.meas tran vdout1_6ck50 FIND v(dout1_6) AT=30.025n

.meas tran vdout1_7ck50 FIND v(dout1_7) AT=30.025n

.meas tran vdout1_8ck50 FIND v(dout1_8) AT=30.025n

.meas tran vdout1_9ck50 FIND v(dout1_9) AT=30.025n

.meas tran vdout1_10ck50 FIND v(dout1_10) AT=30.025n

.meas tran vdout1_11ck50 FIND v(dout1_11) AT=30.025n

.meas tran vdout1_12ck50 FIND v(dout1_12) AT=30.025n

.meas tran vdout1_13ck50 FIND v(dout1_13) AT=30.025n

.meas tran vdout1_14ck50 FIND v(dout1_14) AT=30.025n

.meas tran vdout1_15ck50 FIND v(dout1_15) AT=30.025n

.meas tran vdout1_16ck50 FIND v(dout1_16) AT=30.025n

.meas tran vdout1_17ck50 FIND v(dout1_17) AT=30.025n

.meas tran vdout1_18ck50 FIND v(dout1_18) AT=30.025n

.meas tran vdout1_19ck50 FIND v(dout1_19) AT=30.025n

.meas tran vdout1_20ck50 FIND v(dout1_20) AT=30.025n

.meas tran vdout1_21ck50 FIND v(dout1_21) AT=30.025n

.meas tran vdout1_22ck50 FIND v(dout1_22) AT=30.025n

.meas tran vdout1_23ck50 FIND v(dout1_23) AT=30.025n

.meas tran vdout1_24ck50 FIND v(dout1_24) AT=30.025n

.meas tran vdout1_25ck50 FIND v(dout1_25) AT=30.025n

.meas tran vdout1_26ck50 FIND v(dout1_26) AT=30.025n

.meas tran vdout1_27ck50 FIND v(dout1_27) AT=30.025n

.meas tran vdout1_28ck50 FIND v(dout1_28) AT=30.025n

.meas tran vdout1_29ck50 FIND v(dout1_29) AT=30.025n

.meas tran vdout1_30ck50 FIND v(dout1_30) AT=30.025n

.meas tran vdout1_31ck50 FIND v(dout1_31) AT=30.025n

.meas tran vdout1_32ck50 FIND v(dout1_32) AT=30.025n

.meas tran vdout1_33ck50 FIND v(dout1_33) AT=30.025n

.meas tran vdout1_34ck50 FIND v(dout1_34) AT=30.025n

.meas tran vdout1_35ck50 FIND v(dout1_35) AT=30.025n

.meas tran vdout1_36ck50 FIND v(dout1_36) AT=30.025n

.meas tran vdout1_37ck50 FIND v(dout1_37) AT=30.025n

.meas tran vdout1_38ck50 FIND v(dout1_38) AT=30.025n

.meas tran vdout1_39ck50 FIND v(dout1_39) AT=30.025n

.meas tran vdout1_40ck50 FIND v(dout1_40) AT=30.025n

.meas tran vdout1_41ck50 FIND v(dout1_41) AT=30.025n

.meas tran vdout1_42ck50 FIND v(dout1_42) AT=30.025n

.meas tran vdout1_43ck50 FIND v(dout1_43) AT=30.025n

.meas tran vdout1_44ck50 FIND v(dout1_44) AT=30.025n

.meas tran vdout1_45ck50 FIND v(dout1_45) AT=30.025n

.meas tran vdout1_46ck50 FIND v(dout1_46) AT=30.025n

.meas tran vdout1_47ck50 FIND v(dout1_47) AT=30.025n

.meas tran vdout1_48ck50 FIND v(dout1_48) AT=30.025n

.meas tran vdout1_49ck50 FIND v(dout1_49) AT=30.025n

.meas tran vdout1_50ck50 FIND v(dout1_50) AT=30.025n

.meas tran vdout1_51ck50 FIND v(dout1_51) AT=30.025n

.meas tran vdout1_52ck50 FIND v(dout1_52) AT=30.025n

.meas tran vdout1_53ck50 FIND v(dout1_53) AT=30.025n

.meas tran vdout1_54ck50 FIND v(dout1_54) AT=30.025n

.meas tran vdout1_55ck50 FIND v(dout1_55) AT=30.025n

.meas tran vdout1_56ck50 FIND v(dout1_56) AT=30.025n

.meas tran vdout1_57ck50 FIND v(dout1_57) AT=30.025n

.meas tran vdout1_58ck50 FIND v(dout1_58) AT=30.025n

.meas tran vdout1_59ck50 FIND v(dout1_59) AT=30.025n

.meas tran vdout1_60ck50 FIND v(dout1_60) AT=30.025n

.meas tran vdout1_61ck50 FIND v(dout1_61) AT=30.025n

.meas tran vdout1_62ck50 FIND v(dout1_62) AT=30.025n

.meas tran vdout1_63ck50 FIND v(dout1_63) AT=30.025n

.meas tran vdout0_0ck70 FIND v(dout0_0) AT=40.025n

.meas tran vdout0_1ck70 FIND v(dout0_1) AT=40.025n

.meas tran vdout0_2ck70 FIND v(dout0_2) AT=40.025n

.meas tran vdout0_3ck70 FIND v(dout0_3) AT=40.025n

.meas tran vdout0_4ck70 FIND v(dout0_4) AT=40.025n

.meas tran vdout0_5ck70 FIND v(dout0_5) AT=40.025n

.meas tran vdout0_6ck70 FIND v(dout0_6) AT=40.025n

.meas tran vdout0_7ck70 FIND v(dout0_7) AT=40.025n

.meas tran vdout0_8ck70 FIND v(dout0_8) AT=40.025n

.meas tran vdout0_9ck70 FIND v(dout0_9) AT=40.025n

.meas tran vdout0_10ck70 FIND v(dout0_10) AT=40.025n

.meas tran vdout0_11ck70 FIND v(dout0_11) AT=40.025n

.meas tran vdout0_12ck70 FIND v(dout0_12) AT=40.025n

.meas tran vdout0_13ck70 FIND v(dout0_13) AT=40.025n

.meas tran vdout0_14ck70 FIND v(dout0_14) AT=40.025n

.meas tran vdout0_15ck70 FIND v(dout0_15) AT=40.025n

.meas tran vdout0_16ck70 FIND v(dout0_16) AT=40.025n

.meas tran vdout0_17ck70 FIND v(dout0_17) AT=40.025n

.meas tran vdout0_18ck70 FIND v(dout0_18) AT=40.025n

.meas tran vdout0_19ck70 FIND v(dout0_19) AT=40.025n

.meas tran vdout0_20ck70 FIND v(dout0_20) AT=40.025n

.meas tran vdout0_21ck70 FIND v(dout0_21) AT=40.025n

.meas tran vdout0_22ck70 FIND v(dout0_22) AT=40.025n

.meas tran vdout0_23ck70 FIND v(dout0_23) AT=40.025n

.meas tran vdout0_24ck70 FIND v(dout0_24) AT=40.025n

.meas tran vdout0_25ck70 FIND v(dout0_25) AT=40.025n

.meas tran vdout0_26ck70 FIND v(dout0_26) AT=40.025n

.meas tran vdout0_27ck70 FIND v(dout0_27) AT=40.025n

.meas tran vdout0_28ck70 FIND v(dout0_28) AT=40.025n

.meas tran vdout0_29ck70 FIND v(dout0_29) AT=40.025n

.meas tran vdout0_30ck70 FIND v(dout0_30) AT=40.025n

.meas tran vdout0_31ck70 FIND v(dout0_31) AT=40.025n

.meas tran vdout0_32ck70 FIND v(dout0_32) AT=40.025n

.meas tran vdout0_33ck70 FIND v(dout0_33) AT=40.025n

.meas tran vdout0_34ck70 FIND v(dout0_34) AT=40.025n

.meas tran vdout0_35ck70 FIND v(dout0_35) AT=40.025n

.meas tran vdout0_36ck70 FIND v(dout0_36) AT=40.025n

.meas tran vdout0_37ck70 FIND v(dout0_37) AT=40.025n

.meas tran vdout0_38ck70 FIND v(dout0_38) AT=40.025n

.meas tran vdout0_39ck70 FIND v(dout0_39) AT=40.025n

.meas tran vdout0_40ck70 FIND v(dout0_40) AT=40.025n

.meas tran vdout0_41ck70 FIND v(dout0_41) AT=40.025n

.meas tran vdout0_42ck70 FIND v(dout0_42) AT=40.025n

.meas tran vdout0_43ck70 FIND v(dout0_43) AT=40.025n

.meas tran vdout0_44ck70 FIND v(dout0_44) AT=40.025n

.meas tran vdout0_45ck70 FIND v(dout0_45) AT=40.025n

.meas tran vdout0_46ck70 FIND v(dout0_46) AT=40.025n

.meas tran vdout0_47ck70 FIND v(dout0_47) AT=40.025n

.meas tran vdout0_48ck70 FIND v(dout0_48) AT=40.025n

.meas tran vdout0_49ck70 FIND v(dout0_49) AT=40.025n

.meas tran vdout0_50ck70 FIND v(dout0_50) AT=40.025n

.meas tran vdout0_51ck70 FIND v(dout0_51) AT=40.025n

.meas tran vdout0_52ck70 FIND v(dout0_52) AT=40.025n

.meas tran vdout0_53ck70 FIND v(dout0_53) AT=40.025n

.meas tran vdout0_54ck70 FIND v(dout0_54) AT=40.025n

.meas tran vdout0_55ck70 FIND v(dout0_55) AT=40.025n

.meas tran vdout0_56ck70 FIND v(dout0_56) AT=40.025n

.meas tran vdout0_57ck70 FIND v(dout0_57) AT=40.025n

.meas tran vdout0_58ck70 FIND v(dout0_58) AT=40.025n

.meas tran vdout0_59ck70 FIND v(dout0_59) AT=40.025n

.meas tran vdout0_60ck70 FIND v(dout0_60) AT=40.025n

.meas tran vdout0_61ck70 FIND v(dout0_61) AT=40.025n

.meas tran vdout0_62ck70 FIND v(dout0_62) AT=40.025n

.meas tran vdout0_63ck70 FIND v(dout0_63) AT=40.025n

.meas tran vdout1_0ck80 FIND v(dout1_0) AT=45.025n

.meas tran vdout1_1ck80 FIND v(dout1_1) AT=45.025n

.meas tran vdout1_2ck80 FIND v(dout1_2) AT=45.025n

.meas tran vdout1_3ck80 FIND v(dout1_3) AT=45.025n

.meas tran vdout1_4ck80 FIND v(dout1_4) AT=45.025n

.meas tran vdout1_5ck80 FIND v(dout1_5) AT=45.025n

.meas tran vdout1_6ck80 FIND v(dout1_6) AT=45.025n

.meas tran vdout1_7ck80 FIND v(dout1_7) AT=45.025n

.meas tran vdout1_8ck80 FIND v(dout1_8) AT=45.025n

.meas tran vdout1_9ck80 FIND v(dout1_9) AT=45.025n

.meas tran vdout1_10ck80 FIND v(dout1_10) AT=45.025n

.meas tran vdout1_11ck80 FIND v(dout1_11) AT=45.025n

.meas tran vdout1_12ck80 FIND v(dout1_12) AT=45.025n

.meas tran vdout1_13ck80 FIND v(dout1_13) AT=45.025n

.meas tran vdout1_14ck80 FIND v(dout1_14) AT=45.025n

.meas tran vdout1_15ck80 FIND v(dout1_15) AT=45.025n

.meas tran vdout1_16ck80 FIND v(dout1_16) AT=45.025n

.meas tran vdout1_17ck80 FIND v(dout1_17) AT=45.025n

.meas tran vdout1_18ck80 FIND v(dout1_18) AT=45.025n

.meas tran vdout1_19ck80 FIND v(dout1_19) AT=45.025n

.meas tran vdout1_20ck80 FIND v(dout1_20) AT=45.025n

.meas tran vdout1_21ck80 FIND v(dout1_21) AT=45.025n

.meas tran vdout1_22ck80 FIND v(dout1_22) AT=45.025n

.meas tran vdout1_23ck80 FIND v(dout1_23) AT=45.025n

.meas tran vdout1_24ck80 FIND v(dout1_24) AT=45.025n

.meas tran vdout1_25ck80 FIND v(dout1_25) AT=45.025n

.meas tran vdout1_26ck80 FIND v(dout1_26) AT=45.025n

.meas tran vdout1_27ck80 FIND v(dout1_27) AT=45.025n

.meas tran vdout1_28ck80 FIND v(dout1_28) AT=45.025n

.meas tran vdout1_29ck80 FIND v(dout1_29) AT=45.025n

.meas tran vdout1_30ck80 FIND v(dout1_30) AT=45.025n

.meas tran vdout1_31ck80 FIND v(dout1_31) AT=45.025n

.meas tran vdout1_32ck80 FIND v(dout1_32) AT=45.025n

.meas tran vdout1_33ck80 FIND v(dout1_33) AT=45.025n

.meas tran vdout1_34ck80 FIND v(dout1_34) AT=45.025n

.meas tran vdout1_35ck80 FIND v(dout1_35) AT=45.025n

.meas tran vdout1_36ck80 FIND v(dout1_36) AT=45.025n

.meas tran vdout1_37ck80 FIND v(dout1_37) AT=45.025n

.meas tran vdout1_38ck80 FIND v(dout1_38) AT=45.025n

.meas tran vdout1_39ck80 FIND v(dout1_39) AT=45.025n

.meas tran vdout1_40ck80 FIND v(dout1_40) AT=45.025n

.meas tran vdout1_41ck80 FIND v(dout1_41) AT=45.025n

.meas tran vdout1_42ck80 FIND v(dout1_42) AT=45.025n

.meas tran vdout1_43ck80 FIND v(dout1_43) AT=45.025n

.meas tran vdout1_44ck80 FIND v(dout1_44) AT=45.025n

.meas tran vdout1_45ck80 FIND v(dout1_45) AT=45.025n

.meas tran vdout1_46ck80 FIND v(dout1_46) AT=45.025n

.meas tran vdout1_47ck80 FIND v(dout1_47) AT=45.025n

.meas tran vdout1_48ck80 FIND v(dout1_48) AT=45.025n

.meas tran vdout1_49ck80 FIND v(dout1_49) AT=45.025n

.meas tran vdout1_50ck80 FIND v(dout1_50) AT=45.025n

.meas tran vdout1_51ck80 FIND v(dout1_51) AT=45.025n

.meas tran vdout1_52ck80 FIND v(dout1_52) AT=45.025n

.meas tran vdout1_53ck80 FIND v(dout1_53) AT=45.025n

.meas tran vdout1_54ck80 FIND v(dout1_54) AT=45.025n

.meas tran vdout1_55ck80 FIND v(dout1_55) AT=45.025n

.meas tran vdout1_56ck80 FIND v(dout1_56) AT=45.025n

.meas tran vdout1_57ck80 FIND v(dout1_57) AT=45.025n

.meas tran vdout1_58ck80 FIND v(dout1_58) AT=45.025n

.meas tran vdout1_59ck80 FIND v(dout1_59) AT=45.025n

.meas tran vdout1_60ck80 FIND v(dout1_60) AT=45.025n

.meas tran vdout1_61ck80 FIND v(dout1_61) AT=45.025n

.meas tran vdout1_62ck80 FIND v(dout1_62) AT=45.025n

.meas tran vdout1_63ck80 FIND v(dout1_63) AT=45.025n

.meas tran vdout1_0ck100 FIND v(dout1_0) AT=55.025n

.meas tran vdout1_1ck100 FIND v(dout1_1) AT=55.025n

.meas tran vdout1_2ck100 FIND v(dout1_2) AT=55.025n

.meas tran vdout1_3ck100 FIND v(dout1_3) AT=55.025n

.meas tran vdout1_4ck100 FIND v(dout1_4) AT=55.025n

.meas tran vdout1_5ck100 FIND v(dout1_5) AT=55.025n

.meas tran vdout1_6ck100 FIND v(dout1_6) AT=55.025n

.meas tran vdout1_7ck100 FIND v(dout1_7) AT=55.025n

.meas tran vdout1_8ck100 FIND v(dout1_8) AT=55.025n

.meas tran vdout1_9ck100 FIND v(dout1_9) AT=55.025n

.meas tran vdout1_10ck100 FIND v(dout1_10) AT=55.025n

.meas tran vdout1_11ck100 FIND v(dout1_11) AT=55.025n

.meas tran vdout1_12ck100 FIND v(dout1_12) AT=55.025n

.meas tran vdout1_13ck100 FIND v(dout1_13) AT=55.025n

.meas tran vdout1_14ck100 FIND v(dout1_14) AT=55.025n

.meas tran vdout1_15ck100 FIND v(dout1_15) AT=55.025n

.meas tran vdout1_16ck100 FIND v(dout1_16) AT=55.025n

.meas tran vdout1_17ck100 FIND v(dout1_17) AT=55.025n

.meas tran vdout1_18ck100 FIND v(dout1_18) AT=55.025n

.meas tran vdout1_19ck100 FIND v(dout1_19) AT=55.025n

.meas tran vdout1_20ck100 FIND v(dout1_20) AT=55.025n

.meas tran vdout1_21ck100 FIND v(dout1_21) AT=55.025n

.meas tran vdout1_22ck100 FIND v(dout1_22) AT=55.025n

.meas tran vdout1_23ck100 FIND v(dout1_23) AT=55.025n

.meas tran vdout1_24ck100 FIND v(dout1_24) AT=55.025n

.meas tran vdout1_25ck100 FIND v(dout1_25) AT=55.025n

.meas tran vdout1_26ck100 FIND v(dout1_26) AT=55.025n

.meas tran vdout1_27ck100 FIND v(dout1_27) AT=55.025n

.meas tran vdout1_28ck100 FIND v(dout1_28) AT=55.025n

.meas tran vdout1_29ck100 FIND v(dout1_29) AT=55.025n

.meas tran vdout1_30ck100 FIND v(dout1_30) AT=55.025n

.meas tran vdout1_31ck100 FIND v(dout1_31) AT=55.025n

.meas tran vdout1_32ck100 FIND v(dout1_32) AT=55.025n

.meas tran vdout1_33ck100 FIND v(dout1_33) AT=55.025n

.meas tran vdout1_34ck100 FIND v(dout1_34) AT=55.025n

.meas tran vdout1_35ck100 FIND v(dout1_35) AT=55.025n

.meas tran vdout1_36ck100 FIND v(dout1_36) AT=55.025n

.meas tran vdout1_37ck100 FIND v(dout1_37) AT=55.025n

.meas tran vdout1_38ck100 FIND v(dout1_38) AT=55.025n

.meas tran vdout1_39ck100 FIND v(dout1_39) AT=55.025n

.meas tran vdout1_40ck100 FIND v(dout1_40) AT=55.025n

.meas tran vdout1_41ck100 FIND v(dout1_41) AT=55.025n

.meas tran vdout1_42ck100 FIND v(dout1_42) AT=55.025n

.meas tran vdout1_43ck100 FIND v(dout1_43) AT=55.025n

.meas tran vdout1_44ck100 FIND v(dout1_44) AT=55.025n

.meas tran vdout1_45ck100 FIND v(dout1_45) AT=55.025n

.meas tran vdout1_46ck100 FIND v(dout1_46) AT=55.025n

.meas tran vdout1_47ck100 FIND v(dout1_47) AT=55.025n

.meas tran vdout1_48ck100 FIND v(dout1_48) AT=55.025n

.meas tran vdout1_49ck100 FIND v(dout1_49) AT=55.025n

.meas tran vdout1_50ck100 FIND v(dout1_50) AT=55.025n

.meas tran vdout1_51ck100 FIND v(dout1_51) AT=55.025n

.meas tran vdout1_52ck100 FIND v(dout1_52) AT=55.025n

.meas tran vdout1_53ck100 FIND v(dout1_53) AT=55.025n

.meas tran vdout1_54ck100 FIND v(dout1_54) AT=55.025n

.meas tran vdout1_55ck100 FIND v(dout1_55) AT=55.025n

.meas tran vdout1_56ck100 FIND v(dout1_56) AT=55.025n

.meas tran vdout1_57ck100 FIND v(dout1_57) AT=55.025n

.meas tran vdout1_58ck100 FIND v(dout1_58) AT=55.025n

.meas tran vdout1_59ck100 FIND v(dout1_59) AT=55.025n

.meas tran vdout1_60ck100 FIND v(dout1_60) AT=55.025n

.meas tran vdout1_61ck100 FIND v(dout1_61) AT=55.025n

.meas tran vdout1_62ck100 FIND v(dout1_62) AT=55.025n

.meas tran vdout1_63ck100 FIND v(dout1_63) AT=55.025n

.meas tran vdout0_0ck110 FIND v(dout0_0) AT=60.025n

.meas tran vdout0_1ck110 FIND v(dout0_1) AT=60.025n

.meas tran vdout0_2ck110 FIND v(dout0_2) AT=60.025n

.meas tran vdout0_3ck110 FIND v(dout0_3) AT=60.025n

.meas tran vdout0_4ck110 FIND v(dout0_4) AT=60.025n

.meas tran vdout0_5ck110 FIND v(dout0_5) AT=60.025n

.meas tran vdout0_6ck110 FIND v(dout0_6) AT=60.025n

.meas tran vdout0_7ck110 FIND v(dout0_7) AT=60.025n

.meas tran vdout0_8ck110 FIND v(dout0_8) AT=60.025n

.meas tran vdout0_9ck110 FIND v(dout0_9) AT=60.025n

.meas tran vdout0_10ck110 FIND v(dout0_10) AT=60.025n

.meas tran vdout0_11ck110 FIND v(dout0_11) AT=60.025n

.meas tran vdout0_12ck110 FIND v(dout0_12) AT=60.025n

.meas tran vdout0_13ck110 FIND v(dout0_13) AT=60.025n

.meas tran vdout0_14ck110 FIND v(dout0_14) AT=60.025n

.meas tran vdout0_15ck110 FIND v(dout0_15) AT=60.025n

.meas tran vdout0_16ck110 FIND v(dout0_16) AT=60.025n

.meas tran vdout0_17ck110 FIND v(dout0_17) AT=60.025n

.meas tran vdout0_18ck110 FIND v(dout0_18) AT=60.025n

.meas tran vdout0_19ck110 FIND v(dout0_19) AT=60.025n

.meas tran vdout0_20ck110 FIND v(dout0_20) AT=60.025n

.meas tran vdout0_21ck110 FIND v(dout0_21) AT=60.025n

.meas tran vdout0_22ck110 FIND v(dout0_22) AT=60.025n

.meas tran vdout0_23ck110 FIND v(dout0_23) AT=60.025n

.meas tran vdout0_24ck110 FIND v(dout0_24) AT=60.025n

.meas tran vdout0_25ck110 FIND v(dout0_25) AT=60.025n

.meas tran vdout0_26ck110 FIND v(dout0_26) AT=60.025n

.meas tran vdout0_27ck110 FIND v(dout0_27) AT=60.025n

.meas tran vdout0_28ck110 FIND v(dout0_28) AT=60.025n

.meas tran vdout0_29ck110 FIND v(dout0_29) AT=60.025n

.meas tran vdout0_30ck110 FIND v(dout0_30) AT=60.025n

.meas tran vdout0_31ck110 FIND v(dout0_31) AT=60.025n

.meas tran vdout0_32ck110 FIND v(dout0_32) AT=60.025n

.meas tran vdout0_33ck110 FIND v(dout0_33) AT=60.025n

.meas tran vdout0_34ck110 FIND v(dout0_34) AT=60.025n

.meas tran vdout0_35ck110 FIND v(dout0_35) AT=60.025n

.meas tran vdout0_36ck110 FIND v(dout0_36) AT=60.025n

.meas tran vdout0_37ck110 FIND v(dout0_37) AT=60.025n

.meas tran vdout0_38ck110 FIND v(dout0_38) AT=60.025n

.meas tran vdout0_39ck110 FIND v(dout0_39) AT=60.025n

.meas tran vdout0_40ck110 FIND v(dout0_40) AT=60.025n

.meas tran vdout0_41ck110 FIND v(dout0_41) AT=60.025n

.meas tran vdout0_42ck110 FIND v(dout0_42) AT=60.025n

.meas tran vdout0_43ck110 FIND v(dout0_43) AT=60.025n

.meas tran vdout0_44ck110 FIND v(dout0_44) AT=60.025n

.meas tran vdout0_45ck110 FIND v(dout0_45) AT=60.025n

.meas tran vdout0_46ck110 FIND v(dout0_46) AT=60.025n

.meas tran vdout0_47ck110 FIND v(dout0_47) AT=60.025n

.meas tran vdout0_48ck110 FIND v(dout0_48) AT=60.025n

.meas tran vdout0_49ck110 FIND v(dout0_49) AT=60.025n

.meas tran vdout0_50ck110 FIND v(dout0_50) AT=60.025n

.meas tran vdout0_51ck110 FIND v(dout0_51) AT=60.025n

.meas tran vdout0_52ck110 FIND v(dout0_52) AT=60.025n

.meas tran vdout0_53ck110 FIND v(dout0_53) AT=60.025n

.meas tran vdout0_54ck110 FIND v(dout0_54) AT=60.025n

.meas tran vdout0_55ck110 FIND v(dout0_55) AT=60.025n

.meas tran vdout0_56ck110 FIND v(dout0_56) AT=60.025n

.meas tran vdout0_57ck110 FIND v(dout0_57) AT=60.025n

.meas tran vdout0_58ck110 FIND v(dout0_58) AT=60.025n

.meas tran vdout0_59ck110 FIND v(dout0_59) AT=60.025n

.meas tran vdout0_60ck110 FIND v(dout0_60) AT=60.025n

.meas tran vdout0_61ck110 FIND v(dout0_61) AT=60.025n

.meas tran vdout0_62ck110 FIND v(dout0_62) AT=60.025n

.meas tran vdout0_63ck110 FIND v(dout0_63) AT=60.025n

.meas tran vdout1_0ck110 FIND v(dout1_0) AT=60.025n

.meas tran vdout1_1ck110 FIND v(dout1_1) AT=60.025n

.meas tran vdout1_2ck110 FIND v(dout1_2) AT=60.025n

.meas tran vdout1_3ck110 FIND v(dout1_3) AT=60.025n

.meas tran vdout1_4ck110 FIND v(dout1_4) AT=60.025n

.meas tran vdout1_5ck110 FIND v(dout1_5) AT=60.025n

.meas tran vdout1_6ck110 FIND v(dout1_6) AT=60.025n

.meas tran vdout1_7ck110 FIND v(dout1_7) AT=60.025n

.meas tran vdout1_8ck110 FIND v(dout1_8) AT=60.025n

.meas tran vdout1_9ck110 FIND v(dout1_9) AT=60.025n

.meas tran vdout1_10ck110 FIND v(dout1_10) AT=60.025n

.meas tran vdout1_11ck110 FIND v(dout1_11) AT=60.025n

.meas tran vdout1_12ck110 FIND v(dout1_12) AT=60.025n

.meas tran vdout1_13ck110 FIND v(dout1_13) AT=60.025n

.meas tran vdout1_14ck110 FIND v(dout1_14) AT=60.025n

.meas tran vdout1_15ck110 FIND v(dout1_15) AT=60.025n

.meas tran vdout1_16ck110 FIND v(dout1_16) AT=60.025n

.meas tran vdout1_17ck110 FIND v(dout1_17) AT=60.025n

.meas tran vdout1_18ck110 FIND v(dout1_18) AT=60.025n

.meas tran vdout1_19ck110 FIND v(dout1_19) AT=60.025n

.meas tran vdout1_20ck110 FIND v(dout1_20) AT=60.025n

.meas tran vdout1_21ck110 FIND v(dout1_21) AT=60.025n

.meas tran vdout1_22ck110 FIND v(dout1_22) AT=60.025n

.meas tran vdout1_23ck110 FIND v(dout1_23) AT=60.025n

.meas tran vdout1_24ck110 FIND v(dout1_24) AT=60.025n

.meas tran vdout1_25ck110 FIND v(dout1_25) AT=60.025n

.meas tran vdout1_26ck110 FIND v(dout1_26) AT=60.025n

.meas tran vdout1_27ck110 FIND v(dout1_27) AT=60.025n

.meas tran vdout1_28ck110 FIND v(dout1_28) AT=60.025n

.meas tran vdout1_29ck110 FIND v(dout1_29) AT=60.025n

.meas tran vdout1_30ck110 FIND v(dout1_30) AT=60.025n

.meas tran vdout1_31ck110 FIND v(dout1_31) AT=60.025n

.meas tran vdout1_32ck110 FIND v(dout1_32) AT=60.025n

.meas tran vdout1_33ck110 FIND v(dout1_33) AT=60.025n

.meas tran vdout1_34ck110 FIND v(dout1_34) AT=60.025n

.meas tran vdout1_35ck110 FIND v(dout1_35) AT=60.025n

.meas tran vdout1_36ck110 FIND v(dout1_36) AT=60.025n

.meas tran vdout1_37ck110 FIND v(dout1_37) AT=60.025n

.meas tran vdout1_38ck110 FIND v(dout1_38) AT=60.025n

.meas tran vdout1_39ck110 FIND v(dout1_39) AT=60.025n

.meas tran vdout1_40ck110 FIND v(dout1_40) AT=60.025n

.meas tran vdout1_41ck110 FIND v(dout1_41) AT=60.025n

.meas tran vdout1_42ck110 FIND v(dout1_42) AT=60.025n

.meas tran vdout1_43ck110 FIND v(dout1_43) AT=60.025n

.meas tran vdout1_44ck110 FIND v(dout1_44) AT=60.025n

.meas tran vdout1_45ck110 FIND v(dout1_45) AT=60.025n

.meas tran vdout1_46ck110 FIND v(dout1_46) AT=60.025n

.meas tran vdout1_47ck110 FIND v(dout1_47) AT=60.025n

.meas tran vdout1_48ck110 FIND v(dout1_48) AT=60.025n

.meas tran vdout1_49ck110 FIND v(dout1_49) AT=60.025n

.meas tran vdout1_50ck110 FIND v(dout1_50) AT=60.025n

.meas tran vdout1_51ck110 FIND v(dout1_51) AT=60.025n

.meas tran vdout1_52ck110 FIND v(dout1_52) AT=60.025n

.meas tran vdout1_53ck110 FIND v(dout1_53) AT=60.025n

.meas tran vdout1_54ck110 FIND v(dout1_54) AT=60.025n

.meas tran vdout1_55ck110 FIND v(dout1_55) AT=60.025n

.meas tran vdout1_56ck110 FIND v(dout1_56) AT=60.025n

.meas tran vdout1_57ck110 FIND v(dout1_57) AT=60.025n

.meas tran vdout1_58ck110 FIND v(dout1_58) AT=60.025n

.meas tran vdout1_59ck110 FIND v(dout1_59) AT=60.025n

.meas tran vdout1_60ck110 FIND v(dout1_60) AT=60.025n

.meas tran vdout1_61ck110 FIND v(dout1_61) AT=60.025n

.meas tran vdout1_62ck110 FIND v(dout1_62) AT=60.025n

.meas tran vdout1_63ck110 FIND v(dout1_63) AT=60.025n

.meas tran vdout0_0ck120 FIND v(dout0_0) AT=65.025n

.meas tran vdout0_1ck120 FIND v(dout0_1) AT=65.025n

.meas tran vdout0_2ck120 FIND v(dout0_2) AT=65.025n

.meas tran vdout0_3ck120 FIND v(dout0_3) AT=65.025n

.meas tran vdout0_4ck120 FIND v(dout0_4) AT=65.025n

.meas tran vdout0_5ck120 FIND v(dout0_5) AT=65.025n

.meas tran vdout0_6ck120 FIND v(dout0_6) AT=65.025n

.meas tran vdout0_7ck120 FIND v(dout0_7) AT=65.025n

.meas tran vdout0_8ck120 FIND v(dout0_8) AT=65.025n

.meas tran vdout0_9ck120 FIND v(dout0_9) AT=65.025n

.meas tran vdout0_10ck120 FIND v(dout0_10) AT=65.025n

.meas tran vdout0_11ck120 FIND v(dout0_11) AT=65.025n

.meas tran vdout0_12ck120 FIND v(dout0_12) AT=65.025n

.meas tran vdout0_13ck120 FIND v(dout0_13) AT=65.025n

.meas tran vdout0_14ck120 FIND v(dout0_14) AT=65.025n

.meas tran vdout0_15ck120 FIND v(dout0_15) AT=65.025n

.meas tran vdout0_16ck120 FIND v(dout0_16) AT=65.025n

.meas tran vdout0_17ck120 FIND v(dout0_17) AT=65.025n

.meas tran vdout0_18ck120 FIND v(dout0_18) AT=65.025n

.meas tran vdout0_19ck120 FIND v(dout0_19) AT=65.025n

.meas tran vdout0_20ck120 FIND v(dout0_20) AT=65.025n

.meas tran vdout0_21ck120 FIND v(dout0_21) AT=65.025n

.meas tran vdout0_22ck120 FIND v(dout0_22) AT=65.025n

.meas tran vdout0_23ck120 FIND v(dout0_23) AT=65.025n

.meas tran vdout0_24ck120 FIND v(dout0_24) AT=65.025n

.meas tran vdout0_25ck120 FIND v(dout0_25) AT=65.025n

.meas tran vdout0_26ck120 FIND v(dout0_26) AT=65.025n

.meas tran vdout0_27ck120 FIND v(dout0_27) AT=65.025n

.meas tran vdout0_28ck120 FIND v(dout0_28) AT=65.025n

.meas tran vdout0_29ck120 FIND v(dout0_29) AT=65.025n

.meas tran vdout0_30ck120 FIND v(dout0_30) AT=65.025n

.meas tran vdout0_31ck120 FIND v(dout0_31) AT=65.025n

.meas tran vdout0_32ck120 FIND v(dout0_32) AT=65.025n

.meas tran vdout0_33ck120 FIND v(dout0_33) AT=65.025n

.meas tran vdout0_34ck120 FIND v(dout0_34) AT=65.025n

.meas tran vdout0_35ck120 FIND v(dout0_35) AT=65.025n

.meas tran vdout0_36ck120 FIND v(dout0_36) AT=65.025n

.meas tran vdout0_37ck120 FIND v(dout0_37) AT=65.025n

.meas tran vdout0_38ck120 FIND v(dout0_38) AT=65.025n

.meas tran vdout0_39ck120 FIND v(dout0_39) AT=65.025n

.meas tran vdout0_40ck120 FIND v(dout0_40) AT=65.025n

.meas tran vdout0_41ck120 FIND v(dout0_41) AT=65.025n

.meas tran vdout0_42ck120 FIND v(dout0_42) AT=65.025n

.meas tran vdout0_43ck120 FIND v(dout0_43) AT=65.025n

.meas tran vdout0_44ck120 FIND v(dout0_44) AT=65.025n

.meas tran vdout0_45ck120 FIND v(dout0_45) AT=65.025n

.meas tran vdout0_46ck120 FIND v(dout0_46) AT=65.025n

.meas tran vdout0_47ck120 FIND v(dout0_47) AT=65.025n

.meas tran vdout0_48ck120 FIND v(dout0_48) AT=65.025n

.meas tran vdout0_49ck120 FIND v(dout0_49) AT=65.025n

.meas tran vdout0_50ck120 FIND v(dout0_50) AT=65.025n

.meas tran vdout0_51ck120 FIND v(dout0_51) AT=65.025n

.meas tran vdout0_52ck120 FIND v(dout0_52) AT=65.025n

.meas tran vdout0_53ck120 FIND v(dout0_53) AT=65.025n

.meas tran vdout0_54ck120 FIND v(dout0_54) AT=65.025n

.meas tran vdout0_55ck120 FIND v(dout0_55) AT=65.025n

.meas tran vdout0_56ck120 FIND v(dout0_56) AT=65.025n

.meas tran vdout0_57ck120 FIND v(dout0_57) AT=65.025n

.meas tran vdout0_58ck120 FIND v(dout0_58) AT=65.025n

.meas tran vdout0_59ck120 FIND v(dout0_59) AT=65.025n

.meas tran vdout0_60ck120 FIND v(dout0_60) AT=65.025n

.meas tran vdout0_61ck120 FIND v(dout0_61) AT=65.025n

.meas tran vdout0_62ck120 FIND v(dout0_62) AT=65.025n

.meas tran vdout0_63ck120 FIND v(dout0_63) AT=65.025n

.meas tran vdout1_0ck130 FIND v(dout1_0) AT=70.025n

.meas tran vdout1_1ck130 FIND v(dout1_1) AT=70.025n

.meas tran vdout1_2ck130 FIND v(dout1_2) AT=70.025n

.meas tran vdout1_3ck130 FIND v(dout1_3) AT=70.025n

.meas tran vdout1_4ck130 FIND v(dout1_4) AT=70.025n

.meas tran vdout1_5ck130 FIND v(dout1_5) AT=70.025n

.meas tran vdout1_6ck130 FIND v(dout1_6) AT=70.025n

.meas tran vdout1_7ck130 FIND v(dout1_7) AT=70.025n

.meas tran vdout1_8ck130 FIND v(dout1_8) AT=70.025n

.meas tran vdout1_9ck130 FIND v(dout1_9) AT=70.025n

.meas tran vdout1_10ck130 FIND v(dout1_10) AT=70.025n

.meas tran vdout1_11ck130 FIND v(dout1_11) AT=70.025n

.meas tran vdout1_12ck130 FIND v(dout1_12) AT=70.025n

.meas tran vdout1_13ck130 FIND v(dout1_13) AT=70.025n

.meas tran vdout1_14ck130 FIND v(dout1_14) AT=70.025n

.meas tran vdout1_15ck130 FIND v(dout1_15) AT=70.025n

.meas tran vdout1_16ck130 FIND v(dout1_16) AT=70.025n

.meas tran vdout1_17ck130 FIND v(dout1_17) AT=70.025n

.meas tran vdout1_18ck130 FIND v(dout1_18) AT=70.025n

.meas tran vdout1_19ck130 FIND v(dout1_19) AT=70.025n

.meas tran vdout1_20ck130 FIND v(dout1_20) AT=70.025n

.meas tran vdout1_21ck130 FIND v(dout1_21) AT=70.025n

.meas tran vdout1_22ck130 FIND v(dout1_22) AT=70.025n

.meas tran vdout1_23ck130 FIND v(dout1_23) AT=70.025n

.meas tran vdout1_24ck130 FIND v(dout1_24) AT=70.025n

.meas tran vdout1_25ck130 FIND v(dout1_25) AT=70.025n

.meas tran vdout1_26ck130 FIND v(dout1_26) AT=70.025n

.meas tran vdout1_27ck130 FIND v(dout1_27) AT=70.025n

.meas tran vdout1_28ck130 FIND v(dout1_28) AT=70.025n

.meas tran vdout1_29ck130 FIND v(dout1_29) AT=70.025n

.meas tran vdout1_30ck130 FIND v(dout1_30) AT=70.025n

.meas tran vdout1_31ck130 FIND v(dout1_31) AT=70.025n

.meas tran vdout1_32ck130 FIND v(dout1_32) AT=70.025n

.meas tran vdout1_33ck130 FIND v(dout1_33) AT=70.025n

.meas tran vdout1_34ck130 FIND v(dout1_34) AT=70.025n

.meas tran vdout1_35ck130 FIND v(dout1_35) AT=70.025n

.meas tran vdout1_36ck130 FIND v(dout1_36) AT=70.025n

.meas tran vdout1_37ck130 FIND v(dout1_37) AT=70.025n

.meas tran vdout1_38ck130 FIND v(dout1_38) AT=70.025n

.meas tran vdout1_39ck130 FIND v(dout1_39) AT=70.025n

.meas tran vdout1_40ck130 FIND v(dout1_40) AT=70.025n

.meas tran vdout1_41ck130 FIND v(dout1_41) AT=70.025n

.meas tran vdout1_42ck130 FIND v(dout1_42) AT=70.025n

.meas tran vdout1_43ck130 FIND v(dout1_43) AT=70.025n

.meas tran vdout1_44ck130 FIND v(dout1_44) AT=70.025n

.meas tran vdout1_45ck130 FIND v(dout1_45) AT=70.025n

.meas tran vdout1_46ck130 FIND v(dout1_46) AT=70.025n

.meas tran vdout1_47ck130 FIND v(dout1_47) AT=70.025n

.meas tran vdout1_48ck130 FIND v(dout1_48) AT=70.025n

.meas tran vdout1_49ck130 FIND v(dout1_49) AT=70.025n

.meas tran vdout1_50ck130 FIND v(dout1_50) AT=70.025n

.meas tran vdout1_51ck130 FIND v(dout1_51) AT=70.025n

.meas tran vdout1_52ck130 FIND v(dout1_52) AT=70.025n

.meas tran vdout1_53ck130 FIND v(dout1_53) AT=70.025n

.meas tran vdout1_54ck130 FIND v(dout1_54) AT=70.025n

.meas tran vdout1_55ck130 FIND v(dout1_55) AT=70.025n

.meas tran vdout1_56ck130 FIND v(dout1_56) AT=70.025n

.meas tran vdout1_57ck130 FIND v(dout1_57) AT=70.025n

.meas tran vdout1_58ck130 FIND v(dout1_58) AT=70.025n

.meas tran vdout1_59ck130 FIND v(dout1_59) AT=70.025n

.meas tran vdout1_60ck130 FIND v(dout1_60) AT=70.025n

.meas tran vdout1_61ck130 FIND v(dout1_61) AT=70.025n

.meas tran vdout1_62ck130 FIND v(dout1_62) AT=70.025n

.meas tran vdout1_63ck130 FIND v(dout1_63) AT=70.025n

.meas tran vdout0_0ck140 FIND v(dout0_0) AT=75.025n

.meas tran vdout0_1ck140 FIND v(dout0_1) AT=75.025n

.meas tran vdout0_2ck140 FIND v(dout0_2) AT=75.025n

.meas tran vdout0_3ck140 FIND v(dout0_3) AT=75.025n

.meas tran vdout0_4ck140 FIND v(dout0_4) AT=75.025n

.meas tran vdout0_5ck140 FIND v(dout0_5) AT=75.025n

.meas tran vdout0_6ck140 FIND v(dout0_6) AT=75.025n

.meas tran vdout0_7ck140 FIND v(dout0_7) AT=75.025n

.meas tran vdout0_8ck140 FIND v(dout0_8) AT=75.025n

.meas tran vdout0_9ck140 FIND v(dout0_9) AT=75.025n

.meas tran vdout0_10ck140 FIND v(dout0_10) AT=75.025n

.meas tran vdout0_11ck140 FIND v(dout0_11) AT=75.025n

.meas tran vdout0_12ck140 FIND v(dout0_12) AT=75.025n

.meas tran vdout0_13ck140 FIND v(dout0_13) AT=75.025n

.meas tran vdout0_14ck140 FIND v(dout0_14) AT=75.025n

.meas tran vdout0_15ck140 FIND v(dout0_15) AT=75.025n

.meas tran vdout0_16ck140 FIND v(dout0_16) AT=75.025n

.meas tran vdout0_17ck140 FIND v(dout0_17) AT=75.025n

.meas tran vdout0_18ck140 FIND v(dout0_18) AT=75.025n

.meas tran vdout0_19ck140 FIND v(dout0_19) AT=75.025n

.meas tran vdout0_20ck140 FIND v(dout0_20) AT=75.025n

.meas tran vdout0_21ck140 FIND v(dout0_21) AT=75.025n

.meas tran vdout0_22ck140 FIND v(dout0_22) AT=75.025n

.meas tran vdout0_23ck140 FIND v(dout0_23) AT=75.025n

.meas tran vdout0_24ck140 FIND v(dout0_24) AT=75.025n

.meas tran vdout0_25ck140 FIND v(dout0_25) AT=75.025n

.meas tran vdout0_26ck140 FIND v(dout0_26) AT=75.025n

.meas tran vdout0_27ck140 FIND v(dout0_27) AT=75.025n

.meas tran vdout0_28ck140 FIND v(dout0_28) AT=75.025n

.meas tran vdout0_29ck140 FIND v(dout0_29) AT=75.025n

.meas tran vdout0_30ck140 FIND v(dout0_30) AT=75.025n

.meas tran vdout0_31ck140 FIND v(dout0_31) AT=75.025n

.meas tran vdout0_32ck140 FIND v(dout0_32) AT=75.025n

.meas tran vdout0_33ck140 FIND v(dout0_33) AT=75.025n

.meas tran vdout0_34ck140 FIND v(dout0_34) AT=75.025n

.meas tran vdout0_35ck140 FIND v(dout0_35) AT=75.025n

.meas tran vdout0_36ck140 FIND v(dout0_36) AT=75.025n

.meas tran vdout0_37ck140 FIND v(dout0_37) AT=75.025n

.meas tran vdout0_38ck140 FIND v(dout0_38) AT=75.025n

.meas tran vdout0_39ck140 FIND v(dout0_39) AT=75.025n

.meas tran vdout0_40ck140 FIND v(dout0_40) AT=75.025n

.meas tran vdout0_41ck140 FIND v(dout0_41) AT=75.025n

.meas tran vdout0_42ck140 FIND v(dout0_42) AT=75.025n

.meas tran vdout0_43ck140 FIND v(dout0_43) AT=75.025n

.meas tran vdout0_44ck140 FIND v(dout0_44) AT=75.025n

.meas tran vdout0_45ck140 FIND v(dout0_45) AT=75.025n

.meas tran vdout0_46ck140 FIND v(dout0_46) AT=75.025n

.meas tran vdout0_47ck140 FIND v(dout0_47) AT=75.025n

.meas tran vdout0_48ck140 FIND v(dout0_48) AT=75.025n

.meas tran vdout0_49ck140 FIND v(dout0_49) AT=75.025n

.meas tran vdout0_50ck140 FIND v(dout0_50) AT=75.025n

.meas tran vdout0_51ck140 FIND v(dout0_51) AT=75.025n

.meas tran vdout0_52ck140 FIND v(dout0_52) AT=75.025n

.meas tran vdout0_53ck140 FIND v(dout0_53) AT=75.025n

.meas tran vdout0_54ck140 FIND v(dout0_54) AT=75.025n

.meas tran vdout0_55ck140 FIND v(dout0_55) AT=75.025n

.meas tran vdout0_56ck140 FIND v(dout0_56) AT=75.025n

.meas tran vdout0_57ck140 FIND v(dout0_57) AT=75.025n

.meas tran vdout0_58ck140 FIND v(dout0_58) AT=75.025n

.meas tran vdout0_59ck140 FIND v(dout0_59) AT=75.025n

.meas tran vdout0_60ck140 FIND v(dout0_60) AT=75.025n

.meas tran vdout0_61ck140 FIND v(dout0_61) AT=75.025n

.meas tran vdout0_62ck140 FIND v(dout0_62) AT=75.025n

.meas tran vdout0_63ck140 FIND v(dout0_63) AT=75.025n

.meas tran vdout1_0ck140 FIND v(dout1_0) AT=75.025n

.meas tran vdout1_1ck140 FIND v(dout1_1) AT=75.025n

.meas tran vdout1_2ck140 FIND v(dout1_2) AT=75.025n

.meas tran vdout1_3ck140 FIND v(dout1_3) AT=75.025n

.meas tran vdout1_4ck140 FIND v(dout1_4) AT=75.025n

.meas tran vdout1_5ck140 FIND v(dout1_5) AT=75.025n

.meas tran vdout1_6ck140 FIND v(dout1_6) AT=75.025n

.meas tran vdout1_7ck140 FIND v(dout1_7) AT=75.025n

.meas tran vdout1_8ck140 FIND v(dout1_8) AT=75.025n

.meas tran vdout1_9ck140 FIND v(dout1_9) AT=75.025n

.meas tran vdout1_10ck140 FIND v(dout1_10) AT=75.025n

.meas tran vdout1_11ck140 FIND v(dout1_11) AT=75.025n

.meas tran vdout1_12ck140 FIND v(dout1_12) AT=75.025n

.meas tran vdout1_13ck140 FIND v(dout1_13) AT=75.025n

.meas tran vdout1_14ck140 FIND v(dout1_14) AT=75.025n

.meas tran vdout1_15ck140 FIND v(dout1_15) AT=75.025n

.meas tran vdout1_16ck140 FIND v(dout1_16) AT=75.025n

.meas tran vdout1_17ck140 FIND v(dout1_17) AT=75.025n

.meas tran vdout1_18ck140 FIND v(dout1_18) AT=75.025n

.meas tran vdout1_19ck140 FIND v(dout1_19) AT=75.025n

.meas tran vdout1_20ck140 FIND v(dout1_20) AT=75.025n

.meas tran vdout1_21ck140 FIND v(dout1_21) AT=75.025n

.meas tran vdout1_22ck140 FIND v(dout1_22) AT=75.025n

.meas tran vdout1_23ck140 FIND v(dout1_23) AT=75.025n

.meas tran vdout1_24ck140 FIND v(dout1_24) AT=75.025n

.meas tran vdout1_25ck140 FIND v(dout1_25) AT=75.025n

.meas tran vdout1_26ck140 FIND v(dout1_26) AT=75.025n

.meas tran vdout1_27ck140 FIND v(dout1_27) AT=75.025n

.meas tran vdout1_28ck140 FIND v(dout1_28) AT=75.025n

.meas tran vdout1_29ck140 FIND v(dout1_29) AT=75.025n

.meas tran vdout1_30ck140 FIND v(dout1_30) AT=75.025n

.meas tran vdout1_31ck140 FIND v(dout1_31) AT=75.025n

.meas tran vdout1_32ck140 FIND v(dout1_32) AT=75.025n

.meas tran vdout1_33ck140 FIND v(dout1_33) AT=75.025n

.meas tran vdout1_34ck140 FIND v(dout1_34) AT=75.025n

.meas tran vdout1_35ck140 FIND v(dout1_35) AT=75.025n

.meas tran vdout1_36ck140 FIND v(dout1_36) AT=75.025n

.meas tran vdout1_37ck140 FIND v(dout1_37) AT=75.025n

.meas tran vdout1_38ck140 FIND v(dout1_38) AT=75.025n

.meas tran vdout1_39ck140 FIND v(dout1_39) AT=75.025n

.meas tran vdout1_40ck140 FIND v(dout1_40) AT=75.025n

.meas tran vdout1_41ck140 FIND v(dout1_41) AT=75.025n

.meas tran vdout1_42ck140 FIND v(dout1_42) AT=75.025n

.meas tran vdout1_43ck140 FIND v(dout1_43) AT=75.025n

.meas tran vdout1_44ck140 FIND v(dout1_44) AT=75.025n

.meas tran vdout1_45ck140 FIND v(dout1_45) AT=75.025n

.meas tran vdout1_46ck140 FIND v(dout1_46) AT=75.025n

.meas tran vdout1_47ck140 FIND v(dout1_47) AT=75.025n

.meas tran vdout1_48ck140 FIND v(dout1_48) AT=75.025n

.meas tran vdout1_49ck140 FIND v(dout1_49) AT=75.025n

.meas tran vdout1_50ck140 FIND v(dout1_50) AT=75.025n

.meas tran vdout1_51ck140 FIND v(dout1_51) AT=75.025n

.meas tran vdout1_52ck140 FIND v(dout1_52) AT=75.025n

.meas tran vdout1_53ck140 FIND v(dout1_53) AT=75.025n

.meas tran vdout1_54ck140 FIND v(dout1_54) AT=75.025n

.meas tran vdout1_55ck140 FIND v(dout1_55) AT=75.025n

.meas tran vdout1_56ck140 FIND v(dout1_56) AT=75.025n

.meas tran vdout1_57ck140 FIND v(dout1_57) AT=75.025n

.meas tran vdout1_58ck140 FIND v(dout1_58) AT=75.025n

.meas tran vdout1_59ck140 FIND v(dout1_59) AT=75.025n

.meas tran vdout1_60ck140 FIND v(dout1_60) AT=75.025n

.meas tran vdout1_61ck140 FIND v(dout1_61) AT=75.025n

.meas tran vdout1_62ck140 FIND v(dout1_62) AT=75.025n

.meas tran vdout1_63ck140 FIND v(dout1_63) AT=75.025n

.meas tran vdout0_0ck150 FIND v(dout0_0) AT=80.025n

.meas tran vdout0_1ck150 FIND v(dout0_1) AT=80.025n

.meas tran vdout0_2ck150 FIND v(dout0_2) AT=80.025n

.meas tran vdout0_3ck150 FIND v(dout0_3) AT=80.025n

.meas tran vdout0_4ck150 FIND v(dout0_4) AT=80.025n

.meas tran vdout0_5ck150 FIND v(dout0_5) AT=80.025n

.meas tran vdout0_6ck150 FIND v(dout0_6) AT=80.025n

.meas tran vdout0_7ck150 FIND v(dout0_7) AT=80.025n

.meas tran vdout0_8ck150 FIND v(dout0_8) AT=80.025n

.meas tran vdout0_9ck150 FIND v(dout0_9) AT=80.025n

.meas tran vdout0_10ck150 FIND v(dout0_10) AT=80.025n

.meas tran vdout0_11ck150 FIND v(dout0_11) AT=80.025n

.meas tran vdout0_12ck150 FIND v(dout0_12) AT=80.025n

.meas tran vdout0_13ck150 FIND v(dout0_13) AT=80.025n

.meas tran vdout0_14ck150 FIND v(dout0_14) AT=80.025n

.meas tran vdout0_15ck150 FIND v(dout0_15) AT=80.025n

.meas tran vdout0_16ck150 FIND v(dout0_16) AT=80.025n

.meas tran vdout0_17ck150 FIND v(dout0_17) AT=80.025n

.meas tran vdout0_18ck150 FIND v(dout0_18) AT=80.025n

.meas tran vdout0_19ck150 FIND v(dout0_19) AT=80.025n

.meas tran vdout0_20ck150 FIND v(dout0_20) AT=80.025n

.meas tran vdout0_21ck150 FIND v(dout0_21) AT=80.025n

.meas tran vdout0_22ck150 FIND v(dout0_22) AT=80.025n

.meas tran vdout0_23ck150 FIND v(dout0_23) AT=80.025n

.meas tran vdout0_24ck150 FIND v(dout0_24) AT=80.025n

.meas tran vdout0_25ck150 FIND v(dout0_25) AT=80.025n

.meas tran vdout0_26ck150 FIND v(dout0_26) AT=80.025n

.meas tran vdout0_27ck150 FIND v(dout0_27) AT=80.025n

.meas tran vdout0_28ck150 FIND v(dout0_28) AT=80.025n

.meas tran vdout0_29ck150 FIND v(dout0_29) AT=80.025n

.meas tran vdout0_30ck150 FIND v(dout0_30) AT=80.025n

.meas tran vdout0_31ck150 FIND v(dout0_31) AT=80.025n

.meas tran vdout0_32ck150 FIND v(dout0_32) AT=80.025n

.meas tran vdout0_33ck150 FIND v(dout0_33) AT=80.025n

.meas tran vdout0_34ck150 FIND v(dout0_34) AT=80.025n

.meas tran vdout0_35ck150 FIND v(dout0_35) AT=80.025n

.meas tran vdout0_36ck150 FIND v(dout0_36) AT=80.025n

.meas tran vdout0_37ck150 FIND v(dout0_37) AT=80.025n

.meas tran vdout0_38ck150 FIND v(dout0_38) AT=80.025n

.meas tran vdout0_39ck150 FIND v(dout0_39) AT=80.025n

.meas tran vdout0_40ck150 FIND v(dout0_40) AT=80.025n

.meas tran vdout0_41ck150 FIND v(dout0_41) AT=80.025n

.meas tran vdout0_42ck150 FIND v(dout0_42) AT=80.025n

.meas tran vdout0_43ck150 FIND v(dout0_43) AT=80.025n

.meas tran vdout0_44ck150 FIND v(dout0_44) AT=80.025n

.meas tran vdout0_45ck150 FIND v(dout0_45) AT=80.025n

.meas tran vdout0_46ck150 FIND v(dout0_46) AT=80.025n

.meas tran vdout0_47ck150 FIND v(dout0_47) AT=80.025n

.meas tran vdout0_48ck150 FIND v(dout0_48) AT=80.025n

.meas tran vdout0_49ck150 FIND v(dout0_49) AT=80.025n

.meas tran vdout0_50ck150 FIND v(dout0_50) AT=80.025n

.meas tran vdout0_51ck150 FIND v(dout0_51) AT=80.025n

.meas tran vdout0_52ck150 FIND v(dout0_52) AT=80.025n

.meas tran vdout0_53ck150 FIND v(dout0_53) AT=80.025n

.meas tran vdout0_54ck150 FIND v(dout0_54) AT=80.025n

.meas tran vdout0_55ck150 FIND v(dout0_55) AT=80.025n

.meas tran vdout0_56ck150 FIND v(dout0_56) AT=80.025n

.meas tran vdout0_57ck150 FIND v(dout0_57) AT=80.025n

.meas tran vdout0_58ck150 FIND v(dout0_58) AT=80.025n

.meas tran vdout0_59ck150 FIND v(dout0_59) AT=80.025n

.meas tran vdout0_60ck150 FIND v(dout0_60) AT=80.025n

.meas tran vdout0_61ck150 FIND v(dout0_61) AT=80.025n

.meas tran vdout0_62ck150 FIND v(dout0_62) AT=80.025n

.meas tran vdout0_63ck150 FIND v(dout0_63) AT=80.025n

.meas tran vdout1_0ck150 FIND v(dout1_0) AT=80.025n

.meas tran vdout1_1ck150 FIND v(dout1_1) AT=80.025n

.meas tran vdout1_2ck150 FIND v(dout1_2) AT=80.025n

.meas tran vdout1_3ck150 FIND v(dout1_3) AT=80.025n

.meas tran vdout1_4ck150 FIND v(dout1_4) AT=80.025n

.meas tran vdout1_5ck150 FIND v(dout1_5) AT=80.025n

.meas tran vdout1_6ck150 FIND v(dout1_6) AT=80.025n

.meas tran vdout1_7ck150 FIND v(dout1_7) AT=80.025n

.meas tran vdout1_8ck150 FIND v(dout1_8) AT=80.025n

.meas tran vdout1_9ck150 FIND v(dout1_9) AT=80.025n

.meas tran vdout1_10ck150 FIND v(dout1_10) AT=80.025n

.meas tran vdout1_11ck150 FIND v(dout1_11) AT=80.025n

.meas tran vdout1_12ck150 FIND v(dout1_12) AT=80.025n

.meas tran vdout1_13ck150 FIND v(dout1_13) AT=80.025n

.meas tran vdout1_14ck150 FIND v(dout1_14) AT=80.025n

.meas tran vdout1_15ck150 FIND v(dout1_15) AT=80.025n

.meas tran vdout1_16ck150 FIND v(dout1_16) AT=80.025n

.meas tran vdout1_17ck150 FIND v(dout1_17) AT=80.025n

.meas tran vdout1_18ck150 FIND v(dout1_18) AT=80.025n

.meas tran vdout1_19ck150 FIND v(dout1_19) AT=80.025n

.meas tran vdout1_20ck150 FIND v(dout1_20) AT=80.025n

.meas tran vdout1_21ck150 FIND v(dout1_21) AT=80.025n

.meas tran vdout1_22ck150 FIND v(dout1_22) AT=80.025n

.meas tran vdout1_23ck150 FIND v(dout1_23) AT=80.025n

.meas tran vdout1_24ck150 FIND v(dout1_24) AT=80.025n

.meas tran vdout1_25ck150 FIND v(dout1_25) AT=80.025n

.meas tran vdout1_26ck150 FIND v(dout1_26) AT=80.025n

.meas tran vdout1_27ck150 FIND v(dout1_27) AT=80.025n

.meas tran vdout1_28ck150 FIND v(dout1_28) AT=80.025n

.meas tran vdout1_29ck150 FIND v(dout1_29) AT=80.025n

.meas tran vdout1_30ck150 FIND v(dout1_30) AT=80.025n

.meas tran vdout1_31ck150 FIND v(dout1_31) AT=80.025n

.meas tran vdout1_32ck150 FIND v(dout1_32) AT=80.025n

.meas tran vdout1_33ck150 FIND v(dout1_33) AT=80.025n

.meas tran vdout1_34ck150 FIND v(dout1_34) AT=80.025n

.meas tran vdout1_35ck150 FIND v(dout1_35) AT=80.025n

.meas tran vdout1_36ck150 FIND v(dout1_36) AT=80.025n

.meas tran vdout1_37ck150 FIND v(dout1_37) AT=80.025n

.meas tran vdout1_38ck150 FIND v(dout1_38) AT=80.025n

.meas tran vdout1_39ck150 FIND v(dout1_39) AT=80.025n

.meas tran vdout1_40ck150 FIND v(dout1_40) AT=80.025n

.meas tran vdout1_41ck150 FIND v(dout1_41) AT=80.025n

.meas tran vdout1_42ck150 FIND v(dout1_42) AT=80.025n

.meas tran vdout1_43ck150 FIND v(dout1_43) AT=80.025n

.meas tran vdout1_44ck150 FIND v(dout1_44) AT=80.025n

.meas tran vdout1_45ck150 FIND v(dout1_45) AT=80.025n

.meas tran vdout1_46ck150 FIND v(dout1_46) AT=80.025n

.meas tran vdout1_47ck150 FIND v(dout1_47) AT=80.025n

.meas tran vdout1_48ck150 FIND v(dout1_48) AT=80.025n

.meas tran vdout1_49ck150 FIND v(dout1_49) AT=80.025n

.meas tran vdout1_50ck150 FIND v(dout1_50) AT=80.025n

.meas tran vdout1_51ck150 FIND v(dout1_51) AT=80.025n

.meas tran vdout1_52ck150 FIND v(dout1_52) AT=80.025n

.meas tran vdout1_53ck150 FIND v(dout1_53) AT=80.025n

.meas tran vdout1_54ck150 FIND v(dout1_54) AT=80.025n

.meas tran vdout1_55ck150 FIND v(dout1_55) AT=80.025n

.meas tran vdout1_56ck150 FIND v(dout1_56) AT=80.025n

.meas tran vdout1_57ck150 FIND v(dout1_57) AT=80.025n

.meas tran vdout1_58ck150 FIND v(dout1_58) AT=80.025n

.meas tran vdout1_59ck150 FIND v(dout1_59) AT=80.025n

.meas tran vdout1_60ck150 FIND v(dout1_60) AT=80.025n

.meas tran vdout1_61ck150 FIND v(dout1_61) AT=80.025n

.meas tran vdout1_62ck150 FIND v(dout1_62) AT=80.025n

.meas tran vdout1_63ck150 FIND v(dout1_63) AT=80.025n

.meas tran vdout0_0ck160 FIND v(dout0_0) AT=85.025n

.meas tran vdout0_1ck160 FIND v(dout0_1) AT=85.025n

.meas tran vdout0_2ck160 FIND v(dout0_2) AT=85.025n

.meas tran vdout0_3ck160 FIND v(dout0_3) AT=85.025n

.meas tran vdout0_4ck160 FIND v(dout0_4) AT=85.025n

.meas tran vdout0_5ck160 FIND v(dout0_5) AT=85.025n

.meas tran vdout0_6ck160 FIND v(dout0_6) AT=85.025n

.meas tran vdout0_7ck160 FIND v(dout0_7) AT=85.025n

.meas tran vdout0_8ck160 FIND v(dout0_8) AT=85.025n

.meas tran vdout0_9ck160 FIND v(dout0_9) AT=85.025n

.meas tran vdout0_10ck160 FIND v(dout0_10) AT=85.025n

.meas tran vdout0_11ck160 FIND v(dout0_11) AT=85.025n

.meas tran vdout0_12ck160 FIND v(dout0_12) AT=85.025n

.meas tran vdout0_13ck160 FIND v(dout0_13) AT=85.025n

.meas tran vdout0_14ck160 FIND v(dout0_14) AT=85.025n

.meas tran vdout0_15ck160 FIND v(dout0_15) AT=85.025n

.meas tran vdout0_16ck160 FIND v(dout0_16) AT=85.025n

.meas tran vdout0_17ck160 FIND v(dout0_17) AT=85.025n

.meas tran vdout0_18ck160 FIND v(dout0_18) AT=85.025n

.meas tran vdout0_19ck160 FIND v(dout0_19) AT=85.025n

.meas tran vdout0_20ck160 FIND v(dout0_20) AT=85.025n

.meas tran vdout0_21ck160 FIND v(dout0_21) AT=85.025n

.meas tran vdout0_22ck160 FIND v(dout0_22) AT=85.025n

.meas tran vdout0_23ck160 FIND v(dout0_23) AT=85.025n

.meas tran vdout0_24ck160 FIND v(dout0_24) AT=85.025n

.meas tran vdout0_25ck160 FIND v(dout0_25) AT=85.025n

.meas tran vdout0_26ck160 FIND v(dout0_26) AT=85.025n

.meas tran vdout0_27ck160 FIND v(dout0_27) AT=85.025n

.meas tran vdout0_28ck160 FIND v(dout0_28) AT=85.025n

.meas tran vdout0_29ck160 FIND v(dout0_29) AT=85.025n

.meas tran vdout0_30ck160 FIND v(dout0_30) AT=85.025n

.meas tran vdout0_31ck160 FIND v(dout0_31) AT=85.025n

.meas tran vdout0_32ck160 FIND v(dout0_32) AT=85.025n

.meas tran vdout0_33ck160 FIND v(dout0_33) AT=85.025n

.meas tran vdout0_34ck160 FIND v(dout0_34) AT=85.025n

.meas tran vdout0_35ck160 FIND v(dout0_35) AT=85.025n

.meas tran vdout0_36ck160 FIND v(dout0_36) AT=85.025n

.meas tran vdout0_37ck160 FIND v(dout0_37) AT=85.025n

.meas tran vdout0_38ck160 FIND v(dout0_38) AT=85.025n

.meas tran vdout0_39ck160 FIND v(dout0_39) AT=85.025n

.meas tran vdout0_40ck160 FIND v(dout0_40) AT=85.025n

.meas tran vdout0_41ck160 FIND v(dout0_41) AT=85.025n

.meas tran vdout0_42ck160 FIND v(dout0_42) AT=85.025n

.meas tran vdout0_43ck160 FIND v(dout0_43) AT=85.025n

.meas tran vdout0_44ck160 FIND v(dout0_44) AT=85.025n

.meas tran vdout0_45ck160 FIND v(dout0_45) AT=85.025n

.meas tran vdout0_46ck160 FIND v(dout0_46) AT=85.025n

.meas tran vdout0_47ck160 FIND v(dout0_47) AT=85.025n

.meas tran vdout0_48ck160 FIND v(dout0_48) AT=85.025n

.meas tran vdout0_49ck160 FIND v(dout0_49) AT=85.025n

.meas tran vdout0_50ck160 FIND v(dout0_50) AT=85.025n

.meas tran vdout0_51ck160 FIND v(dout0_51) AT=85.025n

.meas tran vdout0_52ck160 FIND v(dout0_52) AT=85.025n

.meas tran vdout0_53ck160 FIND v(dout0_53) AT=85.025n

.meas tran vdout0_54ck160 FIND v(dout0_54) AT=85.025n

.meas tran vdout0_55ck160 FIND v(dout0_55) AT=85.025n

.meas tran vdout0_56ck160 FIND v(dout0_56) AT=85.025n

.meas tran vdout0_57ck160 FIND v(dout0_57) AT=85.025n

.meas tran vdout0_58ck160 FIND v(dout0_58) AT=85.025n

.meas tran vdout0_59ck160 FIND v(dout0_59) AT=85.025n

.meas tran vdout0_60ck160 FIND v(dout0_60) AT=85.025n

.meas tran vdout0_61ck160 FIND v(dout0_61) AT=85.025n

.meas tran vdout0_62ck160 FIND v(dout0_62) AT=85.025n

.meas tran vdout0_63ck160 FIND v(dout0_63) AT=85.025n

.meas tran vdout1_0ck170 FIND v(dout1_0) AT=90.025n

.meas tran vdout1_1ck170 FIND v(dout1_1) AT=90.025n

.meas tran vdout1_2ck170 FIND v(dout1_2) AT=90.025n

.meas tran vdout1_3ck170 FIND v(dout1_3) AT=90.025n

.meas tran vdout1_4ck170 FIND v(dout1_4) AT=90.025n

.meas tran vdout1_5ck170 FIND v(dout1_5) AT=90.025n

.meas tran vdout1_6ck170 FIND v(dout1_6) AT=90.025n

.meas tran vdout1_7ck170 FIND v(dout1_7) AT=90.025n

.meas tran vdout1_8ck170 FIND v(dout1_8) AT=90.025n

.meas tran vdout1_9ck170 FIND v(dout1_9) AT=90.025n

.meas tran vdout1_10ck170 FIND v(dout1_10) AT=90.025n

.meas tran vdout1_11ck170 FIND v(dout1_11) AT=90.025n

.meas tran vdout1_12ck170 FIND v(dout1_12) AT=90.025n

.meas tran vdout1_13ck170 FIND v(dout1_13) AT=90.025n

.meas tran vdout1_14ck170 FIND v(dout1_14) AT=90.025n

.meas tran vdout1_15ck170 FIND v(dout1_15) AT=90.025n

.meas tran vdout1_16ck170 FIND v(dout1_16) AT=90.025n

.meas tran vdout1_17ck170 FIND v(dout1_17) AT=90.025n

.meas tran vdout1_18ck170 FIND v(dout1_18) AT=90.025n

.meas tran vdout1_19ck170 FIND v(dout1_19) AT=90.025n

.meas tran vdout1_20ck170 FIND v(dout1_20) AT=90.025n

.meas tran vdout1_21ck170 FIND v(dout1_21) AT=90.025n

.meas tran vdout1_22ck170 FIND v(dout1_22) AT=90.025n

.meas tran vdout1_23ck170 FIND v(dout1_23) AT=90.025n

.meas tran vdout1_24ck170 FIND v(dout1_24) AT=90.025n

.meas tran vdout1_25ck170 FIND v(dout1_25) AT=90.025n

.meas tran vdout1_26ck170 FIND v(dout1_26) AT=90.025n

.meas tran vdout1_27ck170 FIND v(dout1_27) AT=90.025n

.meas tran vdout1_28ck170 FIND v(dout1_28) AT=90.025n

.meas tran vdout1_29ck170 FIND v(dout1_29) AT=90.025n

.meas tran vdout1_30ck170 FIND v(dout1_30) AT=90.025n

.meas tran vdout1_31ck170 FIND v(dout1_31) AT=90.025n

.meas tran vdout1_32ck170 FIND v(dout1_32) AT=90.025n

.meas tran vdout1_33ck170 FIND v(dout1_33) AT=90.025n

.meas tran vdout1_34ck170 FIND v(dout1_34) AT=90.025n

.meas tran vdout1_35ck170 FIND v(dout1_35) AT=90.025n

.meas tran vdout1_36ck170 FIND v(dout1_36) AT=90.025n

.meas tran vdout1_37ck170 FIND v(dout1_37) AT=90.025n

.meas tran vdout1_38ck170 FIND v(dout1_38) AT=90.025n

.meas tran vdout1_39ck170 FIND v(dout1_39) AT=90.025n

.meas tran vdout1_40ck170 FIND v(dout1_40) AT=90.025n

.meas tran vdout1_41ck170 FIND v(dout1_41) AT=90.025n

.meas tran vdout1_42ck170 FIND v(dout1_42) AT=90.025n

.meas tran vdout1_43ck170 FIND v(dout1_43) AT=90.025n

.meas tran vdout1_44ck170 FIND v(dout1_44) AT=90.025n

.meas tran vdout1_45ck170 FIND v(dout1_45) AT=90.025n

.meas tran vdout1_46ck170 FIND v(dout1_46) AT=90.025n

.meas tran vdout1_47ck170 FIND v(dout1_47) AT=90.025n

.meas tran vdout1_48ck170 FIND v(dout1_48) AT=90.025n

.meas tran vdout1_49ck170 FIND v(dout1_49) AT=90.025n

.meas tran vdout1_50ck170 FIND v(dout1_50) AT=90.025n

.meas tran vdout1_51ck170 FIND v(dout1_51) AT=90.025n

.meas tran vdout1_52ck170 FIND v(dout1_52) AT=90.025n

.meas tran vdout1_53ck170 FIND v(dout1_53) AT=90.025n

.meas tran vdout1_54ck170 FIND v(dout1_54) AT=90.025n

.meas tran vdout1_55ck170 FIND v(dout1_55) AT=90.025n

.meas tran vdout1_56ck170 FIND v(dout1_56) AT=90.025n

.meas tran vdout1_57ck170 FIND v(dout1_57) AT=90.025n

.meas tran vdout1_58ck170 FIND v(dout1_58) AT=90.025n

.meas tran vdout1_59ck170 FIND v(dout1_59) AT=90.025n

.meas tran vdout1_60ck170 FIND v(dout1_60) AT=90.025n

.meas tran vdout1_61ck170 FIND v(dout1_61) AT=90.025n

.meas tran vdout1_62ck170 FIND v(dout1_62) AT=90.025n

.meas tran vdout1_63ck170 FIND v(dout1_63) AT=90.025n

.meas tran vdout0_0ck180 FIND v(dout0_0) AT=95.025n

.meas tran vdout0_1ck180 FIND v(dout0_1) AT=95.025n

.meas tran vdout0_2ck180 FIND v(dout0_2) AT=95.025n

.meas tran vdout0_3ck180 FIND v(dout0_3) AT=95.025n

.meas tran vdout0_4ck180 FIND v(dout0_4) AT=95.025n

.meas tran vdout0_5ck180 FIND v(dout0_5) AT=95.025n

.meas tran vdout0_6ck180 FIND v(dout0_6) AT=95.025n

.meas tran vdout0_7ck180 FIND v(dout0_7) AT=95.025n

.meas tran vdout0_8ck180 FIND v(dout0_8) AT=95.025n

.meas tran vdout0_9ck180 FIND v(dout0_9) AT=95.025n

.meas tran vdout0_10ck180 FIND v(dout0_10) AT=95.025n

.meas tran vdout0_11ck180 FIND v(dout0_11) AT=95.025n

.meas tran vdout0_12ck180 FIND v(dout0_12) AT=95.025n

.meas tran vdout0_13ck180 FIND v(dout0_13) AT=95.025n

.meas tran vdout0_14ck180 FIND v(dout0_14) AT=95.025n

.meas tran vdout0_15ck180 FIND v(dout0_15) AT=95.025n

.meas tran vdout0_16ck180 FIND v(dout0_16) AT=95.025n

.meas tran vdout0_17ck180 FIND v(dout0_17) AT=95.025n

.meas tran vdout0_18ck180 FIND v(dout0_18) AT=95.025n

.meas tran vdout0_19ck180 FIND v(dout0_19) AT=95.025n

.meas tran vdout0_20ck180 FIND v(dout0_20) AT=95.025n

.meas tran vdout0_21ck180 FIND v(dout0_21) AT=95.025n

.meas tran vdout0_22ck180 FIND v(dout0_22) AT=95.025n

.meas tran vdout0_23ck180 FIND v(dout0_23) AT=95.025n

.meas tran vdout0_24ck180 FIND v(dout0_24) AT=95.025n

.meas tran vdout0_25ck180 FIND v(dout0_25) AT=95.025n

.meas tran vdout0_26ck180 FIND v(dout0_26) AT=95.025n

.meas tran vdout0_27ck180 FIND v(dout0_27) AT=95.025n

.meas tran vdout0_28ck180 FIND v(dout0_28) AT=95.025n

.meas tran vdout0_29ck180 FIND v(dout0_29) AT=95.025n

.meas tran vdout0_30ck180 FIND v(dout0_30) AT=95.025n

.meas tran vdout0_31ck180 FIND v(dout0_31) AT=95.025n

.meas tran vdout0_32ck180 FIND v(dout0_32) AT=95.025n

.meas tran vdout0_33ck180 FIND v(dout0_33) AT=95.025n

.meas tran vdout0_34ck180 FIND v(dout0_34) AT=95.025n

.meas tran vdout0_35ck180 FIND v(dout0_35) AT=95.025n

.meas tran vdout0_36ck180 FIND v(dout0_36) AT=95.025n

.meas tran vdout0_37ck180 FIND v(dout0_37) AT=95.025n

.meas tran vdout0_38ck180 FIND v(dout0_38) AT=95.025n

.meas tran vdout0_39ck180 FIND v(dout0_39) AT=95.025n

.meas tran vdout0_40ck180 FIND v(dout0_40) AT=95.025n

.meas tran vdout0_41ck180 FIND v(dout0_41) AT=95.025n

.meas tran vdout0_42ck180 FIND v(dout0_42) AT=95.025n

.meas tran vdout0_43ck180 FIND v(dout0_43) AT=95.025n

.meas tran vdout0_44ck180 FIND v(dout0_44) AT=95.025n

.meas tran vdout0_45ck180 FIND v(dout0_45) AT=95.025n

.meas tran vdout0_46ck180 FIND v(dout0_46) AT=95.025n

.meas tran vdout0_47ck180 FIND v(dout0_47) AT=95.025n

.meas tran vdout0_48ck180 FIND v(dout0_48) AT=95.025n

.meas tran vdout0_49ck180 FIND v(dout0_49) AT=95.025n

.meas tran vdout0_50ck180 FIND v(dout0_50) AT=95.025n

.meas tran vdout0_51ck180 FIND v(dout0_51) AT=95.025n

.meas tran vdout0_52ck180 FIND v(dout0_52) AT=95.025n

.meas tran vdout0_53ck180 FIND v(dout0_53) AT=95.025n

.meas tran vdout0_54ck180 FIND v(dout0_54) AT=95.025n

.meas tran vdout0_55ck180 FIND v(dout0_55) AT=95.025n

.meas tran vdout0_56ck180 FIND v(dout0_56) AT=95.025n

.meas tran vdout0_57ck180 FIND v(dout0_57) AT=95.025n

.meas tran vdout0_58ck180 FIND v(dout0_58) AT=95.025n

.meas tran vdout0_59ck180 FIND v(dout0_59) AT=95.025n

.meas tran vdout0_60ck180 FIND v(dout0_60) AT=95.025n

.meas tran vdout0_61ck180 FIND v(dout0_61) AT=95.025n

.meas tran vdout0_62ck180 FIND v(dout0_62) AT=95.025n

.meas tran vdout0_63ck180 FIND v(dout0_63) AT=95.025n

.meas tran vdout0_0ck190 FIND v(dout0_0) AT=100.025n

.meas tran vdout0_1ck190 FIND v(dout0_1) AT=100.025n

.meas tran vdout0_2ck190 FIND v(dout0_2) AT=100.025n

.meas tran vdout0_3ck190 FIND v(dout0_3) AT=100.025n

.meas tran vdout0_4ck190 FIND v(dout0_4) AT=100.025n

.meas tran vdout0_5ck190 FIND v(dout0_5) AT=100.025n

.meas tran vdout0_6ck190 FIND v(dout0_6) AT=100.025n

.meas tran vdout0_7ck190 FIND v(dout0_7) AT=100.025n

.meas tran vdout0_8ck190 FIND v(dout0_8) AT=100.025n

.meas tran vdout0_9ck190 FIND v(dout0_9) AT=100.025n

.meas tran vdout0_10ck190 FIND v(dout0_10) AT=100.025n

.meas tran vdout0_11ck190 FIND v(dout0_11) AT=100.025n

.meas tran vdout0_12ck190 FIND v(dout0_12) AT=100.025n

.meas tran vdout0_13ck190 FIND v(dout0_13) AT=100.025n

.meas tran vdout0_14ck190 FIND v(dout0_14) AT=100.025n

.meas tran vdout0_15ck190 FIND v(dout0_15) AT=100.025n

.meas tran vdout0_16ck190 FIND v(dout0_16) AT=100.025n

.meas tran vdout0_17ck190 FIND v(dout0_17) AT=100.025n

.meas tran vdout0_18ck190 FIND v(dout0_18) AT=100.025n

.meas tran vdout0_19ck190 FIND v(dout0_19) AT=100.025n

.meas tran vdout0_20ck190 FIND v(dout0_20) AT=100.025n

.meas tran vdout0_21ck190 FIND v(dout0_21) AT=100.025n

.meas tran vdout0_22ck190 FIND v(dout0_22) AT=100.025n

.meas tran vdout0_23ck190 FIND v(dout0_23) AT=100.025n

.meas tran vdout0_24ck190 FIND v(dout0_24) AT=100.025n

.meas tran vdout0_25ck190 FIND v(dout0_25) AT=100.025n

.meas tran vdout0_26ck190 FIND v(dout0_26) AT=100.025n

.meas tran vdout0_27ck190 FIND v(dout0_27) AT=100.025n

.meas tran vdout0_28ck190 FIND v(dout0_28) AT=100.025n

.meas tran vdout0_29ck190 FIND v(dout0_29) AT=100.025n

.meas tran vdout0_30ck190 FIND v(dout0_30) AT=100.025n

.meas tran vdout0_31ck190 FIND v(dout0_31) AT=100.025n

.meas tran vdout0_32ck190 FIND v(dout0_32) AT=100.025n

.meas tran vdout0_33ck190 FIND v(dout0_33) AT=100.025n

.meas tran vdout0_34ck190 FIND v(dout0_34) AT=100.025n

.meas tran vdout0_35ck190 FIND v(dout0_35) AT=100.025n

.meas tran vdout0_36ck190 FIND v(dout0_36) AT=100.025n

.meas tran vdout0_37ck190 FIND v(dout0_37) AT=100.025n

.meas tran vdout0_38ck190 FIND v(dout0_38) AT=100.025n

.meas tran vdout0_39ck190 FIND v(dout0_39) AT=100.025n

.meas tran vdout0_40ck190 FIND v(dout0_40) AT=100.025n

.meas tran vdout0_41ck190 FIND v(dout0_41) AT=100.025n

.meas tran vdout0_42ck190 FIND v(dout0_42) AT=100.025n

.meas tran vdout0_43ck190 FIND v(dout0_43) AT=100.025n

.meas tran vdout0_44ck190 FIND v(dout0_44) AT=100.025n

.meas tran vdout0_45ck190 FIND v(dout0_45) AT=100.025n

.meas tran vdout0_46ck190 FIND v(dout0_46) AT=100.025n

.meas tran vdout0_47ck190 FIND v(dout0_47) AT=100.025n

.meas tran vdout0_48ck190 FIND v(dout0_48) AT=100.025n

.meas tran vdout0_49ck190 FIND v(dout0_49) AT=100.025n

.meas tran vdout0_50ck190 FIND v(dout0_50) AT=100.025n

.meas tran vdout0_51ck190 FIND v(dout0_51) AT=100.025n

.meas tran vdout0_52ck190 FIND v(dout0_52) AT=100.025n

.meas tran vdout0_53ck190 FIND v(dout0_53) AT=100.025n

.meas tran vdout0_54ck190 FIND v(dout0_54) AT=100.025n

.meas tran vdout0_55ck190 FIND v(dout0_55) AT=100.025n

.meas tran vdout0_56ck190 FIND v(dout0_56) AT=100.025n

.meas tran vdout0_57ck190 FIND v(dout0_57) AT=100.025n

.meas tran vdout0_58ck190 FIND v(dout0_58) AT=100.025n

.meas tran vdout0_59ck190 FIND v(dout0_59) AT=100.025n

.meas tran vdout0_60ck190 FIND v(dout0_60) AT=100.025n

.meas tran vdout0_61ck190 FIND v(dout0_61) AT=100.025n

.meas tran vdout0_62ck190 FIND v(dout0_62) AT=100.025n

.meas tran vdout0_63ck190 FIND v(dout0_63) AT=100.025n

.meas tran vdout1_0ck210 FIND v(dout1_0) AT=110.025n

.meas tran vdout1_1ck210 FIND v(dout1_1) AT=110.025n

.meas tran vdout1_2ck210 FIND v(dout1_2) AT=110.025n

.meas tran vdout1_3ck210 FIND v(dout1_3) AT=110.025n

.meas tran vdout1_4ck210 FIND v(dout1_4) AT=110.025n

.meas tran vdout1_5ck210 FIND v(dout1_5) AT=110.025n

.meas tran vdout1_6ck210 FIND v(dout1_6) AT=110.025n

.meas tran vdout1_7ck210 FIND v(dout1_7) AT=110.025n

.meas tran vdout1_8ck210 FIND v(dout1_8) AT=110.025n

.meas tran vdout1_9ck210 FIND v(dout1_9) AT=110.025n

.meas tran vdout1_10ck210 FIND v(dout1_10) AT=110.025n

.meas tran vdout1_11ck210 FIND v(dout1_11) AT=110.025n

.meas tran vdout1_12ck210 FIND v(dout1_12) AT=110.025n

.meas tran vdout1_13ck210 FIND v(dout1_13) AT=110.025n

.meas tran vdout1_14ck210 FIND v(dout1_14) AT=110.025n

.meas tran vdout1_15ck210 FIND v(dout1_15) AT=110.025n

.meas tran vdout1_16ck210 FIND v(dout1_16) AT=110.025n

.meas tran vdout1_17ck210 FIND v(dout1_17) AT=110.025n

.meas tran vdout1_18ck210 FIND v(dout1_18) AT=110.025n

.meas tran vdout1_19ck210 FIND v(dout1_19) AT=110.025n

.meas tran vdout1_20ck210 FIND v(dout1_20) AT=110.025n

.meas tran vdout1_21ck210 FIND v(dout1_21) AT=110.025n

.meas tran vdout1_22ck210 FIND v(dout1_22) AT=110.025n

.meas tran vdout1_23ck210 FIND v(dout1_23) AT=110.025n

.meas tran vdout1_24ck210 FIND v(dout1_24) AT=110.025n

.meas tran vdout1_25ck210 FIND v(dout1_25) AT=110.025n

.meas tran vdout1_26ck210 FIND v(dout1_26) AT=110.025n

.meas tran vdout1_27ck210 FIND v(dout1_27) AT=110.025n

.meas tran vdout1_28ck210 FIND v(dout1_28) AT=110.025n

.meas tran vdout1_29ck210 FIND v(dout1_29) AT=110.025n

.meas tran vdout1_30ck210 FIND v(dout1_30) AT=110.025n

.meas tran vdout1_31ck210 FIND v(dout1_31) AT=110.025n

.meas tran vdout1_32ck210 FIND v(dout1_32) AT=110.025n

.meas tran vdout1_33ck210 FIND v(dout1_33) AT=110.025n

.meas tran vdout1_34ck210 FIND v(dout1_34) AT=110.025n

.meas tran vdout1_35ck210 FIND v(dout1_35) AT=110.025n

.meas tran vdout1_36ck210 FIND v(dout1_36) AT=110.025n

.meas tran vdout1_37ck210 FIND v(dout1_37) AT=110.025n

.meas tran vdout1_38ck210 FIND v(dout1_38) AT=110.025n

.meas tran vdout1_39ck210 FIND v(dout1_39) AT=110.025n

.meas tran vdout1_40ck210 FIND v(dout1_40) AT=110.025n

.meas tran vdout1_41ck210 FIND v(dout1_41) AT=110.025n

.meas tran vdout1_42ck210 FIND v(dout1_42) AT=110.025n

.meas tran vdout1_43ck210 FIND v(dout1_43) AT=110.025n

.meas tran vdout1_44ck210 FIND v(dout1_44) AT=110.025n

.meas tran vdout1_45ck210 FIND v(dout1_45) AT=110.025n

.meas tran vdout1_46ck210 FIND v(dout1_46) AT=110.025n

.meas tran vdout1_47ck210 FIND v(dout1_47) AT=110.025n

.meas tran vdout1_48ck210 FIND v(dout1_48) AT=110.025n

.meas tran vdout1_49ck210 FIND v(dout1_49) AT=110.025n

.meas tran vdout1_50ck210 FIND v(dout1_50) AT=110.025n

.meas tran vdout1_51ck210 FIND v(dout1_51) AT=110.025n

.meas tran vdout1_52ck210 FIND v(dout1_52) AT=110.025n

.meas tran vdout1_53ck210 FIND v(dout1_53) AT=110.025n

.meas tran vdout1_54ck210 FIND v(dout1_54) AT=110.025n

.meas tran vdout1_55ck210 FIND v(dout1_55) AT=110.025n

.meas tran vdout1_56ck210 FIND v(dout1_56) AT=110.025n

.meas tran vdout1_57ck210 FIND v(dout1_57) AT=110.025n

.meas tran vdout1_58ck210 FIND v(dout1_58) AT=110.025n

.meas tran vdout1_59ck210 FIND v(dout1_59) AT=110.025n

.meas tran vdout1_60ck210 FIND v(dout1_60) AT=110.025n

.meas tran vdout1_61ck210 FIND v(dout1_61) AT=110.025n

.meas tran vdout1_62ck210 FIND v(dout1_62) AT=110.025n

.meas tran vdout1_63ck210 FIND v(dout1_63) AT=110.025n

.meas tran vdout1_0ck220 FIND v(dout1_0) AT=115.025n

.meas tran vdout1_1ck220 FIND v(dout1_1) AT=115.025n

.meas tran vdout1_2ck220 FIND v(dout1_2) AT=115.025n

.meas tran vdout1_3ck220 FIND v(dout1_3) AT=115.025n

.meas tran vdout1_4ck220 FIND v(dout1_4) AT=115.025n

.meas tran vdout1_5ck220 FIND v(dout1_5) AT=115.025n

.meas tran vdout1_6ck220 FIND v(dout1_6) AT=115.025n

.meas tran vdout1_7ck220 FIND v(dout1_7) AT=115.025n

.meas tran vdout1_8ck220 FIND v(dout1_8) AT=115.025n

.meas tran vdout1_9ck220 FIND v(dout1_9) AT=115.025n

.meas tran vdout1_10ck220 FIND v(dout1_10) AT=115.025n

.meas tran vdout1_11ck220 FIND v(dout1_11) AT=115.025n

.meas tran vdout1_12ck220 FIND v(dout1_12) AT=115.025n

.meas tran vdout1_13ck220 FIND v(dout1_13) AT=115.025n

.meas tran vdout1_14ck220 FIND v(dout1_14) AT=115.025n

.meas tran vdout1_15ck220 FIND v(dout1_15) AT=115.025n

.meas tran vdout1_16ck220 FIND v(dout1_16) AT=115.025n

.meas tran vdout1_17ck220 FIND v(dout1_17) AT=115.025n

.meas tran vdout1_18ck220 FIND v(dout1_18) AT=115.025n

.meas tran vdout1_19ck220 FIND v(dout1_19) AT=115.025n

.meas tran vdout1_20ck220 FIND v(dout1_20) AT=115.025n

.meas tran vdout1_21ck220 FIND v(dout1_21) AT=115.025n

.meas tran vdout1_22ck220 FIND v(dout1_22) AT=115.025n

.meas tran vdout1_23ck220 FIND v(dout1_23) AT=115.025n

.meas tran vdout1_24ck220 FIND v(dout1_24) AT=115.025n

.meas tran vdout1_25ck220 FIND v(dout1_25) AT=115.025n

.meas tran vdout1_26ck220 FIND v(dout1_26) AT=115.025n

.meas tran vdout1_27ck220 FIND v(dout1_27) AT=115.025n

.meas tran vdout1_28ck220 FIND v(dout1_28) AT=115.025n

.meas tran vdout1_29ck220 FIND v(dout1_29) AT=115.025n

.meas tran vdout1_30ck220 FIND v(dout1_30) AT=115.025n

.meas tran vdout1_31ck220 FIND v(dout1_31) AT=115.025n

.meas tran vdout1_32ck220 FIND v(dout1_32) AT=115.025n

.meas tran vdout1_33ck220 FIND v(dout1_33) AT=115.025n

.meas tran vdout1_34ck220 FIND v(dout1_34) AT=115.025n

.meas tran vdout1_35ck220 FIND v(dout1_35) AT=115.025n

.meas tran vdout1_36ck220 FIND v(dout1_36) AT=115.025n

.meas tran vdout1_37ck220 FIND v(dout1_37) AT=115.025n

.meas tran vdout1_38ck220 FIND v(dout1_38) AT=115.025n

.meas tran vdout1_39ck220 FIND v(dout1_39) AT=115.025n

.meas tran vdout1_40ck220 FIND v(dout1_40) AT=115.025n

.meas tran vdout1_41ck220 FIND v(dout1_41) AT=115.025n

.meas tran vdout1_42ck220 FIND v(dout1_42) AT=115.025n

.meas tran vdout1_43ck220 FIND v(dout1_43) AT=115.025n

.meas tran vdout1_44ck220 FIND v(dout1_44) AT=115.025n

.meas tran vdout1_45ck220 FIND v(dout1_45) AT=115.025n

.meas tran vdout1_46ck220 FIND v(dout1_46) AT=115.025n

.meas tran vdout1_47ck220 FIND v(dout1_47) AT=115.025n

.meas tran vdout1_48ck220 FIND v(dout1_48) AT=115.025n

.meas tran vdout1_49ck220 FIND v(dout1_49) AT=115.025n

.meas tran vdout1_50ck220 FIND v(dout1_50) AT=115.025n

.meas tran vdout1_51ck220 FIND v(dout1_51) AT=115.025n

.meas tran vdout1_52ck220 FIND v(dout1_52) AT=115.025n

.meas tran vdout1_53ck220 FIND v(dout1_53) AT=115.025n

.meas tran vdout1_54ck220 FIND v(dout1_54) AT=115.025n

.meas tran vdout1_55ck220 FIND v(dout1_55) AT=115.025n

.meas tran vdout1_56ck220 FIND v(dout1_56) AT=115.025n

.meas tran vdout1_57ck220 FIND v(dout1_57) AT=115.025n

.meas tran vdout1_58ck220 FIND v(dout1_58) AT=115.025n

.meas tran vdout1_59ck220 FIND v(dout1_59) AT=115.025n

.meas tran vdout1_60ck220 FIND v(dout1_60) AT=115.025n

.meas tran vdout1_61ck220 FIND v(dout1_61) AT=115.025n

.meas tran vdout1_62ck220 FIND v(dout1_62) AT=115.025n

.meas tran vdout1_63ck220 FIND v(dout1_63) AT=115.025n

.meas tran vdout0_0ck240 FIND v(dout0_0) AT=125.025n

.meas tran vdout0_1ck240 FIND v(dout0_1) AT=125.025n

.meas tran vdout0_2ck240 FIND v(dout0_2) AT=125.025n

.meas tran vdout0_3ck240 FIND v(dout0_3) AT=125.025n

.meas tran vdout0_4ck240 FIND v(dout0_4) AT=125.025n

.meas tran vdout0_5ck240 FIND v(dout0_5) AT=125.025n

.meas tran vdout0_6ck240 FIND v(dout0_6) AT=125.025n

.meas tran vdout0_7ck240 FIND v(dout0_7) AT=125.025n

.meas tran vdout0_8ck240 FIND v(dout0_8) AT=125.025n

.meas tran vdout0_9ck240 FIND v(dout0_9) AT=125.025n

.meas tran vdout0_10ck240 FIND v(dout0_10) AT=125.025n

.meas tran vdout0_11ck240 FIND v(dout0_11) AT=125.025n

.meas tran vdout0_12ck240 FIND v(dout0_12) AT=125.025n

.meas tran vdout0_13ck240 FIND v(dout0_13) AT=125.025n

.meas tran vdout0_14ck240 FIND v(dout0_14) AT=125.025n

.meas tran vdout0_15ck240 FIND v(dout0_15) AT=125.025n

.meas tran vdout0_16ck240 FIND v(dout0_16) AT=125.025n

.meas tran vdout0_17ck240 FIND v(dout0_17) AT=125.025n

.meas tran vdout0_18ck240 FIND v(dout0_18) AT=125.025n

.meas tran vdout0_19ck240 FIND v(dout0_19) AT=125.025n

.meas tran vdout0_20ck240 FIND v(dout0_20) AT=125.025n

.meas tran vdout0_21ck240 FIND v(dout0_21) AT=125.025n

.meas tran vdout0_22ck240 FIND v(dout0_22) AT=125.025n

.meas tran vdout0_23ck240 FIND v(dout0_23) AT=125.025n

.meas tran vdout0_24ck240 FIND v(dout0_24) AT=125.025n

.meas tran vdout0_25ck240 FIND v(dout0_25) AT=125.025n

.meas tran vdout0_26ck240 FIND v(dout0_26) AT=125.025n

.meas tran vdout0_27ck240 FIND v(dout0_27) AT=125.025n

.meas tran vdout0_28ck240 FIND v(dout0_28) AT=125.025n

.meas tran vdout0_29ck240 FIND v(dout0_29) AT=125.025n

.meas tran vdout0_30ck240 FIND v(dout0_30) AT=125.025n

.meas tran vdout0_31ck240 FIND v(dout0_31) AT=125.025n

.meas tran vdout0_32ck240 FIND v(dout0_32) AT=125.025n

.meas tran vdout0_33ck240 FIND v(dout0_33) AT=125.025n

.meas tran vdout0_34ck240 FIND v(dout0_34) AT=125.025n

.meas tran vdout0_35ck240 FIND v(dout0_35) AT=125.025n

.meas tran vdout0_36ck240 FIND v(dout0_36) AT=125.025n

.meas tran vdout0_37ck240 FIND v(dout0_37) AT=125.025n

.meas tran vdout0_38ck240 FIND v(dout0_38) AT=125.025n

.meas tran vdout0_39ck240 FIND v(dout0_39) AT=125.025n

.meas tran vdout0_40ck240 FIND v(dout0_40) AT=125.025n

.meas tran vdout0_41ck240 FIND v(dout0_41) AT=125.025n

.meas tran vdout0_42ck240 FIND v(dout0_42) AT=125.025n

.meas tran vdout0_43ck240 FIND v(dout0_43) AT=125.025n

.meas tran vdout0_44ck240 FIND v(dout0_44) AT=125.025n

.meas tran vdout0_45ck240 FIND v(dout0_45) AT=125.025n

.meas tran vdout0_46ck240 FIND v(dout0_46) AT=125.025n

.meas tran vdout0_47ck240 FIND v(dout0_47) AT=125.025n

.meas tran vdout0_48ck240 FIND v(dout0_48) AT=125.025n

.meas tran vdout0_49ck240 FIND v(dout0_49) AT=125.025n

.meas tran vdout0_50ck240 FIND v(dout0_50) AT=125.025n

.meas tran vdout0_51ck240 FIND v(dout0_51) AT=125.025n

.meas tran vdout0_52ck240 FIND v(dout0_52) AT=125.025n

.meas tran vdout0_53ck240 FIND v(dout0_53) AT=125.025n

.meas tran vdout0_54ck240 FIND v(dout0_54) AT=125.025n

.meas tran vdout0_55ck240 FIND v(dout0_55) AT=125.025n

.meas tran vdout0_56ck240 FIND v(dout0_56) AT=125.025n

.meas tran vdout0_57ck240 FIND v(dout0_57) AT=125.025n

.meas tran vdout0_58ck240 FIND v(dout0_58) AT=125.025n

.meas tran vdout0_59ck240 FIND v(dout0_59) AT=125.025n

.meas tran vdout0_60ck240 FIND v(dout0_60) AT=125.025n

.meas tran vdout0_61ck240 FIND v(dout0_61) AT=125.025n

.meas tran vdout0_62ck240 FIND v(dout0_62) AT=125.025n

.meas tran vdout0_63ck240 FIND v(dout0_63) AT=125.025n

.meas tran vdout0_0ck260 FIND v(dout0_0) AT=135.025n

.meas tran vdout0_1ck260 FIND v(dout0_1) AT=135.025n

.meas tran vdout0_2ck260 FIND v(dout0_2) AT=135.025n

.meas tran vdout0_3ck260 FIND v(dout0_3) AT=135.025n

.meas tran vdout0_4ck260 FIND v(dout0_4) AT=135.025n

.meas tran vdout0_5ck260 FIND v(dout0_5) AT=135.025n

.meas tran vdout0_6ck260 FIND v(dout0_6) AT=135.025n

.meas tran vdout0_7ck260 FIND v(dout0_7) AT=135.025n

.meas tran vdout0_8ck260 FIND v(dout0_8) AT=135.025n

.meas tran vdout0_9ck260 FIND v(dout0_9) AT=135.025n

.meas tran vdout0_10ck260 FIND v(dout0_10) AT=135.025n

.meas tran vdout0_11ck260 FIND v(dout0_11) AT=135.025n

.meas tran vdout0_12ck260 FIND v(dout0_12) AT=135.025n

.meas tran vdout0_13ck260 FIND v(dout0_13) AT=135.025n

.meas tran vdout0_14ck260 FIND v(dout0_14) AT=135.025n

.meas tran vdout0_15ck260 FIND v(dout0_15) AT=135.025n

.meas tran vdout0_16ck260 FIND v(dout0_16) AT=135.025n

.meas tran vdout0_17ck260 FIND v(dout0_17) AT=135.025n

.meas tran vdout0_18ck260 FIND v(dout0_18) AT=135.025n

.meas tran vdout0_19ck260 FIND v(dout0_19) AT=135.025n

.meas tran vdout0_20ck260 FIND v(dout0_20) AT=135.025n

.meas tran vdout0_21ck260 FIND v(dout0_21) AT=135.025n

.meas tran vdout0_22ck260 FIND v(dout0_22) AT=135.025n

.meas tran vdout0_23ck260 FIND v(dout0_23) AT=135.025n

.meas tran vdout0_24ck260 FIND v(dout0_24) AT=135.025n

.meas tran vdout0_25ck260 FIND v(dout0_25) AT=135.025n

.meas tran vdout0_26ck260 FIND v(dout0_26) AT=135.025n

.meas tran vdout0_27ck260 FIND v(dout0_27) AT=135.025n

.meas tran vdout0_28ck260 FIND v(dout0_28) AT=135.025n

.meas tran vdout0_29ck260 FIND v(dout0_29) AT=135.025n

.meas tran vdout0_30ck260 FIND v(dout0_30) AT=135.025n

.meas tran vdout0_31ck260 FIND v(dout0_31) AT=135.025n

.meas tran vdout0_32ck260 FIND v(dout0_32) AT=135.025n

.meas tran vdout0_33ck260 FIND v(dout0_33) AT=135.025n

.meas tran vdout0_34ck260 FIND v(dout0_34) AT=135.025n

.meas tran vdout0_35ck260 FIND v(dout0_35) AT=135.025n

.meas tran vdout0_36ck260 FIND v(dout0_36) AT=135.025n

.meas tran vdout0_37ck260 FIND v(dout0_37) AT=135.025n

.meas tran vdout0_38ck260 FIND v(dout0_38) AT=135.025n

.meas tran vdout0_39ck260 FIND v(dout0_39) AT=135.025n

.meas tran vdout0_40ck260 FIND v(dout0_40) AT=135.025n

.meas tran vdout0_41ck260 FIND v(dout0_41) AT=135.025n

.meas tran vdout0_42ck260 FIND v(dout0_42) AT=135.025n

.meas tran vdout0_43ck260 FIND v(dout0_43) AT=135.025n

.meas tran vdout0_44ck260 FIND v(dout0_44) AT=135.025n

.meas tran vdout0_45ck260 FIND v(dout0_45) AT=135.025n

.meas tran vdout0_46ck260 FIND v(dout0_46) AT=135.025n

.meas tran vdout0_47ck260 FIND v(dout0_47) AT=135.025n

.meas tran vdout0_48ck260 FIND v(dout0_48) AT=135.025n

.meas tran vdout0_49ck260 FIND v(dout0_49) AT=135.025n

.meas tran vdout0_50ck260 FIND v(dout0_50) AT=135.025n

.meas tran vdout0_51ck260 FIND v(dout0_51) AT=135.025n

.meas tran vdout0_52ck260 FIND v(dout0_52) AT=135.025n

.meas tran vdout0_53ck260 FIND v(dout0_53) AT=135.025n

.meas tran vdout0_54ck260 FIND v(dout0_54) AT=135.025n

.meas tran vdout0_55ck260 FIND v(dout0_55) AT=135.025n

.meas tran vdout0_56ck260 FIND v(dout0_56) AT=135.025n

.meas tran vdout0_57ck260 FIND v(dout0_57) AT=135.025n

.meas tran vdout0_58ck260 FIND v(dout0_58) AT=135.025n

.meas tran vdout0_59ck260 FIND v(dout0_59) AT=135.025n

.meas tran vdout0_60ck260 FIND v(dout0_60) AT=135.025n

.meas tran vdout0_61ck260 FIND v(dout0_61) AT=135.025n

.meas tran vdout0_62ck260 FIND v(dout0_62) AT=135.025n

.meas tran vdout0_63ck260 FIND v(dout0_63) AT=135.025n

.meas tran vdout0_0ck270 FIND v(dout0_0) AT=140.025n

.meas tran vdout0_1ck270 FIND v(dout0_1) AT=140.025n

.meas tran vdout0_2ck270 FIND v(dout0_2) AT=140.025n

.meas tran vdout0_3ck270 FIND v(dout0_3) AT=140.025n

.meas tran vdout0_4ck270 FIND v(dout0_4) AT=140.025n

.meas tran vdout0_5ck270 FIND v(dout0_5) AT=140.025n

.meas tran vdout0_6ck270 FIND v(dout0_6) AT=140.025n

.meas tran vdout0_7ck270 FIND v(dout0_7) AT=140.025n

.meas tran vdout0_8ck270 FIND v(dout0_8) AT=140.025n

.meas tran vdout0_9ck270 FIND v(dout0_9) AT=140.025n

.meas tran vdout0_10ck270 FIND v(dout0_10) AT=140.025n

.meas tran vdout0_11ck270 FIND v(dout0_11) AT=140.025n

.meas tran vdout0_12ck270 FIND v(dout0_12) AT=140.025n

.meas tran vdout0_13ck270 FIND v(dout0_13) AT=140.025n

.meas tran vdout0_14ck270 FIND v(dout0_14) AT=140.025n

.meas tran vdout0_15ck270 FIND v(dout0_15) AT=140.025n

.meas tran vdout0_16ck270 FIND v(dout0_16) AT=140.025n

.meas tran vdout0_17ck270 FIND v(dout0_17) AT=140.025n

.meas tran vdout0_18ck270 FIND v(dout0_18) AT=140.025n

.meas tran vdout0_19ck270 FIND v(dout0_19) AT=140.025n

.meas tran vdout0_20ck270 FIND v(dout0_20) AT=140.025n

.meas tran vdout0_21ck270 FIND v(dout0_21) AT=140.025n

.meas tran vdout0_22ck270 FIND v(dout0_22) AT=140.025n

.meas tran vdout0_23ck270 FIND v(dout0_23) AT=140.025n

.meas tran vdout0_24ck270 FIND v(dout0_24) AT=140.025n

.meas tran vdout0_25ck270 FIND v(dout0_25) AT=140.025n

.meas tran vdout0_26ck270 FIND v(dout0_26) AT=140.025n

.meas tran vdout0_27ck270 FIND v(dout0_27) AT=140.025n

.meas tran vdout0_28ck270 FIND v(dout0_28) AT=140.025n

.meas tran vdout0_29ck270 FIND v(dout0_29) AT=140.025n

.meas tran vdout0_30ck270 FIND v(dout0_30) AT=140.025n

.meas tran vdout0_31ck270 FIND v(dout0_31) AT=140.025n

.meas tran vdout0_32ck270 FIND v(dout0_32) AT=140.025n

.meas tran vdout0_33ck270 FIND v(dout0_33) AT=140.025n

.meas tran vdout0_34ck270 FIND v(dout0_34) AT=140.025n

.meas tran vdout0_35ck270 FIND v(dout0_35) AT=140.025n

.meas tran vdout0_36ck270 FIND v(dout0_36) AT=140.025n

.meas tran vdout0_37ck270 FIND v(dout0_37) AT=140.025n

.meas tran vdout0_38ck270 FIND v(dout0_38) AT=140.025n

.meas tran vdout0_39ck270 FIND v(dout0_39) AT=140.025n

.meas tran vdout0_40ck270 FIND v(dout0_40) AT=140.025n

.meas tran vdout0_41ck270 FIND v(dout0_41) AT=140.025n

.meas tran vdout0_42ck270 FIND v(dout0_42) AT=140.025n

.meas tran vdout0_43ck270 FIND v(dout0_43) AT=140.025n

.meas tran vdout0_44ck270 FIND v(dout0_44) AT=140.025n

.meas tran vdout0_45ck270 FIND v(dout0_45) AT=140.025n

.meas tran vdout0_46ck270 FIND v(dout0_46) AT=140.025n

.meas tran vdout0_47ck270 FIND v(dout0_47) AT=140.025n

.meas tran vdout0_48ck270 FIND v(dout0_48) AT=140.025n

.meas tran vdout0_49ck270 FIND v(dout0_49) AT=140.025n

.meas tran vdout0_50ck270 FIND v(dout0_50) AT=140.025n

.meas tran vdout0_51ck270 FIND v(dout0_51) AT=140.025n

.meas tran vdout0_52ck270 FIND v(dout0_52) AT=140.025n

.meas tran vdout0_53ck270 FIND v(dout0_53) AT=140.025n

.meas tran vdout0_54ck270 FIND v(dout0_54) AT=140.025n

.meas tran vdout0_55ck270 FIND v(dout0_55) AT=140.025n

.meas tran vdout0_56ck270 FIND v(dout0_56) AT=140.025n

.meas tran vdout0_57ck270 FIND v(dout0_57) AT=140.025n

.meas tran vdout0_58ck270 FIND v(dout0_58) AT=140.025n

.meas tran vdout0_59ck270 FIND v(dout0_59) AT=140.025n

.meas tran vdout0_60ck270 FIND v(dout0_60) AT=140.025n

.meas tran vdout0_61ck270 FIND v(dout0_61) AT=140.025n

.meas tran vdout0_62ck270 FIND v(dout0_62) AT=140.025n

.meas tran vdout0_63ck270 FIND v(dout0_63) AT=140.025n

.meas tran vdout1_0ck270 FIND v(dout1_0) AT=140.025n

.meas tran vdout1_1ck270 FIND v(dout1_1) AT=140.025n

.meas tran vdout1_2ck270 FIND v(dout1_2) AT=140.025n

.meas tran vdout1_3ck270 FIND v(dout1_3) AT=140.025n

.meas tran vdout1_4ck270 FIND v(dout1_4) AT=140.025n

.meas tran vdout1_5ck270 FIND v(dout1_5) AT=140.025n

.meas tran vdout1_6ck270 FIND v(dout1_6) AT=140.025n

.meas tran vdout1_7ck270 FIND v(dout1_7) AT=140.025n

.meas tran vdout1_8ck270 FIND v(dout1_8) AT=140.025n

.meas tran vdout1_9ck270 FIND v(dout1_9) AT=140.025n

.meas tran vdout1_10ck270 FIND v(dout1_10) AT=140.025n

.meas tran vdout1_11ck270 FIND v(dout1_11) AT=140.025n

.meas tran vdout1_12ck270 FIND v(dout1_12) AT=140.025n

.meas tran vdout1_13ck270 FIND v(dout1_13) AT=140.025n

.meas tran vdout1_14ck270 FIND v(dout1_14) AT=140.025n

.meas tran vdout1_15ck270 FIND v(dout1_15) AT=140.025n

.meas tran vdout1_16ck270 FIND v(dout1_16) AT=140.025n

.meas tran vdout1_17ck270 FIND v(dout1_17) AT=140.025n

.meas tran vdout1_18ck270 FIND v(dout1_18) AT=140.025n

.meas tran vdout1_19ck270 FIND v(dout1_19) AT=140.025n

.meas tran vdout1_20ck270 FIND v(dout1_20) AT=140.025n

.meas tran vdout1_21ck270 FIND v(dout1_21) AT=140.025n

.meas tran vdout1_22ck270 FIND v(dout1_22) AT=140.025n

.meas tran vdout1_23ck270 FIND v(dout1_23) AT=140.025n

.meas tran vdout1_24ck270 FIND v(dout1_24) AT=140.025n

.meas tran vdout1_25ck270 FIND v(dout1_25) AT=140.025n

.meas tran vdout1_26ck270 FIND v(dout1_26) AT=140.025n

.meas tran vdout1_27ck270 FIND v(dout1_27) AT=140.025n

.meas tran vdout1_28ck270 FIND v(dout1_28) AT=140.025n

.meas tran vdout1_29ck270 FIND v(dout1_29) AT=140.025n

.meas tran vdout1_30ck270 FIND v(dout1_30) AT=140.025n

.meas tran vdout1_31ck270 FIND v(dout1_31) AT=140.025n

.meas tran vdout1_32ck270 FIND v(dout1_32) AT=140.025n

.meas tran vdout1_33ck270 FIND v(dout1_33) AT=140.025n

.meas tran vdout1_34ck270 FIND v(dout1_34) AT=140.025n

.meas tran vdout1_35ck270 FIND v(dout1_35) AT=140.025n

.meas tran vdout1_36ck270 FIND v(dout1_36) AT=140.025n

.meas tran vdout1_37ck270 FIND v(dout1_37) AT=140.025n

.meas tran vdout1_38ck270 FIND v(dout1_38) AT=140.025n

.meas tran vdout1_39ck270 FIND v(dout1_39) AT=140.025n

.meas tran vdout1_40ck270 FIND v(dout1_40) AT=140.025n

.meas tran vdout1_41ck270 FIND v(dout1_41) AT=140.025n

.meas tran vdout1_42ck270 FIND v(dout1_42) AT=140.025n

.meas tran vdout1_43ck270 FIND v(dout1_43) AT=140.025n

.meas tran vdout1_44ck270 FIND v(dout1_44) AT=140.025n

.meas tran vdout1_45ck270 FIND v(dout1_45) AT=140.025n

.meas tran vdout1_46ck270 FIND v(dout1_46) AT=140.025n

.meas tran vdout1_47ck270 FIND v(dout1_47) AT=140.025n

.meas tran vdout1_48ck270 FIND v(dout1_48) AT=140.025n

.meas tran vdout1_49ck270 FIND v(dout1_49) AT=140.025n

.meas tran vdout1_50ck270 FIND v(dout1_50) AT=140.025n

.meas tran vdout1_51ck270 FIND v(dout1_51) AT=140.025n

.meas tran vdout1_52ck270 FIND v(dout1_52) AT=140.025n

.meas tran vdout1_53ck270 FIND v(dout1_53) AT=140.025n

.meas tran vdout1_54ck270 FIND v(dout1_54) AT=140.025n

.meas tran vdout1_55ck270 FIND v(dout1_55) AT=140.025n

.meas tran vdout1_56ck270 FIND v(dout1_56) AT=140.025n

.meas tran vdout1_57ck270 FIND v(dout1_57) AT=140.025n

.meas tran vdout1_58ck270 FIND v(dout1_58) AT=140.025n

.meas tran vdout1_59ck270 FIND v(dout1_59) AT=140.025n

.meas tran vdout1_60ck270 FIND v(dout1_60) AT=140.025n

.meas tran vdout1_61ck270 FIND v(dout1_61) AT=140.025n

.meas tran vdout1_62ck270 FIND v(dout1_62) AT=140.025n

.meas tran vdout1_63ck270 FIND v(dout1_63) AT=140.025n

.meas tran vdout0_0ck280 FIND v(dout0_0) AT=145.025n

.meas tran vdout0_1ck280 FIND v(dout0_1) AT=145.025n

.meas tran vdout0_2ck280 FIND v(dout0_2) AT=145.025n

.meas tran vdout0_3ck280 FIND v(dout0_3) AT=145.025n

.meas tran vdout0_4ck280 FIND v(dout0_4) AT=145.025n

.meas tran vdout0_5ck280 FIND v(dout0_5) AT=145.025n

.meas tran vdout0_6ck280 FIND v(dout0_6) AT=145.025n

.meas tran vdout0_7ck280 FIND v(dout0_7) AT=145.025n

.meas tran vdout0_8ck280 FIND v(dout0_8) AT=145.025n

.meas tran vdout0_9ck280 FIND v(dout0_9) AT=145.025n

.meas tran vdout0_10ck280 FIND v(dout0_10) AT=145.025n

.meas tran vdout0_11ck280 FIND v(dout0_11) AT=145.025n

.meas tran vdout0_12ck280 FIND v(dout0_12) AT=145.025n

.meas tran vdout0_13ck280 FIND v(dout0_13) AT=145.025n

.meas tran vdout0_14ck280 FIND v(dout0_14) AT=145.025n

.meas tran vdout0_15ck280 FIND v(dout0_15) AT=145.025n

.meas tran vdout0_16ck280 FIND v(dout0_16) AT=145.025n

.meas tran vdout0_17ck280 FIND v(dout0_17) AT=145.025n

.meas tran vdout0_18ck280 FIND v(dout0_18) AT=145.025n

.meas tran vdout0_19ck280 FIND v(dout0_19) AT=145.025n

.meas tran vdout0_20ck280 FIND v(dout0_20) AT=145.025n

.meas tran vdout0_21ck280 FIND v(dout0_21) AT=145.025n

.meas tran vdout0_22ck280 FIND v(dout0_22) AT=145.025n

.meas tran vdout0_23ck280 FIND v(dout0_23) AT=145.025n

.meas tran vdout0_24ck280 FIND v(dout0_24) AT=145.025n

.meas tran vdout0_25ck280 FIND v(dout0_25) AT=145.025n

.meas tran vdout0_26ck280 FIND v(dout0_26) AT=145.025n

.meas tran vdout0_27ck280 FIND v(dout0_27) AT=145.025n

.meas tran vdout0_28ck280 FIND v(dout0_28) AT=145.025n

.meas tran vdout0_29ck280 FIND v(dout0_29) AT=145.025n

.meas tran vdout0_30ck280 FIND v(dout0_30) AT=145.025n

.meas tran vdout0_31ck280 FIND v(dout0_31) AT=145.025n

.meas tran vdout0_32ck280 FIND v(dout0_32) AT=145.025n

.meas tran vdout0_33ck280 FIND v(dout0_33) AT=145.025n

.meas tran vdout0_34ck280 FIND v(dout0_34) AT=145.025n

.meas tran vdout0_35ck280 FIND v(dout0_35) AT=145.025n

.meas tran vdout0_36ck280 FIND v(dout0_36) AT=145.025n

.meas tran vdout0_37ck280 FIND v(dout0_37) AT=145.025n

.meas tran vdout0_38ck280 FIND v(dout0_38) AT=145.025n

.meas tran vdout0_39ck280 FIND v(dout0_39) AT=145.025n

.meas tran vdout0_40ck280 FIND v(dout0_40) AT=145.025n

.meas tran vdout0_41ck280 FIND v(dout0_41) AT=145.025n

.meas tran vdout0_42ck280 FIND v(dout0_42) AT=145.025n

.meas tran vdout0_43ck280 FIND v(dout0_43) AT=145.025n

.meas tran vdout0_44ck280 FIND v(dout0_44) AT=145.025n

.meas tran vdout0_45ck280 FIND v(dout0_45) AT=145.025n

.meas tran vdout0_46ck280 FIND v(dout0_46) AT=145.025n

.meas tran vdout0_47ck280 FIND v(dout0_47) AT=145.025n

.meas tran vdout0_48ck280 FIND v(dout0_48) AT=145.025n

.meas tran vdout0_49ck280 FIND v(dout0_49) AT=145.025n

.meas tran vdout0_50ck280 FIND v(dout0_50) AT=145.025n

.meas tran vdout0_51ck280 FIND v(dout0_51) AT=145.025n

.meas tran vdout0_52ck280 FIND v(dout0_52) AT=145.025n

.meas tran vdout0_53ck280 FIND v(dout0_53) AT=145.025n

.meas tran vdout0_54ck280 FIND v(dout0_54) AT=145.025n

.meas tran vdout0_55ck280 FIND v(dout0_55) AT=145.025n

.meas tran vdout0_56ck280 FIND v(dout0_56) AT=145.025n

.meas tran vdout0_57ck280 FIND v(dout0_57) AT=145.025n

.meas tran vdout0_58ck280 FIND v(dout0_58) AT=145.025n

.meas tran vdout0_59ck280 FIND v(dout0_59) AT=145.025n

.meas tran vdout0_60ck280 FIND v(dout0_60) AT=145.025n

.meas tran vdout0_61ck280 FIND v(dout0_61) AT=145.025n

.meas tran vdout0_62ck280 FIND v(dout0_62) AT=145.025n

.meas tran vdout0_63ck280 FIND v(dout0_63) AT=145.025n

.meas tran vdout1_0ck280 FIND v(dout1_0) AT=145.025n

.meas tran vdout1_1ck280 FIND v(dout1_1) AT=145.025n

.meas tran vdout1_2ck280 FIND v(dout1_2) AT=145.025n

.meas tran vdout1_3ck280 FIND v(dout1_3) AT=145.025n

.meas tran vdout1_4ck280 FIND v(dout1_4) AT=145.025n

.meas tran vdout1_5ck280 FIND v(dout1_5) AT=145.025n

.meas tran vdout1_6ck280 FIND v(dout1_6) AT=145.025n

.meas tran vdout1_7ck280 FIND v(dout1_7) AT=145.025n

.meas tran vdout1_8ck280 FIND v(dout1_8) AT=145.025n

.meas tran vdout1_9ck280 FIND v(dout1_9) AT=145.025n

.meas tran vdout1_10ck280 FIND v(dout1_10) AT=145.025n

.meas tran vdout1_11ck280 FIND v(dout1_11) AT=145.025n

.meas tran vdout1_12ck280 FIND v(dout1_12) AT=145.025n

.meas tran vdout1_13ck280 FIND v(dout1_13) AT=145.025n

.meas tran vdout1_14ck280 FIND v(dout1_14) AT=145.025n

.meas tran vdout1_15ck280 FIND v(dout1_15) AT=145.025n

.meas tran vdout1_16ck280 FIND v(dout1_16) AT=145.025n

.meas tran vdout1_17ck280 FIND v(dout1_17) AT=145.025n

.meas tran vdout1_18ck280 FIND v(dout1_18) AT=145.025n

.meas tran vdout1_19ck280 FIND v(dout1_19) AT=145.025n

.meas tran vdout1_20ck280 FIND v(dout1_20) AT=145.025n

.meas tran vdout1_21ck280 FIND v(dout1_21) AT=145.025n

.meas tran vdout1_22ck280 FIND v(dout1_22) AT=145.025n

.meas tran vdout1_23ck280 FIND v(dout1_23) AT=145.025n

.meas tran vdout1_24ck280 FIND v(dout1_24) AT=145.025n

.meas tran vdout1_25ck280 FIND v(dout1_25) AT=145.025n

.meas tran vdout1_26ck280 FIND v(dout1_26) AT=145.025n

.meas tran vdout1_27ck280 FIND v(dout1_27) AT=145.025n

.meas tran vdout1_28ck280 FIND v(dout1_28) AT=145.025n

.meas tran vdout1_29ck280 FIND v(dout1_29) AT=145.025n

.meas tran vdout1_30ck280 FIND v(dout1_30) AT=145.025n

.meas tran vdout1_31ck280 FIND v(dout1_31) AT=145.025n

.meas tran vdout1_32ck280 FIND v(dout1_32) AT=145.025n

.meas tran vdout1_33ck280 FIND v(dout1_33) AT=145.025n

.meas tran vdout1_34ck280 FIND v(dout1_34) AT=145.025n

.meas tran vdout1_35ck280 FIND v(dout1_35) AT=145.025n

.meas tran vdout1_36ck280 FIND v(dout1_36) AT=145.025n

.meas tran vdout1_37ck280 FIND v(dout1_37) AT=145.025n

.meas tran vdout1_38ck280 FIND v(dout1_38) AT=145.025n

.meas tran vdout1_39ck280 FIND v(dout1_39) AT=145.025n

.meas tran vdout1_40ck280 FIND v(dout1_40) AT=145.025n

.meas tran vdout1_41ck280 FIND v(dout1_41) AT=145.025n

.meas tran vdout1_42ck280 FIND v(dout1_42) AT=145.025n

.meas tran vdout1_43ck280 FIND v(dout1_43) AT=145.025n

.meas tran vdout1_44ck280 FIND v(dout1_44) AT=145.025n

.meas tran vdout1_45ck280 FIND v(dout1_45) AT=145.025n

.meas tran vdout1_46ck280 FIND v(dout1_46) AT=145.025n

.meas tran vdout1_47ck280 FIND v(dout1_47) AT=145.025n

.meas tran vdout1_48ck280 FIND v(dout1_48) AT=145.025n

.meas tran vdout1_49ck280 FIND v(dout1_49) AT=145.025n

.meas tran vdout1_50ck280 FIND v(dout1_50) AT=145.025n

.meas tran vdout1_51ck280 FIND v(dout1_51) AT=145.025n

.meas tran vdout1_52ck280 FIND v(dout1_52) AT=145.025n

.meas tran vdout1_53ck280 FIND v(dout1_53) AT=145.025n

.meas tran vdout1_54ck280 FIND v(dout1_54) AT=145.025n

.meas tran vdout1_55ck280 FIND v(dout1_55) AT=145.025n

.meas tran vdout1_56ck280 FIND v(dout1_56) AT=145.025n

.meas tran vdout1_57ck280 FIND v(dout1_57) AT=145.025n

.meas tran vdout1_58ck280 FIND v(dout1_58) AT=145.025n

.meas tran vdout1_59ck280 FIND v(dout1_59) AT=145.025n

.meas tran vdout1_60ck280 FIND v(dout1_60) AT=145.025n

.meas tran vdout1_61ck280 FIND v(dout1_61) AT=145.025n

.meas tran vdout1_62ck280 FIND v(dout1_62) AT=145.025n

.meas tran vdout1_63ck280 FIND v(dout1_63) AT=145.025n

.meas tran vdout0_0ck290 FIND v(dout0_0) AT=150.025n

.meas tran vdout0_1ck290 FIND v(dout0_1) AT=150.025n

.meas tran vdout0_2ck290 FIND v(dout0_2) AT=150.025n

.meas tran vdout0_3ck290 FIND v(dout0_3) AT=150.025n

.meas tran vdout0_4ck290 FIND v(dout0_4) AT=150.025n

.meas tran vdout0_5ck290 FIND v(dout0_5) AT=150.025n

.meas tran vdout0_6ck290 FIND v(dout0_6) AT=150.025n

.meas tran vdout0_7ck290 FIND v(dout0_7) AT=150.025n

.meas tran vdout0_8ck290 FIND v(dout0_8) AT=150.025n

.meas tran vdout0_9ck290 FIND v(dout0_9) AT=150.025n

.meas tran vdout0_10ck290 FIND v(dout0_10) AT=150.025n

.meas tran vdout0_11ck290 FIND v(dout0_11) AT=150.025n

.meas tran vdout0_12ck290 FIND v(dout0_12) AT=150.025n

.meas tran vdout0_13ck290 FIND v(dout0_13) AT=150.025n

.meas tran vdout0_14ck290 FIND v(dout0_14) AT=150.025n

.meas tran vdout0_15ck290 FIND v(dout0_15) AT=150.025n

.meas tran vdout0_16ck290 FIND v(dout0_16) AT=150.025n

.meas tran vdout0_17ck290 FIND v(dout0_17) AT=150.025n

.meas tran vdout0_18ck290 FIND v(dout0_18) AT=150.025n

.meas tran vdout0_19ck290 FIND v(dout0_19) AT=150.025n

.meas tran vdout0_20ck290 FIND v(dout0_20) AT=150.025n

.meas tran vdout0_21ck290 FIND v(dout0_21) AT=150.025n

.meas tran vdout0_22ck290 FIND v(dout0_22) AT=150.025n

.meas tran vdout0_23ck290 FIND v(dout0_23) AT=150.025n

.meas tran vdout0_24ck290 FIND v(dout0_24) AT=150.025n

.meas tran vdout0_25ck290 FIND v(dout0_25) AT=150.025n

.meas tran vdout0_26ck290 FIND v(dout0_26) AT=150.025n

.meas tran vdout0_27ck290 FIND v(dout0_27) AT=150.025n

.meas tran vdout0_28ck290 FIND v(dout0_28) AT=150.025n

.meas tran vdout0_29ck290 FIND v(dout0_29) AT=150.025n

.meas tran vdout0_30ck290 FIND v(dout0_30) AT=150.025n

.meas tran vdout0_31ck290 FIND v(dout0_31) AT=150.025n

.meas tran vdout0_32ck290 FIND v(dout0_32) AT=150.025n

.meas tran vdout0_33ck290 FIND v(dout0_33) AT=150.025n

.meas tran vdout0_34ck290 FIND v(dout0_34) AT=150.025n

.meas tran vdout0_35ck290 FIND v(dout0_35) AT=150.025n

.meas tran vdout0_36ck290 FIND v(dout0_36) AT=150.025n

.meas tran vdout0_37ck290 FIND v(dout0_37) AT=150.025n

.meas tran vdout0_38ck290 FIND v(dout0_38) AT=150.025n

.meas tran vdout0_39ck290 FIND v(dout0_39) AT=150.025n

.meas tran vdout0_40ck290 FIND v(dout0_40) AT=150.025n

.meas tran vdout0_41ck290 FIND v(dout0_41) AT=150.025n

.meas tran vdout0_42ck290 FIND v(dout0_42) AT=150.025n

.meas tran vdout0_43ck290 FIND v(dout0_43) AT=150.025n

.meas tran vdout0_44ck290 FIND v(dout0_44) AT=150.025n

.meas tran vdout0_45ck290 FIND v(dout0_45) AT=150.025n

.meas tran vdout0_46ck290 FIND v(dout0_46) AT=150.025n

.meas tran vdout0_47ck290 FIND v(dout0_47) AT=150.025n

.meas tran vdout0_48ck290 FIND v(dout0_48) AT=150.025n

.meas tran vdout0_49ck290 FIND v(dout0_49) AT=150.025n

.meas tran vdout0_50ck290 FIND v(dout0_50) AT=150.025n

.meas tran vdout0_51ck290 FIND v(dout0_51) AT=150.025n

.meas tran vdout0_52ck290 FIND v(dout0_52) AT=150.025n

.meas tran vdout0_53ck290 FIND v(dout0_53) AT=150.025n

.meas tran vdout0_54ck290 FIND v(dout0_54) AT=150.025n

.meas tran vdout0_55ck290 FIND v(dout0_55) AT=150.025n

.meas tran vdout0_56ck290 FIND v(dout0_56) AT=150.025n

.meas tran vdout0_57ck290 FIND v(dout0_57) AT=150.025n

.meas tran vdout0_58ck290 FIND v(dout0_58) AT=150.025n

.meas tran vdout0_59ck290 FIND v(dout0_59) AT=150.025n

.meas tran vdout0_60ck290 FIND v(dout0_60) AT=150.025n

.meas tran vdout0_61ck290 FIND v(dout0_61) AT=150.025n

.meas tran vdout0_62ck290 FIND v(dout0_62) AT=150.025n

.meas tran vdout0_63ck290 FIND v(dout0_63) AT=150.025n

.meas tran vdout1_0ck320 FIND v(dout1_0) AT=165.025n

.meas tran vdout1_1ck320 FIND v(dout1_1) AT=165.025n

.meas tran vdout1_2ck320 FIND v(dout1_2) AT=165.025n

.meas tran vdout1_3ck320 FIND v(dout1_3) AT=165.025n

.meas tran vdout1_4ck320 FIND v(dout1_4) AT=165.025n

.meas tran vdout1_5ck320 FIND v(dout1_5) AT=165.025n

.meas tran vdout1_6ck320 FIND v(dout1_6) AT=165.025n

.meas tran vdout1_7ck320 FIND v(dout1_7) AT=165.025n

.meas tran vdout1_8ck320 FIND v(dout1_8) AT=165.025n

.meas tran vdout1_9ck320 FIND v(dout1_9) AT=165.025n

.meas tran vdout1_10ck320 FIND v(dout1_10) AT=165.025n

.meas tran vdout1_11ck320 FIND v(dout1_11) AT=165.025n

.meas tran vdout1_12ck320 FIND v(dout1_12) AT=165.025n

.meas tran vdout1_13ck320 FIND v(dout1_13) AT=165.025n

.meas tran vdout1_14ck320 FIND v(dout1_14) AT=165.025n

.meas tran vdout1_15ck320 FIND v(dout1_15) AT=165.025n

.meas tran vdout1_16ck320 FIND v(dout1_16) AT=165.025n

.meas tran vdout1_17ck320 FIND v(dout1_17) AT=165.025n

.meas tran vdout1_18ck320 FIND v(dout1_18) AT=165.025n

.meas tran vdout1_19ck320 FIND v(dout1_19) AT=165.025n

.meas tran vdout1_20ck320 FIND v(dout1_20) AT=165.025n

.meas tran vdout1_21ck320 FIND v(dout1_21) AT=165.025n

.meas tran vdout1_22ck320 FIND v(dout1_22) AT=165.025n

.meas tran vdout1_23ck320 FIND v(dout1_23) AT=165.025n

.meas tran vdout1_24ck320 FIND v(dout1_24) AT=165.025n

.meas tran vdout1_25ck320 FIND v(dout1_25) AT=165.025n

.meas tran vdout1_26ck320 FIND v(dout1_26) AT=165.025n

.meas tran vdout1_27ck320 FIND v(dout1_27) AT=165.025n

.meas tran vdout1_28ck320 FIND v(dout1_28) AT=165.025n

.meas tran vdout1_29ck320 FIND v(dout1_29) AT=165.025n

.meas tran vdout1_30ck320 FIND v(dout1_30) AT=165.025n

.meas tran vdout1_31ck320 FIND v(dout1_31) AT=165.025n

.meas tran vdout1_32ck320 FIND v(dout1_32) AT=165.025n

.meas tran vdout1_33ck320 FIND v(dout1_33) AT=165.025n

.meas tran vdout1_34ck320 FIND v(dout1_34) AT=165.025n

.meas tran vdout1_35ck320 FIND v(dout1_35) AT=165.025n

.meas tran vdout1_36ck320 FIND v(dout1_36) AT=165.025n

.meas tran vdout1_37ck320 FIND v(dout1_37) AT=165.025n

.meas tran vdout1_38ck320 FIND v(dout1_38) AT=165.025n

.meas tran vdout1_39ck320 FIND v(dout1_39) AT=165.025n

.meas tran vdout1_40ck320 FIND v(dout1_40) AT=165.025n

.meas tran vdout1_41ck320 FIND v(dout1_41) AT=165.025n

.meas tran vdout1_42ck320 FIND v(dout1_42) AT=165.025n

.meas tran vdout1_43ck320 FIND v(dout1_43) AT=165.025n

.meas tran vdout1_44ck320 FIND v(dout1_44) AT=165.025n

.meas tran vdout1_45ck320 FIND v(dout1_45) AT=165.025n

.meas tran vdout1_46ck320 FIND v(dout1_46) AT=165.025n

.meas tran vdout1_47ck320 FIND v(dout1_47) AT=165.025n

.meas tran vdout1_48ck320 FIND v(dout1_48) AT=165.025n

.meas tran vdout1_49ck320 FIND v(dout1_49) AT=165.025n

.meas tran vdout1_50ck320 FIND v(dout1_50) AT=165.025n

.meas tran vdout1_51ck320 FIND v(dout1_51) AT=165.025n

.meas tran vdout1_52ck320 FIND v(dout1_52) AT=165.025n

.meas tran vdout1_53ck320 FIND v(dout1_53) AT=165.025n

.meas tran vdout1_54ck320 FIND v(dout1_54) AT=165.025n

.meas tran vdout1_55ck320 FIND v(dout1_55) AT=165.025n

.meas tran vdout1_56ck320 FIND v(dout1_56) AT=165.025n

.meas tran vdout1_57ck320 FIND v(dout1_57) AT=165.025n

.meas tran vdout1_58ck320 FIND v(dout1_58) AT=165.025n

.meas tran vdout1_59ck320 FIND v(dout1_59) AT=165.025n

.meas tran vdout1_60ck320 FIND v(dout1_60) AT=165.025n

.meas tran vdout1_61ck320 FIND v(dout1_61) AT=165.025n

.meas tran vdout1_62ck320 FIND v(dout1_62) AT=165.025n

.meas tran vdout1_63ck320 FIND v(dout1_63) AT=165.025n

.meas tran vdout1_0ck330 FIND v(dout1_0) AT=170.025n

.meas tran vdout1_1ck330 FIND v(dout1_1) AT=170.025n

.meas tran vdout1_2ck330 FIND v(dout1_2) AT=170.025n

.meas tran vdout1_3ck330 FIND v(dout1_3) AT=170.025n

.meas tran vdout1_4ck330 FIND v(dout1_4) AT=170.025n

.meas tran vdout1_5ck330 FIND v(dout1_5) AT=170.025n

.meas tran vdout1_6ck330 FIND v(dout1_6) AT=170.025n

.meas tran vdout1_7ck330 FIND v(dout1_7) AT=170.025n

.meas tran vdout1_8ck330 FIND v(dout1_8) AT=170.025n

.meas tran vdout1_9ck330 FIND v(dout1_9) AT=170.025n

.meas tran vdout1_10ck330 FIND v(dout1_10) AT=170.025n

.meas tran vdout1_11ck330 FIND v(dout1_11) AT=170.025n

.meas tran vdout1_12ck330 FIND v(dout1_12) AT=170.025n

.meas tran vdout1_13ck330 FIND v(dout1_13) AT=170.025n

.meas tran vdout1_14ck330 FIND v(dout1_14) AT=170.025n

.meas tran vdout1_15ck330 FIND v(dout1_15) AT=170.025n

.meas tran vdout1_16ck330 FIND v(dout1_16) AT=170.025n

.meas tran vdout1_17ck330 FIND v(dout1_17) AT=170.025n

.meas tran vdout1_18ck330 FIND v(dout1_18) AT=170.025n

.meas tran vdout1_19ck330 FIND v(dout1_19) AT=170.025n

.meas tran vdout1_20ck330 FIND v(dout1_20) AT=170.025n

.meas tran vdout1_21ck330 FIND v(dout1_21) AT=170.025n

.meas tran vdout1_22ck330 FIND v(dout1_22) AT=170.025n

.meas tran vdout1_23ck330 FIND v(dout1_23) AT=170.025n

.meas tran vdout1_24ck330 FIND v(dout1_24) AT=170.025n

.meas tran vdout1_25ck330 FIND v(dout1_25) AT=170.025n

.meas tran vdout1_26ck330 FIND v(dout1_26) AT=170.025n

.meas tran vdout1_27ck330 FIND v(dout1_27) AT=170.025n

.meas tran vdout1_28ck330 FIND v(dout1_28) AT=170.025n

.meas tran vdout1_29ck330 FIND v(dout1_29) AT=170.025n

.meas tran vdout1_30ck330 FIND v(dout1_30) AT=170.025n

.meas tran vdout1_31ck330 FIND v(dout1_31) AT=170.025n

.meas tran vdout1_32ck330 FIND v(dout1_32) AT=170.025n

.meas tran vdout1_33ck330 FIND v(dout1_33) AT=170.025n

.meas tran vdout1_34ck330 FIND v(dout1_34) AT=170.025n

.meas tran vdout1_35ck330 FIND v(dout1_35) AT=170.025n

.meas tran vdout1_36ck330 FIND v(dout1_36) AT=170.025n

.meas tran vdout1_37ck330 FIND v(dout1_37) AT=170.025n

.meas tran vdout1_38ck330 FIND v(dout1_38) AT=170.025n

.meas tran vdout1_39ck330 FIND v(dout1_39) AT=170.025n

.meas tran vdout1_40ck330 FIND v(dout1_40) AT=170.025n

.meas tran vdout1_41ck330 FIND v(dout1_41) AT=170.025n

.meas tran vdout1_42ck330 FIND v(dout1_42) AT=170.025n

.meas tran vdout1_43ck330 FIND v(dout1_43) AT=170.025n

.meas tran vdout1_44ck330 FIND v(dout1_44) AT=170.025n

.meas tran vdout1_45ck330 FIND v(dout1_45) AT=170.025n

.meas tran vdout1_46ck330 FIND v(dout1_46) AT=170.025n

.meas tran vdout1_47ck330 FIND v(dout1_47) AT=170.025n

.meas tran vdout1_48ck330 FIND v(dout1_48) AT=170.025n

.meas tran vdout1_49ck330 FIND v(dout1_49) AT=170.025n

.meas tran vdout1_50ck330 FIND v(dout1_50) AT=170.025n

.meas tran vdout1_51ck330 FIND v(dout1_51) AT=170.025n

.meas tran vdout1_52ck330 FIND v(dout1_52) AT=170.025n

.meas tran vdout1_53ck330 FIND v(dout1_53) AT=170.025n

.meas tran vdout1_54ck330 FIND v(dout1_54) AT=170.025n

.meas tran vdout1_55ck330 FIND v(dout1_55) AT=170.025n

.meas tran vdout1_56ck330 FIND v(dout1_56) AT=170.025n

.meas tran vdout1_57ck330 FIND v(dout1_57) AT=170.025n

.meas tran vdout1_58ck330 FIND v(dout1_58) AT=170.025n

.meas tran vdout1_59ck330 FIND v(dout1_59) AT=170.025n

.meas tran vdout1_60ck330 FIND v(dout1_60) AT=170.025n

.meas tran vdout1_61ck330 FIND v(dout1_61) AT=170.025n

.meas tran vdout1_62ck330 FIND v(dout1_62) AT=170.025n

.meas tran vdout1_63ck330 FIND v(dout1_63) AT=170.025n

.meas tran vdout0_0ck340 FIND v(dout0_0) AT=175.025n

.meas tran vdout0_1ck340 FIND v(dout0_1) AT=175.025n

.meas tran vdout0_2ck340 FIND v(dout0_2) AT=175.025n

.meas tran vdout0_3ck340 FIND v(dout0_3) AT=175.025n

.meas tran vdout0_4ck340 FIND v(dout0_4) AT=175.025n

.meas tran vdout0_5ck340 FIND v(dout0_5) AT=175.025n

.meas tran vdout0_6ck340 FIND v(dout0_6) AT=175.025n

.meas tran vdout0_7ck340 FIND v(dout0_7) AT=175.025n

.meas tran vdout0_8ck340 FIND v(dout0_8) AT=175.025n

.meas tran vdout0_9ck340 FIND v(dout0_9) AT=175.025n

.meas tran vdout0_10ck340 FIND v(dout0_10) AT=175.025n

.meas tran vdout0_11ck340 FIND v(dout0_11) AT=175.025n

.meas tran vdout0_12ck340 FIND v(dout0_12) AT=175.025n

.meas tran vdout0_13ck340 FIND v(dout0_13) AT=175.025n

.meas tran vdout0_14ck340 FIND v(dout0_14) AT=175.025n

.meas tran vdout0_15ck340 FIND v(dout0_15) AT=175.025n

.meas tran vdout0_16ck340 FIND v(dout0_16) AT=175.025n

.meas tran vdout0_17ck340 FIND v(dout0_17) AT=175.025n

.meas tran vdout0_18ck340 FIND v(dout0_18) AT=175.025n

.meas tran vdout0_19ck340 FIND v(dout0_19) AT=175.025n

.meas tran vdout0_20ck340 FIND v(dout0_20) AT=175.025n

.meas tran vdout0_21ck340 FIND v(dout0_21) AT=175.025n

.meas tran vdout0_22ck340 FIND v(dout0_22) AT=175.025n

.meas tran vdout0_23ck340 FIND v(dout0_23) AT=175.025n

.meas tran vdout0_24ck340 FIND v(dout0_24) AT=175.025n

.meas tran vdout0_25ck340 FIND v(dout0_25) AT=175.025n

.meas tran vdout0_26ck340 FIND v(dout0_26) AT=175.025n

.meas tran vdout0_27ck340 FIND v(dout0_27) AT=175.025n

.meas tran vdout0_28ck340 FIND v(dout0_28) AT=175.025n

.meas tran vdout0_29ck340 FIND v(dout0_29) AT=175.025n

.meas tran vdout0_30ck340 FIND v(dout0_30) AT=175.025n

.meas tran vdout0_31ck340 FIND v(dout0_31) AT=175.025n

.meas tran vdout0_32ck340 FIND v(dout0_32) AT=175.025n

.meas tran vdout0_33ck340 FIND v(dout0_33) AT=175.025n

.meas tran vdout0_34ck340 FIND v(dout0_34) AT=175.025n

.meas tran vdout0_35ck340 FIND v(dout0_35) AT=175.025n

.meas tran vdout0_36ck340 FIND v(dout0_36) AT=175.025n

.meas tran vdout0_37ck340 FIND v(dout0_37) AT=175.025n

.meas tran vdout0_38ck340 FIND v(dout0_38) AT=175.025n

.meas tran vdout0_39ck340 FIND v(dout0_39) AT=175.025n

.meas tran vdout0_40ck340 FIND v(dout0_40) AT=175.025n

.meas tran vdout0_41ck340 FIND v(dout0_41) AT=175.025n

.meas tran vdout0_42ck340 FIND v(dout0_42) AT=175.025n

.meas tran vdout0_43ck340 FIND v(dout0_43) AT=175.025n

.meas tran vdout0_44ck340 FIND v(dout0_44) AT=175.025n

.meas tran vdout0_45ck340 FIND v(dout0_45) AT=175.025n

.meas tran vdout0_46ck340 FIND v(dout0_46) AT=175.025n

.meas tran vdout0_47ck340 FIND v(dout0_47) AT=175.025n

.meas tran vdout0_48ck340 FIND v(dout0_48) AT=175.025n

.meas tran vdout0_49ck340 FIND v(dout0_49) AT=175.025n

.meas tran vdout0_50ck340 FIND v(dout0_50) AT=175.025n

.meas tran vdout0_51ck340 FIND v(dout0_51) AT=175.025n

.meas tran vdout0_52ck340 FIND v(dout0_52) AT=175.025n

.meas tran vdout0_53ck340 FIND v(dout0_53) AT=175.025n

.meas tran vdout0_54ck340 FIND v(dout0_54) AT=175.025n

.meas tran vdout0_55ck340 FIND v(dout0_55) AT=175.025n

.meas tran vdout0_56ck340 FIND v(dout0_56) AT=175.025n

.meas tran vdout0_57ck340 FIND v(dout0_57) AT=175.025n

.meas tran vdout0_58ck340 FIND v(dout0_58) AT=175.025n

.meas tran vdout0_59ck340 FIND v(dout0_59) AT=175.025n

.meas tran vdout0_60ck340 FIND v(dout0_60) AT=175.025n

.meas tran vdout0_61ck340 FIND v(dout0_61) AT=175.025n

.meas tran vdout0_62ck340 FIND v(dout0_62) AT=175.025n

.meas tran vdout0_63ck340 FIND v(dout0_63) AT=175.025n

.meas tran vdout0_0ck370 FIND v(dout0_0) AT=190.025n

.meas tran vdout0_1ck370 FIND v(dout0_1) AT=190.025n

.meas tran vdout0_2ck370 FIND v(dout0_2) AT=190.025n

.meas tran vdout0_3ck370 FIND v(dout0_3) AT=190.025n

.meas tran vdout0_4ck370 FIND v(dout0_4) AT=190.025n

.meas tran vdout0_5ck370 FIND v(dout0_5) AT=190.025n

.meas tran vdout0_6ck370 FIND v(dout0_6) AT=190.025n

.meas tran vdout0_7ck370 FIND v(dout0_7) AT=190.025n

.meas tran vdout0_8ck370 FIND v(dout0_8) AT=190.025n

.meas tran vdout0_9ck370 FIND v(dout0_9) AT=190.025n

.meas tran vdout0_10ck370 FIND v(dout0_10) AT=190.025n

.meas tran vdout0_11ck370 FIND v(dout0_11) AT=190.025n

.meas tran vdout0_12ck370 FIND v(dout0_12) AT=190.025n

.meas tran vdout0_13ck370 FIND v(dout0_13) AT=190.025n

.meas tran vdout0_14ck370 FIND v(dout0_14) AT=190.025n

.meas tran vdout0_15ck370 FIND v(dout0_15) AT=190.025n

.meas tran vdout0_16ck370 FIND v(dout0_16) AT=190.025n

.meas tran vdout0_17ck370 FIND v(dout0_17) AT=190.025n

.meas tran vdout0_18ck370 FIND v(dout0_18) AT=190.025n

.meas tran vdout0_19ck370 FIND v(dout0_19) AT=190.025n

.meas tran vdout0_20ck370 FIND v(dout0_20) AT=190.025n

.meas tran vdout0_21ck370 FIND v(dout0_21) AT=190.025n

.meas tran vdout0_22ck370 FIND v(dout0_22) AT=190.025n

.meas tran vdout0_23ck370 FIND v(dout0_23) AT=190.025n

.meas tran vdout0_24ck370 FIND v(dout0_24) AT=190.025n

.meas tran vdout0_25ck370 FIND v(dout0_25) AT=190.025n

.meas tran vdout0_26ck370 FIND v(dout0_26) AT=190.025n

.meas tran vdout0_27ck370 FIND v(dout0_27) AT=190.025n

.meas tran vdout0_28ck370 FIND v(dout0_28) AT=190.025n

.meas tran vdout0_29ck370 FIND v(dout0_29) AT=190.025n

.meas tran vdout0_30ck370 FIND v(dout0_30) AT=190.025n

.meas tran vdout0_31ck370 FIND v(dout0_31) AT=190.025n

.meas tran vdout0_32ck370 FIND v(dout0_32) AT=190.025n

.meas tran vdout0_33ck370 FIND v(dout0_33) AT=190.025n

.meas tran vdout0_34ck370 FIND v(dout0_34) AT=190.025n

.meas tran vdout0_35ck370 FIND v(dout0_35) AT=190.025n

.meas tran vdout0_36ck370 FIND v(dout0_36) AT=190.025n

.meas tran vdout0_37ck370 FIND v(dout0_37) AT=190.025n

.meas tran vdout0_38ck370 FIND v(dout0_38) AT=190.025n

.meas tran vdout0_39ck370 FIND v(dout0_39) AT=190.025n

.meas tran vdout0_40ck370 FIND v(dout0_40) AT=190.025n

.meas tran vdout0_41ck370 FIND v(dout0_41) AT=190.025n

.meas tran vdout0_42ck370 FIND v(dout0_42) AT=190.025n

.meas tran vdout0_43ck370 FIND v(dout0_43) AT=190.025n

.meas tran vdout0_44ck370 FIND v(dout0_44) AT=190.025n

.meas tran vdout0_45ck370 FIND v(dout0_45) AT=190.025n

.meas tran vdout0_46ck370 FIND v(dout0_46) AT=190.025n

.meas tran vdout0_47ck370 FIND v(dout0_47) AT=190.025n

.meas tran vdout0_48ck370 FIND v(dout0_48) AT=190.025n

.meas tran vdout0_49ck370 FIND v(dout0_49) AT=190.025n

.meas tran vdout0_50ck370 FIND v(dout0_50) AT=190.025n

.meas tran vdout0_51ck370 FIND v(dout0_51) AT=190.025n

.meas tran vdout0_52ck370 FIND v(dout0_52) AT=190.025n

.meas tran vdout0_53ck370 FIND v(dout0_53) AT=190.025n

.meas tran vdout0_54ck370 FIND v(dout0_54) AT=190.025n

.meas tran vdout0_55ck370 FIND v(dout0_55) AT=190.025n

.meas tran vdout0_56ck370 FIND v(dout0_56) AT=190.025n

.meas tran vdout0_57ck370 FIND v(dout0_57) AT=190.025n

.meas tran vdout0_58ck370 FIND v(dout0_58) AT=190.025n

.meas tran vdout0_59ck370 FIND v(dout0_59) AT=190.025n

.meas tran vdout0_60ck370 FIND v(dout0_60) AT=190.025n

.meas tran vdout0_61ck370 FIND v(dout0_61) AT=190.025n

.meas tran vdout0_62ck370 FIND v(dout0_62) AT=190.025n

.meas tran vdout0_63ck370 FIND v(dout0_63) AT=190.025n

.meas tran vdout0_0ck400 FIND v(dout0_0) AT=205.025n

.meas tran vdout0_1ck400 FIND v(dout0_1) AT=205.025n

.meas tran vdout0_2ck400 FIND v(dout0_2) AT=205.025n

.meas tran vdout0_3ck400 FIND v(dout0_3) AT=205.025n

.meas tran vdout0_4ck400 FIND v(dout0_4) AT=205.025n

.meas tran vdout0_5ck400 FIND v(dout0_5) AT=205.025n

.meas tran vdout0_6ck400 FIND v(dout0_6) AT=205.025n

.meas tran vdout0_7ck400 FIND v(dout0_7) AT=205.025n

.meas tran vdout0_8ck400 FIND v(dout0_8) AT=205.025n

.meas tran vdout0_9ck400 FIND v(dout0_9) AT=205.025n

.meas tran vdout0_10ck400 FIND v(dout0_10) AT=205.025n

.meas tran vdout0_11ck400 FIND v(dout0_11) AT=205.025n

.meas tran vdout0_12ck400 FIND v(dout0_12) AT=205.025n

.meas tran vdout0_13ck400 FIND v(dout0_13) AT=205.025n

.meas tran vdout0_14ck400 FIND v(dout0_14) AT=205.025n

.meas tran vdout0_15ck400 FIND v(dout0_15) AT=205.025n

.meas tran vdout0_16ck400 FIND v(dout0_16) AT=205.025n

.meas tran vdout0_17ck400 FIND v(dout0_17) AT=205.025n

.meas tran vdout0_18ck400 FIND v(dout0_18) AT=205.025n

.meas tran vdout0_19ck400 FIND v(dout0_19) AT=205.025n

.meas tran vdout0_20ck400 FIND v(dout0_20) AT=205.025n

.meas tran vdout0_21ck400 FIND v(dout0_21) AT=205.025n

.meas tran vdout0_22ck400 FIND v(dout0_22) AT=205.025n

.meas tran vdout0_23ck400 FIND v(dout0_23) AT=205.025n

.meas tran vdout0_24ck400 FIND v(dout0_24) AT=205.025n

.meas tran vdout0_25ck400 FIND v(dout0_25) AT=205.025n

.meas tran vdout0_26ck400 FIND v(dout0_26) AT=205.025n

.meas tran vdout0_27ck400 FIND v(dout0_27) AT=205.025n

.meas tran vdout0_28ck400 FIND v(dout0_28) AT=205.025n

.meas tran vdout0_29ck400 FIND v(dout0_29) AT=205.025n

.meas tran vdout0_30ck400 FIND v(dout0_30) AT=205.025n

.meas tran vdout0_31ck400 FIND v(dout0_31) AT=205.025n

.meas tran vdout0_32ck400 FIND v(dout0_32) AT=205.025n

.meas tran vdout0_33ck400 FIND v(dout0_33) AT=205.025n

.meas tran vdout0_34ck400 FIND v(dout0_34) AT=205.025n

.meas tran vdout0_35ck400 FIND v(dout0_35) AT=205.025n

.meas tran vdout0_36ck400 FIND v(dout0_36) AT=205.025n

.meas tran vdout0_37ck400 FIND v(dout0_37) AT=205.025n

.meas tran vdout0_38ck400 FIND v(dout0_38) AT=205.025n

.meas tran vdout0_39ck400 FIND v(dout0_39) AT=205.025n

.meas tran vdout0_40ck400 FIND v(dout0_40) AT=205.025n

.meas tran vdout0_41ck400 FIND v(dout0_41) AT=205.025n

.meas tran vdout0_42ck400 FIND v(dout0_42) AT=205.025n

.meas tran vdout0_43ck400 FIND v(dout0_43) AT=205.025n

.meas tran vdout0_44ck400 FIND v(dout0_44) AT=205.025n

.meas tran vdout0_45ck400 FIND v(dout0_45) AT=205.025n

.meas tran vdout0_46ck400 FIND v(dout0_46) AT=205.025n

.meas tran vdout0_47ck400 FIND v(dout0_47) AT=205.025n

.meas tran vdout0_48ck400 FIND v(dout0_48) AT=205.025n

.meas tran vdout0_49ck400 FIND v(dout0_49) AT=205.025n

.meas tran vdout0_50ck400 FIND v(dout0_50) AT=205.025n

.meas tran vdout0_51ck400 FIND v(dout0_51) AT=205.025n

.meas tran vdout0_52ck400 FIND v(dout0_52) AT=205.025n

.meas tran vdout0_53ck400 FIND v(dout0_53) AT=205.025n

.meas tran vdout0_54ck400 FIND v(dout0_54) AT=205.025n

.meas tran vdout0_55ck400 FIND v(dout0_55) AT=205.025n

.meas tran vdout0_56ck400 FIND v(dout0_56) AT=205.025n

.meas tran vdout0_57ck400 FIND v(dout0_57) AT=205.025n

.meas tran vdout0_58ck400 FIND v(dout0_58) AT=205.025n

.meas tran vdout0_59ck400 FIND v(dout0_59) AT=205.025n

.meas tran vdout0_60ck400 FIND v(dout0_60) AT=205.025n

.meas tran vdout0_61ck400 FIND v(dout0_61) AT=205.025n

.meas tran vdout0_62ck400 FIND v(dout0_62) AT=205.025n

.meas tran vdout0_63ck400 FIND v(dout0_63) AT=205.025n

.meas tran vdout0_0ck410 FIND v(dout0_0) AT=210.025n

.meas tran vdout0_1ck410 FIND v(dout0_1) AT=210.025n

.meas tran vdout0_2ck410 FIND v(dout0_2) AT=210.025n

.meas tran vdout0_3ck410 FIND v(dout0_3) AT=210.025n

.meas tran vdout0_4ck410 FIND v(dout0_4) AT=210.025n

.meas tran vdout0_5ck410 FIND v(dout0_5) AT=210.025n

.meas tran vdout0_6ck410 FIND v(dout0_6) AT=210.025n

.meas tran vdout0_7ck410 FIND v(dout0_7) AT=210.025n

.meas tran vdout0_8ck410 FIND v(dout0_8) AT=210.025n

.meas tran vdout0_9ck410 FIND v(dout0_9) AT=210.025n

.meas tran vdout0_10ck410 FIND v(dout0_10) AT=210.025n

.meas tran vdout0_11ck410 FIND v(dout0_11) AT=210.025n

.meas tran vdout0_12ck410 FIND v(dout0_12) AT=210.025n

.meas tran vdout0_13ck410 FIND v(dout0_13) AT=210.025n

.meas tran vdout0_14ck410 FIND v(dout0_14) AT=210.025n

.meas tran vdout0_15ck410 FIND v(dout0_15) AT=210.025n

.meas tran vdout0_16ck410 FIND v(dout0_16) AT=210.025n

.meas tran vdout0_17ck410 FIND v(dout0_17) AT=210.025n

.meas tran vdout0_18ck410 FIND v(dout0_18) AT=210.025n

.meas tran vdout0_19ck410 FIND v(dout0_19) AT=210.025n

.meas tran vdout0_20ck410 FIND v(dout0_20) AT=210.025n

.meas tran vdout0_21ck410 FIND v(dout0_21) AT=210.025n

.meas tran vdout0_22ck410 FIND v(dout0_22) AT=210.025n

.meas tran vdout0_23ck410 FIND v(dout0_23) AT=210.025n

.meas tran vdout0_24ck410 FIND v(dout0_24) AT=210.025n

.meas tran vdout0_25ck410 FIND v(dout0_25) AT=210.025n

.meas tran vdout0_26ck410 FIND v(dout0_26) AT=210.025n

.meas tran vdout0_27ck410 FIND v(dout0_27) AT=210.025n

.meas tran vdout0_28ck410 FIND v(dout0_28) AT=210.025n

.meas tran vdout0_29ck410 FIND v(dout0_29) AT=210.025n

.meas tran vdout0_30ck410 FIND v(dout0_30) AT=210.025n

.meas tran vdout0_31ck410 FIND v(dout0_31) AT=210.025n

.meas tran vdout0_32ck410 FIND v(dout0_32) AT=210.025n

.meas tran vdout0_33ck410 FIND v(dout0_33) AT=210.025n

.meas tran vdout0_34ck410 FIND v(dout0_34) AT=210.025n

.meas tran vdout0_35ck410 FIND v(dout0_35) AT=210.025n

.meas tran vdout0_36ck410 FIND v(dout0_36) AT=210.025n

.meas tran vdout0_37ck410 FIND v(dout0_37) AT=210.025n

.meas tran vdout0_38ck410 FIND v(dout0_38) AT=210.025n

.meas tran vdout0_39ck410 FIND v(dout0_39) AT=210.025n

.meas tran vdout0_40ck410 FIND v(dout0_40) AT=210.025n

.meas tran vdout0_41ck410 FIND v(dout0_41) AT=210.025n

.meas tran vdout0_42ck410 FIND v(dout0_42) AT=210.025n

.meas tran vdout0_43ck410 FIND v(dout0_43) AT=210.025n

.meas tran vdout0_44ck410 FIND v(dout0_44) AT=210.025n

.meas tran vdout0_45ck410 FIND v(dout0_45) AT=210.025n

.meas tran vdout0_46ck410 FIND v(dout0_46) AT=210.025n

.meas tran vdout0_47ck410 FIND v(dout0_47) AT=210.025n

.meas tran vdout0_48ck410 FIND v(dout0_48) AT=210.025n

.meas tran vdout0_49ck410 FIND v(dout0_49) AT=210.025n

.meas tran vdout0_50ck410 FIND v(dout0_50) AT=210.025n

.meas tran vdout0_51ck410 FIND v(dout0_51) AT=210.025n

.meas tran vdout0_52ck410 FIND v(dout0_52) AT=210.025n

.meas tran vdout0_53ck410 FIND v(dout0_53) AT=210.025n

.meas tran vdout0_54ck410 FIND v(dout0_54) AT=210.025n

.meas tran vdout0_55ck410 FIND v(dout0_55) AT=210.025n

.meas tran vdout0_56ck410 FIND v(dout0_56) AT=210.025n

.meas tran vdout0_57ck410 FIND v(dout0_57) AT=210.025n

.meas tran vdout0_58ck410 FIND v(dout0_58) AT=210.025n

.meas tran vdout0_59ck410 FIND v(dout0_59) AT=210.025n

.meas tran vdout0_60ck410 FIND v(dout0_60) AT=210.025n

.meas tran vdout0_61ck410 FIND v(dout0_61) AT=210.025n

.meas tran vdout0_62ck410 FIND v(dout0_62) AT=210.025n

.meas tran vdout0_63ck410 FIND v(dout0_63) AT=210.025n

.meas tran vdout1_0ck410 FIND v(dout1_0) AT=210.025n

.meas tran vdout1_1ck410 FIND v(dout1_1) AT=210.025n

.meas tran vdout1_2ck410 FIND v(dout1_2) AT=210.025n

.meas tran vdout1_3ck410 FIND v(dout1_3) AT=210.025n

.meas tran vdout1_4ck410 FIND v(dout1_4) AT=210.025n

.meas tran vdout1_5ck410 FIND v(dout1_5) AT=210.025n

.meas tran vdout1_6ck410 FIND v(dout1_6) AT=210.025n

.meas tran vdout1_7ck410 FIND v(dout1_7) AT=210.025n

.meas tran vdout1_8ck410 FIND v(dout1_8) AT=210.025n

.meas tran vdout1_9ck410 FIND v(dout1_9) AT=210.025n

.meas tran vdout1_10ck410 FIND v(dout1_10) AT=210.025n

.meas tran vdout1_11ck410 FIND v(dout1_11) AT=210.025n

.meas tran vdout1_12ck410 FIND v(dout1_12) AT=210.025n

.meas tran vdout1_13ck410 FIND v(dout1_13) AT=210.025n

.meas tran vdout1_14ck410 FIND v(dout1_14) AT=210.025n

.meas tran vdout1_15ck410 FIND v(dout1_15) AT=210.025n

.meas tran vdout1_16ck410 FIND v(dout1_16) AT=210.025n

.meas tran vdout1_17ck410 FIND v(dout1_17) AT=210.025n

.meas tran vdout1_18ck410 FIND v(dout1_18) AT=210.025n

.meas tran vdout1_19ck410 FIND v(dout1_19) AT=210.025n

.meas tran vdout1_20ck410 FIND v(dout1_20) AT=210.025n

.meas tran vdout1_21ck410 FIND v(dout1_21) AT=210.025n

.meas tran vdout1_22ck410 FIND v(dout1_22) AT=210.025n

.meas tran vdout1_23ck410 FIND v(dout1_23) AT=210.025n

.meas tran vdout1_24ck410 FIND v(dout1_24) AT=210.025n

.meas tran vdout1_25ck410 FIND v(dout1_25) AT=210.025n

.meas tran vdout1_26ck410 FIND v(dout1_26) AT=210.025n

.meas tran vdout1_27ck410 FIND v(dout1_27) AT=210.025n

.meas tran vdout1_28ck410 FIND v(dout1_28) AT=210.025n

.meas tran vdout1_29ck410 FIND v(dout1_29) AT=210.025n

.meas tran vdout1_30ck410 FIND v(dout1_30) AT=210.025n

.meas tran vdout1_31ck410 FIND v(dout1_31) AT=210.025n

.meas tran vdout1_32ck410 FIND v(dout1_32) AT=210.025n

.meas tran vdout1_33ck410 FIND v(dout1_33) AT=210.025n

.meas tran vdout1_34ck410 FIND v(dout1_34) AT=210.025n

.meas tran vdout1_35ck410 FIND v(dout1_35) AT=210.025n

.meas tran vdout1_36ck410 FIND v(dout1_36) AT=210.025n

.meas tran vdout1_37ck410 FIND v(dout1_37) AT=210.025n

.meas tran vdout1_38ck410 FIND v(dout1_38) AT=210.025n

.meas tran vdout1_39ck410 FIND v(dout1_39) AT=210.025n

.meas tran vdout1_40ck410 FIND v(dout1_40) AT=210.025n

.meas tran vdout1_41ck410 FIND v(dout1_41) AT=210.025n

.meas tran vdout1_42ck410 FIND v(dout1_42) AT=210.025n

.meas tran vdout1_43ck410 FIND v(dout1_43) AT=210.025n

.meas tran vdout1_44ck410 FIND v(dout1_44) AT=210.025n

.meas tran vdout1_45ck410 FIND v(dout1_45) AT=210.025n

.meas tran vdout1_46ck410 FIND v(dout1_46) AT=210.025n

.meas tran vdout1_47ck410 FIND v(dout1_47) AT=210.025n

.meas tran vdout1_48ck410 FIND v(dout1_48) AT=210.025n

.meas tran vdout1_49ck410 FIND v(dout1_49) AT=210.025n

.meas tran vdout1_50ck410 FIND v(dout1_50) AT=210.025n

.meas tran vdout1_51ck410 FIND v(dout1_51) AT=210.025n

.meas tran vdout1_52ck410 FIND v(dout1_52) AT=210.025n

.meas tran vdout1_53ck410 FIND v(dout1_53) AT=210.025n

.meas tran vdout1_54ck410 FIND v(dout1_54) AT=210.025n

.meas tran vdout1_55ck410 FIND v(dout1_55) AT=210.025n

.meas tran vdout1_56ck410 FIND v(dout1_56) AT=210.025n

.meas tran vdout1_57ck410 FIND v(dout1_57) AT=210.025n

.meas tran vdout1_58ck410 FIND v(dout1_58) AT=210.025n

.meas tran vdout1_59ck410 FIND v(dout1_59) AT=210.025n

.meas tran vdout1_60ck410 FIND v(dout1_60) AT=210.025n

.meas tran vdout1_61ck410 FIND v(dout1_61) AT=210.025n

.meas tran vdout1_62ck410 FIND v(dout1_62) AT=210.025n

.meas tran vdout1_63ck410 FIND v(dout1_63) AT=210.025n

.meas tran vdout0_0ck420 FIND v(dout0_0) AT=215.025n

.meas tran vdout0_1ck420 FIND v(dout0_1) AT=215.025n

.meas tran vdout0_2ck420 FIND v(dout0_2) AT=215.025n

.meas tran vdout0_3ck420 FIND v(dout0_3) AT=215.025n

.meas tran vdout0_4ck420 FIND v(dout0_4) AT=215.025n

.meas tran vdout0_5ck420 FIND v(dout0_5) AT=215.025n

.meas tran vdout0_6ck420 FIND v(dout0_6) AT=215.025n

.meas tran vdout0_7ck420 FIND v(dout0_7) AT=215.025n

.meas tran vdout0_8ck420 FIND v(dout0_8) AT=215.025n

.meas tran vdout0_9ck420 FIND v(dout0_9) AT=215.025n

.meas tran vdout0_10ck420 FIND v(dout0_10) AT=215.025n

.meas tran vdout0_11ck420 FIND v(dout0_11) AT=215.025n

.meas tran vdout0_12ck420 FIND v(dout0_12) AT=215.025n

.meas tran vdout0_13ck420 FIND v(dout0_13) AT=215.025n

.meas tran vdout0_14ck420 FIND v(dout0_14) AT=215.025n

.meas tran vdout0_15ck420 FIND v(dout0_15) AT=215.025n

.meas tran vdout0_16ck420 FIND v(dout0_16) AT=215.025n

.meas tran vdout0_17ck420 FIND v(dout0_17) AT=215.025n

.meas tran vdout0_18ck420 FIND v(dout0_18) AT=215.025n

.meas tran vdout0_19ck420 FIND v(dout0_19) AT=215.025n

.meas tran vdout0_20ck420 FIND v(dout0_20) AT=215.025n

.meas tran vdout0_21ck420 FIND v(dout0_21) AT=215.025n

.meas tran vdout0_22ck420 FIND v(dout0_22) AT=215.025n

.meas tran vdout0_23ck420 FIND v(dout0_23) AT=215.025n

.meas tran vdout0_24ck420 FIND v(dout0_24) AT=215.025n

.meas tran vdout0_25ck420 FIND v(dout0_25) AT=215.025n

.meas tran vdout0_26ck420 FIND v(dout0_26) AT=215.025n

.meas tran vdout0_27ck420 FIND v(dout0_27) AT=215.025n

.meas tran vdout0_28ck420 FIND v(dout0_28) AT=215.025n

.meas tran vdout0_29ck420 FIND v(dout0_29) AT=215.025n

.meas tran vdout0_30ck420 FIND v(dout0_30) AT=215.025n

.meas tran vdout0_31ck420 FIND v(dout0_31) AT=215.025n

.meas tran vdout0_32ck420 FIND v(dout0_32) AT=215.025n

.meas tran vdout0_33ck420 FIND v(dout0_33) AT=215.025n

.meas tran vdout0_34ck420 FIND v(dout0_34) AT=215.025n

.meas tran vdout0_35ck420 FIND v(dout0_35) AT=215.025n

.meas tran vdout0_36ck420 FIND v(dout0_36) AT=215.025n

.meas tran vdout0_37ck420 FIND v(dout0_37) AT=215.025n

.meas tran vdout0_38ck420 FIND v(dout0_38) AT=215.025n

.meas tran vdout0_39ck420 FIND v(dout0_39) AT=215.025n

.meas tran vdout0_40ck420 FIND v(dout0_40) AT=215.025n

.meas tran vdout0_41ck420 FIND v(dout0_41) AT=215.025n

.meas tran vdout0_42ck420 FIND v(dout0_42) AT=215.025n

.meas tran vdout0_43ck420 FIND v(dout0_43) AT=215.025n

.meas tran vdout0_44ck420 FIND v(dout0_44) AT=215.025n

.meas tran vdout0_45ck420 FIND v(dout0_45) AT=215.025n

.meas tran vdout0_46ck420 FIND v(dout0_46) AT=215.025n

.meas tran vdout0_47ck420 FIND v(dout0_47) AT=215.025n

.meas tran vdout0_48ck420 FIND v(dout0_48) AT=215.025n

.meas tran vdout0_49ck420 FIND v(dout0_49) AT=215.025n

.meas tran vdout0_50ck420 FIND v(dout0_50) AT=215.025n

.meas tran vdout0_51ck420 FIND v(dout0_51) AT=215.025n

.meas tran vdout0_52ck420 FIND v(dout0_52) AT=215.025n

.meas tran vdout0_53ck420 FIND v(dout0_53) AT=215.025n

.meas tran vdout0_54ck420 FIND v(dout0_54) AT=215.025n

.meas tran vdout0_55ck420 FIND v(dout0_55) AT=215.025n

.meas tran vdout0_56ck420 FIND v(dout0_56) AT=215.025n

.meas tran vdout0_57ck420 FIND v(dout0_57) AT=215.025n

.meas tran vdout0_58ck420 FIND v(dout0_58) AT=215.025n

.meas tran vdout0_59ck420 FIND v(dout0_59) AT=215.025n

.meas tran vdout0_60ck420 FIND v(dout0_60) AT=215.025n

.meas tran vdout0_61ck420 FIND v(dout0_61) AT=215.025n

.meas tran vdout0_62ck420 FIND v(dout0_62) AT=215.025n

.meas tran vdout0_63ck420 FIND v(dout0_63) AT=215.025n

.meas tran vdout1_0ck420 FIND v(dout1_0) AT=215.025n

.meas tran vdout1_1ck420 FIND v(dout1_1) AT=215.025n

.meas tran vdout1_2ck420 FIND v(dout1_2) AT=215.025n

.meas tran vdout1_3ck420 FIND v(dout1_3) AT=215.025n

.meas tran vdout1_4ck420 FIND v(dout1_4) AT=215.025n

.meas tran vdout1_5ck420 FIND v(dout1_5) AT=215.025n

.meas tran vdout1_6ck420 FIND v(dout1_6) AT=215.025n

.meas tran vdout1_7ck420 FIND v(dout1_7) AT=215.025n

.meas tran vdout1_8ck420 FIND v(dout1_8) AT=215.025n

.meas tran vdout1_9ck420 FIND v(dout1_9) AT=215.025n

.meas tran vdout1_10ck420 FIND v(dout1_10) AT=215.025n

.meas tran vdout1_11ck420 FIND v(dout1_11) AT=215.025n

.meas tran vdout1_12ck420 FIND v(dout1_12) AT=215.025n

.meas tran vdout1_13ck420 FIND v(dout1_13) AT=215.025n

.meas tran vdout1_14ck420 FIND v(dout1_14) AT=215.025n

.meas tran vdout1_15ck420 FIND v(dout1_15) AT=215.025n

.meas tran vdout1_16ck420 FIND v(dout1_16) AT=215.025n

.meas tran vdout1_17ck420 FIND v(dout1_17) AT=215.025n

.meas tran vdout1_18ck420 FIND v(dout1_18) AT=215.025n

.meas tran vdout1_19ck420 FIND v(dout1_19) AT=215.025n

.meas tran vdout1_20ck420 FIND v(dout1_20) AT=215.025n

.meas tran vdout1_21ck420 FIND v(dout1_21) AT=215.025n

.meas tran vdout1_22ck420 FIND v(dout1_22) AT=215.025n

.meas tran vdout1_23ck420 FIND v(dout1_23) AT=215.025n

.meas tran vdout1_24ck420 FIND v(dout1_24) AT=215.025n

.meas tran vdout1_25ck420 FIND v(dout1_25) AT=215.025n

.meas tran vdout1_26ck420 FIND v(dout1_26) AT=215.025n

.meas tran vdout1_27ck420 FIND v(dout1_27) AT=215.025n

.meas tran vdout1_28ck420 FIND v(dout1_28) AT=215.025n

.meas tran vdout1_29ck420 FIND v(dout1_29) AT=215.025n

.meas tran vdout1_30ck420 FIND v(dout1_30) AT=215.025n

.meas tran vdout1_31ck420 FIND v(dout1_31) AT=215.025n

.meas tran vdout1_32ck420 FIND v(dout1_32) AT=215.025n

.meas tran vdout1_33ck420 FIND v(dout1_33) AT=215.025n

.meas tran vdout1_34ck420 FIND v(dout1_34) AT=215.025n

.meas tran vdout1_35ck420 FIND v(dout1_35) AT=215.025n

.meas tran vdout1_36ck420 FIND v(dout1_36) AT=215.025n

.meas tran vdout1_37ck420 FIND v(dout1_37) AT=215.025n

.meas tran vdout1_38ck420 FIND v(dout1_38) AT=215.025n

.meas tran vdout1_39ck420 FIND v(dout1_39) AT=215.025n

.meas tran vdout1_40ck420 FIND v(dout1_40) AT=215.025n

.meas tran vdout1_41ck420 FIND v(dout1_41) AT=215.025n

.meas tran vdout1_42ck420 FIND v(dout1_42) AT=215.025n

.meas tran vdout1_43ck420 FIND v(dout1_43) AT=215.025n

.meas tran vdout1_44ck420 FIND v(dout1_44) AT=215.025n

.meas tran vdout1_45ck420 FIND v(dout1_45) AT=215.025n

.meas tran vdout1_46ck420 FIND v(dout1_46) AT=215.025n

.meas tran vdout1_47ck420 FIND v(dout1_47) AT=215.025n

.meas tran vdout1_48ck420 FIND v(dout1_48) AT=215.025n

.meas tran vdout1_49ck420 FIND v(dout1_49) AT=215.025n

.meas tran vdout1_50ck420 FIND v(dout1_50) AT=215.025n

.meas tran vdout1_51ck420 FIND v(dout1_51) AT=215.025n

.meas tran vdout1_52ck420 FIND v(dout1_52) AT=215.025n

.meas tran vdout1_53ck420 FIND v(dout1_53) AT=215.025n

.meas tran vdout1_54ck420 FIND v(dout1_54) AT=215.025n

.meas tran vdout1_55ck420 FIND v(dout1_55) AT=215.025n

.meas tran vdout1_56ck420 FIND v(dout1_56) AT=215.025n

.meas tran vdout1_57ck420 FIND v(dout1_57) AT=215.025n

.meas tran vdout1_58ck420 FIND v(dout1_58) AT=215.025n

.meas tran vdout1_59ck420 FIND v(dout1_59) AT=215.025n

.meas tran vdout1_60ck420 FIND v(dout1_60) AT=215.025n

.meas tran vdout1_61ck420 FIND v(dout1_61) AT=215.025n

.meas tran vdout1_62ck420 FIND v(dout1_62) AT=215.025n

.meas tran vdout1_63ck420 FIND v(dout1_63) AT=215.025n

.meas tran vdout0_0ck430 FIND v(dout0_0) AT=220.025n

.meas tran vdout0_1ck430 FIND v(dout0_1) AT=220.025n

.meas tran vdout0_2ck430 FIND v(dout0_2) AT=220.025n

.meas tran vdout0_3ck430 FIND v(dout0_3) AT=220.025n

.meas tran vdout0_4ck430 FIND v(dout0_4) AT=220.025n

.meas tran vdout0_5ck430 FIND v(dout0_5) AT=220.025n

.meas tran vdout0_6ck430 FIND v(dout0_6) AT=220.025n

.meas tran vdout0_7ck430 FIND v(dout0_7) AT=220.025n

.meas tran vdout0_8ck430 FIND v(dout0_8) AT=220.025n

.meas tran vdout0_9ck430 FIND v(dout0_9) AT=220.025n

.meas tran vdout0_10ck430 FIND v(dout0_10) AT=220.025n

.meas tran vdout0_11ck430 FIND v(dout0_11) AT=220.025n

.meas tran vdout0_12ck430 FIND v(dout0_12) AT=220.025n

.meas tran vdout0_13ck430 FIND v(dout0_13) AT=220.025n

.meas tran vdout0_14ck430 FIND v(dout0_14) AT=220.025n

.meas tran vdout0_15ck430 FIND v(dout0_15) AT=220.025n

.meas tran vdout0_16ck430 FIND v(dout0_16) AT=220.025n

.meas tran vdout0_17ck430 FIND v(dout0_17) AT=220.025n

.meas tran vdout0_18ck430 FIND v(dout0_18) AT=220.025n

.meas tran vdout0_19ck430 FIND v(dout0_19) AT=220.025n

.meas tran vdout0_20ck430 FIND v(dout0_20) AT=220.025n

.meas tran vdout0_21ck430 FIND v(dout0_21) AT=220.025n

.meas tran vdout0_22ck430 FIND v(dout0_22) AT=220.025n

.meas tran vdout0_23ck430 FIND v(dout0_23) AT=220.025n

.meas tran vdout0_24ck430 FIND v(dout0_24) AT=220.025n

.meas tran vdout0_25ck430 FIND v(dout0_25) AT=220.025n

.meas tran vdout0_26ck430 FIND v(dout0_26) AT=220.025n

.meas tran vdout0_27ck430 FIND v(dout0_27) AT=220.025n

.meas tran vdout0_28ck430 FIND v(dout0_28) AT=220.025n

.meas tran vdout0_29ck430 FIND v(dout0_29) AT=220.025n

.meas tran vdout0_30ck430 FIND v(dout0_30) AT=220.025n

.meas tran vdout0_31ck430 FIND v(dout0_31) AT=220.025n

.meas tran vdout0_32ck430 FIND v(dout0_32) AT=220.025n

.meas tran vdout0_33ck430 FIND v(dout0_33) AT=220.025n

.meas tran vdout0_34ck430 FIND v(dout0_34) AT=220.025n

.meas tran vdout0_35ck430 FIND v(dout0_35) AT=220.025n

.meas tran vdout0_36ck430 FIND v(dout0_36) AT=220.025n

.meas tran vdout0_37ck430 FIND v(dout0_37) AT=220.025n

.meas tran vdout0_38ck430 FIND v(dout0_38) AT=220.025n

.meas tran vdout0_39ck430 FIND v(dout0_39) AT=220.025n

.meas tran vdout0_40ck430 FIND v(dout0_40) AT=220.025n

.meas tran vdout0_41ck430 FIND v(dout0_41) AT=220.025n

.meas tran vdout0_42ck430 FIND v(dout0_42) AT=220.025n

.meas tran vdout0_43ck430 FIND v(dout0_43) AT=220.025n

.meas tran vdout0_44ck430 FIND v(dout0_44) AT=220.025n

.meas tran vdout0_45ck430 FIND v(dout0_45) AT=220.025n

.meas tran vdout0_46ck430 FIND v(dout0_46) AT=220.025n

.meas tran vdout0_47ck430 FIND v(dout0_47) AT=220.025n

.meas tran vdout0_48ck430 FIND v(dout0_48) AT=220.025n

.meas tran vdout0_49ck430 FIND v(dout0_49) AT=220.025n

.meas tran vdout0_50ck430 FIND v(dout0_50) AT=220.025n

.meas tran vdout0_51ck430 FIND v(dout0_51) AT=220.025n

.meas tran vdout0_52ck430 FIND v(dout0_52) AT=220.025n

.meas tran vdout0_53ck430 FIND v(dout0_53) AT=220.025n

.meas tran vdout0_54ck430 FIND v(dout0_54) AT=220.025n

.meas tran vdout0_55ck430 FIND v(dout0_55) AT=220.025n

.meas tran vdout0_56ck430 FIND v(dout0_56) AT=220.025n

.meas tran vdout0_57ck430 FIND v(dout0_57) AT=220.025n

.meas tran vdout0_58ck430 FIND v(dout0_58) AT=220.025n

.meas tran vdout0_59ck430 FIND v(dout0_59) AT=220.025n

.meas tran vdout0_60ck430 FIND v(dout0_60) AT=220.025n

.meas tran vdout0_61ck430 FIND v(dout0_61) AT=220.025n

.meas tran vdout0_62ck430 FIND v(dout0_62) AT=220.025n

.meas tran vdout0_63ck430 FIND v(dout0_63) AT=220.025n

.meas tran vdout1_0ck430 FIND v(dout1_0) AT=220.025n

.meas tran vdout1_1ck430 FIND v(dout1_1) AT=220.025n

.meas tran vdout1_2ck430 FIND v(dout1_2) AT=220.025n

.meas tran vdout1_3ck430 FIND v(dout1_3) AT=220.025n

.meas tran vdout1_4ck430 FIND v(dout1_4) AT=220.025n

.meas tran vdout1_5ck430 FIND v(dout1_5) AT=220.025n

.meas tran vdout1_6ck430 FIND v(dout1_6) AT=220.025n

.meas tran vdout1_7ck430 FIND v(dout1_7) AT=220.025n

.meas tran vdout1_8ck430 FIND v(dout1_8) AT=220.025n

.meas tran vdout1_9ck430 FIND v(dout1_9) AT=220.025n

.meas tran vdout1_10ck430 FIND v(dout1_10) AT=220.025n

.meas tran vdout1_11ck430 FIND v(dout1_11) AT=220.025n

.meas tran vdout1_12ck430 FIND v(dout1_12) AT=220.025n

.meas tran vdout1_13ck430 FIND v(dout1_13) AT=220.025n

.meas tran vdout1_14ck430 FIND v(dout1_14) AT=220.025n

.meas tran vdout1_15ck430 FIND v(dout1_15) AT=220.025n

.meas tran vdout1_16ck430 FIND v(dout1_16) AT=220.025n

.meas tran vdout1_17ck430 FIND v(dout1_17) AT=220.025n

.meas tran vdout1_18ck430 FIND v(dout1_18) AT=220.025n

.meas tran vdout1_19ck430 FIND v(dout1_19) AT=220.025n

.meas tran vdout1_20ck430 FIND v(dout1_20) AT=220.025n

.meas tran vdout1_21ck430 FIND v(dout1_21) AT=220.025n

.meas tran vdout1_22ck430 FIND v(dout1_22) AT=220.025n

.meas tran vdout1_23ck430 FIND v(dout1_23) AT=220.025n

.meas tran vdout1_24ck430 FIND v(dout1_24) AT=220.025n

.meas tran vdout1_25ck430 FIND v(dout1_25) AT=220.025n

.meas tran vdout1_26ck430 FIND v(dout1_26) AT=220.025n

.meas tran vdout1_27ck430 FIND v(dout1_27) AT=220.025n

.meas tran vdout1_28ck430 FIND v(dout1_28) AT=220.025n

.meas tran vdout1_29ck430 FIND v(dout1_29) AT=220.025n

.meas tran vdout1_30ck430 FIND v(dout1_30) AT=220.025n

.meas tran vdout1_31ck430 FIND v(dout1_31) AT=220.025n

.meas tran vdout1_32ck430 FIND v(dout1_32) AT=220.025n

.meas tran vdout1_33ck430 FIND v(dout1_33) AT=220.025n

.meas tran vdout1_34ck430 FIND v(dout1_34) AT=220.025n

.meas tran vdout1_35ck430 FIND v(dout1_35) AT=220.025n

.meas tran vdout1_36ck430 FIND v(dout1_36) AT=220.025n

.meas tran vdout1_37ck430 FIND v(dout1_37) AT=220.025n

.meas tran vdout1_38ck430 FIND v(dout1_38) AT=220.025n

.meas tran vdout1_39ck430 FIND v(dout1_39) AT=220.025n

.meas tran vdout1_40ck430 FIND v(dout1_40) AT=220.025n

.meas tran vdout1_41ck430 FIND v(dout1_41) AT=220.025n

.meas tran vdout1_42ck430 FIND v(dout1_42) AT=220.025n

.meas tran vdout1_43ck430 FIND v(dout1_43) AT=220.025n

.meas tran vdout1_44ck430 FIND v(dout1_44) AT=220.025n

.meas tran vdout1_45ck430 FIND v(dout1_45) AT=220.025n

.meas tran vdout1_46ck430 FIND v(dout1_46) AT=220.025n

.meas tran vdout1_47ck430 FIND v(dout1_47) AT=220.025n

.meas tran vdout1_48ck430 FIND v(dout1_48) AT=220.025n

.meas tran vdout1_49ck430 FIND v(dout1_49) AT=220.025n

.meas tran vdout1_50ck430 FIND v(dout1_50) AT=220.025n

.meas tran vdout1_51ck430 FIND v(dout1_51) AT=220.025n

.meas tran vdout1_52ck430 FIND v(dout1_52) AT=220.025n

.meas tran vdout1_53ck430 FIND v(dout1_53) AT=220.025n

.meas tran vdout1_54ck430 FIND v(dout1_54) AT=220.025n

.meas tran vdout1_55ck430 FIND v(dout1_55) AT=220.025n

.meas tran vdout1_56ck430 FIND v(dout1_56) AT=220.025n

.meas tran vdout1_57ck430 FIND v(dout1_57) AT=220.025n

.meas tran vdout1_58ck430 FIND v(dout1_58) AT=220.025n

.meas tran vdout1_59ck430 FIND v(dout1_59) AT=220.025n

.meas tran vdout1_60ck430 FIND v(dout1_60) AT=220.025n

.meas tran vdout1_61ck430 FIND v(dout1_61) AT=220.025n

.meas tran vdout1_62ck430 FIND v(dout1_62) AT=220.025n

.meas tran vdout1_63ck430 FIND v(dout1_63) AT=220.025n

.meas tran vdout0_0ck440 FIND v(dout0_0) AT=225.025n

.meas tran vdout0_1ck440 FIND v(dout0_1) AT=225.025n

.meas tran vdout0_2ck440 FIND v(dout0_2) AT=225.025n

.meas tran vdout0_3ck440 FIND v(dout0_3) AT=225.025n

.meas tran vdout0_4ck440 FIND v(dout0_4) AT=225.025n

.meas tran vdout0_5ck440 FIND v(dout0_5) AT=225.025n

.meas tran vdout0_6ck440 FIND v(dout0_6) AT=225.025n

.meas tran vdout0_7ck440 FIND v(dout0_7) AT=225.025n

.meas tran vdout0_8ck440 FIND v(dout0_8) AT=225.025n

.meas tran vdout0_9ck440 FIND v(dout0_9) AT=225.025n

.meas tran vdout0_10ck440 FIND v(dout0_10) AT=225.025n

.meas tran vdout0_11ck440 FIND v(dout0_11) AT=225.025n

.meas tran vdout0_12ck440 FIND v(dout0_12) AT=225.025n

.meas tran vdout0_13ck440 FIND v(dout0_13) AT=225.025n

.meas tran vdout0_14ck440 FIND v(dout0_14) AT=225.025n

.meas tran vdout0_15ck440 FIND v(dout0_15) AT=225.025n

.meas tran vdout0_16ck440 FIND v(dout0_16) AT=225.025n

.meas tran vdout0_17ck440 FIND v(dout0_17) AT=225.025n

.meas tran vdout0_18ck440 FIND v(dout0_18) AT=225.025n

.meas tran vdout0_19ck440 FIND v(dout0_19) AT=225.025n

.meas tran vdout0_20ck440 FIND v(dout0_20) AT=225.025n

.meas tran vdout0_21ck440 FIND v(dout0_21) AT=225.025n

.meas tran vdout0_22ck440 FIND v(dout0_22) AT=225.025n

.meas tran vdout0_23ck440 FIND v(dout0_23) AT=225.025n

.meas tran vdout0_24ck440 FIND v(dout0_24) AT=225.025n

.meas tran vdout0_25ck440 FIND v(dout0_25) AT=225.025n

.meas tran vdout0_26ck440 FIND v(dout0_26) AT=225.025n

.meas tran vdout0_27ck440 FIND v(dout0_27) AT=225.025n

.meas tran vdout0_28ck440 FIND v(dout0_28) AT=225.025n

.meas tran vdout0_29ck440 FIND v(dout0_29) AT=225.025n

.meas tran vdout0_30ck440 FIND v(dout0_30) AT=225.025n

.meas tran vdout0_31ck440 FIND v(dout0_31) AT=225.025n

.meas tran vdout0_32ck440 FIND v(dout0_32) AT=225.025n

.meas tran vdout0_33ck440 FIND v(dout0_33) AT=225.025n

.meas tran vdout0_34ck440 FIND v(dout0_34) AT=225.025n

.meas tran vdout0_35ck440 FIND v(dout0_35) AT=225.025n

.meas tran vdout0_36ck440 FIND v(dout0_36) AT=225.025n

.meas tran vdout0_37ck440 FIND v(dout0_37) AT=225.025n

.meas tran vdout0_38ck440 FIND v(dout0_38) AT=225.025n

.meas tran vdout0_39ck440 FIND v(dout0_39) AT=225.025n

.meas tran vdout0_40ck440 FIND v(dout0_40) AT=225.025n

.meas tran vdout0_41ck440 FIND v(dout0_41) AT=225.025n

.meas tran vdout0_42ck440 FIND v(dout0_42) AT=225.025n

.meas tran vdout0_43ck440 FIND v(dout0_43) AT=225.025n

.meas tran vdout0_44ck440 FIND v(dout0_44) AT=225.025n

.meas tran vdout0_45ck440 FIND v(dout0_45) AT=225.025n

.meas tran vdout0_46ck440 FIND v(dout0_46) AT=225.025n

.meas tran vdout0_47ck440 FIND v(dout0_47) AT=225.025n

.meas tran vdout0_48ck440 FIND v(dout0_48) AT=225.025n

.meas tran vdout0_49ck440 FIND v(dout0_49) AT=225.025n

.meas tran vdout0_50ck440 FIND v(dout0_50) AT=225.025n

.meas tran vdout0_51ck440 FIND v(dout0_51) AT=225.025n

.meas tran vdout0_52ck440 FIND v(dout0_52) AT=225.025n

.meas tran vdout0_53ck440 FIND v(dout0_53) AT=225.025n

.meas tran vdout0_54ck440 FIND v(dout0_54) AT=225.025n

.meas tran vdout0_55ck440 FIND v(dout0_55) AT=225.025n

.meas tran vdout0_56ck440 FIND v(dout0_56) AT=225.025n

.meas tran vdout0_57ck440 FIND v(dout0_57) AT=225.025n

.meas tran vdout0_58ck440 FIND v(dout0_58) AT=225.025n

.meas tran vdout0_59ck440 FIND v(dout0_59) AT=225.025n

.meas tran vdout0_60ck440 FIND v(dout0_60) AT=225.025n

.meas tran vdout0_61ck440 FIND v(dout0_61) AT=225.025n

.meas tran vdout0_62ck440 FIND v(dout0_62) AT=225.025n

.meas tran vdout0_63ck440 FIND v(dout0_63) AT=225.025n

.meas tran vdout1_0ck440 FIND v(dout1_0) AT=225.025n

.meas tran vdout1_1ck440 FIND v(dout1_1) AT=225.025n

.meas tran vdout1_2ck440 FIND v(dout1_2) AT=225.025n

.meas tran vdout1_3ck440 FIND v(dout1_3) AT=225.025n

.meas tran vdout1_4ck440 FIND v(dout1_4) AT=225.025n

.meas tran vdout1_5ck440 FIND v(dout1_5) AT=225.025n

.meas tran vdout1_6ck440 FIND v(dout1_6) AT=225.025n

.meas tran vdout1_7ck440 FIND v(dout1_7) AT=225.025n

.meas tran vdout1_8ck440 FIND v(dout1_8) AT=225.025n

.meas tran vdout1_9ck440 FIND v(dout1_9) AT=225.025n

.meas tran vdout1_10ck440 FIND v(dout1_10) AT=225.025n

.meas tran vdout1_11ck440 FIND v(dout1_11) AT=225.025n

.meas tran vdout1_12ck440 FIND v(dout1_12) AT=225.025n

.meas tran vdout1_13ck440 FIND v(dout1_13) AT=225.025n

.meas tran vdout1_14ck440 FIND v(dout1_14) AT=225.025n

.meas tran vdout1_15ck440 FIND v(dout1_15) AT=225.025n

.meas tran vdout1_16ck440 FIND v(dout1_16) AT=225.025n

.meas tran vdout1_17ck440 FIND v(dout1_17) AT=225.025n

.meas tran vdout1_18ck440 FIND v(dout1_18) AT=225.025n

.meas tran vdout1_19ck440 FIND v(dout1_19) AT=225.025n

.meas tran vdout1_20ck440 FIND v(dout1_20) AT=225.025n

.meas tran vdout1_21ck440 FIND v(dout1_21) AT=225.025n

.meas tran vdout1_22ck440 FIND v(dout1_22) AT=225.025n

.meas tran vdout1_23ck440 FIND v(dout1_23) AT=225.025n

.meas tran vdout1_24ck440 FIND v(dout1_24) AT=225.025n

.meas tran vdout1_25ck440 FIND v(dout1_25) AT=225.025n

.meas tran vdout1_26ck440 FIND v(dout1_26) AT=225.025n

.meas tran vdout1_27ck440 FIND v(dout1_27) AT=225.025n

.meas tran vdout1_28ck440 FIND v(dout1_28) AT=225.025n

.meas tran vdout1_29ck440 FIND v(dout1_29) AT=225.025n

.meas tran vdout1_30ck440 FIND v(dout1_30) AT=225.025n

.meas tran vdout1_31ck440 FIND v(dout1_31) AT=225.025n

.meas tran vdout1_32ck440 FIND v(dout1_32) AT=225.025n

.meas tran vdout1_33ck440 FIND v(dout1_33) AT=225.025n

.meas tran vdout1_34ck440 FIND v(dout1_34) AT=225.025n

.meas tran vdout1_35ck440 FIND v(dout1_35) AT=225.025n

.meas tran vdout1_36ck440 FIND v(dout1_36) AT=225.025n

.meas tran vdout1_37ck440 FIND v(dout1_37) AT=225.025n

.meas tran vdout1_38ck440 FIND v(dout1_38) AT=225.025n

.meas tran vdout1_39ck440 FIND v(dout1_39) AT=225.025n

.meas tran vdout1_40ck440 FIND v(dout1_40) AT=225.025n

.meas tran vdout1_41ck440 FIND v(dout1_41) AT=225.025n

.meas tran vdout1_42ck440 FIND v(dout1_42) AT=225.025n

.meas tran vdout1_43ck440 FIND v(dout1_43) AT=225.025n

.meas tran vdout1_44ck440 FIND v(dout1_44) AT=225.025n

.meas tran vdout1_45ck440 FIND v(dout1_45) AT=225.025n

.meas tran vdout1_46ck440 FIND v(dout1_46) AT=225.025n

.meas tran vdout1_47ck440 FIND v(dout1_47) AT=225.025n

.meas tran vdout1_48ck440 FIND v(dout1_48) AT=225.025n

.meas tran vdout1_49ck440 FIND v(dout1_49) AT=225.025n

.meas tran vdout1_50ck440 FIND v(dout1_50) AT=225.025n

.meas tran vdout1_51ck440 FIND v(dout1_51) AT=225.025n

.meas tran vdout1_52ck440 FIND v(dout1_52) AT=225.025n

.meas tran vdout1_53ck440 FIND v(dout1_53) AT=225.025n

.meas tran vdout1_54ck440 FIND v(dout1_54) AT=225.025n

.meas tran vdout1_55ck440 FIND v(dout1_55) AT=225.025n

.meas tran vdout1_56ck440 FIND v(dout1_56) AT=225.025n

.meas tran vdout1_57ck440 FIND v(dout1_57) AT=225.025n

.meas tran vdout1_58ck440 FIND v(dout1_58) AT=225.025n

.meas tran vdout1_59ck440 FIND v(dout1_59) AT=225.025n

.meas tran vdout1_60ck440 FIND v(dout1_60) AT=225.025n

.meas tran vdout1_61ck440 FIND v(dout1_61) AT=225.025n

.meas tran vdout1_62ck440 FIND v(dout1_62) AT=225.025n

.meas tran vdout1_63ck440 FIND v(dout1_63) AT=225.025n

.meas tran vdout0_0ck460 FIND v(dout0_0) AT=235.025n

.meas tran vdout0_1ck460 FIND v(dout0_1) AT=235.025n

.meas tran vdout0_2ck460 FIND v(dout0_2) AT=235.025n

.meas tran vdout0_3ck460 FIND v(dout0_3) AT=235.025n

.meas tran vdout0_4ck460 FIND v(dout0_4) AT=235.025n

.meas tran vdout0_5ck460 FIND v(dout0_5) AT=235.025n

.meas tran vdout0_6ck460 FIND v(dout0_6) AT=235.025n

.meas tran vdout0_7ck460 FIND v(dout0_7) AT=235.025n

.meas tran vdout0_8ck460 FIND v(dout0_8) AT=235.025n

.meas tran vdout0_9ck460 FIND v(dout0_9) AT=235.025n

.meas tran vdout0_10ck460 FIND v(dout0_10) AT=235.025n

.meas tran vdout0_11ck460 FIND v(dout0_11) AT=235.025n

.meas tran vdout0_12ck460 FIND v(dout0_12) AT=235.025n

.meas tran vdout0_13ck460 FIND v(dout0_13) AT=235.025n

.meas tran vdout0_14ck460 FIND v(dout0_14) AT=235.025n

.meas tran vdout0_15ck460 FIND v(dout0_15) AT=235.025n

.meas tran vdout0_16ck460 FIND v(dout0_16) AT=235.025n

.meas tran vdout0_17ck460 FIND v(dout0_17) AT=235.025n

.meas tran vdout0_18ck460 FIND v(dout0_18) AT=235.025n

.meas tran vdout0_19ck460 FIND v(dout0_19) AT=235.025n

.meas tran vdout0_20ck460 FIND v(dout0_20) AT=235.025n

.meas tran vdout0_21ck460 FIND v(dout0_21) AT=235.025n

.meas tran vdout0_22ck460 FIND v(dout0_22) AT=235.025n

.meas tran vdout0_23ck460 FIND v(dout0_23) AT=235.025n

.meas tran vdout0_24ck460 FIND v(dout0_24) AT=235.025n

.meas tran vdout0_25ck460 FIND v(dout0_25) AT=235.025n

.meas tran vdout0_26ck460 FIND v(dout0_26) AT=235.025n

.meas tran vdout0_27ck460 FIND v(dout0_27) AT=235.025n

.meas tran vdout0_28ck460 FIND v(dout0_28) AT=235.025n

.meas tran vdout0_29ck460 FIND v(dout0_29) AT=235.025n

.meas tran vdout0_30ck460 FIND v(dout0_30) AT=235.025n

.meas tran vdout0_31ck460 FIND v(dout0_31) AT=235.025n

.meas tran vdout0_32ck460 FIND v(dout0_32) AT=235.025n

.meas tran vdout0_33ck460 FIND v(dout0_33) AT=235.025n

.meas tran vdout0_34ck460 FIND v(dout0_34) AT=235.025n

.meas tran vdout0_35ck460 FIND v(dout0_35) AT=235.025n

.meas tran vdout0_36ck460 FIND v(dout0_36) AT=235.025n

.meas tran vdout0_37ck460 FIND v(dout0_37) AT=235.025n

.meas tran vdout0_38ck460 FIND v(dout0_38) AT=235.025n

.meas tran vdout0_39ck460 FIND v(dout0_39) AT=235.025n

.meas tran vdout0_40ck460 FIND v(dout0_40) AT=235.025n

.meas tran vdout0_41ck460 FIND v(dout0_41) AT=235.025n

.meas tran vdout0_42ck460 FIND v(dout0_42) AT=235.025n

.meas tran vdout0_43ck460 FIND v(dout0_43) AT=235.025n

.meas tran vdout0_44ck460 FIND v(dout0_44) AT=235.025n

.meas tran vdout0_45ck460 FIND v(dout0_45) AT=235.025n

.meas tran vdout0_46ck460 FIND v(dout0_46) AT=235.025n

.meas tran vdout0_47ck460 FIND v(dout0_47) AT=235.025n

.meas tran vdout0_48ck460 FIND v(dout0_48) AT=235.025n

.meas tran vdout0_49ck460 FIND v(dout0_49) AT=235.025n

.meas tran vdout0_50ck460 FIND v(dout0_50) AT=235.025n

.meas tran vdout0_51ck460 FIND v(dout0_51) AT=235.025n

.meas tran vdout0_52ck460 FIND v(dout0_52) AT=235.025n

.meas tran vdout0_53ck460 FIND v(dout0_53) AT=235.025n

.meas tran vdout0_54ck460 FIND v(dout0_54) AT=235.025n

.meas tran vdout0_55ck460 FIND v(dout0_55) AT=235.025n

.meas tran vdout0_56ck460 FIND v(dout0_56) AT=235.025n

.meas tran vdout0_57ck460 FIND v(dout0_57) AT=235.025n

.meas tran vdout0_58ck460 FIND v(dout0_58) AT=235.025n

.meas tran vdout0_59ck460 FIND v(dout0_59) AT=235.025n

.meas tran vdout0_60ck460 FIND v(dout0_60) AT=235.025n

.meas tran vdout0_61ck460 FIND v(dout0_61) AT=235.025n

.meas tran vdout0_62ck460 FIND v(dout0_62) AT=235.025n

.meas tran vdout0_63ck460 FIND v(dout0_63) AT=235.025n

.meas tran vdout1_0ck460 FIND v(dout1_0) AT=235.025n

.meas tran vdout1_1ck460 FIND v(dout1_1) AT=235.025n

.meas tran vdout1_2ck460 FIND v(dout1_2) AT=235.025n

.meas tran vdout1_3ck460 FIND v(dout1_3) AT=235.025n

.meas tran vdout1_4ck460 FIND v(dout1_4) AT=235.025n

.meas tran vdout1_5ck460 FIND v(dout1_5) AT=235.025n

.meas tran vdout1_6ck460 FIND v(dout1_6) AT=235.025n

.meas tran vdout1_7ck460 FIND v(dout1_7) AT=235.025n

.meas tran vdout1_8ck460 FIND v(dout1_8) AT=235.025n

.meas tran vdout1_9ck460 FIND v(dout1_9) AT=235.025n

.meas tran vdout1_10ck460 FIND v(dout1_10) AT=235.025n

.meas tran vdout1_11ck460 FIND v(dout1_11) AT=235.025n

.meas tran vdout1_12ck460 FIND v(dout1_12) AT=235.025n

.meas tran vdout1_13ck460 FIND v(dout1_13) AT=235.025n

.meas tran vdout1_14ck460 FIND v(dout1_14) AT=235.025n

.meas tran vdout1_15ck460 FIND v(dout1_15) AT=235.025n

.meas tran vdout1_16ck460 FIND v(dout1_16) AT=235.025n

.meas tran vdout1_17ck460 FIND v(dout1_17) AT=235.025n

.meas tran vdout1_18ck460 FIND v(dout1_18) AT=235.025n

.meas tran vdout1_19ck460 FIND v(dout1_19) AT=235.025n

.meas tran vdout1_20ck460 FIND v(dout1_20) AT=235.025n

.meas tran vdout1_21ck460 FIND v(dout1_21) AT=235.025n

.meas tran vdout1_22ck460 FIND v(dout1_22) AT=235.025n

.meas tran vdout1_23ck460 FIND v(dout1_23) AT=235.025n

.meas tran vdout1_24ck460 FIND v(dout1_24) AT=235.025n

.meas tran vdout1_25ck460 FIND v(dout1_25) AT=235.025n

.meas tran vdout1_26ck460 FIND v(dout1_26) AT=235.025n

.meas tran vdout1_27ck460 FIND v(dout1_27) AT=235.025n

.meas tran vdout1_28ck460 FIND v(dout1_28) AT=235.025n

.meas tran vdout1_29ck460 FIND v(dout1_29) AT=235.025n

.meas tran vdout1_30ck460 FIND v(dout1_30) AT=235.025n

.meas tran vdout1_31ck460 FIND v(dout1_31) AT=235.025n

.meas tran vdout1_32ck460 FIND v(dout1_32) AT=235.025n

.meas tran vdout1_33ck460 FIND v(dout1_33) AT=235.025n

.meas tran vdout1_34ck460 FIND v(dout1_34) AT=235.025n

.meas tran vdout1_35ck460 FIND v(dout1_35) AT=235.025n

.meas tran vdout1_36ck460 FIND v(dout1_36) AT=235.025n

.meas tran vdout1_37ck460 FIND v(dout1_37) AT=235.025n

.meas tran vdout1_38ck460 FIND v(dout1_38) AT=235.025n

.meas tran vdout1_39ck460 FIND v(dout1_39) AT=235.025n

.meas tran vdout1_40ck460 FIND v(dout1_40) AT=235.025n

.meas tran vdout1_41ck460 FIND v(dout1_41) AT=235.025n

.meas tran vdout1_42ck460 FIND v(dout1_42) AT=235.025n

.meas tran vdout1_43ck460 FIND v(dout1_43) AT=235.025n

.meas tran vdout1_44ck460 FIND v(dout1_44) AT=235.025n

.meas tran vdout1_45ck460 FIND v(dout1_45) AT=235.025n

.meas tran vdout1_46ck460 FIND v(dout1_46) AT=235.025n

.meas tran vdout1_47ck460 FIND v(dout1_47) AT=235.025n

.meas tran vdout1_48ck460 FIND v(dout1_48) AT=235.025n

.meas tran vdout1_49ck460 FIND v(dout1_49) AT=235.025n

.meas tran vdout1_50ck460 FIND v(dout1_50) AT=235.025n

.meas tran vdout1_51ck460 FIND v(dout1_51) AT=235.025n

.meas tran vdout1_52ck460 FIND v(dout1_52) AT=235.025n

.meas tran vdout1_53ck460 FIND v(dout1_53) AT=235.025n

.meas tran vdout1_54ck460 FIND v(dout1_54) AT=235.025n

.meas tran vdout1_55ck460 FIND v(dout1_55) AT=235.025n

.meas tran vdout1_56ck460 FIND v(dout1_56) AT=235.025n

.meas tran vdout1_57ck460 FIND v(dout1_57) AT=235.025n

.meas tran vdout1_58ck460 FIND v(dout1_58) AT=235.025n

.meas tran vdout1_59ck460 FIND v(dout1_59) AT=235.025n

.meas tran vdout1_60ck460 FIND v(dout1_60) AT=235.025n

.meas tran vdout1_61ck460 FIND v(dout1_61) AT=235.025n

.meas tran vdout1_62ck460 FIND v(dout1_62) AT=235.025n

.meas tran vdout1_63ck460 FIND v(dout1_63) AT=235.025n

.meas tran vdout0_0ck470 FIND v(dout0_0) AT=240.025n

.meas tran vdout0_1ck470 FIND v(dout0_1) AT=240.025n

.meas tran vdout0_2ck470 FIND v(dout0_2) AT=240.025n

.meas tran vdout0_3ck470 FIND v(dout0_3) AT=240.025n

.meas tran vdout0_4ck470 FIND v(dout0_4) AT=240.025n

.meas tran vdout0_5ck470 FIND v(dout0_5) AT=240.025n

.meas tran vdout0_6ck470 FIND v(dout0_6) AT=240.025n

.meas tran vdout0_7ck470 FIND v(dout0_7) AT=240.025n

.meas tran vdout0_8ck470 FIND v(dout0_8) AT=240.025n

.meas tran vdout0_9ck470 FIND v(dout0_9) AT=240.025n

.meas tran vdout0_10ck470 FIND v(dout0_10) AT=240.025n

.meas tran vdout0_11ck470 FIND v(dout0_11) AT=240.025n

.meas tran vdout0_12ck470 FIND v(dout0_12) AT=240.025n

.meas tran vdout0_13ck470 FIND v(dout0_13) AT=240.025n

.meas tran vdout0_14ck470 FIND v(dout0_14) AT=240.025n

.meas tran vdout0_15ck470 FIND v(dout0_15) AT=240.025n

.meas tran vdout0_16ck470 FIND v(dout0_16) AT=240.025n

.meas tran vdout0_17ck470 FIND v(dout0_17) AT=240.025n

.meas tran vdout0_18ck470 FIND v(dout0_18) AT=240.025n

.meas tran vdout0_19ck470 FIND v(dout0_19) AT=240.025n

.meas tran vdout0_20ck470 FIND v(dout0_20) AT=240.025n

.meas tran vdout0_21ck470 FIND v(dout0_21) AT=240.025n

.meas tran vdout0_22ck470 FIND v(dout0_22) AT=240.025n

.meas tran vdout0_23ck470 FIND v(dout0_23) AT=240.025n

.meas tran vdout0_24ck470 FIND v(dout0_24) AT=240.025n

.meas tran vdout0_25ck470 FIND v(dout0_25) AT=240.025n

.meas tran vdout0_26ck470 FIND v(dout0_26) AT=240.025n

.meas tran vdout0_27ck470 FIND v(dout0_27) AT=240.025n

.meas tran vdout0_28ck470 FIND v(dout0_28) AT=240.025n

.meas tran vdout0_29ck470 FIND v(dout0_29) AT=240.025n

.meas tran vdout0_30ck470 FIND v(dout0_30) AT=240.025n

.meas tran vdout0_31ck470 FIND v(dout0_31) AT=240.025n

.meas tran vdout0_32ck470 FIND v(dout0_32) AT=240.025n

.meas tran vdout0_33ck470 FIND v(dout0_33) AT=240.025n

.meas tran vdout0_34ck470 FIND v(dout0_34) AT=240.025n

.meas tran vdout0_35ck470 FIND v(dout0_35) AT=240.025n

.meas tran vdout0_36ck470 FIND v(dout0_36) AT=240.025n

.meas tran vdout0_37ck470 FIND v(dout0_37) AT=240.025n

.meas tran vdout0_38ck470 FIND v(dout0_38) AT=240.025n

.meas tran vdout0_39ck470 FIND v(dout0_39) AT=240.025n

.meas tran vdout0_40ck470 FIND v(dout0_40) AT=240.025n

.meas tran vdout0_41ck470 FIND v(dout0_41) AT=240.025n

.meas tran vdout0_42ck470 FIND v(dout0_42) AT=240.025n

.meas tran vdout0_43ck470 FIND v(dout0_43) AT=240.025n

.meas tran vdout0_44ck470 FIND v(dout0_44) AT=240.025n

.meas tran vdout0_45ck470 FIND v(dout0_45) AT=240.025n

.meas tran vdout0_46ck470 FIND v(dout0_46) AT=240.025n

.meas tran vdout0_47ck470 FIND v(dout0_47) AT=240.025n

.meas tran vdout0_48ck470 FIND v(dout0_48) AT=240.025n

.meas tran vdout0_49ck470 FIND v(dout0_49) AT=240.025n

.meas tran vdout0_50ck470 FIND v(dout0_50) AT=240.025n

.meas tran vdout0_51ck470 FIND v(dout0_51) AT=240.025n

.meas tran vdout0_52ck470 FIND v(dout0_52) AT=240.025n

.meas tran vdout0_53ck470 FIND v(dout0_53) AT=240.025n

.meas tran vdout0_54ck470 FIND v(dout0_54) AT=240.025n

.meas tran vdout0_55ck470 FIND v(dout0_55) AT=240.025n

.meas tran vdout0_56ck470 FIND v(dout0_56) AT=240.025n

.meas tran vdout0_57ck470 FIND v(dout0_57) AT=240.025n

.meas tran vdout0_58ck470 FIND v(dout0_58) AT=240.025n

.meas tran vdout0_59ck470 FIND v(dout0_59) AT=240.025n

.meas tran vdout0_60ck470 FIND v(dout0_60) AT=240.025n

.meas tran vdout0_61ck470 FIND v(dout0_61) AT=240.025n

.meas tran vdout0_62ck470 FIND v(dout0_62) AT=240.025n

.meas tran vdout0_63ck470 FIND v(dout0_63) AT=240.025n

.meas tran vdout1_0ck470 FIND v(dout1_0) AT=240.025n

.meas tran vdout1_1ck470 FIND v(dout1_1) AT=240.025n

.meas tran vdout1_2ck470 FIND v(dout1_2) AT=240.025n

.meas tran vdout1_3ck470 FIND v(dout1_3) AT=240.025n

.meas tran vdout1_4ck470 FIND v(dout1_4) AT=240.025n

.meas tran vdout1_5ck470 FIND v(dout1_5) AT=240.025n

.meas tran vdout1_6ck470 FIND v(dout1_6) AT=240.025n

.meas tran vdout1_7ck470 FIND v(dout1_7) AT=240.025n

.meas tran vdout1_8ck470 FIND v(dout1_8) AT=240.025n

.meas tran vdout1_9ck470 FIND v(dout1_9) AT=240.025n

.meas tran vdout1_10ck470 FIND v(dout1_10) AT=240.025n

.meas tran vdout1_11ck470 FIND v(dout1_11) AT=240.025n

.meas tran vdout1_12ck470 FIND v(dout1_12) AT=240.025n

.meas tran vdout1_13ck470 FIND v(dout1_13) AT=240.025n

.meas tran vdout1_14ck470 FIND v(dout1_14) AT=240.025n

.meas tran vdout1_15ck470 FIND v(dout1_15) AT=240.025n

.meas tran vdout1_16ck470 FIND v(dout1_16) AT=240.025n

.meas tran vdout1_17ck470 FIND v(dout1_17) AT=240.025n

.meas tran vdout1_18ck470 FIND v(dout1_18) AT=240.025n

.meas tran vdout1_19ck470 FIND v(dout1_19) AT=240.025n

.meas tran vdout1_20ck470 FIND v(dout1_20) AT=240.025n

.meas tran vdout1_21ck470 FIND v(dout1_21) AT=240.025n

.meas tran vdout1_22ck470 FIND v(dout1_22) AT=240.025n

.meas tran vdout1_23ck470 FIND v(dout1_23) AT=240.025n

.meas tran vdout1_24ck470 FIND v(dout1_24) AT=240.025n

.meas tran vdout1_25ck470 FIND v(dout1_25) AT=240.025n

.meas tran vdout1_26ck470 FIND v(dout1_26) AT=240.025n

.meas tran vdout1_27ck470 FIND v(dout1_27) AT=240.025n

.meas tran vdout1_28ck470 FIND v(dout1_28) AT=240.025n

.meas tran vdout1_29ck470 FIND v(dout1_29) AT=240.025n

.meas tran vdout1_30ck470 FIND v(dout1_30) AT=240.025n

.meas tran vdout1_31ck470 FIND v(dout1_31) AT=240.025n

.meas tran vdout1_32ck470 FIND v(dout1_32) AT=240.025n

.meas tran vdout1_33ck470 FIND v(dout1_33) AT=240.025n

.meas tran vdout1_34ck470 FIND v(dout1_34) AT=240.025n

.meas tran vdout1_35ck470 FIND v(dout1_35) AT=240.025n

.meas tran vdout1_36ck470 FIND v(dout1_36) AT=240.025n

.meas tran vdout1_37ck470 FIND v(dout1_37) AT=240.025n

.meas tran vdout1_38ck470 FIND v(dout1_38) AT=240.025n

.meas tran vdout1_39ck470 FIND v(dout1_39) AT=240.025n

.meas tran vdout1_40ck470 FIND v(dout1_40) AT=240.025n

.meas tran vdout1_41ck470 FIND v(dout1_41) AT=240.025n

.meas tran vdout1_42ck470 FIND v(dout1_42) AT=240.025n

.meas tran vdout1_43ck470 FIND v(dout1_43) AT=240.025n

.meas tran vdout1_44ck470 FIND v(dout1_44) AT=240.025n

.meas tran vdout1_45ck470 FIND v(dout1_45) AT=240.025n

.meas tran vdout1_46ck470 FIND v(dout1_46) AT=240.025n

.meas tran vdout1_47ck470 FIND v(dout1_47) AT=240.025n

.meas tran vdout1_48ck470 FIND v(dout1_48) AT=240.025n

.meas tran vdout1_49ck470 FIND v(dout1_49) AT=240.025n

.meas tran vdout1_50ck470 FIND v(dout1_50) AT=240.025n

.meas tran vdout1_51ck470 FIND v(dout1_51) AT=240.025n

.meas tran vdout1_52ck470 FIND v(dout1_52) AT=240.025n

.meas tran vdout1_53ck470 FIND v(dout1_53) AT=240.025n

.meas tran vdout1_54ck470 FIND v(dout1_54) AT=240.025n

.meas tran vdout1_55ck470 FIND v(dout1_55) AT=240.025n

.meas tran vdout1_56ck470 FIND v(dout1_56) AT=240.025n

.meas tran vdout1_57ck470 FIND v(dout1_57) AT=240.025n

.meas tran vdout1_58ck470 FIND v(dout1_58) AT=240.025n

.meas tran vdout1_59ck470 FIND v(dout1_59) AT=240.025n

.meas tran vdout1_60ck470 FIND v(dout1_60) AT=240.025n

.meas tran vdout1_61ck470 FIND v(dout1_61) AT=240.025n

.meas tran vdout1_62ck470 FIND v(dout1_62) AT=240.025n

.meas tran vdout1_63ck470 FIND v(dout1_63) AT=240.025n

.meas tran vdout0_0ck480 FIND v(dout0_0) AT=245.025n

.meas tran vdout0_1ck480 FIND v(dout0_1) AT=245.025n

.meas tran vdout0_2ck480 FIND v(dout0_2) AT=245.025n

.meas tran vdout0_3ck480 FIND v(dout0_3) AT=245.025n

.meas tran vdout0_4ck480 FIND v(dout0_4) AT=245.025n

.meas tran vdout0_5ck480 FIND v(dout0_5) AT=245.025n

.meas tran vdout0_6ck480 FIND v(dout0_6) AT=245.025n

.meas tran vdout0_7ck480 FIND v(dout0_7) AT=245.025n

.meas tran vdout0_8ck480 FIND v(dout0_8) AT=245.025n

.meas tran vdout0_9ck480 FIND v(dout0_9) AT=245.025n

.meas tran vdout0_10ck480 FIND v(dout0_10) AT=245.025n

.meas tran vdout0_11ck480 FIND v(dout0_11) AT=245.025n

.meas tran vdout0_12ck480 FIND v(dout0_12) AT=245.025n

.meas tran vdout0_13ck480 FIND v(dout0_13) AT=245.025n

.meas tran vdout0_14ck480 FIND v(dout0_14) AT=245.025n

.meas tran vdout0_15ck480 FIND v(dout0_15) AT=245.025n

.meas tran vdout0_16ck480 FIND v(dout0_16) AT=245.025n

.meas tran vdout0_17ck480 FIND v(dout0_17) AT=245.025n

.meas tran vdout0_18ck480 FIND v(dout0_18) AT=245.025n

.meas tran vdout0_19ck480 FIND v(dout0_19) AT=245.025n

.meas tran vdout0_20ck480 FIND v(dout0_20) AT=245.025n

.meas tran vdout0_21ck480 FIND v(dout0_21) AT=245.025n

.meas tran vdout0_22ck480 FIND v(dout0_22) AT=245.025n

.meas tran vdout0_23ck480 FIND v(dout0_23) AT=245.025n

.meas tran vdout0_24ck480 FIND v(dout0_24) AT=245.025n

.meas tran vdout0_25ck480 FIND v(dout0_25) AT=245.025n

.meas tran vdout0_26ck480 FIND v(dout0_26) AT=245.025n

.meas tran vdout0_27ck480 FIND v(dout0_27) AT=245.025n

.meas tran vdout0_28ck480 FIND v(dout0_28) AT=245.025n

.meas tran vdout0_29ck480 FIND v(dout0_29) AT=245.025n

.meas tran vdout0_30ck480 FIND v(dout0_30) AT=245.025n

.meas tran vdout0_31ck480 FIND v(dout0_31) AT=245.025n

.meas tran vdout0_32ck480 FIND v(dout0_32) AT=245.025n

.meas tran vdout0_33ck480 FIND v(dout0_33) AT=245.025n

.meas tran vdout0_34ck480 FIND v(dout0_34) AT=245.025n

.meas tran vdout0_35ck480 FIND v(dout0_35) AT=245.025n

.meas tran vdout0_36ck480 FIND v(dout0_36) AT=245.025n

.meas tran vdout0_37ck480 FIND v(dout0_37) AT=245.025n

.meas tran vdout0_38ck480 FIND v(dout0_38) AT=245.025n

.meas tran vdout0_39ck480 FIND v(dout0_39) AT=245.025n

.meas tran vdout0_40ck480 FIND v(dout0_40) AT=245.025n

.meas tran vdout0_41ck480 FIND v(dout0_41) AT=245.025n

.meas tran vdout0_42ck480 FIND v(dout0_42) AT=245.025n

.meas tran vdout0_43ck480 FIND v(dout0_43) AT=245.025n

.meas tran vdout0_44ck480 FIND v(dout0_44) AT=245.025n

.meas tran vdout0_45ck480 FIND v(dout0_45) AT=245.025n

.meas tran vdout0_46ck480 FIND v(dout0_46) AT=245.025n

.meas tran vdout0_47ck480 FIND v(dout0_47) AT=245.025n

.meas tran vdout0_48ck480 FIND v(dout0_48) AT=245.025n

.meas tran vdout0_49ck480 FIND v(dout0_49) AT=245.025n

.meas tran vdout0_50ck480 FIND v(dout0_50) AT=245.025n

.meas tran vdout0_51ck480 FIND v(dout0_51) AT=245.025n

.meas tran vdout0_52ck480 FIND v(dout0_52) AT=245.025n

.meas tran vdout0_53ck480 FIND v(dout0_53) AT=245.025n

.meas tran vdout0_54ck480 FIND v(dout0_54) AT=245.025n

.meas tran vdout0_55ck480 FIND v(dout0_55) AT=245.025n

.meas tran vdout0_56ck480 FIND v(dout0_56) AT=245.025n

.meas tran vdout0_57ck480 FIND v(dout0_57) AT=245.025n

.meas tran vdout0_58ck480 FIND v(dout0_58) AT=245.025n

.meas tran vdout0_59ck480 FIND v(dout0_59) AT=245.025n

.meas tran vdout0_60ck480 FIND v(dout0_60) AT=245.025n

.meas tran vdout0_61ck480 FIND v(dout0_61) AT=245.025n

.meas tran vdout0_62ck480 FIND v(dout0_62) AT=245.025n

.meas tran vdout0_63ck480 FIND v(dout0_63) AT=245.025n

.meas tran vdout1_0ck480 FIND v(dout1_0) AT=245.025n

.meas tran vdout1_1ck480 FIND v(dout1_1) AT=245.025n

.meas tran vdout1_2ck480 FIND v(dout1_2) AT=245.025n

.meas tran vdout1_3ck480 FIND v(dout1_3) AT=245.025n

.meas tran vdout1_4ck480 FIND v(dout1_4) AT=245.025n

.meas tran vdout1_5ck480 FIND v(dout1_5) AT=245.025n

.meas tran vdout1_6ck480 FIND v(dout1_6) AT=245.025n

.meas tran vdout1_7ck480 FIND v(dout1_7) AT=245.025n

.meas tran vdout1_8ck480 FIND v(dout1_8) AT=245.025n

.meas tran vdout1_9ck480 FIND v(dout1_9) AT=245.025n

.meas tran vdout1_10ck480 FIND v(dout1_10) AT=245.025n

.meas tran vdout1_11ck480 FIND v(dout1_11) AT=245.025n

.meas tran vdout1_12ck480 FIND v(dout1_12) AT=245.025n

.meas tran vdout1_13ck480 FIND v(dout1_13) AT=245.025n

.meas tran vdout1_14ck480 FIND v(dout1_14) AT=245.025n

.meas tran vdout1_15ck480 FIND v(dout1_15) AT=245.025n

.meas tran vdout1_16ck480 FIND v(dout1_16) AT=245.025n

.meas tran vdout1_17ck480 FIND v(dout1_17) AT=245.025n

.meas tran vdout1_18ck480 FIND v(dout1_18) AT=245.025n

.meas tran vdout1_19ck480 FIND v(dout1_19) AT=245.025n

.meas tran vdout1_20ck480 FIND v(dout1_20) AT=245.025n

.meas tran vdout1_21ck480 FIND v(dout1_21) AT=245.025n

.meas tran vdout1_22ck480 FIND v(dout1_22) AT=245.025n

.meas tran vdout1_23ck480 FIND v(dout1_23) AT=245.025n

.meas tran vdout1_24ck480 FIND v(dout1_24) AT=245.025n

.meas tran vdout1_25ck480 FIND v(dout1_25) AT=245.025n

.meas tran vdout1_26ck480 FIND v(dout1_26) AT=245.025n

.meas tran vdout1_27ck480 FIND v(dout1_27) AT=245.025n

.meas tran vdout1_28ck480 FIND v(dout1_28) AT=245.025n

.meas tran vdout1_29ck480 FIND v(dout1_29) AT=245.025n

.meas tran vdout1_30ck480 FIND v(dout1_30) AT=245.025n

.meas tran vdout1_31ck480 FIND v(dout1_31) AT=245.025n

.meas tran vdout1_32ck480 FIND v(dout1_32) AT=245.025n

.meas tran vdout1_33ck480 FIND v(dout1_33) AT=245.025n

.meas tran vdout1_34ck480 FIND v(dout1_34) AT=245.025n

.meas tran vdout1_35ck480 FIND v(dout1_35) AT=245.025n

.meas tran vdout1_36ck480 FIND v(dout1_36) AT=245.025n

.meas tran vdout1_37ck480 FIND v(dout1_37) AT=245.025n

.meas tran vdout1_38ck480 FIND v(dout1_38) AT=245.025n

.meas tran vdout1_39ck480 FIND v(dout1_39) AT=245.025n

.meas tran vdout1_40ck480 FIND v(dout1_40) AT=245.025n

.meas tran vdout1_41ck480 FIND v(dout1_41) AT=245.025n

.meas tran vdout1_42ck480 FIND v(dout1_42) AT=245.025n

.meas tran vdout1_43ck480 FIND v(dout1_43) AT=245.025n

.meas tran vdout1_44ck480 FIND v(dout1_44) AT=245.025n

.meas tran vdout1_45ck480 FIND v(dout1_45) AT=245.025n

.meas tran vdout1_46ck480 FIND v(dout1_46) AT=245.025n

.meas tran vdout1_47ck480 FIND v(dout1_47) AT=245.025n

.meas tran vdout1_48ck480 FIND v(dout1_48) AT=245.025n

.meas tran vdout1_49ck480 FIND v(dout1_49) AT=245.025n

.meas tran vdout1_50ck480 FIND v(dout1_50) AT=245.025n

.meas tran vdout1_51ck480 FIND v(dout1_51) AT=245.025n

.meas tran vdout1_52ck480 FIND v(dout1_52) AT=245.025n

.meas tran vdout1_53ck480 FIND v(dout1_53) AT=245.025n

.meas tran vdout1_54ck480 FIND v(dout1_54) AT=245.025n

.meas tran vdout1_55ck480 FIND v(dout1_55) AT=245.025n

.meas tran vdout1_56ck480 FIND v(dout1_56) AT=245.025n

.meas tran vdout1_57ck480 FIND v(dout1_57) AT=245.025n

.meas tran vdout1_58ck480 FIND v(dout1_58) AT=245.025n

.meas tran vdout1_59ck480 FIND v(dout1_59) AT=245.025n

.meas tran vdout1_60ck480 FIND v(dout1_60) AT=245.025n

.meas tran vdout1_61ck480 FIND v(dout1_61) AT=245.025n

.meas tran vdout1_62ck480 FIND v(dout1_62) AT=245.025n

.meas tran vdout1_63ck480 FIND v(dout1_63) AT=245.025n

.meas tran vdout0_0ck500 FIND v(dout0_0) AT=255.025n

.meas tran vdout0_1ck500 FIND v(dout0_1) AT=255.025n

.meas tran vdout0_2ck500 FIND v(dout0_2) AT=255.025n

.meas tran vdout0_3ck500 FIND v(dout0_3) AT=255.025n

.meas tran vdout0_4ck500 FIND v(dout0_4) AT=255.025n

.meas tran vdout0_5ck500 FIND v(dout0_5) AT=255.025n

.meas tran vdout0_6ck500 FIND v(dout0_6) AT=255.025n

.meas tran vdout0_7ck500 FIND v(dout0_7) AT=255.025n

.meas tran vdout0_8ck500 FIND v(dout0_8) AT=255.025n

.meas tran vdout0_9ck500 FIND v(dout0_9) AT=255.025n

.meas tran vdout0_10ck500 FIND v(dout0_10) AT=255.025n

.meas tran vdout0_11ck500 FIND v(dout0_11) AT=255.025n

.meas tran vdout0_12ck500 FIND v(dout0_12) AT=255.025n

.meas tran vdout0_13ck500 FIND v(dout0_13) AT=255.025n

.meas tran vdout0_14ck500 FIND v(dout0_14) AT=255.025n

.meas tran vdout0_15ck500 FIND v(dout0_15) AT=255.025n

.meas tran vdout0_16ck500 FIND v(dout0_16) AT=255.025n

.meas tran vdout0_17ck500 FIND v(dout0_17) AT=255.025n

.meas tran vdout0_18ck500 FIND v(dout0_18) AT=255.025n

.meas tran vdout0_19ck500 FIND v(dout0_19) AT=255.025n

.meas tran vdout0_20ck500 FIND v(dout0_20) AT=255.025n

.meas tran vdout0_21ck500 FIND v(dout0_21) AT=255.025n

.meas tran vdout0_22ck500 FIND v(dout0_22) AT=255.025n

.meas tran vdout0_23ck500 FIND v(dout0_23) AT=255.025n

.meas tran vdout0_24ck500 FIND v(dout0_24) AT=255.025n

.meas tran vdout0_25ck500 FIND v(dout0_25) AT=255.025n

.meas tran vdout0_26ck500 FIND v(dout0_26) AT=255.025n

.meas tran vdout0_27ck500 FIND v(dout0_27) AT=255.025n

.meas tran vdout0_28ck500 FIND v(dout0_28) AT=255.025n

.meas tran vdout0_29ck500 FIND v(dout0_29) AT=255.025n

.meas tran vdout0_30ck500 FIND v(dout0_30) AT=255.025n

.meas tran vdout0_31ck500 FIND v(dout0_31) AT=255.025n

.meas tran vdout0_32ck500 FIND v(dout0_32) AT=255.025n

.meas tran vdout0_33ck500 FIND v(dout0_33) AT=255.025n

.meas tran vdout0_34ck500 FIND v(dout0_34) AT=255.025n

.meas tran vdout0_35ck500 FIND v(dout0_35) AT=255.025n

.meas tran vdout0_36ck500 FIND v(dout0_36) AT=255.025n

.meas tran vdout0_37ck500 FIND v(dout0_37) AT=255.025n

.meas tran vdout0_38ck500 FIND v(dout0_38) AT=255.025n

.meas tran vdout0_39ck500 FIND v(dout0_39) AT=255.025n

.meas tran vdout0_40ck500 FIND v(dout0_40) AT=255.025n

.meas tran vdout0_41ck500 FIND v(dout0_41) AT=255.025n

.meas tran vdout0_42ck500 FIND v(dout0_42) AT=255.025n

.meas tran vdout0_43ck500 FIND v(dout0_43) AT=255.025n

.meas tran vdout0_44ck500 FIND v(dout0_44) AT=255.025n

.meas tran vdout0_45ck500 FIND v(dout0_45) AT=255.025n

.meas tran vdout0_46ck500 FIND v(dout0_46) AT=255.025n

.meas tran vdout0_47ck500 FIND v(dout0_47) AT=255.025n

.meas tran vdout0_48ck500 FIND v(dout0_48) AT=255.025n

.meas tran vdout0_49ck500 FIND v(dout0_49) AT=255.025n

.meas tran vdout0_50ck500 FIND v(dout0_50) AT=255.025n

.meas tran vdout0_51ck500 FIND v(dout0_51) AT=255.025n

.meas tran vdout0_52ck500 FIND v(dout0_52) AT=255.025n

.meas tran vdout0_53ck500 FIND v(dout0_53) AT=255.025n

.meas tran vdout0_54ck500 FIND v(dout0_54) AT=255.025n

.meas tran vdout0_55ck500 FIND v(dout0_55) AT=255.025n

.meas tran vdout0_56ck500 FIND v(dout0_56) AT=255.025n

.meas tran vdout0_57ck500 FIND v(dout0_57) AT=255.025n

.meas tran vdout0_58ck500 FIND v(dout0_58) AT=255.025n

.meas tran vdout0_59ck500 FIND v(dout0_59) AT=255.025n

.meas tran vdout0_60ck500 FIND v(dout0_60) AT=255.025n

.meas tran vdout0_61ck500 FIND v(dout0_61) AT=255.025n

.meas tran vdout0_62ck500 FIND v(dout0_62) AT=255.025n

.meas tran vdout0_63ck500 FIND v(dout0_63) AT=255.025n

.meas tran vdout1_0ck510 FIND v(dout1_0) AT=260.025n

.meas tran vdout1_1ck510 FIND v(dout1_1) AT=260.025n

.meas tran vdout1_2ck510 FIND v(dout1_2) AT=260.025n

.meas tran vdout1_3ck510 FIND v(dout1_3) AT=260.025n

.meas tran vdout1_4ck510 FIND v(dout1_4) AT=260.025n

.meas tran vdout1_5ck510 FIND v(dout1_5) AT=260.025n

.meas tran vdout1_6ck510 FIND v(dout1_6) AT=260.025n

.meas tran vdout1_7ck510 FIND v(dout1_7) AT=260.025n

.meas tran vdout1_8ck510 FIND v(dout1_8) AT=260.025n

.meas tran vdout1_9ck510 FIND v(dout1_9) AT=260.025n

.meas tran vdout1_10ck510 FIND v(dout1_10) AT=260.025n

.meas tran vdout1_11ck510 FIND v(dout1_11) AT=260.025n

.meas tran vdout1_12ck510 FIND v(dout1_12) AT=260.025n

.meas tran vdout1_13ck510 FIND v(dout1_13) AT=260.025n

.meas tran vdout1_14ck510 FIND v(dout1_14) AT=260.025n

.meas tran vdout1_15ck510 FIND v(dout1_15) AT=260.025n

.meas tran vdout1_16ck510 FIND v(dout1_16) AT=260.025n

.meas tran vdout1_17ck510 FIND v(dout1_17) AT=260.025n

.meas tran vdout1_18ck510 FIND v(dout1_18) AT=260.025n

.meas tran vdout1_19ck510 FIND v(dout1_19) AT=260.025n

.meas tran vdout1_20ck510 FIND v(dout1_20) AT=260.025n

.meas tran vdout1_21ck510 FIND v(dout1_21) AT=260.025n

.meas tran vdout1_22ck510 FIND v(dout1_22) AT=260.025n

.meas tran vdout1_23ck510 FIND v(dout1_23) AT=260.025n

.meas tran vdout1_24ck510 FIND v(dout1_24) AT=260.025n

.meas tran vdout1_25ck510 FIND v(dout1_25) AT=260.025n

.meas tran vdout1_26ck510 FIND v(dout1_26) AT=260.025n

.meas tran vdout1_27ck510 FIND v(dout1_27) AT=260.025n

.meas tran vdout1_28ck510 FIND v(dout1_28) AT=260.025n

.meas tran vdout1_29ck510 FIND v(dout1_29) AT=260.025n

.meas tran vdout1_30ck510 FIND v(dout1_30) AT=260.025n

.meas tran vdout1_31ck510 FIND v(dout1_31) AT=260.025n

.meas tran vdout1_32ck510 FIND v(dout1_32) AT=260.025n

.meas tran vdout1_33ck510 FIND v(dout1_33) AT=260.025n

.meas tran vdout1_34ck510 FIND v(dout1_34) AT=260.025n

.meas tran vdout1_35ck510 FIND v(dout1_35) AT=260.025n

.meas tran vdout1_36ck510 FIND v(dout1_36) AT=260.025n

.meas tran vdout1_37ck510 FIND v(dout1_37) AT=260.025n

.meas tran vdout1_38ck510 FIND v(dout1_38) AT=260.025n

.meas tran vdout1_39ck510 FIND v(dout1_39) AT=260.025n

.meas tran vdout1_40ck510 FIND v(dout1_40) AT=260.025n

.meas tran vdout1_41ck510 FIND v(dout1_41) AT=260.025n

.meas tran vdout1_42ck510 FIND v(dout1_42) AT=260.025n

.meas tran vdout1_43ck510 FIND v(dout1_43) AT=260.025n

.meas tran vdout1_44ck510 FIND v(dout1_44) AT=260.025n

.meas tran vdout1_45ck510 FIND v(dout1_45) AT=260.025n

.meas tran vdout1_46ck510 FIND v(dout1_46) AT=260.025n

.meas tran vdout1_47ck510 FIND v(dout1_47) AT=260.025n

.meas tran vdout1_48ck510 FIND v(dout1_48) AT=260.025n

.meas tran vdout1_49ck510 FIND v(dout1_49) AT=260.025n

.meas tran vdout1_50ck510 FIND v(dout1_50) AT=260.025n

.meas tran vdout1_51ck510 FIND v(dout1_51) AT=260.025n

.meas tran vdout1_52ck510 FIND v(dout1_52) AT=260.025n

.meas tran vdout1_53ck510 FIND v(dout1_53) AT=260.025n

.meas tran vdout1_54ck510 FIND v(dout1_54) AT=260.025n

.meas tran vdout1_55ck510 FIND v(dout1_55) AT=260.025n

.meas tran vdout1_56ck510 FIND v(dout1_56) AT=260.025n

.meas tran vdout1_57ck510 FIND v(dout1_57) AT=260.025n

.meas tran vdout1_58ck510 FIND v(dout1_58) AT=260.025n

.meas tran vdout1_59ck510 FIND v(dout1_59) AT=260.025n

.meas tran vdout1_60ck510 FIND v(dout1_60) AT=260.025n

.meas tran vdout1_61ck510 FIND v(dout1_61) AT=260.025n

.meas tran vdout1_62ck510 FIND v(dout1_62) AT=260.025n

.meas tran vdout1_63ck510 FIND v(dout1_63) AT=260.025n

.meas tran vdout0_0ck530 FIND v(dout0_0) AT=270.025n

.meas tran vdout0_1ck530 FIND v(dout0_1) AT=270.025n

.meas tran vdout0_2ck530 FIND v(dout0_2) AT=270.025n

.meas tran vdout0_3ck530 FIND v(dout0_3) AT=270.025n

.meas tran vdout0_4ck530 FIND v(dout0_4) AT=270.025n

.meas tran vdout0_5ck530 FIND v(dout0_5) AT=270.025n

.meas tran vdout0_6ck530 FIND v(dout0_6) AT=270.025n

.meas tran vdout0_7ck530 FIND v(dout0_7) AT=270.025n

.meas tran vdout0_8ck530 FIND v(dout0_8) AT=270.025n

.meas tran vdout0_9ck530 FIND v(dout0_9) AT=270.025n

.meas tran vdout0_10ck530 FIND v(dout0_10) AT=270.025n

.meas tran vdout0_11ck530 FIND v(dout0_11) AT=270.025n

.meas tran vdout0_12ck530 FIND v(dout0_12) AT=270.025n

.meas tran vdout0_13ck530 FIND v(dout0_13) AT=270.025n

.meas tran vdout0_14ck530 FIND v(dout0_14) AT=270.025n

.meas tran vdout0_15ck530 FIND v(dout0_15) AT=270.025n

.meas tran vdout0_16ck530 FIND v(dout0_16) AT=270.025n

.meas tran vdout0_17ck530 FIND v(dout0_17) AT=270.025n

.meas tran vdout0_18ck530 FIND v(dout0_18) AT=270.025n

.meas tran vdout0_19ck530 FIND v(dout0_19) AT=270.025n

.meas tran vdout0_20ck530 FIND v(dout0_20) AT=270.025n

.meas tran vdout0_21ck530 FIND v(dout0_21) AT=270.025n

.meas tran vdout0_22ck530 FIND v(dout0_22) AT=270.025n

.meas tran vdout0_23ck530 FIND v(dout0_23) AT=270.025n

.meas tran vdout0_24ck530 FIND v(dout0_24) AT=270.025n

.meas tran vdout0_25ck530 FIND v(dout0_25) AT=270.025n

.meas tran vdout0_26ck530 FIND v(dout0_26) AT=270.025n

.meas tran vdout0_27ck530 FIND v(dout0_27) AT=270.025n

.meas tran vdout0_28ck530 FIND v(dout0_28) AT=270.025n

.meas tran vdout0_29ck530 FIND v(dout0_29) AT=270.025n

.meas tran vdout0_30ck530 FIND v(dout0_30) AT=270.025n

.meas tran vdout0_31ck530 FIND v(dout0_31) AT=270.025n

.meas tran vdout0_32ck530 FIND v(dout0_32) AT=270.025n

.meas tran vdout0_33ck530 FIND v(dout0_33) AT=270.025n

.meas tran vdout0_34ck530 FIND v(dout0_34) AT=270.025n

.meas tran vdout0_35ck530 FIND v(dout0_35) AT=270.025n

.meas tran vdout0_36ck530 FIND v(dout0_36) AT=270.025n

.meas tran vdout0_37ck530 FIND v(dout0_37) AT=270.025n

.meas tran vdout0_38ck530 FIND v(dout0_38) AT=270.025n

.meas tran vdout0_39ck530 FIND v(dout0_39) AT=270.025n

.meas tran vdout0_40ck530 FIND v(dout0_40) AT=270.025n

.meas tran vdout0_41ck530 FIND v(dout0_41) AT=270.025n

.meas tran vdout0_42ck530 FIND v(dout0_42) AT=270.025n

.meas tran vdout0_43ck530 FIND v(dout0_43) AT=270.025n

.meas tran vdout0_44ck530 FIND v(dout0_44) AT=270.025n

.meas tran vdout0_45ck530 FIND v(dout0_45) AT=270.025n

.meas tran vdout0_46ck530 FIND v(dout0_46) AT=270.025n

.meas tran vdout0_47ck530 FIND v(dout0_47) AT=270.025n

.meas tran vdout0_48ck530 FIND v(dout0_48) AT=270.025n

.meas tran vdout0_49ck530 FIND v(dout0_49) AT=270.025n

.meas tran vdout0_50ck530 FIND v(dout0_50) AT=270.025n

.meas tran vdout0_51ck530 FIND v(dout0_51) AT=270.025n

.meas tran vdout0_52ck530 FIND v(dout0_52) AT=270.025n

.meas tran vdout0_53ck530 FIND v(dout0_53) AT=270.025n

.meas tran vdout0_54ck530 FIND v(dout0_54) AT=270.025n

.meas tran vdout0_55ck530 FIND v(dout0_55) AT=270.025n

.meas tran vdout0_56ck530 FIND v(dout0_56) AT=270.025n

.meas tran vdout0_57ck530 FIND v(dout0_57) AT=270.025n

.meas tran vdout0_58ck530 FIND v(dout0_58) AT=270.025n

.meas tran vdout0_59ck530 FIND v(dout0_59) AT=270.025n

.meas tran vdout0_60ck530 FIND v(dout0_60) AT=270.025n

.meas tran vdout0_61ck530 FIND v(dout0_61) AT=270.025n

.meas tran vdout0_62ck530 FIND v(dout0_62) AT=270.025n

.meas tran vdout0_63ck530 FIND v(dout0_63) AT=270.025n

.meas tran vdout1_0ck530 FIND v(dout1_0) AT=270.025n

.meas tran vdout1_1ck530 FIND v(dout1_1) AT=270.025n

.meas tran vdout1_2ck530 FIND v(dout1_2) AT=270.025n

.meas tran vdout1_3ck530 FIND v(dout1_3) AT=270.025n

.meas tran vdout1_4ck530 FIND v(dout1_4) AT=270.025n

.meas tran vdout1_5ck530 FIND v(dout1_5) AT=270.025n

.meas tran vdout1_6ck530 FIND v(dout1_6) AT=270.025n

.meas tran vdout1_7ck530 FIND v(dout1_7) AT=270.025n

.meas tran vdout1_8ck530 FIND v(dout1_8) AT=270.025n

.meas tran vdout1_9ck530 FIND v(dout1_9) AT=270.025n

.meas tran vdout1_10ck530 FIND v(dout1_10) AT=270.025n

.meas tran vdout1_11ck530 FIND v(dout1_11) AT=270.025n

.meas tran vdout1_12ck530 FIND v(dout1_12) AT=270.025n

.meas tran vdout1_13ck530 FIND v(dout1_13) AT=270.025n

.meas tran vdout1_14ck530 FIND v(dout1_14) AT=270.025n

.meas tran vdout1_15ck530 FIND v(dout1_15) AT=270.025n

.meas tran vdout1_16ck530 FIND v(dout1_16) AT=270.025n

.meas tran vdout1_17ck530 FIND v(dout1_17) AT=270.025n

.meas tran vdout1_18ck530 FIND v(dout1_18) AT=270.025n

.meas tran vdout1_19ck530 FIND v(dout1_19) AT=270.025n

.meas tran vdout1_20ck530 FIND v(dout1_20) AT=270.025n

.meas tran vdout1_21ck530 FIND v(dout1_21) AT=270.025n

.meas tran vdout1_22ck530 FIND v(dout1_22) AT=270.025n

.meas tran vdout1_23ck530 FIND v(dout1_23) AT=270.025n

.meas tran vdout1_24ck530 FIND v(dout1_24) AT=270.025n

.meas tran vdout1_25ck530 FIND v(dout1_25) AT=270.025n

.meas tran vdout1_26ck530 FIND v(dout1_26) AT=270.025n

.meas tran vdout1_27ck530 FIND v(dout1_27) AT=270.025n

.meas tran vdout1_28ck530 FIND v(dout1_28) AT=270.025n

.meas tran vdout1_29ck530 FIND v(dout1_29) AT=270.025n

.meas tran vdout1_30ck530 FIND v(dout1_30) AT=270.025n

.meas tran vdout1_31ck530 FIND v(dout1_31) AT=270.025n

.meas tran vdout1_32ck530 FIND v(dout1_32) AT=270.025n

.meas tran vdout1_33ck530 FIND v(dout1_33) AT=270.025n

.meas tran vdout1_34ck530 FIND v(dout1_34) AT=270.025n

.meas tran vdout1_35ck530 FIND v(dout1_35) AT=270.025n

.meas tran vdout1_36ck530 FIND v(dout1_36) AT=270.025n

.meas tran vdout1_37ck530 FIND v(dout1_37) AT=270.025n

.meas tran vdout1_38ck530 FIND v(dout1_38) AT=270.025n

.meas tran vdout1_39ck530 FIND v(dout1_39) AT=270.025n

.meas tran vdout1_40ck530 FIND v(dout1_40) AT=270.025n

.meas tran vdout1_41ck530 FIND v(dout1_41) AT=270.025n

.meas tran vdout1_42ck530 FIND v(dout1_42) AT=270.025n

.meas tran vdout1_43ck530 FIND v(dout1_43) AT=270.025n

.meas tran vdout1_44ck530 FIND v(dout1_44) AT=270.025n

.meas tran vdout1_45ck530 FIND v(dout1_45) AT=270.025n

.meas tran vdout1_46ck530 FIND v(dout1_46) AT=270.025n

.meas tran vdout1_47ck530 FIND v(dout1_47) AT=270.025n

.meas tran vdout1_48ck530 FIND v(dout1_48) AT=270.025n

.meas tran vdout1_49ck530 FIND v(dout1_49) AT=270.025n

.meas tran vdout1_50ck530 FIND v(dout1_50) AT=270.025n

.meas tran vdout1_51ck530 FIND v(dout1_51) AT=270.025n

.meas tran vdout1_52ck530 FIND v(dout1_52) AT=270.025n

.meas tran vdout1_53ck530 FIND v(dout1_53) AT=270.025n

.meas tran vdout1_54ck530 FIND v(dout1_54) AT=270.025n

.meas tran vdout1_55ck530 FIND v(dout1_55) AT=270.025n

.meas tran vdout1_56ck530 FIND v(dout1_56) AT=270.025n

.meas tran vdout1_57ck530 FIND v(dout1_57) AT=270.025n

.meas tran vdout1_58ck530 FIND v(dout1_58) AT=270.025n

.meas tran vdout1_59ck530 FIND v(dout1_59) AT=270.025n

.meas tran vdout1_60ck530 FIND v(dout1_60) AT=270.025n

.meas tran vdout1_61ck530 FIND v(dout1_61) AT=270.025n

.meas tran vdout1_62ck530 FIND v(dout1_62) AT=270.025n

.meas tran vdout1_63ck530 FIND v(dout1_63) AT=270.025n

.meas tran vdout0_0ck550 FIND v(dout0_0) AT=280.025n

.meas tran vdout0_1ck550 FIND v(dout0_1) AT=280.025n

.meas tran vdout0_2ck550 FIND v(dout0_2) AT=280.025n

.meas tran vdout0_3ck550 FIND v(dout0_3) AT=280.025n

.meas tran vdout0_4ck550 FIND v(dout0_4) AT=280.025n

.meas tran vdout0_5ck550 FIND v(dout0_5) AT=280.025n

.meas tran vdout0_6ck550 FIND v(dout0_6) AT=280.025n

.meas tran vdout0_7ck550 FIND v(dout0_7) AT=280.025n

.meas tran vdout0_8ck550 FIND v(dout0_8) AT=280.025n

.meas tran vdout0_9ck550 FIND v(dout0_9) AT=280.025n

.meas tran vdout0_10ck550 FIND v(dout0_10) AT=280.025n

.meas tran vdout0_11ck550 FIND v(dout0_11) AT=280.025n

.meas tran vdout0_12ck550 FIND v(dout0_12) AT=280.025n

.meas tran vdout0_13ck550 FIND v(dout0_13) AT=280.025n

.meas tran vdout0_14ck550 FIND v(dout0_14) AT=280.025n

.meas tran vdout0_15ck550 FIND v(dout0_15) AT=280.025n

.meas tran vdout0_16ck550 FIND v(dout0_16) AT=280.025n

.meas tran vdout0_17ck550 FIND v(dout0_17) AT=280.025n

.meas tran vdout0_18ck550 FIND v(dout0_18) AT=280.025n

.meas tran vdout0_19ck550 FIND v(dout0_19) AT=280.025n

.meas tran vdout0_20ck550 FIND v(dout0_20) AT=280.025n

.meas tran vdout0_21ck550 FIND v(dout0_21) AT=280.025n

.meas tran vdout0_22ck550 FIND v(dout0_22) AT=280.025n

.meas tran vdout0_23ck550 FIND v(dout0_23) AT=280.025n

.meas tran vdout0_24ck550 FIND v(dout0_24) AT=280.025n

.meas tran vdout0_25ck550 FIND v(dout0_25) AT=280.025n

.meas tran vdout0_26ck550 FIND v(dout0_26) AT=280.025n

.meas tran vdout0_27ck550 FIND v(dout0_27) AT=280.025n

.meas tran vdout0_28ck550 FIND v(dout0_28) AT=280.025n

.meas tran vdout0_29ck550 FIND v(dout0_29) AT=280.025n

.meas tran vdout0_30ck550 FIND v(dout0_30) AT=280.025n

.meas tran vdout0_31ck550 FIND v(dout0_31) AT=280.025n

.meas tran vdout0_32ck550 FIND v(dout0_32) AT=280.025n

.meas tran vdout0_33ck550 FIND v(dout0_33) AT=280.025n

.meas tran vdout0_34ck550 FIND v(dout0_34) AT=280.025n

.meas tran vdout0_35ck550 FIND v(dout0_35) AT=280.025n

.meas tran vdout0_36ck550 FIND v(dout0_36) AT=280.025n

.meas tran vdout0_37ck550 FIND v(dout0_37) AT=280.025n

.meas tran vdout0_38ck550 FIND v(dout0_38) AT=280.025n

.meas tran vdout0_39ck550 FIND v(dout0_39) AT=280.025n

.meas tran vdout0_40ck550 FIND v(dout0_40) AT=280.025n

.meas tran vdout0_41ck550 FIND v(dout0_41) AT=280.025n

.meas tran vdout0_42ck550 FIND v(dout0_42) AT=280.025n

.meas tran vdout0_43ck550 FIND v(dout0_43) AT=280.025n

.meas tran vdout0_44ck550 FIND v(dout0_44) AT=280.025n

.meas tran vdout0_45ck550 FIND v(dout0_45) AT=280.025n

.meas tran vdout0_46ck550 FIND v(dout0_46) AT=280.025n

.meas tran vdout0_47ck550 FIND v(dout0_47) AT=280.025n

.meas tran vdout0_48ck550 FIND v(dout0_48) AT=280.025n

.meas tran vdout0_49ck550 FIND v(dout0_49) AT=280.025n

.meas tran vdout0_50ck550 FIND v(dout0_50) AT=280.025n

.meas tran vdout0_51ck550 FIND v(dout0_51) AT=280.025n

.meas tran vdout0_52ck550 FIND v(dout0_52) AT=280.025n

.meas tran vdout0_53ck550 FIND v(dout0_53) AT=280.025n

.meas tran vdout0_54ck550 FIND v(dout0_54) AT=280.025n

.meas tran vdout0_55ck550 FIND v(dout0_55) AT=280.025n

.meas tran vdout0_56ck550 FIND v(dout0_56) AT=280.025n

.meas tran vdout0_57ck550 FIND v(dout0_57) AT=280.025n

.meas tran vdout0_58ck550 FIND v(dout0_58) AT=280.025n

.meas tran vdout0_59ck550 FIND v(dout0_59) AT=280.025n

.meas tran vdout0_60ck550 FIND v(dout0_60) AT=280.025n

.meas tran vdout0_61ck550 FIND v(dout0_61) AT=280.025n

.meas tran vdout0_62ck550 FIND v(dout0_62) AT=280.025n

.meas tran vdout0_63ck550 FIND v(dout0_63) AT=280.025n

.meas tran vdout1_0ck550 FIND v(dout1_0) AT=280.025n

.meas tran vdout1_1ck550 FIND v(dout1_1) AT=280.025n

.meas tran vdout1_2ck550 FIND v(dout1_2) AT=280.025n

.meas tran vdout1_3ck550 FIND v(dout1_3) AT=280.025n

.meas tran vdout1_4ck550 FIND v(dout1_4) AT=280.025n

.meas tran vdout1_5ck550 FIND v(dout1_5) AT=280.025n

.meas tran vdout1_6ck550 FIND v(dout1_6) AT=280.025n

.meas tran vdout1_7ck550 FIND v(dout1_7) AT=280.025n

.meas tran vdout1_8ck550 FIND v(dout1_8) AT=280.025n

.meas tran vdout1_9ck550 FIND v(dout1_9) AT=280.025n

.meas tran vdout1_10ck550 FIND v(dout1_10) AT=280.025n

.meas tran vdout1_11ck550 FIND v(dout1_11) AT=280.025n

.meas tran vdout1_12ck550 FIND v(dout1_12) AT=280.025n

.meas tran vdout1_13ck550 FIND v(dout1_13) AT=280.025n

.meas tran vdout1_14ck550 FIND v(dout1_14) AT=280.025n

.meas tran vdout1_15ck550 FIND v(dout1_15) AT=280.025n

.meas tran vdout1_16ck550 FIND v(dout1_16) AT=280.025n

.meas tran vdout1_17ck550 FIND v(dout1_17) AT=280.025n

.meas tran vdout1_18ck550 FIND v(dout1_18) AT=280.025n

.meas tran vdout1_19ck550 FIND v(dout1_19) AT=280.025n

.meas tran vdout1_20ck550 FIND v(dout1_20) AT=280.025n

.meas tran vdout1_21ck550 FIND v(dout1_21) AT=280.025n

.meas tran vdout1_22ck550 FIND v(dout1_22) AT=280.025n

.meas tran vdout1_23ck550 FIND v(dout1_23) AT=280.025n

.meas tran vdout1_24ck550 FIND v(dout1_24) AT=280.025n

.meas tran vdout1_25ck550 FIND v(dout1_25) AT=280.025n

.meas tran vdout1_26ck550 FIND v(dout1_26) AT=280.025n

.meas tran vdout1_27ck550 FIND v(dout1_27) AT=280.025n

.meas tran vdout1_28ck550 FIND v(dout1_28) AT=280.025n

.meas tran vdout1_29ck550 FIND v(dout1_29) AT=280.025n

.meas tran vdout1_30ck550 FIND v(dout1_30) AT=280.025n

.meas tran vdout1_31ck550 FIND v(dout1_31) AT=280.025n

.meas tran vdout1_32ck550 FIND v(dout1_32) AT=280.025n

.meas tran vdout1_33ck550 FIND v(dout1_33) AT=280.025n

.meas tran vdout1_34ck550 FIND v(dout1_34) AT=280.025n

.meas tran vdout1_35ck550 FIND v(dout1_35) AT=280.025n

.meas tran vdout1_36ck550 FIND v(dout1_36) AT=280.025n

.meas tran vdout1_37ck550 FIND v(dout1_37) AT=280.025n

.meas tran vdout1_38ck550 FIND v(dout1_38) AT=280.025n

.meas tran vdout1_39ck550 FIND v(dout1_39) AT=280.025n

.meas tran vdout1_40ck550 FIND v(dout1_40) AT=280.025n

.meas tran vdout1_41ck550 FIND v(dout1_41) AT=280.025n

.meas tran vdout1_42ck550 FIND v(dout1_42) AT=280.025n

.meas tran vdout1_43ck550 FIND v(dout1_43) AT=280.025n

.meas tran vdout1_44ck550 FIND v(dout1_44) AT=280.025n

.meas tran vdout1_45ck550 FIND v(dout1_45) AT=280.025n

.meas tran vdout1_46ck550 FIND v(dout1_46) AT=280.025n

.meas tran vdout1_47ck550 FIND v(dout1_47) AT=280.025n

.meas tran vdout1_48ck550 FIND v(dout1_48) AT=280.025n

.meas tran vdout1_49ck550 FIND v(dout1_49) AT=280.025n

.meas tran vdout1_50ck550 FIND v(dout1_50) AT=280.025n

.meas tran vdout1_51ck550 FIND v(dout1_51) AT=280.025n

.meas tran vdout1_52ck550 FIND v(dout1_52) AT=280.025n

.meas tran vdout1_53ck550 FIND v(dout1_53) AT=280.025n

.meas tran vdout1_54ck550 FIND v(dout1_54) AT=280.025n

.meas tran vdout1_55ck550 FIND v(dout1_55) AT=280.025n

.meas tran vdout1_56ck550 FIND v(dout1_56) AT=280.025n

.meas tran vdout1_57ck550 FIND v(dout1_57) AT=280.025n

.meas tran vdout1_58ck550 FIND v(dout1_58) AT=280.025n

.meas tran vdout1_59ck550 FIND v(dout1_59) AT=280.025n

.meas tran vdout1_60ck550 FIND v(dout1_60) AT=280.025n

.meas tran vdout1_61ck550 FIND v(dout1_61) AT=280.025n

.meas tran vdout1_62ck550 FIND v(dout1_62) AT=280.025n

.meas tran vdout1_63ck550 FIND v(dout1_63) AT=280.025n

.meas tran vdout0_0ck560 FIND v(dout0_0) AT=285.025n

.meas tran vdout0_1ck560 FIND v(dout0_1) AT=285.025n

.meas tran vdout0_2ck560 FIND v(dout0_2) AT=285.025n

.meas tran vdout0_3ck560 FIND v(dout0_3) AT=285.025n

.meas tran vdout0_4ck560 FIND v(dout0_4) AT=285.025n

.meas tran vdout0_5ck560 FIND v(dout0_5) AT=285.025n

.meas tran vdout0_6ck560 FIND v(dout0_6) AT=285.025n

.meas tran vdout0_7ck560 FIND v(dout0_7) AT=285.025n

.meas tran vdout0_8ck560 FIND v(dout0_8) AT=285.025n

.meas tran vdout0_9ck560 FIND v(dout0_9) AT=285.025n

.meas tran vdout0_10ck560 FIND v(dout0_10) AT=285.025n

.meas tran vdout0_11ck560 FIND v(dout0_11) AT=285.025n

.meas tran vdout0_12ck560 FIND v(dout0_12) AT=285.025n

.meas tran vdout0_13ck560 FIND v(dout0_13) AT=285.025n

.meas tran vdout0_14ck560 FIND v(dout0_14) AT=285.025n

.meas tran vdout0_15ck560 FIND v(dout0_15) AT=285.025n

.meas tran vdout0_16ck560 FIND v(dout0_16) AT=285.025n

.meas tran vdout0_17ck560 FIND v(dout0_17) AT=285.025n

.meas tran vdout0_18ck560 FIND v(dout0_18) AT=285.025n

.meas tran vdout0_19ck560 FIND v(dout0_19) AT=285.025n

.meas tran vdout0_20ck560 FIND v(dout0_20) AT=285.025n

.meas tran vdout0_21ck560 FIND v(dout0_21) AT=285.025n

.meas tran vdout0_22ck560 FIND v(dout0_22) AT=285.025n

.meas tran vdout0_23ck560 FIND v(dout0_23) AT=285.025n

.meas tran vdout0_24ck560 FIND v(dout0_24) AT=285.025n

.meas tran vdout0_25ck560 FIND v(dout0_25) AT=285.025n

.meas tran vdout0_26ck560 FIND v(dout0_26) AT=285.025n

.meas tran vdout0_27ck560 FIND v(dout0_27) AT=285.025n

.meas tran vdout0_28ck560 FIND v(dout0_28) AT=285.025n

.meas tran vdout0_29ck560 FIND v(dout0_29) AT=285.025n

.meas tran vdout0_30ck560 FIND v(dout0_30) AT=285.025n

.meas tran vdout0_31ck560 FIND v(dout0_31) AT=285.025n

.meas tran vdout0_32ck560 FIND v(dout0_32) AT=285.025n

.meas tran vdout0_33ck560 FIND v(dout0_33) AT=285.025n

.meas tran vdout0_34ck560 FIND v(dout0_34) AT=285.025n

.meas tran vdout0_35ck560 FIND v(dout0_35) AT=285.025n

.meas tran vdout0_36ck560 FIND v(dout0_36) AT=285.025n

.meas tran vdout0_37ck560 FIND v(dout0_37) AT=285.025n

.meas tran vdout0_38ck560 FIND v(dout0_38) AT=285.025n

.meas tran vdout0_39ck560 FIND v(dout0_39) AT=285.025n

.meas tran vdout0_40ck560 FIND v(dout0_40) AT=285.025n

.meas tran vdout0_41ck560 FIND v(dout0_41) AT=285.025n

.meas tran vdout0_42ck560 FIND v(dout0_42) AT=285.025n

.meas tran vdout0_43ck560 FIND v(dout0_43) AT=285.025n

.meas tran vdout0_44ck560 FIND v(dout0_44) AT=285.025n

.meas tran vdout0_45ck560 FIND v(dout0_45) AT=285.025n

.meas tran vdout0_46ck560 FIND v(dout0_46) AT=285.025n

.meas tran vdout0_47ck560 FIND v(dout0_47) AT=285.025n

.meas tran vdout0_48ck560 FIND v(dout0_48) AT=285.025n

.meas tran vdout0_49ck560 FIND v(dout0_49) AT=285.025n

.meas tran vdout0_50ck560 FIND v(dout0_50) AT=285.025n

.meas tran vdout0_51ck560 FIND v(dout0_51) AT=285.025n

.meas tran vdout0_52ck560 FIND v(dout0_52) AT=285.025n

.meas tran vdout0_53ck560 FIND v(dout0_53) AT=285.025n

.meas tran vdout0_54ck560 FIND v(dout0_54) AT=285.025n

.meas tran vdout0_55ck560 FIND v(dout0_55) AT=285.025n

.meas tran vdout0_56ck560 FIND v(dout0_56) AT=285.025n

.meas tran vdout0_57ck560 FIND v(dout0_57) AT=285.025n

.meas tran vdout0_58ck560 FIND v(dout0_58) AT=285.025n

.meas tran vdout0_59ck560 FIND v(dout0_59) AT=285.025n

.meas tran vdout0_60ck560 FIND v(dout0_60) AT=285.025n

.meas tran vdout0_61ck560 FIND v(dout0_61) AT=285.025n

.meas tran vdout0_62ck560 FIND v(dout0_62) AT=285.025n

.meas tran vdout0_63ck560 FIND v(dout0_63) AT=285.025n

.meas tran vdout1_0ck560 FIND v(dout1_0) AT=285.025n

.meas tran vdout1_1ck560 FIND v(dout1_1) AT=285.025n

.meas tran vdout1_2ck560 FIND v(dout1_2) AT=285.025n

.meas tran vdout1_3ck560 FIND v(dout1_3) AT=285.025n

.meas tran vdout1_4ck560 FIND v(dout1_4) AT=285.025n

.meas tran vdout1_5ck560 FIND v(dout1_5) AT=285.025n

.meas tran vdout1_6ck560 FIND v(dout1_6) AT=285.025n

.meas tran vdout1_7ck560 FIND v(dout1_7) AT=285.025n

.meas tran vdout1_8ck560 FIND v(dout1_8) AT=285.025n

.meas tran vdout1_9ck560 FIND v(dout1_9) AT=285.025n

.meas tran vdout1_10ck560 FIND v(dout1_10) AT=285.025n

.meas tran vdout1_11ck560 FIND v(dout1_11) AT=285.025n

.meas tran vdout1_12ck560 FIND v(dout1_12) AT=285.025n

.meas tran vdout1_13ck560 FIND v(dout1_13) AT=285.025n

.meas tran vdout1_14ck560 FIND v(dout1_14) AT=285.025n

.meas tran vdout1_15ck560 FIND v(dout1_15) AT=285.025n

.meas tran vdout1_16ck560 FIND v(dout1_16) AT=285.025n

.meas tran vdout1_17ck560 FIND v(dout1_17) AT=285.025n

.meas tran vdout1_18ck560 FIND v(dout1_18) AT=285.025n

.meas tran vdout1_19ck560 FIND v(dout1_19) AT=285.025n

.meas tran vdout1_20ck560 FIND v(dout1_20) AT=285.025n

.meas tran vdout1_21ck560 FIND v(dout1_21) AT=285.025n

.meas tran vdout1_22ck560 FIND v(dout1_22) AT=285.025n

.meas tran vdout1_23ck560 FIND v(dout1_23) AT=285.025n

.meas tran vdout1_24ck560 FIND v(dout1_24) AT=285.025n

.meas tran vdout1_25ck560 FIND v(dout1_25) AT=285.025n

.meas tran vdout1_26ck560 FIND v(dout1_26) AT=285.025n

.meas tran vdout1_27ck560 FIND v(dout1_27) AT=285.025n

.meas tran vdout1_28ck560 FIND v(dout1_28) AT=285.025n

.meas tran vdout1_29ck560 FIND v(dout1_29) AT=285.025n

.meas tran vdout1_30ck560 FIND v(dout1_30) AT=285.025n

.meas tran vdout1_31ck560 FIND v(dout1_31) AT=285.025n

.meas tran vdout1_32ck560 FIND v(dout1_32) AT=285.025n

.meas tran vdout1_33ck560 FIND v(dout1_33) AT=285.025n

.meas tran vdout1_34ck560 FIND v(dout1_34) AT=285.025n

.meas tran vdout1_35ck560 FIND v(dout1_35) AT=285.025n

.meas tran vdout1_36ck560 FIND v(dout1_36) AT=285.025n

.meas tran vdout1_37ck560 FIND v(dout1_37) AT=285.025n

.meas tran vdout1_38ck560 FIND v(dout1_38) AT=285.025n

.meas tran vdout1_39ck560 FIND v(dout1_39) AT=285.025n

.meas tran vdout1_40ck560 FIND v(dout1_40) AT=285.025n

.meas tran vdout1_41ck560 FIND v(dout1_41) AT=285.025n

.meas tran vdout1_42ck560 FIND v(dout1_42) AT=285.025n

.meas tran vdout1_43ck560 FIND v(dout1_43) AT=285.025n

.meas tran vdout1_44ck560 FIND v(dout1_44) AT=285.025n

.meas tran vdout1_45ck560 FIND v(dout1_45) AT=285.025n

.meas tran vdout1_46ck560 FIND v(dout1_46) AT=285.025n

.meas tran vdout1_47ck560 FIND v(dout1_47) AT=285.025n

.meas tran vdout1_48ck560 FIND v(dout1_48) AT=285.025n

.meas tran vdout1_49ck560 FIND v(dout1_49) AT=285.025n

.meas tran vdout1_50ck560 FIND v(dout1_50) AT=285.025n

.meas tran vdout1_51ck560 FIND v(dout1_51) AT=285.025n

.meas tran vdout1_52ck560 FIND v(dout1_52) AT=285.025n

.meas tran vdout1_53ck560 FIND v(dout1_53) AT=285.025n

.meas tran vdout1_54ck560 FIND v(dout1_54) AT=285.025n

.meas tran vdout1_55ck560 FIND v(dout1_55) AT=285.025n

.meas tran vdout1_56ck560 FIND v(dout1_56) AT=285.025n

.meas tran vdout1_57ck560 FIND v(dout1_57) AT=285.025n

.meas tran vdout1_58ck560 FIND v(dout1_58) AT=285.025n

.meas tran vdout1_59ck560 FIND v(dout1_59) AT=285.025n

.meas tran vdout1_60ck560 FIND v(dout1_60) AT=285.025n

.meas tran vdout1_61ck560 FIND v(dout1_61) AT=285.025n

.meas tran vdout1_62ck560 FIND v(dout1_62) AT=285.025n

.meas tran vdout1_63ck560 FIND v(dout1_63) AT=285.025n

.meas tran vdout0_0ck570 FIND v(dout0_0) AT=290.025n

.meas tran vdout0_1ck570 FIND v(dout0_1) AT=290.025n

.meas tran vdout0_2ck570 FIND v(dout0_2) AT=290.025n

.meas tran vdout0_3ck570 FIND v(dout0_3) AT=290.025n

.meas tran vdout0_4ck570 FIND v(dout0_4) AT=290.025n

.meas tran vdout0_5ck570 FIND v(dout0_5) AT=290.025n

.meas tran vdout0_6ck570 FIND v(dout0_6) AT=290.025n

.meas tran vdout0_7ck570 FIND v(dout0_7) AT=290.025n

.meas tran vdout0_8ck570 FIND v(dout0_8) AT=290.025n

.meas tran vdout0_9ck570 FIND v(dout0_9) AT=290.025n

.meas tran vdout0_10ck570 FIND v(dout0_10) AT=290.025n

.meas tran vdout0_11ck570 FIND v(dout0_11) AT=290.025n

.meas tran vdout0_12ck570 FIND v(dout0_12) AT=290.025n

.meas tran vdout0_13ck570 FIND v(dout0_13) AT=290.025n

.meas tran vdout0_14ck570 FIND v(dout0_14) AT=290.025n

.meas tran vdout0_15ck570 FIND v(dout0_15) AT=290.025n

.meas tran vdout0_16ck570 FIND v(dout0_16) AT=290.025n

.meas tran vdout0_17ck570 FIND v(dout0_17) AT=290.025n

.meas tran vdout0_18ck570 FIND v(dout0_18) AT=290.025n

.meas tran vdout0_19ck570 FIND v(dout0_19) AT=290.025n

.meas tran vdout0_20ck570 FIND v(dout0_20) AT=290.025n

.meas tran vdout0_21ck570 FIND v(dout0_21) AT=290.025n

.meas tran vdout0_22ck570 FIND v(dout0_22) AT=290.025n

.meas tran vdout0_23ck570 FIND v(dout0_23) AT=290.025n

.meas tran vdout0_24ck570 FIND v(dout0_24) AT=290.025n

.meas tran vdout0_25ck570 FIND v(dout0_25) AT=290.025n

.meas tran vdout0_26ck570 FIND v(dout0_26) AT=290.025n

.meas tran vdout0_27ck570 FIND v(dout0_27) AT=290.025n

.meas tran vdout0_28ck570 FIND v(dout0_28) AT=290.025n

.meas tran vdout0_29ck570 FIND v(dout0_29) AT=290.025n

.meas tran vdout0_30ck570 FIND v(dout0_30) AT=290.025n

.meas tran vdout0_31ck570 FIND v(dout0_31) AT=290.025n

.meas tran vdout0_32ck570 FIND v(dout0_32) AT=290.025n

.meas tran vdout0_33ck570 FIND v(dout0_33) AT=290.025n

.meas tran vdout0_34ck570 FIND v(dout0_34) AT=290.025n

.meas tran vdout0_35ck570 FIND v(dout0_35) AT=290.025n

.meas tran vdout0_36ck570 FIND v(dout0_36) AT=290.025n

.meas tran vdout0_37ck570 FIND v(dout0_37) AT=290.025n

.meas tran vdout0_38ck570 FIND v(dout0_38) AT=290.025n

.meas tran vdout0_39ck570 FIND v(dout0_39) AT=290.025n

.meas tran vdout0_40ck570 FIND v(dout0_40) AT=290.025n

.meas tran vdout0_41ck570 FIND v(dout0_41) AT=290.025n

.meas tran vdout0_42ck570 FIND v(dout0_42) AT=290.025n

.meas tran vdout0_43ck570 FIND v(dout0_43) AT=290.025n

.meas tran vdout0_44ck570 FIND v(dout0_44) AT=290.025n

.meas tran vdout0_45ck570 FIND v(dout0_45) AT=290.025n

.meas tran vdout0_46ck570 FIND v(dout0_46) AT=290.025n

.meas tran vdout0_47ck570 FIND v(dout0_47) AT=290.025n

.meas tran vdout0_48ck570 FIND v(dout0_48) AT=290.025n

.meas tran vdout0_49ck570 FIND v(dout0_49) AT=290.025n

.meas tran vdout0_50ck570 FIND v(dout0_50) AT=290.025n

.meas tran vdout0_51ck570 FIND v(dout0_51) AT=290.025n

.meas tran vdout0_52ck570 FIND v(dout0_52) AT=290.025n

.meas tran vdout0_53ck570 FIND v(dout0_53) AT=290.025n

.meas tran vdout0_54ck570 FIND v(dout0_54) AT=290.025n

.meas tran vdout0_55ck570 FIND v(dout0_55) AT=290.025n

.meas tran vdout0_56ck570 FIND v(dout0_56) AT=290.025n

.meas tran vdout0_57ck570 FIND v(dout0_57) AT=290.025n

.meas tran vdout0_58ck570 FIND v(dout0_58) AT=290.025n

.meas tran vdout0_59ck570 FIND v(dout0_59) AT=290.025n

.meas tran vdout0_60ck570 FIND v(dout0_60) AT=290.025n

.meas tran vdout0_61ck570 FIND v(dout0_61) AT=290.025n

.meas tran vdout0_62ck570 FIND v(dout0_62) AT=290.025n

.meas tran vdout0_63ck570 FIND v(dout0_63) AT=290.025n

.meas tran vdout0_0ck590 FIND v(dout0_0) AT=300.025n

.meas tran vdout0_1ck590 FIND v(dout0_1) AT=300.025n

.meas tran vdout0_2ck590 FIND v(dout0_2) AT=300.025n

.meas tran vdout0_3ck590 FIND v(dout0_3) AT=300.025n

.meas tran vdout0_4ck590 FIND v(dout0_4) AT=300.025n

.meas tran vdout0_5ck590 FIND v(dout0_5) AT=300.025n

.meas tran vdout0_6ck590 FIND v(dout0_6) AT=300.025n

.meas tran vdout0_7ck590 FIND v(dout0_7) AT=300.025n

.meas tran vdout0_8ck590 FIND v(dout0_8) AT=300.025n

.meas tran vdout0_9ck590 FIND v(dout0_9) AT=300.025n

.meas tran vdout0_10ck590 FIND v(dout0_10) AT=300.025n

.meas tran vdout0_11ck590 FIND v(dout0_11) AT=300.025n

.meas tran vdout0_12ck590 FIND v(dout0_12) AT=300.025n

.meas tran vdout0_13ck590 FIND v(dout0_13) AT=300.025n

.meas tran vdout0_14ck590 FIND v(dout0_14) AT=300.025n

.meas tran vdout0_15ck590 FIND v(dout0_15) AT=300.025n

.meas tran vdout0_16ck590 FIND v(dout0_16) AT=300.025n

.meas tran vdout0_17ck590 FIND v(dout0_17) AT=300.025n

.meas tran vdout0_18ck590 FIND v(dout0_18) AT=300.025n

.meas tran vdout0_19ck590 FIND v(dout0_19) AT=300.025n

.meas tran vdout0_20ck590 FIND v(dout0_20) AT=300.025n

.meas tran vdout0_21ck590 FIND v(dout0_21) AT=300.025n

.meas tran vdout0_22ck590 FIND v(dout0_22) AT=300.025n

.meas tran vdout0_23ck590 FIND v(dout0_23) AT=300.025n

.meas tran vdout0_24ck590 FIND v(dout0_24) AT=300.025n

.meas tran vdout0_25ck590 FIND v(dout0_25) AT=300.025n

.meas tran vdout0_26ck590 FIND v(dout0_26) AT=300.025n

.meas tran vdout0_27ck590 FIND v(dout0_27) AT=300.025n

.meas tran vdout0_28ck590 FIND v(dout0_28) AT=300.025n

.meas tran vdout0_29ck590 FIND v(dout0_29) AT=300.025n

.meas tran vdout0_30ck590 FIND v(dout0_30) AT=300.025n

.meas tran vdout0_31ck590 FIND v(dout0_31) AT=300.025n

.meas tran vdout0_32ck590 FIND v(dout0_32) AT=300.025n

.meas tran vdout0_33ck590 FIND v(dout0_33) AT=300.025n

.meas tran vdout0_34ck590 FIND v(dout0_34) AT=300.025n

.meas tran vdout0_35ck590 FIND v(dout0_35) AT=300.025n

.meas tran vdout0_36ck590 FIND v(dout0_36) AT=300.025n

.meas tran vdout0_37ck590 FIND v(dout0_37) AT=300.025n

.meas tran vdout0_38ck590 FIND v(dout0_38) AT=300.025n

.meas tran vdout0_39ck590 FIND v(dout0_39) AT=300.025n

.meas tran vdout0_40ck590 FIND v(dout0_40) AT=300.025n

.meas tran vdout0_41ck590 FIND v(dout0_41) AT=300.025n

.meas tran vdout0_42ck590 FIND v(dout0_42) AT=300.025n

.meas tran vdout0_43ck590 FIND v(dout0_43) AT=300.025n

.meas tran vdout0_44ck590 FIND v(dout0_44) AT=300.025n

.meas tran vdout0_45ck590 FIND v(dout0_45) AT=300.025n

.meas tran vdout0_46ck590 FIND v(dout0_46) AT=300.025n

.meas tran vdout0_47ck590 FIND v(dout0_47) AT=300.025n

.meas tran vdout0_48ck590 FIND v(dout0_48) AT=300.025n

.meas tran vdout0_49ck590 FIND v(dout0_49) AT=300.025n

.meas tran vdout0_50ck590 FIND v(dout0_50) AT=300.025n

.meas tran vdout0_51ck590 FIND v(dout0_51) AT=300.025n

.meas tran vdout0_52ck590 FIND v(dout0_52) AT=300.025n

.meas tran vdout0_53ck590 FIND v(dout0_53) AT=300.025n

.meas tran vdout0_54ck590 FIND v(dout0_54) AT=300.025n

.meas tran vdout0_55ck590 FIND v(dout0_55) AT=300.025n

.meas tran vdout0_56ck590 FIND v(dout0_56) AT=300.025n

.meas tran vdout0_57ck590 FIND v(dout0_57) AT=300.025n

.meas tran vdout0_58ck590 FIND v(dout0_58) AT=300.025n

.meas tran vdout0_59ck590 FIND v(dout0_59) AT=300.025n

.meas tran vdout0_60ck590 FIND v(dout0_60) AT=300.025n

.meas tran vdout0_61ck590 FIND v(dout0_61) AT=300.025n

.meas tran vdout0_62ck590 FIND v(dout0_62) AT=300.025n

.meas tran vdout0_63ck590 FIND v(dout0_63) AT=300.025n

.meas tran vdout1_0ck590 FIND v(dout1_0) AT=300.025n

.meas tran vdout1_1ck590 FIND v(dout1_1) AT=300.025n

.meas tran vdout1_2ck590 FIND v(dout1_2) AT=300.025n

.meas tran vdout1_3ck590 FIND v(dout1_3) AT=300.025n

.meas tran vdout1_4ck590 FIND v(dout1_4) AT=300.025n

.meas tran vdout1_5ck590 FIND v(dout1_5) AT=300.025n

.meas tran vdout1_6ck590 FIND v(dout1_6) AT=300.025n

.meas tran vdout1_7ck590 FIND v(dout1_7) AT=300.025n

.meas tran vdout1_8ck590 FIND v(dout1_8) AT=300.025n

.meas tran vdout1_9ck590 FIND v(dout1_9) AT=300.025n

.meas tran vdout1_10ck590 FIND v(dout1_10) AT=300.025n

.meas tran vdout1_11ck590 FIND v(dout1_11) AT=300.025n

.meas tran vdout1_12ck590 FIND v(dout1_12) AT=300.025n

.meas tran vdout1_13ck590 FIND v(dout1_13) AT=300.025n

.meas tran vdout1_14ck590 FIND v(dout1_14) AT=300.025n

.meas tran vdout1_15ck590 FIND v(dout1_15) AT=300.025n

.meas tran vdout1_16ck590 FIND v(dout1_16) AT=300.025n

.meas tran vdout1_17ck590 FIND v(dout1_17) AT=300.025n

.meas tran vdout1_18ck590 FIND v(dout1_18) AT=300.025n

.meas tran vdout1_19ck590 FIND v(dout1_19) AT=300.025n

.meas tran vdout1_20ck590 FIND v(dout1_20) AT=300.025n

.meas tran vdout1_21ck590 FIND v(dout1_21) AT=300.025n

.meas tran vdout1_22ck590 FIND v(dout1_22) AT=300.025n

.meas tran vdout1_23ck590 FIND v(dout1_23) AT=300.025n

.meas tran vdout1_24ck590 FIND v(dout1_24) AT=300.025n

.meas tran vdout1_25ck590 FIND v(dout1_25) AT=300.025n

.meas tran vdout1_26ck590 FIND v(dout1_26) AT=300.025n

.meas tran vdout1_27ck590 FIND v(dout1_27) AT=300.025n

.meas tran vdout1_28ck590 FIND v(dout1_28) AT=300.025n

.meas tran vdout1_29ck590 FIND v(dout1_29) AT=300.025n

.meas tran vdout1_30ck590 FIND v(dout1_30) AT=300.025n

.meas tran vdout1_31ck590 FIND v(dout1_31) AT=300.025n

.meas tran vdout1_32ck590 FIND v(dout1_32) AT=300.025n

.meas tran vdout1_33ck590 FIND v(dout1_33) AT=300.025n

.meas tran vdout1_34ck590 FIND v(dout1_34) AT=300.025n

.meas tran vdout1_35ck590 FIND v(dout1_35) AT=300.025n

.meas tran vdout1_36ck590 FIND v(dout1_36) AT=300.025n

.meas tran vdout1_37ck590 FIND v(dout1_37) AT=300.025n

.meas tran vdout1_38ck590 FIND v(dout1_38) AT=300.025n

.meas tran vdout1_39ck590 FIND v(dout1_39) AT=300.025n

.meas tran vdout1_40ck590 FIND v(dout1_40) AT=300.025n

.meas tran vdout1_41ck590 FIND v(dout1_41) AT=300.025n

.meas tran vdout1_42ck590 FIND v(dout1_42) AT=300.025n

.meas tran vdout1_43ck590 FIND v(dout1_43) AT=300.025n

.meas tran vdout1_44ck590 FIND v(dout1_44) AT=300.025n

.meas tran vdout1_45ck590 FIND v(dout1_45) AT=300.025n

.meas tran vdout1_46ck590 FIND v(dout1_46) AT=300.025n

.meas tran vdout1_47ck590 FIND v(dout1_47) AT=300.025n

.meas tran vdout1_48ck590 FIND v(dout1_48) AT=300.025n

.meas tran vdout1_49ck590 FIND v(dout1_49) AT=300.025n

.meas tran vdout1_50ck590 FIND v(dout1_50) AT=300.025n

.meas tran vdout1_51ck590 FIND v(dout1_51) AT=300.025n

.meas tran vdout1_52ck590 FIND v(dout1_52) AT=300.025n

.meas tran vdout1_53ck590 FIND v(dout1_53) AT=300.025n

.meas tran vdout1_54ck590 FIND v(dout1_54) AT=300.025n

.meas tran vdout1_55ck590 FIND v(dout1_55) AT=300.025n

.meas tran vdout1_56ck590 FIND v(dout1_56) AT=300.025n

.meas tran vdout1_57ck590 FIND v(dout1_57) AT=300.025n

.meas tran vdout1_58ck590 FIND v(dout1_58) AT=300.025n

.meas tran vdout1_59ck590 FIND v(dout1_59) AT=300.025n

.meas tran vdout1_60ck590 FIND v(dout1_60) AT=300.025n

.meas tran vdout1_61ck590 FIND v(dout1_61) AT=300.025n

.meas tran vdout1_62ck590 FIND v(dout1_62) AT=300.025n

.meas tran vdout1_63ck590 FIND v(dout1_63) AT=300.025n

.meas tran vdout0_0ck600 FIND v(dout0_0) AT=305.025n

.meas tran vdout0_1ck600 FIND v(dout0_1) AT=305.025n

.meas tran vdout0_2ck600 FIND v(dout0_2) AT=305.025n

.meas tran vdout0_3ck600 FIND v(dout0_3) AT=305.025n

.meas tran vdout0_4ck600 FIND v(dout0_4) AT=305.025n

.meas tran vdout0_5ck600 FIND v(dout0_5) AT=305.025n

.meas tran vdout0_6ck600 FIND v(dout0_6) AT=305.025n

.meas tran vdout0_7ck600 FIND v(dout0_7) AT=305.025n

.meas tran vdout0_8ck600 FIND v(dout0_8) AT=305.025n

.meas tran vdout0_9ck600 FIND v(dout0_9) AT=305.025n

.meas tran vdout0_10ck600 FIND v(dout0_10) AT=305.025n

.meas tran vdout0_11ck600 FIND v(dout0_11) AT=305.025n

.meas tran vdout0_12ck600 FIND v(dout0_12) AT=305.025n

.meas tran vdout0_13ck600 FIND v(dout0_13) AT=305.025n

.meas tran vdout0_14ck600 FIND v(dout0_14) AT=305.025n

.meas tran vdout0_15ck600 FIND v(dout0_15) AT=305.025n

.meas tran vdout0_16ck600 FIND v(dout0_16) AT=305.025n

.meas tran vdout0_17ck600 FIND v(dout0_17) AT=305.025n

.meas tran vdout0_18ck600 FIND v(dout0_18) AT=305.025n

.meas tran vdout0_19ck600 FIND v(dout0_19) AT=305.025n

.meas tran vdout0_20ck600 FIND v(dout0_20) AT=305.025n

.meas tran vdout0_21ck600 FIND v(dout0_21) AT=305.025n

.meas tran vdout0_22ck600 FIND v(dout0_22) AT=305.025n

.meas tran vdout0_23ck600 FIND v(dout0_23) AT=305.025n

.meas tran vdout0_24ck600 FIND v(dout0_24) AT=305.025n

.meas tran vdout0_25ck600 FIND v(dout0_25) AT=305.025n

.meas tran vdout0_26ck600 FIND v(dout0_26) AT=305.025n

.meas tran vdout0_27ck600 FIND v(dout0_27) AT=305.025n

.meas tran vdout0_28ck600 FIND v(dout0_28) AT=305.025n

.meas tran vdout0_29ck600 FIND v(dout0_29) AT=305.025n

.meas tran vdout0_30ck600 FIND v(dout0_30) AT=305.025n

.meas tran vdout0_31ck600 FIND v(dout0_31) AT=305.025n

.meas tran vdout0_32ck600 FIND v(dout0_32) AT=305.025n

.meas tran vdout0_33ck600 FIND v(dout0_33) AT=305.025n

.meas tran vdout0_34ck600 FIND v(dout0_34) AT=305.025n

.meas tran vdout0_35ck600 FIND v(dout0_35) AT=305.025n

.meas tran vdout0_36ck600 FIND v(dout0_36) AT=305.025n

.meas tran vdout0_37ck600 FIND v(dout0_37) AT=305.025n

.meas tran vdout0_38ck600 FIND v(dout0_38) AT=305.025n

.meas tran vdout0_39ck600 FIND v(dout0_39) AT=305.025n

.meas tran vdout0_40ck600 FIND v(dout0_40) AT=305.025n

.meas tran vdout0_41ck600 FIND v(dout0_41) AT=305.025n

.meas tran vdout0_42ck600 FIND v(dout0_42) AT=305.025n

.meas tran vdout0_43ck600 FIND v(dout0_43) AT=305.025n

.meas tran vdout0_44ck600 FIND v(dout0_44) AT=305.025n

.meas tran vdout0_45ck600 FIND v(dout0_45) AT=305.025n

.meas tran vdout0_46ck600 FIND v(dout0_46) AT=305.025n

.meas tran vdout0_47ck600 FIND v(dout0_47) AT=305.025n

.meas tran vdout0_48ck600 FIND v(dout0_48) AT=305.025n

.meas tran vdout0_49ck600 FIND v(dout0_49) AT=305.025n

.meas tran vdout0_50ck600 FIND v(dout0_50) AT=305.025n

.meas tran vdout0_51ck600 FIND v(dout0_51) AT=305.025n

.meas tran vdout0_52ck600 FIND v(dout0_52) AT=305.025n

.meas tran vdout0_53ck600 FIND v(dout0_53) AT=305.025n

.meas tran vdout0_54ck600 FIND v(dout0_54) AT=305.025n

.meas tran vdout0_55ck600 FIND v(dout0_55) AT=305.025n

.meas tran vdout0_56ck600 FIND v(dout0_56) AT=305.025n

.meas tran vdout0_57ck600 FIND v(dout0_57) AT=305.025n

.meas tran vdout0_58ck600 FIND v(dout0_58) AT=305.025n

.meas tran vdout0_59ck600 FIND v(dout0_59) AT=305.025n

.meas tran vdout0_60ck600 FIND v(dout0_60) AT=305.025n

.meas tran vdout0_61ck600 FIND v(dout0_61) AT=305.025n

.meas tran vdout0_62ck600 FIND v(dout0_62) AT=305.025n

.meas tran vdout0_63ck600 FIND v(dout0_63) AT=305.025n

.meas tran vdout0_0ck620 FIND v(dout0_0) AT=315.025n

.meas tran vdout0_1ck620 FIND v(dout0_1) AT=315.025n

.meas tran vdout0_2ck620 FIND v(dout0_2) AT=315.025n

.meas tran vdout0_3ck620 FIND v(dout0_3) AT=315.025n

.meas tran vdout0_4ck620 FIND v(dout0_4) AT=315.025n

.meas tran vdout0_5ck620 FIND v(dout0_5) AT=315.025n

.meas tran vdout0_6ck620 FIND v(dout0_6) AT=315.025n

.meas tran vdout0_7ck620 FIND v(dout0_7) AT=315.025n

.meas tran vdout0_8ck620 FIND v(dout0_8) AT=315.025n

.meas tran vdout0_9ck620 FIND v(dout0_9) AT=315.025n

.meas tran vdout0_10ck620 FIND v(dout0_10) AT=315.025n

.meas tran vdout0_11ck620 FIND v(dout0_11) AT=315.025n

.meas tran vdout0_12ck620 FIND v(dout0_12) AT=315.025n

.meas tran vdout0_13ck620 FIND v(dout0_13) AT=315.025n

.meas tran vdout0_14ck620 FIND v(dout0_14) AT=315.025n

.meas tran vdout0_15ck620 FIND v(dout0_15) AT=315.025n

.meas tran vdout0_16ck620 FIND v(dout0_16) AT=315.025n

.meas tran vdout0_17ck620 FIND v(dout0_17) AT=315.025n

.meas tran vdout0_18ck620 FIND v(dout0_18) AT=315.025n

.meas tran vdout0_19ck620 FIND v(dout0_19) AT=315.025n

.meas tran vdout0_20ck620 FIND v(dout0_20) AT=315.025n

.meas tran vdout0_21ck620 FIND v(dout0_21) AT=315.025n

.meas tran vdout0_22ck620 FIND v(dout0_22) AT=315.025n

.meas tran vdout0_23ck620 FIND v(dout0_23) AT=315.025n

.meas tran vdout0_24ck620 FIND v(dout0_24) AT=315.025n

.meas tran vdout0_25ck620 FIND v(dout0_25) AT=315.025n

.meas tran vdout0_26ck620 FIND v(dout0_26) AT=315.025n

.meas tran vdout0_27ck620 FIND v(dout0_27) AT=315.025n

.meas tran vdout0_28ck620 FIND v(dout0_28) AT=315.025n

.meas tran vdout0_29ck620 FIND v(dout0_29) AT=315.025n

.meas tran vdout0_30ck620 FIND v(dout0_30) AT=315.025n

.meas tran vdout0_31ck620 FIND v(dout0_31) AT=315.025n

.meas tran vdout0_32ck620 FIND v(dout0_32) AT=315.025n

.meas tran vdout0_33ck620 FIND v(dout0_33) AT=315.025n

.meas tran vdout0_34ck620 FIND v(dout0_34) AT=315.025n

.meas tran vdout0_35ck620 FIND v(dout0_35) AT=315.025n

.meas tran vdout0_36ck620 FIND v(dout0_36) AT=315.025n

.meas tran vdout0_37ck620 FIND v(dout0_37) AT=315.025n

.meas tran vdout0_38ck620 FIND v(dout0_38) AT=315.025n

.meas tran vdout0_39ck620 FIND v(dout0_39) AT=315.025n

.meas tran vdout0_40ck620 FIND v(dout0_40) AT=315.025n

.meas tran vdout0_41ck620 FIND v(dout0_41) AT=315.025n

.meas tran vdout0_42ck620 FIND v(dout0_42) AT=315.025n

.meas tran vdout0_43ck620 FIND v(dout0_43) AT=315.025n

.meas tran vdout0_44ck620 FIND v(dout0_44) AT=315.025n

.meas tran vdout0_45ck620 FIND v(dout0_45) AT=315.025n

.meas tran vdout0_46ck620 FIND v(dout0_46) AT=315.025n

.meas tran vdout0_47ck620 FIND v(dout0_47) AT=315.025n

.meas tran vdout0_48ck620 FIND v(dout0_48) AT=315.025n

.meas tran vdout0_49ck620 FIND v(dout0_49) AT=315.025n

.meas tran vdout0_50ck620 FIND v(dout0_50) AT=315.025n

.meas tran vdout0_51ck620 FIND v(dout0_51) AT=315.025n

.meas tran vdout0_52ck620 FIND v(dout0_52) AT=315.025n

.meas tran vdout0_53ck620 FIND v(dout0_53) AT=315.025n

.meas tran vdout0_54ck620 FIND v(dout0_54) AT=315.025n

.meas tran vdout0_55ck620 FIND v(dout0_55) AT=315.025n

.meas tran vdout0_56ck620 FIND v(dout0_56) AT=315.025n

.meas tran vdout0_57ck620 FIND v(dout0_57) AT=315.025n

.meas tran vdout0_58ck620 FIND v(dout0_58) AT=315.025n

.meas tran vdout0_59ck620 FIND v(dout0_59) AT=315.025n

.meas tran vdout0_60ck620 FIND v(dout0_60) AT=315.025n

.meas tran vdout0_61ck620 FIND v(dout0_61) AT=315.025n

.meas tran vdout0_62ck620 FIND v(dout0_62) AT=315.025n

.meas tran vdout0_63ck620 FIND v(dout0_63) AT=315.025n

.meas tran vdout1_0ck620 FIND v(dout1_0) AT=315.025n

.meas tran vdout1_1ck620 FIND v(dout1_1) AT=315.025n

.meas tran vdout1_2ck620 FIND v(dout1_2) AT=315.025n

.meas tran vdout1_3ck620 FIND v(dout1_3) AT=315.025n

.meas tran vdout1_4ck620 FIND v(dout1_4) AT=315.025n

.meas tran vdout1_5ck620 FIND v(dout1_5) AT=315.025n

.meas tran vdout1_6ck620 FIND v(dout1_6) AT=315.025n

.meas tran vdout1_7ck620 FIND v(dout1_7) AT=315.025n

.meas tran vdout1_8ck620 FIND v(dout1_8) AT=315.025n

.meas tran vdout1_9ck620 FIND v(dout1_9) AT=315.025n

.meas tran vdout1_10ck620 FIND v(dout1_10) AT=315.025n

.meas tran vdout1_11ck620 FIND v(dout1_11) AT=315.025n

.meas tran vdout1_12ck620 FIND v(dout1_12) AT=315.025n

.meas tran vdout1_13ck620 FIND v(dout1_13) AT=315.025n

.meas tran vdout1_14ck620 FIND v(dout1_14) AT=315.025n

.meas tran vdout1_15ck620 FIND v(dout1_15) AT=315.025n

.meas tran vdout1_16ck620 FIND v(dout1_16) AT=315.025n

.meas tran vdout1_17ck620 FIND v(dout1_17) AT=315.025n

.meas tran vdout1_18ck620 FIND v(dout1_18) AT=315.025n

.meas tran vdout1_19ck620 FIND v(dout1_19) AT=315.025n

.meas tran vdout1_20ck620 FIND v(dout1_20) AT=315.025n

.meas tran vdout1_21ck620 FIND v(dout1_21) AT=315.025n

.meas tran vdout1_22ck620 FIND v(dout1_22) AT=315.025n

.meas tran vdout1_23ck620 FIND v(dout1_23) AT=315.025n

.meas tran vdout1_24ck620 FIND v(dout1_24) AT=315.025n

.meas tran vdout1_25ck620 FIND v(dout1_25) AT=315.025n

.meas tran vdout1_26ck620 FIND v(dout1_26) AT=315.025n

.meas tran vdout1_27ck620 FIND v(dout1_27) AT=315.025n

.meas tran vdout1_28ck620 FIND v(dout1_28) AT=315.025n

.meas tran vdout1_29ck620 FIND v(dout1_29) AT=315.025n

.meas tran vdout1_30ck620 FIND v(dout1_30) AT=315.025n

.meas tran vdout1_31ck620 FIND v(dout1_31) AT=315.025n

.meas tran vdout1_32ck620 FIND v(dout1_32) AT=315.025n

.meas tran vdout1_33ck620 FIND v(dout1_33) AT=315.025n

.meas tran vdout1_34ck620 FIND v(dout1_34) AT=315.025n

.meas tran vdout1_35ck620 FIND v(dout1_35) AT=315.025n

.meas tran vdout1_36ck620 FIND v(dout1_36) AT=315.025n

.meas tran vdout1_37ck620 FIND v(dout1_37) AT=315.025n

.meas tran vdout1_38ck620 FIND v(dout1_38) AT=315.025n

.meas tran vdout1_39ck620 FIND v(dout1_39) AT=315.025n

.meas tran vdout1_40ck620 FIND v(dout1_40) AT=315.025n

.meas tran vdout1_41ck620 FIND v(dout1_41) AT=315.025n

.meas tran vdout1_42ck620 FIND v(dout1_42) AT=315.025n

.meas tran vdout1_43ck620 FIND v(dout1_43) AT=315.025n

.meas tran vdout1_44ck620 FIND v(dout1_44) AT=315.025n

.meas tran vdout1_45ck620 FIND v(dout1_45) AT=315.025n

.meas tran vdout1_46ck620 FIND v(dout1_46) AT=315.025n

.meas tran vdout1_47ck620 FIND v(dout1_47) AT=315.025n

.meas tran vdout1_48ck620 FIND v(dout1_48) AT=315.025n

.meas tran vdout1_49ck620 FIND v(dout1_49) AT=315.025n

.meas tran vdout1_50ck620 FIND v(dout1_50) AT=315.025n

.meas tran vdout1_51ck620 FIND v(dout1_51) AT=315.025n

.meas tran vdout1_52ck620 FIND v(dout1_52) AT=315.025n

.meas tran vdout1_53ck620 FIND v(dout1_53) AT=315.025n

.meas tran vdout1_54ck620 FIND v(dout1_54) AT=315.025n

.meas tran vdout1_55ck620 FIND v(dout1_55) AT=315.025n

.meas tran vdout1_56ck620 FIND v(dout1_56) AT=315.025n

.meas tran vdout1_57ck620 FIND v(dout1_57) AT=315.025n

.meas tran vdout1_58ck620 FIND v(dout1_58) AT=315.025n

.meas tran vdout1_59ck620 FIND v(dout1_59) AT=315.025n

.meas tran vdout1_60ck620 FIND v(dout1_60) AT=315.025n

.meas tran vdout1_61ck620 FIND v(dout1_61) AT=315.025n

.meas tran vdout1_62ck620 FIND v(dout1_62) AT=315.025n

.meas tran vdout1_63ck620 FIND v(dout1_63) AT=315.025n

.meas tran vdout1_0ck640 FIND v(dout1_0) AT=325.025n

.meas tran vdout1_1ck640 FIND v(dout1_1) AT=325.025n

.meas tran vdout1_2ck640 FIND v(dout1_2) AT=325.025n

.meas tran vdout1_3ck640 FIND v(dout1_3) AT=325.025n

.meas tran vdout1_4ck640 FIND v(dout1_4) AT=325.025n

.meas tran vdout1_5ck640 FIND v(dout1_5) AT=325.025n

.meas tran vdout1_6ck640 FIND v(dout1_6) AT=325.025n

.meas tran vdout1_7ck640 FIND v(dout1_7) AT=325.025n

.meas tran vdout1_8ck640 FIND v(dout1_8) AT=325.025n

.meas tran vdout1_9ck640 FIND v(dout1_9) AT=325.025n

.meas tran vdout1_10ck640 FIND v(dout1_10) AT=325.025n

.meas tran vdout1_11ck640 FIND v(dout1_11) AT=325.025n

.meas tran vdout1_12ck640 FIND v(dout1_12) AT=325.025n

.meas tran vdout1_13ck640 FIND v(dout1_13) AT=325.025n

.meas tran vdout1_14ck640 FIND v(dout1_14) AT=325.025n

.meas tran vdout1_15ck640 FIND v(dout1_15) AT=325.025n

.meas tran vdout1_16ck640 FIND v(dout1_16) AT=325.025n

.meas tran vdout1_17ck640 FIND v(dout1_17) AT=325.025n

.meas tran vdout1_18ck640 FIND v(dout1_18) AT=325.025n

.meas tran vdout1_19ck640 FIND v(dout1_19) AT=325.025n

.meas tran vdout1_20ck640 FIND v(dout1_20) AT=325.025n

.meas tran vdout1_21ck640 FIND v(dout1_21) AT=325.025n

.meas tran vdout1_22ck640 FIND v(dout1_22) AT=325.025n

.meas tran vdout1_23ck640 FIND v(dout1_23) AT=325.025n

.meas tran vdout1_24ck640 FIND v(dout1_24) AT=325.025n

.meas tran vdout1_25ck640 FIND v(dout1_25) AT=325.025n

.meas tran vdout1_26ck640 FIND v(dout1_26) AT=325.025n

.meas tran vdout1_27ck640 FIND v(dout1_27) AT=325.025n

.meas tran vdout1_28ck640 FIND v(dout1_28) AT=325.025n

.meas tran vdout1_29ck640 FIND v(dout1_29) AT=325.025n

.meas tran vdout1_30ck640 FIND v(dout1_30) AT=325.025n

.meas tran vdout1_31ck640 FIND v(dout1_31) AT=325.025n

.meas tran vdout1_32ck640 FIND v(dout1_32) AT=325.025n

.meas tran vdout1_33ck640 FIND v(dout1_33) AT=325.025n

.meas tran vdout1_34ck640 FIND v(dout1_34) AT=325.025n

.meas tran vdout1_35ck640 FIND v(dout1_35) AT=325.025n

.meas tran vdout1_36ck640 FIND v(dout1_36) AT=325.025n

.meas tran vdout1_37ck640 FIND v(dout1_37) AT=325.025n

.meas tran vdout1_38ck640 FIND v(dout1_38) AT=325.025n

.meas tran vdout1_39ck640 FIND v(dout1_39) AT=325.025n

.meas tran vdout1_40ck640 FIND v(dout1_40) AT=325.025n

.meas tran vdout1_41ck640 FIND v(dout1_41) AT=325.025n

.meas tran vdout1_42ck640 FIND v(dout1_42) AT=325.025n

.meas tran vdout1_43ck640 FIND v(dout1_43) AT=325.025n

.meas tran vdout1_44ck640 FIND v(dout1_44) AT=325.025n

.meas tran vdout1_45ck640 FIND v(dout1_45) AT=325.025n

.meas tran vdout1_46ck640 FIND v(dout1_46) AT=325.025n

.meas tran vdout1_47ck640 FIND v(dout1_47) AT=325.025n

.meas tran vdout1_48ck640 FIND v(dout1_48) AT=325.025n

.meas tran vdout1_49ck640 FIND v(dout1_49) AT=325.025n

.meas tran vdout1_50ck640 FIND v(dout1_50) AT=325.025n

.meas tran vdout1_51ck640 FIND v(dout1_51) AT=325.025n

.meas tran vdout1_52ck640 FIND v(dout1_52) AT=325.025n

.meas tran vdout1_53ck640 FIND v(dout1_53) AT=325.025n

.meas tran vdout1_54ck640 FIND v(dout1_54) AT=325.025n

.meas tran vdout1_55ck640 FIND v(dout1_55) AT=325.025n

.meas tran vdout1_56ck640 FIND v(dout1_56) AT=325.025n

.meas tran vdout1_57ck640 FIND v(dout1_57) AT=325.025n

.meas tran vdout1_58ck640 FIND v(dout1_58) AT=325.025n

.meas tran vdout1_59ck640 FIND v(dout1_59) AT=325.025n

.meas tran vdout1_60ck640 FIND v(dout1_60) AT=325.025n

.meas tran vdout1_61ck640 FIND v(dout1_61) AT=325.025n

.meas tran vdout1_62ck640 FIND v(dout1_62) AT=325.025n

.meas tran vdout1_63ck640 FIND v(dout1_63) AT=325.025n

.meas tran vdout1_0ck650 FIND v(dout1_0) AT=330.025n

.meas tran vdout1_1ck650 FIND v(dout1_1) AT=330.025n

.meas tran vdout1_2ck650 FIND v(dout1_2) AT=330.025n

.meas tran vdout1_3ck650 FIND v(dout1_3) AT=330.025n

.meas tran vdout1_4ck650 FIND v(dout1_4) AT=330.025n

.meas tran vdout1_5ck650 FIND v(dout1_5) AT=330.025n

.meas tran vdout1_6ck650 FIND v(dout1_6) AT=330.025n

.meas tran vdout1_7ck650 FIND v(dout1_7) AT=330.025n

.meas tran vdout1_8ck650 FIND v(dout1_8) AT=330.025n

.meas tran vdout1_9ck650 FIND v(dout1_9) AT=330.025n

.meas tran vdout1_10ck650 FIND v(dout1_10) AT=330.025n

.meas tran vdout1_11ck650 FIND v(dout1_11) AT=330.025n

.meas tran vdout1_12ck650 FIND v(dout1_12) AT=330.025n

.meas tran vdout1_13ck650 FIND v(dout1_13) AT=330.025n

.meas tran vdout1_14ck650 FIND v(dout1_14) AT=330.025n

.meas tran vdout1_15ck650 FIND v(dout1_15) AT=330.025n

.meas tran vdout1_16ck650 FIND v(dout1_16) AT=330.025n

.meas tran vdout1_17ck650 FIND v(dout1_17) AT=330.025n

.meas tran vdout1_18ck650 FIND v(dout1_18) AT=330.025n

.meas tran vdout1_19ck650 FIND v(dout1_19) AT=330.025n

.meas tran vdout1_20ck650 FIND v(dout1_20) AT=330.025n

.meas tran vdout1_21ck650 FIND v(dout1_21) AT=330.025n

.meas tran vdout1_22ck650 FIND v(dout1_22) AT=330.025n

.meas tran vdout1_23ck650 FIND v(dout1_23) AT=330.025n

.meas tran vdout1_24ck650 FIND v(dout1_24) AT=330.025n

.meas tran vdout1_25ck650 FIND v(dout1_25) AT=330.025n

.meas tran vdout1_26ck650 FIND v(dout1_26) AT=330.025n

.meas tran vdout1_27ck650 FIND v(dout1_27) AT=330.025n

.meas tran vdout1_28ck650 FIND v(dout1_28) AT=330.025n

.meas tran vdout1_29ck650 FIND v(dout1_29) AT=330.025n

.meas tran vdout1_30ck650 FIND v(dout1_30) AT=330.025n

.meas tran vdout1_31ck650 FIND v(dout1_31) AT=330.025n

.meas tran vdout1_32ck650 FIND v(dout1_32) AT=330.025n

.meas tran vdout1_33ck650 FIND v(dout1_33) AT=330.025n

.meas tran vdout1_34ck650 FIND v(dout1_34) AT=330.025n

.meas tran vdout1_35ck650 FIND v(dout1_35) AT=330.025n

.meas tran vdout1_36ck650 FIND v(dout1_36) AT=330.025n

.meas tran vdout1_37ck650 FIND v(dout1_37) AT=330.025n

.meas tran vdout1_38ck650 FIND v(dout1_38) AT=330.025n

.meas tran vdout1_39ck650 FIND v(dout1_39) AT=330.025n

.meas tran vdout1_40ck650 FIND v(dout1_40) AT=330.025n

.meas tran vdout1_41ck650 FIND v(dout1_41) AT=330.025n

.meas tran vdout1_42ck650 FIND v(dout1_42) AT=330.025n

.meas tran vdout1_43ck650 FIND v(dout1_43) AT=330.025n

.meas tran vdout1_44ck650 FIND v(dout1_44) AT=330.025n

.meas tran vdout1_45ck650 FIND v(dout1_45) AT=330.025n

.meas tran vdout1_46ck650 FIND v(dout1_46) AT=330.025n

.meas tran vdout1_47ck650 FIND v(dout1_47) AT=330.025n

.meas tran vdout1_48ck650 FIND v(dout1_48) AT=330.025n

.meas tran vdout1_49ck650 FIND v(dout1_49) AT=330.025n

.meas tran vdout1_50ck650 FIND v(dout1_50) AT=330.025n

.meas tran vdout1_51ck650 FIND v(dout1_51) AT=330.025n

.meas tran vdout1_52ck650 FIND v(dout1_52) AT=330.025n

.meas tran vdout1_53ck650 FIND v(dout1_53) AT=330.025n

.meas tran vdout1_54ck650 FIND v(dout1_54) AT=330.025n

.meas tran vdout1_55ck650 FIND v(dout1_55) AT=330.025n

.meas tran vdout1_56ck650 FIND v(dout1_56) AT=330.025n

.meas tran vdout1_57ck650 FIND v(dout1_57) AT=330.025n

.meas tran vdout1_58ck650 FIND v(dout1_58) AT=330.025n

.meas tran vdout1_59ck650 FIND v(dout1_59) AT=330.025n

.meas tran vdout1_60ck650 FIND v(dout1_60) AT=330.025n

.meas tran vdout1_61ck650 FIND v(dout1_61) AT=330.025n

.meas tran vdout1_62ck650 FIND v(dout1_62) AT=330.025n

.meas tran vdout1_63ck650 FIND v(dout1_63) AT=330.025n

.meas tran vdout0_0ck680 FIND v(dout0_0) AT=345.025n

.meas tran vdout0_1ck680 FIND v(dout0_1) AT=345.025n

.meas tran vdout0_2ck680 FIND v(dout0_2) AT=345.025n

.meas tran vdout0_3ck680 FIND v(dout0_3) AT=345.025n

.meas tran vdout0_4ck680 FIND v(dout0_4) AT=345.025n

.meas tran vdout0_5ck680 FIND v(dout0_5) AT=345.025n

.meas tran vdout0_6ck680 FIND v(dout0_6) AT=345.025n

.meas tran vdout0_7ck680 FIND v(dout0_7) AT=345.025n

.meas tran vdout0_8ck680 FIND v(dout0_8) AT=345.025n

.meas tran vdout0_9ck680 FIND v(dout0_9) AT=345.025n

.meas tran vdout0_10ck680 FIND v(dout0_10) AT=345.025n

.meas tran vdout0_11ck680 FIND v(dout0_11) AT=345.025n

.meas tran vdout0_12ck680 FIND v(dout0_12) AT=345.025n

.meas tran vdout0_13ck680 FIND v(dout0_13) AT=345.025n

.meas tran vdout0_14ck680 FIND v(dout0_14) AT=345.025n

.meas tran vdout0_15ck680 FIND v(dout0_15) AT=345.025n

.meas tran vdout0_16ck680 FIND v(dout0_16) AT=345.025n

.meas tran vdout0_17ck680 FIND v(dout0_17) AT=345.025n

.meas tran vdout0_18ck680 FIND v(dout0_18) AT=345.025n

.meas tran vdout0_19ck680 FIND v(dout0_19) AT=345.025n

.meas tran vdout0_20ck680 FIND v(dout0_20) AT=345.025n

.meas tran vdout0_21ck680 FIND v(dout0_21) AT=345.025n

.meas tran vdout0_22ck680 FIND v(dout0_22) AT=345.025n

.meas tran vdout0_23ck680 FIND v(dout0_23) AT=345.025n

.meas tran vdout0_24ck680 FIND v(dout0_24) AT=345.025n

.meas tran vdout0_25ck680 FIND v(dout0_25) AT=345.025n

.meas tran vdout0_26ck680 FIND v(dout0_26) AT=345.025n

.meas tran vdout0_27ck680 FIND v(dout0_27) AT=345.025n

.meas tran vdout0_28ck680 FIND v(dout0_28) AT=345.025n

.meas tran vdout0_29ck680 FIND v(dout0_29) AT=345.025n

.meas tran vdout0_30ck680 FIND v(dout0_30) AT=345.025n

.meas tran vdout0_31ck680 FIND v(dout0_31) AT=345.025n

.meas tran vdout0_32ck680 FIND v(dout0_32) AT=345.025n

.meas tran vdout0_33ck680 FIND v(dout0_33) AT=345.025n

.meas tran vdout0_34ck680 FIND v(dout0_34) AT=345.025n

.meas tran vdout0_35ck680 FIND v(dout0_35) AT=345.025n

.meas tran vdout0_36ck680 FIND v(dout0_36) AT=345.025n

.meas tran vdout0_37ck680 FIND v(dout0_37) AT=345.025n

.meas tran vdout0_38ck680 FIND v(dout0_38) AT=345.025n

.meas tran vdout0_39ck680 FIND v(dout0_39) AT=345.025n

.meas tran vdout0_40ck680 FIND v(dout0_40) AT=345.025n

.meas tran vdout0_41ck680 FIND v(dout0_41) AT=345.025n

.meas tran vdout0_42ck680 FIND v(dout0_42) AT=345.025n

.meas tran vdout0_43ck680 FIND v(dout0_43) AT=345.025n

.meas tran vdout0_44ck680 FIND v(dout0_44) AT=345.025n

.meas tran vdout0_45ck680 FIND v(dout0_45) AT=345.025n

.meas tran vdout0_46ck680 FIND v(dout0_46) AT=345.025n

.meas tran vdout0_47ck680 FIND v(dout0_47) AT=345.025n

.meas tran vdout0_48ck680 FIND v(dout0_48) AT=345.025n

.meas tran vdout0_49ck680 FIND v(dout0_49) AT=345.025n

.meas tran vdout0_50ck680 FIND v(dout0_50) AT=345.025n

.meas tran vdout0_51ck680 FIND v(dout0_51) AT=345.025n

.meas tran vdout0_52ck680 FIND v(dout0_52) AT=345.025n

.meas tran vdout0_53ck680 FIND v(dout0_53) AT=345.025n

.meas tran vdout0_54ck680 FIND v(dout0_54) AT=345.025n

.meas tran vdout0_55ck680 FIND v(dout0_55) AT=345.025n

.meas tran vdout0_56ck680 FIND v(dout0_56) AT=345.025n

.meas tran vdout0_57ck680 FIND v(dout0_57) AT=345.025n

.meas tran vdout0_58ck680 FIND v(dout0_58) AT=345.025n

.meas tran vdout0_59ck680 FIND v(dout0_59) AT=345.025n

.meas tran vdout0_60ck680 FIND v(dout0_60) AT=345.025n

.meas tran vdout0_61ck680 FIND v(dout0_61) AT=345.025n

.meas tran vdout0_62ck680 FIND v(dout0_62) AT=345.025n

.meas tran vdout0_63ck680 FIND v(dout0_63) AT=345.025n

.meas tran vdout1_0ck680 FIND v(dout1_0) AT=345.025n

.meas tran vdout1_1ck680 FIND v(dout1_1) AT=345.025n

.meas tran vdout1_2ck680 FIND v(dout1_2) AT=345.025n

.meas tran vdout1_3ck680 FIND v(dout1_3) AT=345.025n

.meas tran vdout1_4ck680 FIND v(dout1_4) AT=345.025n

.meas tran vdout1_5ck680 FIND v(dout1_5) AT=345.025n

.meas tran vdout1_6ck680 FIND v(dout1_6) AT=345.025n

.meas tran vdout1_7ck680 FIND v(dout1_7) AT=345.025n

.meas tran vdout1_8ck680 FIND v(dout1_8) AT=345.025n

.meas tran vdout1_9ck680 FIND v(dout1_9) AT=345.025n

.meas tran vdout1_10ck680 FIND v(dout1_10) AT=345.025n

.meas tran vdout1_11ck680 FIND v(dout1_11) AT=345.025n

.meas tran vdout1_12ck680 FIND v(dout1_12) AT=345.025n

.meas tran vdout1_13ck680 FIND v(dout1_13) AT=345.025n

.meas tran vdout1_14ck680 FIND v(dout1_14) AT=345.025n

.meas tran vdout1_15ck680 FIND v(dout1_15) AT=345.025n

.meas tran vdout1_16ck680 FIND v(dout1_16) AT=345.025n

.meas tran vdout1_17ck680 FIND v(dout1_17) AT=345.025n

.meas tran vdout1_18ck680 FIND v(dout1_18) AT=345.025n

.meas tran vdout1_19ck680 FIND v(dout1_19) AT=345.025n

.meas tran vdout1_20ck680 FIND v(dout1_20) AT=345.025n

.meas tran vdout1_21ck680 FIND v(dout1_21) AT=345.025n

.meas tran vdout1_22ck680 FIND v(dout1_22) AT=345.025n

.meas tran vdout1_23ck680 FIND v(dout1_23) AT=345.025n

.meas tran vdout1_24ck680 FIND v(dout1_24) AT=345.025n

.meas tran vdout1_25ck680 FIND v(dout1_25) AT=345.025n

.meas tran vdout1_26ck680 FIND v(dout1_26) AT=345.025n

.meas tran vdout1_27ck680 FIND v(dout1_27) AT=345.025n

.meas tran vdout1_28ck680 FIND v(dout1_28) AT=345.025n

.meas tran vdout1_29ck680 FIND v(dout1_29) AT=345.025n

.meas tran vdout1_30ck680 FIND v(dout1_30) AT=345.025n

.meas tran vdout1_31ck680 FIND v(dout1_31) AT=345.025n

.meas tran vdout1_32ck680 FIND v(dout1_32) AT=345.025n

.meas tran vdout1_33ck680 FIND v(dout1_33) AT=345.025n

.meas tran vdout1_34ck680 FIND v(dout1_34) AT=345.025n

.meas tran vdout1_35ck680 FIND v(dout1_35) AT=345.025n

.meas tran vdout1_36ck680 FIND v(dout1_36) AT=345.025n

.meas tran vdout1_37ck680 FIND v(dout1_37) AT=345.025n

.meas tran vdout1_38ck680 FIND v(dout1_38) AT=345.025n

.meas tran vdout1_39ck680 FIND v(dout1_39) AT=345.025n

.meas tran vdout1_40ck680 FIND v(dout1_40) AT=345.025n

.meas tran vdout1_41ck680 FIND v(dout1_41) AT=345.025n

.meas tran vdout1_42ck680 FIND v(dout1_42) AT=345.025n

.meas tran vdout1_43ck680 FIND v(dout1_43) AT=345.025n

.meas tran vdout1_44ck680 FIND v(dout1_44) AT=345.025n

.meas tran vdout1_45ck680 FIND v(dout1_45) AT=345.025n

.meas tran vdout1_46ck680 FIND v(dout1_46) AT=345.025n

.meas tran vdout1_47ck680 FIND v(dout1_47) AT=345.025n

.meas tran vdout1_48ck680 FIND v(dout1_48) AT=345.025n

.meas tran vdout1_49ck680 FIND v(dout1_49) AT=345.025n

.meas tran vdout1_50ck680 FIND v(dout1_50) AT=345.025n

.meas tran vdout1_51ck680 FIND v(dout1_51) AT=345.025n

.meas tran vdout1_52ck680 FIND v(dout1_52) AT=345.025n

.meas tran vdout1_53ck680 FIND v(dout1_53) AT=345.025n

.meas tran vdout1_54ck680 FIND v(dout1_54) AT=345.025n

.meas tran vdout1_55ck680 FIND v(dout1_55) AT=345.025n

.meas tran vdout1_56ck680 FIND v(dout1_56) AT=345.025n

.meas tran vdout1_57ck680 FIND v(dout1_57) AT=345.025n

.meas tran vdout1_58ck680 FIND v(dout1_58) AT=345.025n

.meas tran vdout1_59ck680 FIND v(dout1_59) AT=345.025n

.meas tran vdout1_60ck680 FIND v(dout1_60) AT=345.025n

.meas tran vdout1_61ck680 FIND v(dout1_61) AT=345.025n

.meas tran vdout1_62ck680 FIND v(dout1_62) AT=345.025n

.meas tran vdout1_63ck680 FIND v(dout1_63) AT=345.025n

.meas tran vdout0_0ck690 FIND v(dout0_0) AT=350.025n

.meas tran vdout0_1ck690 FIND v(dout0_1) AT=350.025n

.meas tran vdout0_2ck690 FIND v(dout0_2) AT=350.025n

.meas tran vdout0_3ck690 FIND v(dout0_3) AT=350.025n

.meas tran vdout0_4ck690 FIND v(dout0_4) AT=350.025n

.meas tran vdout0_5ck690 FIND v(dout0_5) AT=350.025n

.meas tran vdout0_6ck690 FIND v(dout0_6) AT=350.025n

.meas tran vdout0_7ck690 FIND v(dout0_7) AT=350.025n

.meas tran vdout0_8ck690 FIND v(dout0_8) AT=350.025n

.meas tran vdout0_9ck690 FIND v(dout0_9) AT=350.025n

.meas tran vdout0_10ck690 FIND v(dout0_10) AT=350.025n

.meas tran vdout0_11ck690 FIND v(dout0_11) AT=350.025n

.meas tran vdout0_12ck690 FIND v(dout0_12) AT=350.025n

.meas tran vdout0_13ck690 FIND v(dout0_13) AT=350.025n

.meas tran vdout0_14ck690 FIND v(dout0_14) AT=350.025n

.meas tran vdout0_15ck690 FIND v(dout0_15) AT=350.025n

.meas tran vdout0_16ck690 FIND v(dout0_16) AT=350.025n

.meas tran vdout0_17ck690 FIND v(dout0_17) AT=350.025n

.meas tran vdout0_18ck690 FIND v(dout0_18) AT=350.025n

.meas tran vdout0_19ck690 FIND v(dout0_19) AT=350.025n

.meas tran vdout0_20ck690 FIND v(dout0_20) AT=350.025n

.meas tran vdout0_21ck690 FIND v(dout0_21) AT=350.025n

.meas tran vdout0_22ck690 FIND v(dout0_22) AT=350.025n

.meas tran vdout0_23ck690 FIND v(dout0_23) AT=350.025n

.meas tran vdout0_24ck690 FIND v(dout0_24) AT=350.025n

.meas tran vdout0_25ck690 FIND v(dout0_25) AT=350.025n

.meas tran vdout0_26ck690 FIND v(dout0_26) AT=350.025n

.meas tran vdout0_27ck690 FIND v(dout0_27) AT=350.025n

.meas tran vdout0_28ck690 FIND v(dout0_28) AT=350.025n

.meas tran vdout0_29ck690 FIND v(dout0_29) AT=350.025n

.meas tran vdout0_30ck690 FIND v(dout0_30) AT=350.025n

.meas tran vdout0_31ck690 FIND v(dout0_31) AT=350.025n

.meas tran vdout0_32ck690 FIND v(dout0_32) AT=350.025n

.meas tran vdout0_33ck690 FIND v(dout0_33) AT=350.025n

.meas tran vdout0_34ck690 FIND v(dout0_34) AT=350.025n

.meas tran vdout0_35ck690 FIND v(dout0_35) AT=350.025n

.meas tran vdout0_36ck690 FIND v(dout0_36) AT=350.025n

.meas tran vdout0_37ck690 FIND v(dout0_37) AT=350.025n

.meas tran vdout0_38ck690 FIND v(dout0_38) AT=350.025n

.meas tran vdout0_39ck690 FIND v(dout0_39) AT=350.025n

.meas tran vdout0_40ck690 FIND v(dout0_40) AT=350.025n

.meas tran vdout0_41ck690 FIND v(dout0_41) AT=350.025n

.meas tran vdout0_42ck690 FIND v(dout0_42) AT=350.025n

.meas tran vdout0_43ck690 FIND v(dout0_43) AT=350.025n

.meas tran vdout0_44ck690 FIND v(dout0_44) AT=350.025n

.meas tran vdout0_45ck690 FIND v(dout0_45) AT=350.025n

.meas tran vdout0_46ck690 FIND v(dout0_46) AT=350.025n

.meas tran vdout0_47ck690 FIND v(dout0_47) AT=350.025n

.meas tran vdout0_48ck690 FIND v(dout0_48) AT=350.025n

.meas tran vdout0_49ck690 FIND v(dout0_49) AT=350.025n

.meas tran vdout0_50ck690 FIND v(dout0_50) AT=350.025n

.meas tran vdout0_51ck690 FIND v(dout0_51) AT=350.025n

.meas tran vdout0_52ck690 FIND v(dout0_52) AT=350.025n

.meas tran vdout0_53ck690 FIND v(dout0_53) AT=350.025n

.meas tran vdout0_54ck690 FIND v(dout0_54) AT=350.025n

.meas tran vdout0_55ck690 FIND v(dout0_55) AT=350.025n

.meas tran vdout0_56ck690 FIND v(dout0_56) AT=350.025n

.meas tran vdout0_57ck690 FIND v(dout0_57) AT=350.025n

.meas tran vdout0_58ck690 FIND v(dout0_58) AT=350.025n

.meas tran vdout0_59ck690 FIND v(dout0_59) AT=350.025n

.meas tran vdout0_60ck690 FIND v(dout0_60) AT=350.025n

.meas tran vdout0_61ck690 FIND v(dout0_61) AT=350.025n

.meas tran vdout0_62ck690 FIND v(dout0_62) AT=350.025n

.meas tran vdout0_63ck690 FIND v(dout0_63) AT=350.025n

.meas tran vdout1_0ck690 FIND v(dout1_0) AT=350.025n

.meas tran vdout1_1ck690 FIND v(dout1_1) AT=350.025n

.meas tran vdout1_2ck690 FIND v(dout1_2) AT=350.025n

.meas tran vdout1_3ck690 FIND v(dout1_3) AT=350.025n

.meas tran vdout1_4ck690 FIND v(dout1_4) AT=350.025n

.meas tran vdout1_5ck690 FIND v(dout1_5) AT=350.025n

.meas tran vdout1_6ck690 FIND v(dout1_6) AT=350.025n

.meas tran vdout1_7ck690 FIND v(dout1_7) AT=350.025n

.meas tran vdout1_8ck690 FIND v(dout1_8) AT=350.025n

.meas tran vdout1_9ck690 FIND v(dout1_9) AT=350.025n

.meas tran vdout1_10ck690 FIND v(dout1_10) AT=350.025n

.meas tran vdout1_11ck690 FIND v(dout1_11) AT=350.025n

.meas tran vdout1_12ck690 FIND v(dout1_12) AT=350.025n

.meas tran vdout1_13ck690 FIND v(dout1_13) AT=350.025n

.meas tran vdout1_14ck690 FIND v(dout1_14) AT=350.025n

.meas tran vdout1_15ck690 FIND v(dout1_15) AT=350.025n

.meas tran vdout1_16ck690 FIND v(dout1_16) AT=350.025n

.meas tran vdout1_17ck690 FIND v(dout1_17) AT=350.025n

.meas tran vdout1_18ck690 FIND v(dout1_18) AT=350.025n

.meas tran vdout1_19ck690 FIND v(dout1_19) AT=350.025n

.meas tran vdout1_20ck690 FIND v(dout1_20) AT=350.025n

.meas tran vdout1_21ck690 FIND v(dout1_21) AT=350.025n

.meas tran vdout1_22ck690 FIND v(dout1_22) AT=350.025n

.meas tran vdout1_23ck690 FIND v(dout1_23) AT=350.025n

.meas tran vdout1_24ck690 FIND v(dout1_24) AT=350.025n

.meas tran vdout1_25ck690 FIND v(dout1_25) AT=350.025n

.meas tran vdout1_26ck690 FIND v(dout1_26) AT=350.025n

.meas tran vdout1_27ck690 FIND v(dout1_27) AT=350.025n

.meas tran vdout1_28ck690 FIND v(dout1_28) AT=350.025n

.meas tran vdout1_29ck690 FIND v(dout1_29) AT=350.025n

.meas tran vdout1_30ck690 FIND v(dout1_30) AT=350.025n

.meas tran vdout1_31ck690 FIND v(dout1_31) AT=350.025n

.meas tran vdout1_32ck690 FIND v(dout1_32) AT=350.025n

.meas tran vdout1_33ck690 FIND v(dout1_33) AT=350.025n

.meas tran vdout1_34ck690 FIND v(dout1_34) AT=350.025n

.meas tran vdout1_35ck690 FIND v(dout1_35) AT=350.025n

.meas tran vdout1_36ck690 FIND v(dout1_36) AT=350.025n

.meas tran vdout1_37ck690 FIND v(dout1_37) AT=350.025n

.meas tran vdout1_38ck690 FIND v(dout1_38) AT=350.025n

.meas tran vdout1_39ck690 FIND v(dout1_39) AT=350.025n

.meas tran vdout1_40ck690 FIND v(dout1_40) AT=350.025n

.meas tran vdout1_41ck690 FIND v(dout1_41) AT=350.025n

.meas tran vdout1_42ck690 FIND v(dout1_42) AT=350.025n

.meas tran vdout1_43ck690 FIND v(dout1_43) AT=350.025n

.meas tran vdout1_44ck690 FIND v(dout1_44) AT=350.025n

.meas tran vdout1_45ck690 FIND v(dout1_45) AT=350.025n

.meas tran vdout1_46ck690 FIND v(dout1_46) AT=350.025n

.meas tran vdout1_47ck690 FIND v(dout1_47) AT=350.025n

.meas tran vdout1_48ck690 FIND v(dout1_48) AT=350.025n

.meas tran vdout1_49ck690 FIND v(dout1_49) AT=350.025n

.meas tran vdout1_50ck690 FIND v(dout1_50) AT=350.025n

.meas tran vdout1_51ck690 FIND v(dout1_51) AT=350.025n

.meas tran vdout1_52ck690 FIND v(dout1_52) AT=350.025n

.meas tran vdout1_53ck690 FIND v(dout1_53) AT=350.025n

.meas tran vdout1_54ck690 FIND v(dout1_54) AT=350.025n

.meas tran vdout1_55ck690 FIND v(dout1_55) AT=350.025n

.meas tran vdout1_56ck690 FIND v(dout1_56) AT=350.025n

.meas tran vdout1_57ck690 FIND v(dout1_57) AT=350.025n

.meas tran vdout1_58ck690 FIND v(dout1_58) AT=350.025n

.meas tran vdout1_59ck690 FIND v(dout1_59) AT=350.025n

.meas tran vdout1_60ck690 FIND v(dout1_60) AT=350.025n

.meas tran vdout1_61ck690 FIND v(dout1_61) AT=350.025n

.meas tran vdout1_62ck690 FIND v(dout1_62) AT=350.025n

.meas tran vdout1_63ck690 FIND v(dout1_63) AT=350.025n

.meas tran vdout1_0ck700 FIND v(dout1_0) AT=355.025n

.meas tran vdout1_1ck700 FIND v(dout1_1) AT=355.025n

.meas tran vdout1_2ck700 FIND v(dout1_2) AT=355.025n

.meas tran vdout1_3ck700 FIND v(dout1_3) AT=355.025n

.meas tran vdout1_4ck700 FIND v(dout1_4) AT=355.025n

.meas tran vdout1_5ck700 FIND v(dout1_5) AT=355.025n

.meas tran vdout1_6ck700 FIND v(dout1_6) AT=355.025n

.meas tran vdout1_7ck700 FIND v(dout1_7) AT=355.025n

.meas tran vdout1_8ck700 FIND v(dout1_8) AT=355.025n

.meas tran vdout1_9ck700 FIND v(dout1_9) AT=355.025n

.meas tran vdout1_10ck700 FIND v(dout1_10) AT=355.025n

.meas tran vdout1_11ck700 FIND v(dout1_11) AT=355.025n

.meas tran vdout1_12ck700 FIND v(dout1_12) AT=355.025n

.meas tran vdout1_13ck700 FIND v(dout1_13) AT=355.025n

.meas tran vdout1_14ck700 FIND v(dout1_14) AT=355.025n

.meas tran vdout1_15ck700 FIND v(dout1_15) AT=355.025n

.meas tran vdout1_16ck700 FIND v(dout1_16) AT=355.025n

.meas tran vdout1_17ck700 FIND v(dout1_17) AT=355.025n

.meas tran vdout1_18ck700 FIND v(dout1_18) AT=355.025n

.meas tran vdout1_19ck700 FIND v(dout1_19) AT=355.025n

.meas tran vdout1_20ck700 FIND v(dout1_20) AT=355.025n

.meas tran vdout1_21ck700 FIND v(dout1_21) AT=355.025n

.meas tran vdout1_22ck700 FIND v(dout1_22) AT=355.025n

.meas tran vdout1_23ck700 FIND v(dout1_23) AT=355.025n

.meas tran vdout1_24ck700 FIND v(dout1_24) AT=355.025n

.meas tran vdout1_25ck700 FIND v(dout1_25) AT=355.025n

.meas tran vdout1_26ck700 FIND v(dout1_26) AT=355.025n

.meas tran vdout1_27ck700 FIND v(dout1_27) AT=355.025n

.meas tran vdout1_28ck700 FIND v(dout1_28) AT=355.025n

.meas tran vdout1_29ck700 FIND v(dout1_29) AT=355.025n

.meas tran vdout1_30ck700 FIND v(dout1_30) AT=355.025n

.meas tran vdout1_31ck700 FIND v(dout1_31) AT=355.025n

.meas tran vdout1_32ck700 FIND v(dout1_32) AT=355.025n

.meas tran vdout1_33ck700 FIND v(dout1_33) AT=355.025n

.meas tran vdout1_34ck700 FIND v(dout1_34) AT=355.025n

.meas tran vdout1_35ck700 FIND v(dout1_35) AT=355.025n

.meas tran vdout1_36ck700 FIND v(dout1_36) AT=355.025n

.meas tran vdout1_37ck700 FIND v(dout1_37) AT=355.025n

.meas tran vdout1_38ck700 FIND v(dout1_38) AT=355.025n

.meas tran vdout1_39ck700 FIND v(dout1_39) AT=355.025n

.meas tran vdout1_40ck700 FIND v(dout1_40) AT=355.025n

.meas tran vdout1_41ck700 FIND v(dout1_41) AT=355.025n

.meas tran vdout1_42ck700 FIND v(dout1_42) AT=355.025n

.meas tran vdout1_43ck700 FIND v(dout1_43) AT=355.025n

.meas tran vdout1_44ck700 FIND v(dout1_44) AT=355.025n

.meas tran vdout1_45ck700 FIND v(dout1_45) AT=355.025n

.meas tran vdout1_46ck700 FIND v(dout1_46) AT=355.025n

.meas tran vdout1_47ck700 FIND v(dout1_47) AT=355.025n

.meas tran vdout1_48ck700 FIND v(dout1_48) AT=355.025n

.meas tran vdout1_49ck700 FIND v(dout1_49) AT=355.025n

.meas tran vdout1_50ck700 FIND v(dout1_50) AT=355.025n

.meas tran vdout1_51ck700 FIND v(dout1_51) AT=355.025n

.meas tran vdout1_52ck700 FIND v(dout1_52) AT=355.025n

.meas tran vdout1_53ck700 FIND v(dout1_53) AT=355.025n

.meas tran vdout1_54ck700 FIND v(dout1_54) AT=355.025n

.meas tran vdout1_55ck700 FIND v(dout1_55) AT=355.025n

.meas tran vdout1_56ck700 FIND v(dout1_56) AT=355.025n

.meas tran vdout1_57ck700 FIND v(dout1_57) AT=355.025n

.meas tran vdout1_58ck700 FIND v(dout1_58) AT=355.025n

.meas tran vdout1_59ck700 FIND v(dout1_59) AT=355.025n

.meas tran vdout1_60ck700 FIND v(dout1_60) AT=355.025n

.meas tran vdout1_61ck700 FIND v(dout1_61) AT=355.025n

.meas tran vdout1_62ck700 FIND v(dout1_62) AT=355.025n

.meas tran vdout1_63ck700 FIND v(dout1_63) AT=355.025n

.meas tran vdout1_0ck710 FIND v(dout1_0) AT=360.025n

.meas tran vdout1_1ck710 FIND v(dout1_1) AT=360.025n

.meas tran vdout1_2ck710 FIND v(dout1_2) AT=360.025n

.meas tran vdout1_3ck710 FIND v(dout1_3) AT=360.025n

.meas tran vdout1_4ck710 FIND v(dout1_4) AT=360.025n

.meas tran vdout1_5ck710 FIND v(dout1_5) AT=360.025n

.meas tran vdout1_6ck710 FIND v(dout1_6) AT=360.025n

.meas tran vdout1_7ck710 FIND v(dout1_7) AT=360.025n

.meas tran vdout1_8ck710 FIND v(dout1_8) AT=360.025n

.meas tran vdout1_9ck710 FIND v(dout1_9) AT=360.025n

.meas tran vdout1_10ck710 FIND v(dout1_10) AT=360.025n

.meas tran vdout1_11ck710 FIND v(dout1_11) AT=360.025n

.meas tran vdout1_12ck710 FIND v(dout1_12) AT=360.025n

.meas tran vdout1_13ck710 FIND v(dout1_13) AT=360.025n

.meas tran vdout1_14ck710 FIND v(dout1_14) AT=360.025n

.meas tran vdout1_15ck710 FIND v(dout1_15) AT=360.025n

.meas tran vdout1_16ck710 FIND v(dout1_16) AT=360.025n

.meas tran vdout1_17ck710 FIND v(dout1_17) AT=360.025n

.meas tran vdout1_18ck710 FIND v(dout1_18) AT=360.025n

.meas tran vdout1_19ck710 FIND v(dout1_19) AT=360.025n

.meas tran vdout1_20ck710 FIND v(dout1_20) AT=360.025n

.meas tran vdout1_21ck710 FIND v(dout1_21) AT=360.025n

.meas tran vdout1_22ck710 FIND v(dout1_22) AT=360.025n

.meas tran vdout1_23ck710 FIND v(dout1_23) AT=360.025n

.meas tran vdout1_24ck710 FIND v(dout1_24) AT=360.025n

.meas tran vdout1_25ck710 FIND v(dout1_25) AT=360.025n

.meas tran vdout1_26ck710 FIND v(dout1_26) AT=360.025n

.meas tran vdout1_27ck710 FIND v(dout1_27) AT=360.025n

.meas tran vdout1_28ck710 FIND v(dout1_28) AT=360.025n

.meas tran vdout1_29ck710 FIND v(dout1_29) AT=360.025n

.meas tran vdout1_30ck710 FIND v(dout1_30) AT=360.025n

.meas tran vdout1_31ck710 FIND v(dout1_31) AT=360.025n

.meas tran vdout1_32ck710 FIND v(dout1_32) AT=360.025n

.meas tran vdout1_33ck710 FIND v(dout1_33) AT=360.025n

.meas tran vdout1_34ck710 FIND v(dout1_34) AT=360.025n

.meas tran vdout1_35ck710 FIND v(dout1_35) AT=360.025n

.meas tran vdout1_36ck710 FIND v(dout1_36) AT=360.025n

.meas tran vdout1_37ck710 FIND v(dout1_37) AT=360.025n

.meas tran vdout1_38ck710 FIND v(dout1_38) AT=360.025n

.meas tran vdout1_39ck710 FIND v(dout1_39) AT=360.025n

.meas tran vdout1_40ck710 FIND v(dout1_40) AT=360.025n

.meas tran vdout1_41ck710 FIND v(dout1_41) AT=360.025n

.meas tran vdout1_42ck710 FIND v(dout1_42) AT=360.025n

.meas tran vdout1_43ck710 FIND v(dout1_43) AT=360.025n

.meas tran vdout1_44ck710 FIND v(dout1_44) AT=360.025n

.meas tran vdout1_45ck710 FIND v(dout1_45) AT=360.025n

.meas tran vdout1_46ck710 FIND v(dout1_46) AT=360.025n

.meas tran vdout1_47ck710 FIND v(dout1_47) AT=360.025n

.meas tran vdout1_48ck710 FIND v(dout1_48) AT=360.025n

.meas tran vdout1_49ck710 FIND v(dout1_49) AT=360.025n

.meas tran vdout1_50ck710 FIND v(dout1_50) AT=360.025n

.meas tran vdout1_51ck710 FIND v(dout1_51) AT=360.025n

.meas tran vdout1_52ck710 FIND v(dout1_52) AT=360.025n

.meas tran vdout1_53ck710 FIND v(dout1_53) AT=360.025n

.meas tran vdout1_54ck710 FIND v(dout1_54) AT=360.025n

.meas tran vdout1_55ck710 FIND v(dout1_55) AT=360.025n

.meas tran vdout1_56ck710 FIND v(dout1_56) AT=360.025n

.meas tran vdout1_57ck710 FIND v(dout1_57) AT=360.025n

.meas tran vdout1_58ck710 FIND v(dout1_58) AT=360.025n

.meas tran vdout1_59ck710 FIND v(dout1_59) AT=360.025n

.meas tran vdout1_60ck710 FIND v(dout1_60) AT=360.025n

.meas tran vdout1_61ck710 FIND v(dout1_61) AT=360.025n

.meas tran vdout1_62ck710 FIND v(dout1_62) AT=360.025n

.meas tran vdout1_63ck710 FIND v(dout1_63) AT=360.025n

.meas tran vdout1_0ck720 FIND v(dout1_0) AT=365.025n

.meas tran vdout1_1ck720 FIND v(dout1_1) AT=365.025n

.meas tran vdout1_2ck720 FIND v(dout1_2) AT=365.025n

.meas tran vdout1_3ck720 FIND v(dout1_3) AT=365.025n

.meas tran vdout1_4ck720 FIND v(dout1_4) AT=365.025n

.meas tran vdout1_5ck720 FIND v(dout1_5) AT=365.025n

.meas tran vdout1_6ck720 FIND v(dout1_6) AT=365.025n

.meas tran vdout1_7ck720 FIND v(dout1_7) AT=365.025n

.meas tran vdout1_8ck720 FIND v(dout1_8) AT=365.025n

.meas tran vdout1_9ck720 FIND v(dout1_9) AT=365.025n

.meas tran vdout1_10ck720 FIND v(dout1_10) AT=365.025n

.meas tran vdout1_11ck720 FIND v(dout1_11) AT=365.025n

.meas tran vdout1_12ck720 FIND v(dout1_12) AT=365.025n

.meas tran vdout1_13ck720 FIND v(dout1_13) AT=365.025n

.meas tran vdout1_14ck720 FIND v(dout1_14) AT=365.025n

.meas tran vdout1_15ck720 FIND v(dout1_15) AT=365.025n

.meas tran vdout1_16ck720 FIND v(dout1_16) AT=365.025n

.meas tran vdout1_17ck720 FIND v(dout1_17) AT=365.025n

.meas tran vdout1_18ck720 FIND v(dout1_18) AT=365.025n

.meas tran vdout1_19ck720 FIND v(dout1_19) AT=365.025n

.meas tran vdout1_20ck720 FIND v(dout1_20) AT=365.025n

.meas tran vdout1_21ck720 FIND v(dout1_21) AT=365.025n

.meas tran vdout1_22ck720 FIND v(dout1_22) AT=365.025n

.meas tran vdout1_23ck720 FIND v(dout1_23) AT=365.025n

.meas tran vdout1_24ck720 FIND v(dout1_24) AT=365.025n

.meas tran vdout1_25ck720 FIND v(dout1_25) AT=365.025n

.meas tran vdout1_26ck720 FIND v(dout1_26) AT=365.025n

.meas tran vdout1_27ck720 FIND v(dout1_27) AT=365.025n

.meas tran vdout1_28ck720 FIND v(dout1_28) AT=365.025n

.meas tran vdout1_29ck720 FIND v(dout1_29) AT=365.025n

.meas tran vdout1_30ck720 FIND v(dout1_30) AT=365.025n

.meas tran vdout1_31ck720 FIND v(dout1_31) AT=365.025n

.meas tran vdout1_32ck720 FIND v(dout1_32) AT=365.025n

.meas tran vdout1_33ck720 FIND v(dout1_33) AT=365.025n

.meas tran vdout1_34ck720 FIND v(dout1_34) AT=365.025n

.meas tran vdout1_35ck720 FIND v(dout1_35) AT=365.025n

.meas tran vdout1_36ck720 FIND v(dout1_36) AT=365.025n

.meas tran vdout1_37ck720 FIND v(dout1_37) AT=365.025n

.meas tran vdout1_38ck720 FIND v(dout1_38) AT=365.025n

.meas tran vdout1_39ck720 FIND v(dout1_39) AT=365.025n

.meas tran vdout1_40ck720 FIND v(dout1_40) AT=365.025n

.meas tran vdout1_41ck720 FIND v(dout1_41) AT=365.025n

.meas tran vdout1_42ck720 FIND v(dout1_42) AT=365.025n

.meas tran vdout1_43ck720 FIND v(dout1_43) AT=365.025n

.meas tran vdout1_44ck720 FIND v(dout1_44) AT=365.025n

.meas tran vdout1_45ck720 FIND v(dout1_45) AT=365.025n

.meas tran vdout1_46ck720 FIND v(dout1_46) AT=365.025n

.meas tran vdout1_47ck720 FIND v(dout1_47) AT=365.025n

.meas tran vdout1_48ck720 FIND v(dout1_48) AT=365.025n

.meas tran vdout1_49ck720 FIND v(dout1_49) AT=365.025n

.meas tran vdout1_50ck720 FIND v(dout1_50) AT=365.025n

.meas tran vdout1_51ck720 FIND v(dout1_51) AT=365.025n

.meas tran vdout1_52ck720 FIND v(dout1_52) AT=365.025n

.meas tran vdout1_53ck720 FIND v(dout1_53) AT=365.025n

.meas tran vdout1_54ck720 FIND v(dout1_54) AT=365.025n

.meas tran vdout1_55ck720 FIND v(dout1_55) AT=365.025n

.meas tran vdout1_56ck720 FIND v(dout1_56) AT=365.025n

.meas tran vdout1_57ck720 FIND v(dout1_57) AT=365.025n

.meas tran vdout1_58ck720 FIND v(dout1_58) AT=365.025n

.meas tran vdout1_59ck720 FIND v(dout1_59) AT=365.025n

.meas tran vdout1_60ck720 FIND v(dout1_60) AT=365.025n

.meas tran vdout1_61ck720 FIND v(dout1_61) AT=365.025n

.meas tran vdout1_62ck720 FIND v(dout1_62) AT=365.025n

.meas tran vdout1_63ck720 FIND v(dout1_63) AT=365.025n

.meas tran vdout0_0ck730 FIND v(dout0_0) AT=370.025n

.meas tran vdout0_1ck730 FIND v(dout0_1) AT=370.025n

.meas tran vdout0_2ck730 FIND v(dout0_2) AT=370.025n

.meas tran vdout0_3ck730 FIND v(dout0_3) AT=370.025n

.meas tran vdout0_4ck730 FIND v(dout0_4) AT=370.025n

.meas tran vdout0_5ck730 FIND v(dout0_5) AT=370.025n

.meas tran vdout0_6ck730 FIND v(dout0_6) AT=370.025n

.meas tran vdout0_7ck730 FIND v(dout0_7) AT=370.025n

.meas tran vdout0_8ck730 FIND v(dout0_8) AT=370.025n

.meas tran vdout0_9ck730 FIND v(dout0_9) AT=370.025n

.meas tran vdout0_10ck730 FIND v(dout0_10) AT=370.025n

.meas tran vdout0_11ck730 FIND v(dout0_11) AT=370.025n

.meas tran vdout0_12ck730 FIND v(dout0_12) AT=370.025n

.meas tran vdout0_13ck730 FIND v(dout0_13) AT=370.025n

.meas tran vdout0_14ck730 FIND v(dout0_14) AT=370.025n

.meas tran vdout0_15ck730 FIND v(dout0_15) AT=370.025n

.meas tran vdout0_16ck730 FIND v(dout0_16) AT=370.025n

.meas tran vdout0_17ck730 FIND v(dout0_17) AT=370.025n

.meas tran vdout0_18ck730 FIND v(dout0_18) AT=370.025n

.meas tran vdout0_19ck730 FIND v(dout0_19) AT=370.025n

.meas tran vdout0_20ck730 FIND v(dout0_20) AT=370.025n

.meas tran vdout0_21ck730 FIND v(dout0_21) AT=370.025n

.meas tran vdout0_22ck730 FIND v(dout0_22) AT=370.025n

.meas tran vdout0_23ck730 FIND v(dout0_23) AT=370.025n

.meas tran vdout0_24ck730 FIND v(dout0_24) AT=370.025n

.meas tran vdout0_25ck730 FIND v(dout0_25) AT=370.025n

.meas tran vdout0_26ck730 FIND v(dout0_26) AT=370.025n

.meas tran vdout0_27ck730 FIND v(dout0_27) AT=370.025n

.meas tran vdout0_28ck730 FIND v(dout0_28) AT=370.025n

.meas tran vdout0_29ck730 FIND v(dout0_29) AT=370.025n

.meas tran vdout0_30ck730 FIND v(dout0_30) AT=370.025n

.meas tran vdout0_31ck730 FIND v(dout0_31) AT=370.025n

.meas tran vdout0_32ck730 FIND v(dout0_32) AT=370.025n

.meas tran vdout0_33ck730 FIND v(dout0_33) AT=370.025n

.meas tran vdout0_34ck730 FIND v(dout0_34) AT=370.025n

.meas tran vdout0_35ck730 FIND v(dout0_35) AT=370.025n

.meas tran vdout0_36ck730 FIND v(dout0_36) AT=370.025n

.meas tran vdout0_37ck730 FIND v(dout0_37) AT=370.025n

.meas tran vdout0_38ck730 FIND v(dout0_38) AT=370.025n

.meas tran vdout0_39ck730 FIND v(dout0_39) AT=370.025n

.meas tran vdout0_40ck730 FIND v(dout0_40) AT=370.025n

.meas tran vdout0_41ck730 FIND v(dout0_41) AT=370.025n

.meas tran vdout0_42ck730 FIND v(dout0_42) AT=370.025n

.meas tran vdout0_43ck730 FIND v(dout0_43) AT=370.025n

.meas tran vdout0_44ck730 FIND v(dout0_44) AT=370.025n

.meas tran vdout0_45ck730 FIND v(dout0_45) AT=370.025n

.meas tran vdout0_46ck730 FIND v(dout0_46) AT=370.025n

.meas tran vdout0_47ck730 FIND v(dout0_47) AT=370.025n

.meas tran vdout0_48ck730 FIND v(dout0_48) AT=370.025n

.meas tran vdout0_49ck730 FIND v(dout0_49) AT=370.025n

.meas tran vdout0_50ck730 FIND v(dout0_50) AT=370.025n

.meas tran vdout0_51ck730 FIND v(dout0_51) AT=370.025n

.meas tran vdout0_52ck730 FIND v(dout0_52) AT=370.025n

.meas tran vdout0_53ck730 FIND v(dout0_53) AT=370.025n

.meas tran vdout0_54ck730 FIND v(dout0_54) AT=370.025n

.meas tran vdout0_55ck730 FIND v(dout0_55) AT=370.025n

.meas tran vdout0_56ck730 FIND v(dout0_56) AT=370.025n

.meas tran vdout0_57ck730 FIND v(dout0_57) AT=370.025n

.meas tran vdout0_58ck730 FIND v(dout0_58) AT=370.025n

.meas tran vdout0_59ck730 FIND v(dout0_59) AT=370.025n

.meas tran vdout0_60ck730 FIND v(dout0_60) AT=370.025n

.meas tran vdout0_61ck730 FIND v(dout0_61) AT=370.025n

.meas tran vdout0_62ck730 FIND v(dout0_62) AT=370.025n

.meas tran vdout0_63ck730 FIND v(dout0_63) AT=370.025n

.meas tran vdout0_0ck740 FIND v(dout0_0) AT=375.025n

.meas tran vdout0_1ck740 FIND v(dout0_1) AT=375.025n

.meas tran vdout0_2ck740 FIND v(dout0_2) AT=375.025n

.meas tran vdout0_3ck740 FIND v(dout0_3) AT=375.025n

.meas tran vdout0_4ck740 FIND v(dout0_4) AT=375.025n

.meas tran vdout0_5ck740 FIND v(dout0_5) AT=375.025n

.meas tran vdout0_6ck740 FIND v(dout0_6) AT=375.025n

.meas tran vdout0_7ck740 FIND v(dout0_7) AT=375.025n

.meas tran vdout0_8ck740 FIND v(dout0_8) AT=375.025n

.meas tran vdout0_9ck740 FIND v(dout0_9) AT=375.025n

.meas tran vdout0_10ck740 FIND v(dout0_10) AT=375.025n

.meas tran vdout0_11ck740 FIND v(dout0_11) AT=375.025n

.meas tran vdout0_12ck740 FIND v(dout0_12) AT=375.025n

.meas tran vdout0_13ck740 FIND v(dout0_13) AT=375.025n

.meas tran vdout0_14ck740 FIND v(dout0_14) AT=375.025n

.meas tran vdout0_15ck740 FIND v(dout0_15) AT=375.025n

.meas tran vdout0_16ck740 FIND v(dout0_16) AT=375.025n

.meas tran vdout0_17ck740 FIND v(dout0_17) AT=375.025n

.meas tran vdout0_18ck740 FIND v(dout0_18) AT=375.025n

.meas tran vdout0_19ck740 FIND v(dout0_19) AT=375.025n

.meas tran vdout0_20ck740 FIND v(dout0_20) AT=375.025n

.meas tran vdout0_21ck740 FIND v(dout0_21) AT=375.025n

.meas tran vdout0_22ck740 FIND v(dout0_22) AT=375.025n

.meas tran vdout0_23ck740 FIND v(dout0_23) AT=375.025n

.meas tran vdout0_24ck740 FIND v(dout0_24) AT=375.025n

.meas tran vdout0_25ck740 FIND v(dout0_25) AT=375.025n

.meas tran vdout0_26ck740 FIND v(dout0_26) AT=375.025n

.meas tran vdout0_27ck740 FIND v(dout0_27) AT=375.025n

.meas tran vdout0_28ck740 FIND v(dout0_28) AT=375.025n

.meas tran vdout0_29ck740 FIND v(dout0_29) AT=375.025n

.meas tran vdout0_30ck740 FIND v(dout0_30) AT=375.025n

.meas tran vdout0_31ck740 FIND v(dout0_31) AT=375.025n

.meas tran vdout0_32ck740 FIND v(dout0_32) AT=375.025n

.meas tran vdout0_33ck740 FIND v(dout0_33) AT=375.025n

.meas tran vdout0_34ck740 FIND v(dout0_34) AT=375.025n

.meas tran vdout0_35ck740 FIND v(dout0_35) AT=375.025n

.meas tran vdout0_36ck740 FIND v(dout0_36) AT=375.025n

.meas tran vdout0_37ck740 FIND v(dout0_37) AT=375.025n

.meas tran vdout0_38ck740 FIND v(dout0_38) AT=375.025n

.meas tran vdout0_39ck740 FIND v(dout0_39) AT=375.025n

.meas tran vdout0_40ck740 FIND v(dout0_40) AT=375.025n

.meas tran vdout0_41ck740 FIND v(dout0_41) AT=375.025n

.meas tran vdout0_42ck740 FIND v(dout0_42) AT=375.025n

.meas tran vdout0_43ck740 FIND v(dout0_43) AT=375.025n

.meas tran vdout0_44ck740 FIND v(dout0_44) AT=375.025n

.meas tran vdout0_45ck740 FIND v(dout0_45) AT=375.025n

.meas tran vdout0_46ck740 FIND v(dout0_46) AT=375.025n

.meas tran vdout0_47ck740 FIND v(dout0_47) AT=375.025n

.meas tran vdout0_48ck740 FIND v(dout0_48) AT=375.025n

.meas tran vdout0_49ck740 FIND v(dout0_49) AT=375.025n

.meas tran vdout0_50ck740 FIND v(dout0_50) AT=375.025n

.meas tran vdout0_51ck740 FIND v(dout0_51) AT=375.025n

.meas tran vdout0_52ck740 FIND v(dout0_52) AT=375.025n

.meas tran vdout0_53ck740 FIND v(dout0_53) AT=375.025n

.meas tran vdout0_54ck740 FIND v(dout0_54) AT=375.025n

.meas tran vdout0_55ck740 FIND v(dout0_55) AT=375.025n

.meas tran vdout0_56ck740 FIND v(dout0_56) AT=375.025n

.meas tran vdout0_57ck740 FIND v(dout0_57) AT=375.025n

.meas tran vdout0_58ck740 FIND v(dout0_58) AT=375.025n

.meas tran vdout0_59ck740 FIND v(dout0_59) AT=375.025n

.meas tran vdout0_60ck740 FIND v(dout0_60) AT=375.025n

.meas tran vdout0_61ck740 FIND v(dout0_61) AT=375.025n

.meas tran vdout0_62ck740 FIND v(dout0_62) AT=375.025n

.meas tran vdout0_63ck740 FIND v(dout0_63) AT=375.025n

.meas tran vdout1_0ck750 FIND v(dout1_0) AT=380.025n

.meas tran vdout1_1ck750 FIND v(dout1_1) AT=380.025n

.meas tran vdout1_2ck750 FIND v(dout1_2) AT=380.025n

.meas tran vdout1_3ck750 FIND v(dout1_3) AT=380.025n

.meas tran vdout1_4ck750 FIND v(dout1_4) AT=380.025n

.meas tran vdout1_5ck750 FIND v(dout1_5) AT=380.025n

.meas tran vdout1_6ck750 FIND v(dout1_6) AT=380.025n

.meas tran vdout1_7ck750 FIND v(dout1_7) AT=380.025n

.meas tran vdout1_8ck750 FIND v(dout1_8) AT=380.025n

.meas tran vdout1_9ck750 FIND v(dout1_9) AT=380.025n

.meas tran vdout1_10ck750 FIND v(dout1_10) AT=380.025n

.meas tran vdout1_11ck750 FIND v(dout1_11) AT=380.025n

.meas tran vdout1_12ck750 FIND v(dout1_12) AT=380.025n

.meas tran vdout1_13ck750 FIND v(dout1_13) AT=380.025n

.meas tran vdout1_14ck750 FIND v(dout1_14) AT=380.025n

.meas tran vdout1_15ck750 FIND v(dout1_15) AT=380.025n

.meas tran vdout1_16ck750 FIND v(dout1_16) AT=380.025n

.meas tran vdout1_17ck750 FIND v(dout1_17) AT=380.025n

.meas tran vdout1_18ck750 FIND v(dout1_18) AT=380.025n

.meas tran vdout1_19ck750 FIND v(dout1_19) AT=380.025n

.meas tran vdout1_20ck750 FIND v(dout1_20) AT=380.025n

.meas tran vdout1_21ck750 FIND v(dout1_21) AT=380.025n

.meas tran vdout1_22ck750 FIND v(dout1_22) AT=380.025n

.meas tran vdout1_23ck750 FIND v(dout1_23) AT=380.025n

.meas tran vdout1_24ck750 FIND v(dout1_24) AT=380.025n

.meas tran vdout1_25ck750 FIND v(dout1_25) AT=380.025n

.meas tran vdout1_26ck750 FIND v(dout1_26) AT=380.025n

.meas tran vdout1_27ck750 FIND v(dout1_27) AT=380.025n

.meas tran vdout1_28ck750 FIND v(dout1_28) AT=380.025n

.meas tran vdout1_29ck750 FIND v(dout1_29) AT=380.025n

.meas tran vdout1_30ck750 FIND v(dout1_30) AT=380.025n

.meas tran vdout1_31ck750 FIND v(dout1_31) AT=380.025n

.meas tran vdout1_32ck750 FIND v(dout1_32) AT=380.025n

.meas tran vdout1_33ck750 FIND v(dout1_33) AT=380.025n

.meas tran vdout1_34ck750 FIND v(dout1_34) AT=380.025n

.meas tran vdout1_35ck750 FIND v(dout1_35) AT=380.025n

.meas tran vdout1_36ck750 FIND v(dout1_36) AT=380.025n

.meas tran vdout1_37ck750 FIND v(dout1_37) AT=380.025n

.meas tran vdout1_38ck750 FIND v(dout1_38) AT=380.025n

.meas tran vdout1_39ck750 FIND v(dout1_39) AT=380.025n

.meas tran vdout1_40ck750 FIND v(dout1_40) AT=380.025n

.meas tran vdout1_41ck750 FIND v(dout1_41) AT=380.025n

.meas tran vdout1_42ck750 FIND v(dout1_42) AT=380.025n

.meas tran vdout1_43ck750 FIND v(dout1_43) AT=380.025n

.meas tran vdout1_44ck750 FIND v(dout1_44) AT=380.025n

.meas tran vdout1_45ck750 FIND v(dout1_45) AT=380.025n

.meas tran vdout1_46ck750 FIND v(dout1_46) AT=380.025n

.meas tran vdout1_47ck750 FIND v(dout1_47) AT=380.025n

.meas tran vdout1_48ck750 FIND v(dout1_48) AT=380.025n

.meas tran vdout1_49ck750 FIND v(dout1_49) AT=380.025n

.meas tran vdout1_50ck750 FIND v(dout1_50) AT=380.025n

.meas tran vdout1_51ck750 FIND v(dout1_51) AT=380.025n

.meas tran vdout1_52ck750 FIND v(dout1_52) AT=380.025n

.meas tran vdout1_53ck750 FIND v(dout1_53) AT=380.025n

.meas tran vdout1_54ck750 FIND v(dout1_54) AT=380.025n

.meas tran vdout1_55ck750 FIND v(dout1_55) AT=380.025n

.meas tran vdout1_56ck750 FIND v(dout1_56) AT=380.025n

.meas tran vdout1_57ck750 FIND v(dout1_57) AT=380.025n

.meas tran vdout1_58ck750 FIND v(dout1_58) AT=380.025n

.meas tran vdout1_59ck750 FIND v(dout1_59) AT=380.025n

.meas tran vdout1_60ck750 FIND v(dout1_60) AT=380.025n

.meas tran vdout1_61ck750 FIND v(dout1_61) AT=380.025n

.meas tran vdout1_62ck750 FIND v(dout1_62) AT=380.025n

.meas tran vdout1_63ck750 FIND v(dout1_63) AT=380.025n

.meas tran vdout0_0ck760 FIND v(dout0_0) AT=385.025n

.meas tran vdout0_1ck760 FIND v(dout0_1) AT=385.025n

.meas tran vdout0_2ck760 FIND v(dout0_2) AT=385.025n

.meas tran vdout0_3ck760 FIND v(dout0_3) AT=385.025n

.meas tran vdout0_4ck760 FIND v(dout0_4) AT=385.025n

.meas tran vdout0_5ck760 FIND v(dout0_5) AT=385.025n

.meas tran vdout0_6ck760 FIND v(dout0_6) AT=385.025n

.meas tran vdout0_7ck760 FIND v(dout0_7) AT=385.025n

.meas tran vdout0_8ck760 FIND v(dout0_8) AT=385.025n

.meas tran vdout0_9ck760 FIND v(dout0_9) AT=385.025n

.meas tran vdout0_10ck760 FIND v(dout0_10) AT=385.025n

.meas tran vdout0_11ck760 FIND v(dout0_11) AT=385.025n

.meas tran vdout0_12ck760 FIND v(dout0_12) AT=385.025n

.meas tran vdout0_13ck760 FIND v(dout0_13) AT=385.025n

.meas tran vdout0_14ck760 FIND v(dout0_14) AT=385.025n

.meas tran vdout0_15ck760 FIND v(dout0_15) AT=385.025n

.meas tran vdout0_16ck760 FIND v(dout0_16) AT=385.025n

.meas tran vdout0_17ck760 FIND v(dout0_17) AT=385.025n

.meas tran vdout0_18ck760 FIND v(dout0_18) AT=385.025n

.meas tran vdout0_19ck760 FIND v(dout0_19) AT=385.025n

.meas tran vdout0_20ck760 FIND v(dout0_20) AT=385.025n

.meas tran vdout0_21ck760 FIND v(dout0_21) AT=385.025n

.meas tran vdout0_22ck760 FIND v(dout0_22) AT=385.025n

.meas tran vdout0_23ck760 FIND v(dout0_23) AT=385.025n

.meas tran vdout0_24ck760 FIND v(dout0_24) AT=385.025n

.meas tran vdout0_25ck760 FIND v(dout0_25) AT=385.025n

.meas tran vdout0_26ck760 FIND v(dout0_26) AT=385.025n

.meas tran vdout0_27ck760 FIND v(dout0_27) AT=385.025n

.meas tran vdout0_28ck760 FIND v(dout0_28) AT=385.025n

.meas tran vdout0_29ck760 FIND v(dout0_29) AT=385.025n

.meas tran vdout0_30ck760 FIND v(dout0_30) AT=385.025n

.meas tran vdout0_31ck760 FIND v(dout0_31) AT=385.025n

.meas tran vdout0_32ck760 FIND v(dout0_32) AT=385.025n

.meas tran vdout0_33ck760 FIND v(dout0_33) AT=385.025n

.meas tran vdout0_34ck760 FIND v(dout0_34) AT=385.025n

.meas tran vdout0_35ck760 FIND v(dout0_35) AT=385.025n

.meas tran vdout0_36ck760 FIND v(dout0_36) AT=385.025n

.meas tran vdout0_37ck760 FIND v(dout0_37) AT=385.025n

.meas tran vdout0_38ck760 FIND v(dout0_38) AT=385.025n

.meas tran vdout0_39ck760 FIND v(dout0_39) AT=385.025n

.meas tran vdout0_40ck760 FIND v(dout0_40) AT=385.025n

.meas tran vdout0_41ck760 FIND v(dout0_41) AT=385.025n

.meas tran vdout0_42ck760 FIND v(dout0_42) AT=385.025n

.meas tran vdout0_43ck760 FIND v(dout0_43) AT=385.025n

.meas tran vdout0_44ck760 FIND v(dout0_44) AT=385.025n

.meas tran vdout0_45ck760 FIND v(dout0_45) AT=385.025n

.meas tran vdout0_46ck760 FIND v(dout0_46) AT=385.025n

.meas tran vdout0_47ck760 FIND v(dout0_47) AT=385.025n

.meas tran vdout0_48ck760 FIND v(dout0_48) AT=385.025n

.meas tran vdout0_49ck760 FIND v(dout0_49) AT=385.025n

.meas tran vdout0_50ck760 FIND v(dout0_50) AT=385.025n

.meas tran vdout0_51ck760 FIND v(dout0_51) AT=385.025n

.meas tran vdout0_52ck760 FIND v(dout0_52) AT=385.025n

.meas tran vdout0_53ck760 FIND v(dout0_53) AT=385.025n

.meas tran vdout0_54ck760 FIND v(dout0_54) AT=385.025n

.meas tran vdout0_55ck760 FIND v(dout0_55) AT=385.025n

.meas tran vdout0_56ck760 FIND v(dout0_56) AT=385.025n

.meas tran vdout0_57ck760 FIND v(dout0_57) AT=385.025n

.meas tran vdout0_58ck760 FIND v(dout0_58) AT=385.025n

.meas tran vdout0_59ck760 FIND v(dout0_59) AT=385.025n

.meas tran vdout0_60ck760 FIND v(dout0_60) AT=385.025n

.meas tran vdout0_61ck760 FIND v(dout0_61) AT=385.025n

.meas tran vdout0_62ck760 FIND v(dout0_62) AT=385.025n

.meas tran vdout0_63ck760 FIND v(dout0_63) AT=385.025n

.meas tran vdout1_0ck770 FIND v(dout1_0) AT=390.025n

.meas tran vdout1_1ck770 FIND v(dout1_1) AT=390.025n

.meas tran vdout1_2ck770 FIND v(dout1_2) AT=390.025n

.meas tran vdout1_3ck770 FIND v(dout1_3) AT=390.025n

.meas tran vdout1_4ck770 FIND v(dout1_4) AT=390.025n

.meas tran vdout1_5ck770 FIND v(dout1_5) AT=390.025n

.meas tran vdout1_6ck770 FIND v(dout1_6) AT=390.025n

.meas tran vdout1_7ck770 FIND v(dout1_7) AT=390.025n

.meas tran vdout1_8ck770 FIND v(dout1_8) AT=390.025n

.meas tran vdout1_9ck770 FIND v(dout1_9) AT=390.025n

.meas tran vdout1_10ck770 FIND v(dout1_10) AT=390.025n

.meas tran vdout1_11ck770 FIND v(dout1_11) AT=390.025n

.meas tran vdout1_12ck770 FIND v(dout1_12) AT=390.025n

.meas tran vdout1_13ck770 FIND v(dout1_13) AT=390.025n

.meas tran vdout1_14ck770 FIND v(dout1_14) AT=390.025n

.meas tran vdout1_15ck770 FIND v(dout1_15) AT=390.025n

.meas tran vdout1_16ck770 FIND v(dout1_16) AT=390.025n

.meas tran vdout1_17ck770 FIND v(dout1_17) AT=390.025n

.meas tran vdout1_18ck770 FIND v(dout1_18) AT=390.025n

.meas tran vdout1_19ck770 FIND v(dout1_19) AT=390.025n

.meas tran vdout1_20ck770 FIND v(dout1_20) AT=390.025n

.meas tran vdout1_21ck770 FIND v(dout1_21) AT=390.025n

.meas tran vdout1_22ck770 FIND v(dout1_22) AT=390.025n

.meas tran vdout1_23ck770 FIND v(dout1_23) AT=390.025n

.meas tran vdout1_24ck770 FIND v(dout1_24) AT=390.025n

.meas tran vdout1_25ck770 FIND v(dout1_25) AT=390.025n

.meas tran vdout1_26ck770 FIND v(dout1_26) AT=390.025n

.meas tran vdout1_27ck770 FIND v(dout1_27) AT=390.025n

.meas tran vdout1_28ck770 FIND v(dout1_28) AT=390.025n

.meas tran vdout1_29ck770 FIND v(dout1_29) AT=390.025n

.meas tran vdout1_30ck770 FIND v(dout1_30) AT=390.025n

.meas tran vdout1_31ck770 FIND v(dout1_31) AT=390.025n

.meas tran vdout1_32ck770 FIND v(dout1_32) AT=390.025n

.meas tran vdout1_33ck770 FIND v(dout1_33) AT=390.025n

.meas tran vdout1_34ck770 FIND v(dout1_34) AT=390.025n

.meas tran vdout1_35ck770 FIND v(dout1_35) AT=390.025n

.meas tran vdout1_36ck770 FIND v(dout1_36) AT=390.025n

.meas tran vdout1_37ck770 FIND v(dout1_37) AT=390.025n

.meas tran vdout1_38ck770 FIND v(dout1_38) AT=390.025n

.meas tran vdout1_39ck770 FIND v(dout1_39) AT=390.025n

.meas tran vdout1_40ck770 FIND v(dout1_40) AT=390.025n

.meas tran vdout1_41ck770 FIND v(dout1_41) AT=390.025n

.meas tran vdout1_42ck770 FIND v(dout1_42) AT=390.025n

.meas tran vdout1_43ck770 FIND v(dout1_43) AT=390.025n

.meas tran vdout1_44ck770 FIND v(dout1_44) AT=390.025n

.meas tran vdout1_45ck770 FIND v(dout1_45) AT=390.025n

.meas tran vdout1_46ck770 FIND v(dout1_46) AT=390.025n

.meas tran vdout1_47ck770 FIND v(dout1_47) AT=390.025n

.meas tran vdout1_48ck770 FIND v(dout1_48) AT=390.025n

.meas tran vdout1_49ck770 FIND v(dout1_49) AT=390.025n

.meas tran vdout1_50ck770 FIND v(dout1_50) AT=390.025n

.meas tran vdout1_51ck770 FIND v(dout1_51) AT=390.025n

.meas tran vdout1_52ck770 FIND v(dout1_52) AT=390.025n

.meas tran vdout1_53ck770 FIND v(dout1_53) AT=390.025n

.meas tran vdout1_54ck770 FIND v(dout1_54) AT=390.025n

.meas tran vdout1_55ck770 FIND v(dout1_55) AT=390.025n

.meas tran vdout1_56ck770 FIND v(dout1_56) AT=390.025n

.meas tran vdout1_57ck770 FIND v(dout1_57) AT=390.025n

.meas tran vdout1_58ck770 FIND v(dout1_58) AT=390.025n

.meas tran vdout1_59ck770 FIND v(dout1_59) AT=390.025n

.meas tran vdout1_60ck770 FIND v(dout1_60) AT=390.025n

.meas tran vdout1_61ck770 FIND v(dout1_61) AT=390.025n

.meas tran vdout1_62ck770 FIND v(dout1_62) AT=390.025n

.meas tran vdout1_63ck770 FIND v(dout1_63) AT=390.025n

.meas tran vdout0_0ck780 FIND v(dout0_0) AT=395.025n

.meas tran vdout0_1ck780 FIND v(dout0_1) AT=395.025n

.meas tran vdout0_2ck780 FIND v(dout0_2) AT=395.025n

.meas tran vdout0_3ck780 FIND v(dout0_3) AT=395.025n

.meas tran vdout0_4ck780 FIND v(dout0_4) AT=395.025n

.meas tran vdout0_5ck780 FIND v(dout0_5) AT=395.025n

.meas tran vdout0_6ck780 FIND v(dout0_6) AT=395.025n

.meas tran vdout0_7ck780 FIND v(dout0_7) AT=395.025n

.meas tran vdout0_8ck780 FIND v(dout0_8) AT=395.025n

.meas tran vdout0_9ck780 FIND v(dout0_9) AT=395.025n

.meas tran vdout0_10ck780 FIND v(dout0_10) AT=395.025n

.meas tran vdout0_11ck780 FIND v(dout0_11) AT=395.025n

.meas tran vdout0_12ck780 FIND v(dout0_12) AT=395.025n

.meas tran vdout0_13ck780 FIND v(dout0_13) AT=395.025n

.meas tran vdout0_14ck780 FIND v(dout0_14) AT=395.025n

.meas tran vdout0_15ck780 FIND v(dout0_15) AT=395.025n

.meas tran vdout0_16ck780 FIND v(dout0_16) AT=395.025n

.meas tran vdout0_17ck780 FIND v(dout0_17) AT=395.025n

.meas tran vdout0_18ck780 FIND v(dout0_18) AT=395.025n

.meas tran vdout0_19ck780 FIND v(dout0_19) AT=395.025n

.meas tran vdout0_20ck780 FIND v(dout0_20) AT=395.025n

.meas tran vdout0_21ck780 FIND v(dout0_21) AT=395.025n

.meas tran vdout0_22ck780 FIND v(dout0_22) AT=395.025n

.meas tran vdout0_23ck780 FIND v(dout0_23) AT=395.025n

.meas tran vdout0_24ck780 FIND v(dout0_24) AT=395.025n

.meas tran vdout0_25ck780 FIND v(dout0_25) AT=395.025n

.meas tran vdout0_26ck780 FIND v(dout0_26) AT=395.025n

.meas tran vdout0_27ck780 FIND v(dout0_27) AT=395.025n

.meas tran vdout0_28ck780 FIND v(dout0_28) AT=395.025n

.meas tran vdout0_29ck780 FIND v(dout0_29) AT=395.025n

.meas tran vdout0_30ck780 FIND v(dout0_30) AT=395.025n

.meas tran vdout0_31ck780 FIND v(dout0_31) AT=395.025n

.meas tran vdout0_32ck780 FIND v(dout0_32) AT=395.025n

.meas tran vdout0_33ck780 FIND v(dout0_33) AT=395.025n

.meas tran vdout0_34ck780 FIND v(dout0_34) AT=395.025n

.meas tran vdout0_35ck780 FIND v(dout0_35) AT=395.025n

.meas tran vdout0_36ck780 FIND v(dout0_36) AT=395.025n

.meas tran vdout0_37ck780 FIND v(dout0_37) AT=395.025n

.meas tran vdout0_38ck780 FIND v(dout0_38) AT=395.025n

.meas tran vdout0_39ck780 FIND v(dout0_39) AT=395.025n

.meas tran vdout0_40ck780 FIND v(dout0_40) AT=395.025n

.meas tran vdout0_41ck780 FIND v(dout0_41) AT=395.025n

.meas tran vdout0_42ck780 FIND v(dout0_42) AT=395.025n

.meas tran vdout0_43ck780 FIND v(dout0_43) AT=395.025n

.meas tran vdout0_44ck780 FIND v(dout0_44) AT=395.025n

.meas tran vdout0_45ck780 FIND v(dout0_45) AT=395.025n

.meas tran vdout0_46ck780 FIND v(dout0_46) AT=395.025n

.meas tran vdout0_47ck780 FIND v(dout0_47) AT=395.025n

.meas tran vdout0_48ck780 FIND v(dout0_48) AT=395.025n

.meas tran vdout0_49ck780 FIND v(dout0_49) AT=395.025n

.meas tran vdout0_50ck780 FIND v(dout0_50) AT=395.025n

.meas tran vdout0_51ck780 FIND v(dout0_51) AT=395.025n

.meas tran vdout0_52ck780 FIND v(dout0_52) AT=395.025n

.meas tran vdout0_53ck780 FIND v(dout0_53) AT=395.025n

.meas tran vdout0_54ck780 FIND v(dout0_54) AT=395.025n

.meas tran vdout0_55ck780 FIND v(dout0_55) AT=395.025n

.meas tran vdout0_56ck780 FIND v(dout0_56) AT=395.025n

.meas tran vdout0_57ck780 FIND v(dout0_57) AT=395.025n

.meas tran vdout0_58ck780 FIND v(dout0_58) AT=395.025n

.meas tran vdout0_59ck780 FIND v(dout0_59) AT=395.025n

.meas tran vdout0_60ck780 FIND v(dout0_60) AT=395.025n

.meas tran vdout0_61ck780 FIND v(dout0_61) AT=395.025n

.meas tran vdout0_62ck780 FIND v(dout0_62) AT=395.025n

.meas tran vdout0_63ck780 FIND v(dout0_63) AT=395.025n

.meas tran vdout0_0ck790 FIND v(dout0_0) AT=400.025n

.meas tran vdout0_1ck790 FIND v(dout0_1) AT=400.025n

.meas tran vdout0_2ck790 FIND v(dout0_2) AT=400.025n

.meas tran vdout0_3ck790 FIND v(dout0_3) AT=400.025n

.meas tran vdout0_4ck790 FIND v(dout0_4) AT=400.025n

.meas tran vdout0_5ck790 FIND v(dout0_5) AT=400.025n

.meas tran vdout0_6ck790 FIND v(dout0_6) AT=400.025n

.meas tran vdout0_7ck790 FIND v(dout0_7) AT=400.025n

.meas tran vdout0_8ck790 FIND v(dout0_8) AT=400.025n

.meas tran vdout0_9ck790 FIND v(dout0_9) AT=400.025n

.meas tran vdout0_10ck790 FIND v(dout0_10) AT=400.025n

.meas tran vdout0_11ck790 FIND v(dout0_11) AT=400.025n

.meas tran vdout0_12ck790 FIND v(dout0_12) AT=400.025n

.meas tran vdout0_13ck790 FIND v(dout0_13) AT=400.025n

.meas tran vdout0_14ck790 FIND v(dout0_14) AT=400.025n

.meas tran vdout0_15ck790 FIND v(dout0_15) AT=400.025n

.meas tran vdout0_16ck790 FIND v(dout0_16) AT=400.025n

.meas tran vdout0_17ck790 FIND v(dout0_17) AT=400.025n

.meas tran vdout0_18ck790 FIND v(dout0_18) AT=400.025n

.meas tran vdout0_19ck790 FIND v(dout0_19) AT=400.025n

.meas tran vdout0_20ck790 FIND v(dout0_20) AT=400.025n

.meas tran vdout0_21ck790 FIND v(dout0_21) AT=400.025n

.meas tran vdout0_22ck790 FIND v(dout0_22) AT=400.025n

.meas tran vdout0_23ck790 FIND v(dout0_23) AT=400.025n

.meas tran vdout0_24ck790 FIND v(dout0_24) AT=400.025n

.meas tran vdout0_25ck790 FIND v(dout0_25) AT=400.025n

.meas tran vdout0_26ck790 FIND v(dout0_26) AT=400.025n

.meas tran vdout0_27ck790 FIND v(dout0_27) AT=400.025n

.meas tran vdout0_28ck790 FIND v(dout0_28) AT=400.025n

.meas tran vdout0_29ck790 FIND v(dout0_29) AT=400.025n

.meas tran vdout0_30ck790 FIND v(dout0_30) AT=400.025n

.meas tran vdout0_31ck790 FIND v(dout0_31) AT=400.025n

.meas tran vdout0_32ck790 FIND v(dout0_32) AT=400.025n

.meas tran vdout0_33ck790 FIND v(dout0_33) AT=400.025n

.meas tran vdout0_34ck790 FIND v(dout0_34) AT=400.025n

.meas tran vdout0_35ck790 FIND v(dout0_35) AT=400.025n

.meas tran vdout0_36ck790 FIND v(dout0_36) AT=400.025n

.meas tran vdout0_37ck790 FIND v(dout0_37) AT=400.025n

.meas tran vdout0_38ck790 FIND v(dout0_38) AT=400.025n

.meas tran vdout0_39ck790 FIND v(dout0_39) AT=400.025n

.meas tran vdout0_40ck790 FIND v(dout0_40) AT=400.025n

.meas tran vdout0_41ck790 FIND v(dout0_41) AT=400.025n

.meas tran vdout0_42ck790 FIND v(dout0_42) AT=400.025n

.meas tran vdout0_43ck790 FIND v(dout0_43) AT=400.025n

.meas tran vdout0_44ck790 FIND v(dout0_44) AT=400.025n

.meas tran vdout0_45ck790 FIND v(dout0_45) AT=400.025n

.meas tran vdout0_46ck790 FIND v(dout0_46) AT=400.025n

.meas tran vdout0_47ck790 FIND v(dout0_47) AT=400.025n

.meas tran vdout0_48ck790 FIND v(dout0_48) AT=400.025n

.meas tran vdout0_49ck790 FIND v(dout0_49) AT=400.025n

.meas tran vdout0_50ck790 FIND v(dout0_50) AT=400.025n

.meas tran vdout0_51ck790 FIND v(dout0_51) AT=400.025n

.meas tran vdout0_52ck790 FIND v(dout0_52) AT=400.025n

.meas tran vdout0_53ck790 FIND v(dout0_53) AT=400.025n

.meas tran vdout0_54ck790 FIND v(dout0_54) AT=400.025n

.meas tran vdout0_55ck790 FIND v(dout0_55) AT=400.025n

.meas tran vdout0_56ck790 FIND v(dout0_56) AT=400.025n

.meas tran vdout0_57ck790 FIND v(dout0_57) AT=400.025n

.meas tran vdout0_58ck790 FIND v(dout0_58) AT=400.025n

.meas tran vdout0_59ck790 FIND v(dout0_59) AT=400.025n

.meas tran vdout0_60ck790 FIND v(dout0_60) AT=400.025n

.meas tran vdout0_61ck790 FIND v(dout0_61) AT=400.025n

.meas tran vdout0_62ck790 FIND v(dout0_62) AT=400.025n

.meas tran vdout0_63ck790 FIND v(dout0_63) AT=400.025n

.meas tran vdout0_0ck810 FIND v(dout0_0) AT=410.025n

.meas tran vdout0_1ck810 FIND v(dout0_1) AT=410.025n

.meas tran vdout0_2ck810 FIND v(dout0_2) AT=410.025n

.meas tran vdout0_3ck810 FIND v(dout0_3) AT=410.025n

.meas tran vdout0_4ck810 FIND v(dout0_4) AT=410.025n

.meas tran vdout0_5ck810 FIND v(dout0_5) AT=410.025n

.meas tran vdout0_6ck810 FIND v(dout0_6) AT=410.025n

.meas tran vdout0_7ck810 FIND v(dout0_7) AT=410.025n

.meas tran vdout0_8ck810 FIND v(dout0_8) AT=410.025n

.meas tran vdout0_9ck810 FIND v(dout0_9) AT=410.025n

.meas tran vdout0_10ck810 FIND v(dout0_10) AT=410.025n

.meas tran vdout0_11ck810 FIND v(dout0_11) AT=410.025n

.meas tran vdout0_12ck810 FIND v(dout0_12) AT=410.025n

.meas tran vdout0_13ck810 FIND v(dout0_13) AT=410.025n

.meas tran vdout0_14ck810 FIND v(dout0_14) AT=410.025n

.meas tran vdout0_15ck810 FIND v(dout0_15) AT=410.025n

.meas tran vdout0_16ck810 FIND v(dout0_16) AT=410.025n

.meas tran vdout0_17ck810 FIND v(dout0_17) AT=410.025n

.meas tran vdout0_18ck810 FIND v(dout0_18) AT=410.025n

.meas tran vdout0_19ck810 FIND v(dout0_19) AT=410.025n

.meas tran vdout0_20ck810 FIND v(dout0_20) AT=410.025n

.meas tran vdout0_21ck810 FIND v(dout0_21) AT=410.025n

.meas tran vdout0_22ck810 FIND v(dout0_22) AT=410.025n

.meas tran vdout0_23ck810 FIND v(dout0_23) AT=410.025n

.meas tran vdout0_24ck810 FIND v(dout0_24) AT=410.025n

.meas tran vdout0_25ck810 FIND v(dout0_25) AT=410.025n

.meas tran vdout0_26ck810 FIND v(dout0_26) AT=410.025n

.meas tran vdout0_27ck810 FIND v(dout0_27) AT=410.025n

.meas tran vdout0_28ck810 FIND v(dout0_28) AT=410.025n

.meas tran vdout0_29ck810 FIND v(dout0_29) AT=410.025n

.meas tran vdout0_30ck810 FIND v(dout0_30) AT=410.025n

.meas tran vdout0_31ck810 FIND v(dout0_31) AT=410.025n

.meas tran vdout0_32ck810 FIND v(dout0_32) AT=410.025n

.meas tran vdout0_33ck810 FIND v(dout0_33) AT=410.025n

.meas tran vdout0_34ck810 FIND v(dout0_34) AT=410.025n

.meas tran vdout0_35ck810 FIND v(dout0_35) AT=410.025n

.meas tran vdout0_36ck810 FIND v(dout0_36) AT=410.025n

.meas tran vdout0_37ck810 FIND v(dout0_37) AT=410.025n

.meas tran vdout0_38ck810 FIND v(dout0_38) AT=410.025n

.meas tran vdout0_39ck810 FIND v(dout0_39) AT=410.025n

.meas tran vdout0_40ck810 FIND v(dout0_40) AT=410.025n

.meas tran vdout0_41ck810 FIND v(dout0_41) AT=410.025n

.meas tran vdout0_42ck810 FIND v(dout0_42) AT=410.025n

.meas tran vdout0_43ck810 FIND v(dout0_43) AT=410.025n

.meas tran vdout0_44ck810 FIND v(dout0_44) AT=410.025n

.meas tran vdout0_45ck810 FIND v(dout0_45) AT=410.025n

.meas tran vdout0_46ck810 FIND v(dout0_46) AT=410.025n

.meas tran vdout0_47ck810 FIND v(dout0_47) AT=410.025n

.meas tran vdout0_48ck810 FIND v(dout0_48) AT=410.025n

.meas tran vdout0_49ck810 FIND v(dout0_49) AT=410.025n

.meas tran vdout0_50ck810 FIND v(dout0_50) AT=410.025n

.meas tran vdout0_51ck810 FIND v(dout0_51) AT=410.025n

.meas tran vdout0_52ck810 FIND v(dout0_52) AT=410.025n

.meas tran vdout0_53ck810 FIND v(dout0_53) AT=410.025n

.meas tran vdout0_54ck810 FIND v(dout0_54) AT=410.025n

.meas tran vdout0_55ck810 FIND v(dout0_55) AT=410.025n

.meas tran vdout0_56ck810 FIND v(dout0_56) AT=410.025n

.meas tran vdout0_57ck810 FIND v(dout0_57) AT=410.025n

.meas tran vdout0_58ck810 FIND v(dout0_58) AT=410.025n

.meas tran vdout0_59ck810 FIND v(dout0_59) AT=410.025n

.meas tran vdout0_60ck810 FIND v(dout0_60) AT=410.025n

.meas tran vdout0_61ck810 FIND v(dout0_61) AT=410.025n

.meas tran vdout0_62ck810 FIND v(dout0_62) AT=410.025n

.meas tran vdout0_63ck810 FIND v(dout0_63) AT=410.025n

.meas tran vdout1_0ck810 FIND v(dout1_0) AT=410.025n

.meas tran vdout1_1ck810 FIND v(dout1_1) AT=410.025n

.meas tran vdout1_2ck810 FIND v(dout1_2) AT=410.025n

.meas tran vdout1_3ck810 FIND v(dout1_3) AT=410.025n

.meas tran vdout1_4ck810 FIND v(dout1_4) AT=410.025n

.meas tran vdout1_5ck810 FIND v(dout1_5) AT=410.025n

.meas tran vdout1_6ck810 FIND v(dout1_6) AT=410.025n

.meas tran vdout1_7ck810 FIND v(dout1_7) AT=410.025n

.meas tran vdout1_8ck810 FIND v(dout1_8) AT=410.025n

.meas tran vdout1_9ck810 FIND v(dout1_9) AT=410.025n

.meas tran vdout1_10ck810 FIND v(dout1_10) AT=410.025n

.meas tran vdout1_11ck810 FIND v(dout1_11) AT=410.025n

.meas tran vdout1_12ck810 FIND v(dout1_12) AT=410.025n

.meas tran vdout1_13ck810 FIND v(dout1_13) AT=410.025n

.meas tran vdout1_14ck810 FIND v(dout1_14) AT=410.025n

.meas tran vdout1_15ck810 FIND v(dout1_15) AT=410.025n

.meas tran vdout1_16ck810 FIND v(dout1_16) AT=410.025n

.meas tran vdout1_17ck810 FIND v(dout1_17) AT=410.025n

.meas tran vdout1_18ck810 FIND v(dout1_18) AT=410.025n

.meas tran vdout1_19ck810 FIND v(dout1_19) AT=410.025n

.meas tran vdout1_20ck810 FIND v(dout1_20) AT=410.025n

.meas tran vdout1_21ck810 FIND v(dout1_21) AT=410.025n

.meas tran vdout1_22ck810 FIND v(dout1_22) AT=410.025n

.meas tran vdout1_23ck810 FIND v(dout1_23) AT=410.025n

.meas tran vdout1_24ck810 FIND v(dout1_24) AT=410.025n

.meas tran vdout1_25ck810 FIND v(dout1_25) AT=410.025n

.meas tran vdout1_26ck810 FIND v(dout1_26) AT=410.025n

.meas tran vdout1_27ck810 FIND v(dout1_27) AT=410.025n

.meas tran vdout1_28ck810 FIND v(dout1_28) AT=410.025n

.meas tran vdout1_29ck810 FIND v(dout1_29) AT=410.025n

.meas tran vdout1_30ck810 FIND v(dout1_30) AT=410.025n

.meas tran vdout1_31ck810 FIND v(dout1_31) AT=410.025n

.meas tran vdout1_32ck810 FIND v(dout1_32) AT=410.025n

.meas tran vdout1_33ck810 FIND v(dout1_33) AT=410.025n

.meas tran vdout1_34ck810 FIND v(dout1_34) AT=410.025n

.meas tran vdout1_35ck810 FIND v(dout1_35) AT=410.025n

.meas tran vdout1_36ck810 FIND v(dout1_36) AT=410.025n

.meas tran vdout1_37ck810 FIND v(dout1_37) AT=410.025n

.meas tran vdout1_38ck810 FIND v(dout1_38) AT=410.025n

.meas tran vdout1_39ck810 FIND v(dout1_39) AT=410.025n

.meas tran vdout1_40ck810 FIND v(dout1_40) AT=410.025n

.meas tran vdout1_41ck810 FIND v(dout1_41) AT=410.025n

.meas tran vdout1_42ck810 FIND v(dout1_42) AT=410.025n

.meas tran vdout1_43ck810 FIND v(dout1_43) AT=410.025n

.meas tran vdout1_44ck810 FIND v(dout1_44) AT=410.025n

.meas tran vdout1_45ck810 FIND v(dout1_45) AT=410.025n

.meas tran vdout1_46ck810 FIND v(dout1_46) AT=410.025n

.meas tran vdout1_47ck810 FIND v(dout1_47) AT=410.025n

.meas tran vdout1_48ck810 FIND v(dout1_48) AT=410.025n

.meas tran vdout1_49ck810 FIND v(dout1_49) AT=410.025n

.meas tran vdout1_50ck810 FIND v(dout1_50) AT=410.025n

.meas tran vdout1_51ck810 FIND v(dout1_51) AT=410.025n

.meas tran vdout1_52ck810 FIND v(dout1_52) AT=410.025n

.meas tran vdout1_53ck810 FIND v(dout1_53) AT=410.025n

.meas tran vdout1_54ck810 FIND v(dout1_54) AT=410.025n

.meas tran vdout1_55ck810 FIND v(dout1_55) AT=410.025n

.meas tran vdout1_56ck810 FIND v(dout1_56) AT=410.025n

.meas tran vdout1_57ck810 FIND v(dout1_57) AT=410.025n

.meas tran vdout1_58ck810 FIND v(dout1_58) AT=410.025n

.meas tran vdout1_59ck810 FIND v(dout1_59) AT=410.025n

.meas tran vdout1_60ck810 FIND v(dout1_60) AT=410.025n

.meas tran vdout1_61ck810 FIND v(dout1_61) AT=410.025n

.meas tran vdout1_62ck810 FIND v(dout1_62) AT=410.025n

.meas tran vdout1_63ck810 FIND v(dout1_63) AT=410.025n

.meas tran vdout1_0ck820 FIND v(dout1_0) AT=415.025n

.meas tran vdout1_1ck820 FIND v(dout1_1) AT=415.025n

.meas tran vdout1_2ck820 FIND v(dout1_2) AT=415.025n

.meas tran vdout1_3ck820 FIND v(dout1_3) AT=415.025n

.meas tran vdout1_4ck820 FIND v(dout1_4) AT=415.025n

.meas tran vdout1_5ck820 FIND v(dout1_5) AT=415.025n

.meas tran vdout1_6ck820 FIND v(dout1_6) AT=415.025n

.meas tran vdout1_7ck820 FIND v(dout1_7) AT=415.025n

.meas tran vdout1_8ck820 FIND v(dout1_8) AT=415.025n

.meas tran vdout1_9ck820 FIND v(dout1_9) AT=415.025n

.meas tran vdout1_10ck820 FIND v(dout1_10) AT=415.025n

.meas tran vdout1_11ck820 FIND v(dout1_11) AT=415.025n

.meas tran vdout1_12ck820 FIND v(dout1_12) AT=415.025n

.meas tran vdout1_13ck820 FIND v(dout1_13) AT=415.025n

.meas tran vdout1_14ck820 FIND v(dout1_14) AT=415.025n

.meas tran vdout1_15ck820 FIND v(dout1_15) AT=415.025n

.meas tran vdout1_16ck820 FIND v(dout1_16) AT=415.025n

.meas tran vdout1_17ck820 FIND v(dout1_17) AT=415.025n

.meas tran vdout1_18ck820 FIND v(dout1_18) AT=415.025n

.meas tran vdout1_19ck820 FIND v(dout1_19) AT=415.025n

.meas tran vdout1_20ck820 FIND v(dout1_20) AT=415.025n

.meas tran vdout1_21ck820 FIND v(dout1_21) AT=415.025n

.meas tran vdout1_22ck820 FIND v(dout1_22) AT=415.025n

.meas tran vdout1_23ck820 FIND v(dout1_23) AT=415.025n

.meas tran vdout1_24ck820 FIND v(dout1_24) AT=415.025n

.meas tran vdout1_25ck820 FIND v(dout1_25) AT=415.025n

.meas tran vdout1_26ck820 FIND v(dout1_26) AT=415.025n

.meas tran vdout1_27ck820 FIND v(dout1_27) AT=415.025n

.meas tran vdout1_28ck820 FIND v(dout1_28) AT=415.025n

.meas tran vdout1_29ck820 FIND v(dout1_29) AT=415.025n

.meas tran vdout1_30ck820 FIND v(dout1_30) AT=415.025n

.meas tran vdout1_31ck820 FIND v(dout1_31) AT=415.025n

.meas tran vdout1_32ck820 FIND v(dout1_32) AT=415.025n

.meas tran vdout1_33ck820 FIND v(dout1_33) AT=415.025n

.meas tran vdout1_34ck820 FIND v(dout1_34) AT=415.025n

.meas tran vdout1_35ck820 FIND v(dout1_35) AT=415.025n

.meas tran vdout1_36ck820 FIND v(dout1_36) AT=415.025n

.meas tran vdout1_37ck820 FIND v(dout1_37) AT=415.025n

.meas tran vdout1_38ck820 FIND v(dout1_38) AT=415.025n

.meas tran vdout1_39ck820 FIND v(dout1_39) AT=415.025n

.meas tran vdout1_40ck820 FIND v(dout1_40) AT=415.025n

.meas tran vdout1_41ck820 FIND v(dout1_41) AT=415.025n

.meas tran vdout1_42ck820 FIND v(dout1_42) AT=415.025n

.meas tran vdout1_43ck820 FIND v(dout1_43) AT=415.025n

.meas tran vdout1_44ck820 FIND v(dout1_44) AT=415.025n

.meas tran vdout1_45ck820 FIND v(dout1_45) AT=415.025n

.meas tran vdout1_46ck820 FIND v(dout1_46) AT=415.025n

.meas tran vdout1_47ck820 FIND v(dout1_47) AT=415.025n

.meas tran vdout1_48ck820 FIND v(dout1_48) AT=415.025n

.meas tran vdout1_49ck820 FIND v(dout1_49) AT=415.025n

.meas tran vdout1_50ck820 FIND v(dout1_50) AT=415.025n

.meas tran vdout1_51ck820 FIND v(dout1_51) AT=415.025n

.meas tran vdout1_52ck820 FIND v(dout1_52) AT=415.025n

.meas tran vdout1_53ck820 FIND v(dout1_53) AT=415.025n

.meas tran vdout1_54ck820 FIND v(dout1_54) AT=415.025n

.meas tran vdout1_55ck820 FIND v(dout1_55) AT=415.025n

.meas tran vdout1_56ck820 FIND v(dout1_56) AT=415.025n

.meas tran vdout1_57ck820 FIND v(dout1_57) AT=415.025n

.meas tran vdout1_58ck820 FIND v(dout1_58) AT=415.025n

.meas tran vdout1_59ck820 FIND v(dout1_59) AT=415.025n

.meas tran vdout1_60ck820 FIND v(dout1_60) AT=415.025n

.meas tran vdout1_61ck820 FIND v(dout1_61) AT=415.025n

.meas tran vdout1_62ck820 FIND v(dout1_62) AT=415.025n

.meas tran vdout1_63ck820 FIND v(dout1_63) AT=415.025n

.meas tran vdout0_0ck830 FIND v(dout0_0) AT=420.025n

.meas tran vdout0_1ck830 FIND v(dout0_1) AT=420.025n

.meas tran vdout0_2ck830 FIND v(dout0_2) AT=420.025n

.meas tran vdout0_3ck830 FIND v(dout0_3) AT=420.025n

.meas tran vdout0_4ck830 FIND v(dout0_4) AT=420.025n

.meas tran vdout0_5ck830 FIND v(dout0_5) AT=420.025n

.meas tran vdout0_6ck830 FIND v(dout0_6) AT=420.025n

.meas tran vdout0_7ck830 FIND v(dout0_7) AT=420.025n

.meas tran vdout0_8ck830 FIND v(dout0_8) AT=420.025n

.meas tran vdout0_9ck830 FIND v(dout0_9) AT=420.025n

.meas tran vdout0_10ck830 FIND v(dout0_10) AT=420.025n

.meas tran vdout0_11ck830 FIND v(dout0_11) AT=420.025n

.meas tran vdout0_12ck830 FIND v(dout0_12) AT=420.025n

.meas tran vdout0_13ck830 FIND v(dout0_13) AT=420.025n

.meas tran vdout0_14ck830 FIND v(dout0_14) AT=420.025n

.meas tran vdout0_15ck830 FIND v(dout0_15) AT=420.025n

.meas tran vdout0_16ck830 FIND v(dout0_16) AT=420.025n

.meas tran vdout0_17ck830 FIND v(dout0_17) AT=420.025n

.meas tran vdout0_18ck830 FIND v(dout0_18) AT=420.025n

.meas tran vdout0_19ck830 FIND v(dout0_19) AT=420.025n

.meas tran vdout0_20ck830 FIND v(dout0_20) AT=420.025n

.meas tran vdout0_21ck830 FIND v(dout0_21) AT=420.025n

.meas tran vdout0_22ck830 FIND v(dout0_22) AT=420.025n

.meas tran vdout0_23ck830 FIND v(dout0_23) AT=420.025n

.meas tran vdout0_24ck830 FIND v(dout0_24) AT=420.025n

.meas tran vdout0_25ck830 FIND v(dout0_25) AT=420.025n

.meas tran vdout0_26ck830 FIND v(dout0_26) AT=420.025n

.meas tran vdout0_27ck830 FIND v(dout0_27) AT=420.025n

.meas tran vdout0_28ck830 FIND v(dout0_28) AT=420.025n

.meas tran vdout0_29ck830 FIND v(dout0_29) AT=420.025n

.meas tran vdout0_30ck830 FIND v(dout0_30) AT=420.025n

.meas tran vdout0_31ck830 FIND v(dout0_31) AT=420.025n

.meas tran vdout0_32ck830 FIND v(dout0_32) AT=420.025n

.meas tran vdout0_33ck830 FIND v(dout0_33) AT=420.025n

.meas tran vdout0_34ck830 FIND v(dout0_34) AT=420.025n

.meas tran vdout0_35ck830 FIND v(dout0_35) AT=420.025n

.meas tran vdout0_36ck830 FIND v(dout0_36) AT=420.025n

.meas tran vdout0_37ck830 FIND v(dout0_37) AT=420.025n

.meas tran vdout0_38ck830 FIND v(dout0_38) AT=420.025n

.meas tran vdout0_39ck830 FIND v(dout0_39) AT=420.025n

.meas tran vdout0_40ck830 FIND v(dout0_40) AT=420.025n

.meas tran vdout0_41ck830 FIND v(dout0_41) AT=420.025n

.meas tran vdout0_42ck830 FIND v(dout0_42) AT=420.025n

.meas tran vdout0_43ck830 FIND v(dout0_43) AT=420.025n

.meas tran vdout0_44ck830 FIND v(dout0_44) AT=420.025n

.meas tran vdout0_45ck830 FIND v(dout0_45) AT=420.025n

.meas tran vdout0_46ck830 FIND v(dout0_46) AT=420.025n

.meas tran vdout0_47ck830 FIND v(dout0_47) AT=420.025n

.meas tran vdout0_48ck830 FIND v(dout0_48) AT=420.025n

.meas tran vdout0_49ck830 FIND v(dout0_49) AT=420.025n

.meas tran vdout0_50ck830 FIND v(dout0_50) AT=420.025n

.meas tran vdout0_51ck830 FIND v(dout0_51) AT=420.025n

.meas tran vdout0_52ck830 FIND v(dout0_52) AT=420.025n

.meas tran vdout0_53ck830 FIND v(dout0_53) AT=420.025n

.meas tran vdout0_54ck830 FIND v(dout0_54) AT=420.025n

.meas tran vdout0_55ck830 FIND v(dout0_55) AT=420.025n

.meas tran vdout0_56ck830 FIND v(dout0_56) AT=420.025n

.meas tran vdout0_57ck830 FIND v(dout0_57) AT=420.025n

.meas tran vdout0_58ck830 FIND v(dout0_58) AT=420.025n

.meas tran vdout0_59ck830 FIND v(dout0_59) AT=420.025n

.meas tran vdout0_60ck830 FIND v(dout0_60) AT=420.025n

.meas tran vdout0_61ck830 FIND v(dout0_61) AT=420.025n

.meas tran vdout0_62ck830 FIND v(dout0_62) AT=420.025n

.meas tran vdout0_63ck830 FIND v(dout0_63) AT=420.025n

.meas tran vdout1_0ck830 FIND v(dout1_0) AT=420.025n

.meas tran vdout1_1ck830 FIND v(dout1_1) AT=420.025n

.meas tran vdout1_2ck830 FIND v(dout1_2) AT=420.025n

.meas tran vdout1_3ck830 FIND v(dout1_3) AT=420.025n

.meas tran vdout1_4ck830 FIND v(dout1_4) AT=420.025n

.meas tran vdout1_5ck830 FIND v(dout1_5) AT=420.025n

.meas tran vdout1_6ck830 FIND v(dout1_6) AT=420.025n

.meas tran vdout1_7ck830 FIND v(dout1_7) AT=420.025n

.meas tran vdout1_8ck830 FIND v(dout1_8) AT=420.025n

.meas tran vdout1_9ck830 FIND v(dout1_9) AT=420.025n

.meas tran vdout1_10ck830 FIND v(dout1_10) AT=420.025n

.meas tran vdout1_11ck830 FIND v(dout1_11) AT=420.025n

.meas tran vdout1_12ck830 FIND v(dout1_12) AT=420.025n

.meas tran vdout1_13ck830 FIND v(dout1_13) AT=420.025n

.meas tran vdout1_14ck830 FIND v(dout1_14) AT=420.025n

.meas tran vdout1_15ck830 FIND v(dout1_15) AT=420.025n

.meas tran vdout1_16ck830 FIND v(dout1_16) AT=420.025n

.meas tran vdout1_17ck830 FIND v(dout1_17) AT=420.025n

.meas tran vdout1_18ck830 FIND v(dout1_18) AT=420.025n

.meas tran vdout1_19ck830 FIND v(dout1_19) AT=420.025n

.meas tran vdout1_20ck830 FIND v(dout1_20) AT=420.025n

.meas tran vdout1_21ck830 FIND v(dout1_21) AT=420.025n

.meas tran vdout1_22ck830 FIND v(dout1_22) AT=420.025n

.meas tran vdout1_23ck830 FIND v(dout1_23) AT=420.025n

.meas tran vdout1_24ck830 FIND v(dout1_24) AT=420.025n

.meas tran vdout1_25ck830 FIND v(dout1_25) AT=420.025n

.meas tran vdout1_26ck830 FIND v(dout1_26) AT=420.025n

.meas tran vdout1_27ck830 FIND v(dout1_27) AT=420.025n

.meas tran vdout1_28ck830 FIND v(dout1_28) AT=420.025n

.meas tran vdout1_29ck830 FIND v(dout1_29) AT=420.025n

.meas tran vdout1_30ck830 FIND v(dout1_30) AT=420.025n

.meas tran vdout1_31ck830 FIND v(dout1_31) AT=420.025n

.meas tran vdout1_32ck830 FIND v(dout1_32) AT=420.025n

.meas tran vdout1_33ck830 FIND v(dout1_33) AT=420.025n

.meas tran vdout1_34ck830 FIND v(dout1_34) AT=420.025n

.meas tran vdout1_35ck830 FIND v(dout1_35) AT=420.025n

.meas tran vdout1_36ck830 FIND v(dout1_36) AT=420.025n

.meas tran vdout1_37ck830 FIND v(dout1_37) AT=420.025n

.meas tran vdout1_38ck830 FIND v(dout1_38) AT=420.025n

.meas tran vdout1_39ck830 FIND v(dout1_39) AT=420.025n

.meas tran vdout1_40ck830 FIND v(dout1_40) AT=420.025n

.meas tran vdout1_41ck830 FIND v(dout1_41) AT=420.025n

.meas tran vdout1_42ck830 FIND v(dout1_42) AT=420.025n

.meas tran vdout1_43ck830 FIND v(dout1_43) AT=420.025n

.meas tran vdout1_44ck830 FIND v(dout1_44) AT=420.025n

.meas tran vdout1_45ck830 FIND v(dout1_45) AT=420.025n

.meas tran vdout1_46ck830 FIND v(dout1_46) AT=420.025n

.meas tran vdout1_47ck830 FIND v(dout1_47) AT=420.025n

.meas tran vdout1_48ck830 FIND v(dout1_48) AT=420.025n

.meas tran vdout1_49ck830 FIND v(dout1_49) AT=420.025n

.meas tran vdout1_50ck830 FIND v(dout1_50) AT=420.025n

.meas tran vdout1_51ck830 FIND v(dout1_51) AT=420.025n

.meas tran vdout1_52ck830 FIND v(dout1_52) AT=420.025n

.meas tran vdout1_53ck830 FIND v(dout1_53) AT=420.025n

.meas tran vdout1_54ck830 FIND v(dout1_54) AT=420.025n

.meas tran vdout1_55ck830 FIND v(dout1_55) AT=420.025n

.meas tran vdout1_56ck830 FIND v(dout1_56) AT=420.025n

.meas tran vdout1_57ck830 FIND v(dout1_57) AT=420.025n

.meas tran vdout1_58ck830 FIND v(dout1_58) AT=420.025n

.meas tran vdout1_59ck830 FIND v(dout1_59) AT=420.025n

.meas tran vdout1_60ck830 FIND v(dout1_60) AT=420.025n

.meas tran vdout1_61ck830 FIND v(dout1_61) AT=420.025n

.meas tran vdout1_62ck830 FIND v(dout1_62) AT=420.025n

.meas tran vdout1_63ck830 FIND v(dout1_63) AT=420.025n

.meas tran vdout0_0ck840 FIND v(dout0_0) AT=425.025n

.meas tran vdout0_1ck840 FIND v(dout0_1) AT=425.025n

.meas tran vdout0_2ck840 FIND v(dout0_2) AT=425.025n

.meas tran vdout0_3ck840 FIND v(dout0_3) AT=425.025n

.meas tran vdout0_4ck840 FIND v(dout0_4) AT=425.025n

.meas tran vdout0_5ck840 FIND v(dout0_5) AT=425.025n

.meas tran vdout0_6ck840 FIND v(dout0_6) AT=425.025n

.meas tran vdout0_7ck840 FIND v(dout0_7) AT=425.025n

.meas tran vdout0_8ck840 FIND v(dout0_8) AT=425.025n

.meas tran vdout0_9ck840 FIND v(dout0_9) AT=425.025n

.meas tran vdout0_10ck840 FIND v(dout0_10) AT=425.025n

.meas tran vdout0_11ck840 FIND v(dout0_11) AT=425.025n

.meas tran vdout0_12ck840 FIND v(dout0_12) AT=425.025n

.meas tran vdout0_13ck840 FIND v(dout0_13) AT=425.025n

.meas tran vdout0_14ck840 FIND v(dout0_14) AT=425.025n

.meas tran vdout0_15ck840 FIND v(dout0_15) AT=425.025n

.meas tran vdout0_16ck840 FIND v(dout0_16) AT=425.025n

.meas tran vdout0_17ck840 FIND v(dout0_17) AT=425.025n

.meas tran vdout0_18ck840 FIND v(dout0_18) AT=425.025n

.meas tran vdout0_19ck840 FIND v(dout0_19) AT=425.025n

.meas tran vdout0_20ck840 FIND v(dout0_20) AT=425.025n

.meas tran vdout0_21ck840 FIND v(dout0_21) AT=425.025n

.meas tran vdout0_22ck840 FIND v(dout0_22) AT=425.025n

.meas tran vdout0_23ck840 FIND v(dout0_23) AT=425.025n

.meas tran vdout0_24ck840 FIND v(dout0_24) AT=425.025n

.meas tran vdout0_25ck840 FIND v(dout0_25) AT=425.025n

.meas tran vdout0_26ck840 FIND v(dout0_26) AT=425.025n

.meas tran vdout0_27ck840 FIND v(dout0_27) AT=425.025n

.meas tran vdout0_28ck840 FIND v(dout0_28) AT=425.025n

.meas tran vdout0_29ck840 FIND v(dout0_29) AT=425.025n

.meas tran vdout0_30ck840 FIND v(dout0_30) AT=425.025n

.meas tran vdout0_31ck840 FIND v(dout0_31) AT=425.025n

.meas tran vdout0_32ck840 FIND v(dout0_32) AT=425.025n

.meas tran vdout0_33ck840 FIND v(dout0_33) AT=425.025n

.meas tran vdout0_34ck840 FIND v(dout0_34) AT=425.025n

.meas tran vdout0_35ck840 FIND v(dout0_35) AT=425.025n

.meas tran vdout0_36ck840 FIND v(dout0_36) AT=425.025n

.meas tran vdout0_37ck840 FIND v(dout0_37) AT=425.025n

.meas tran vdout0_38ck840 FIND v(dout0_38) AT=425.025n

.meas tran vdout0_39ck840 FIND v(dout0_39) AT=425.025n

.meas tran vdout0_40ck840 FIND v(dout0_40) AT=425.025n

.meas tran vdout0_41ck840 FIND v(dout0_41) AT=425.025n

.meas tran vdout0_42ck840 FIND v(dout0_42) AT=425.025n

.meas tran vdout0_43ck840 FIND v(dout0_43) AT=425.025n

.meas tran vdout0_44ck840 FIND v(dout0_44) AT=425.025n

.meas tran vdout0_45ck840 FIND v(dout0_45) AT=425.025n

.meas tran vdout0_46ck840 FIND v(dout0_46) AT=425.025n

.meas tran vdout0_47ck840 FIND v(dout0_47) AT=425.025n

.meas tran vdout0_48ck840 FIND v(dout0_48) AT=425.025n

.meas tran vdout0_49ck840 FIND v(dout0_49) AT=425.025n

.meas tran vdout0_50ck840 FIND v(dout0_50) AT=425.025n

.meas tran vdout0_51ck840 FIND v(dout0_51) AT=425.025n

.meas tran vdout0_52ck840 FIND v(dout0_52) AT=425.025n

.meas tran vdout0_53ck840 FIND v(dout0_53) AT=425.025n

.meas tran vdout0_54ck840 FIND v(dout0_54) AT=425.025n

.meas tran vdout0_55ck840 FIND v(dout0_55) AT=425.025n

.meas tran vdout0_56ck840 FIND v(dout0_56) AT=425.025n

.meas tran vdout0_57ck840 FIND v(dout0_57) AT=425.025n

.meas tran vdout0_58ck840 FIND v(dout0_58) AT=425.025n

.meas tran vdout0_59ck840 FIND v(dout0_59) AT=425.025n

.meas tran vdout0_60ck840 FIND v(dout0_60) AT=425.025n

.meas tran vdout0_61ck840 FIND v(dout0_61) AT=425.025n

.meas tran vdout0_62ck840 FIND v(dout0_62) AT=425.025n

.meas tran vdout0_63ck840 FIND v(dout0_63) AT=425.025n

.meas tran vdout0_0ck860 FIND v(dout0_0) AT=435.025n

.meas tran vdout0_1ck860 FIND v(dout0_1) AT=435.025n

.meas tran vdout0_2ck860 FIND v(dout0_2) AT=435.025n

.meas tran vdout0_3ck860 FIND v(dout0_3) AT=435.025n

.meas tran vdout0_4ck860 FIND v(dout0_4) AT=435.025n

.meas tran vdout0_5ck860 FIND v(dout0_5) AT=435.025n

.meas tran vdout0_6ck860 FIND v(dout0_6) AT=435.025n

.meas tran vdout0_7ck860 FIND v(dout0_7) AT=435.025n

.meas tran vdout0_8ck860 FIND v(dout0_8) AT=435.025n

.meas tran vdout0_9ck860 FIND v(dout0_9) AT=435.025n

.meas tran vdout0_10ck860 FIND v(dout0_10) AT=435.025n

.meas tran vdout0_11ck860 FIND v(dout0_11) AT=435.025n

.meas tran vdout0_12ck860 FIND v(dout0_12) AT=435.025n

.meas tran vdout0_13ck860 FIND v(dout0_13) AT=435.025n

.meas tran vdout0_14ck860 FIND v(dout0_14) AT=435.025n

.meas tran vdout0_15ck860 FIND v(dout0_15) AT=435.025n

.meas tran vdout0_16ck860 FIND v(dout0_16) AT=435.025n

.meas tran vdout0_17ck860 FIND v(dout0_17) AT=435.025n

.meas tran vdout0_18ck860 FIND v(dout0_18) AT=435.025n

.meas tran vdout0_19ck860 FIND v(dout0_19) AT=435.025n

.meas tran vdout0_20ck860 FIND v(dout0_20) AT=435.025n

.meas tran vdout0_21ck860 FIND v(dout0_21) AT=435.025n

.meas tran vdout0_22ck860 FIND v(dout0_22) AT=435.025n

.meas tran vdout0_23ck860 FIND v(dout0_23) AT=435.025n

.meas tran vdout0_24ck860 FIND v(dout0_24) AT=435.025n

.meas tran vdout0_25ck860 FIND v(dout0_25) AT=435.025n

.meas tran vdout0_26ck860 FIND v(dout0_26) AT=435.025n

.meas tran vdout0_27ck860 FIND v(dout0_27) AT=435.025n

.meas tran vdout0_28ck860 FIND v(dout0_28) AT=435.025n

.meas tran vdout0_29ck860 FIND v(dout0_29) AT=435.025n

.meas tran vdout0_30ck860 FIND v(dout0_30) AT=435.025n

.meas tran vdout0_31ck860 FIND v(dout0_31) AT=435.025n

.meas tran vdout0_32ck860 FIND v(dout0_32) AT=435.025n

.meas tran vdout0_33ck860 FIND v(dout0_33) AT=435.025n

.meas tran vdout0_34ck860 FIND v(dout0_34) AT=435.025n

.meas tran vdout0_35ck860 FIND v(dout0_35) AT=435.025n

.meas tran vdout0_36ck860 FIND v(dout0_36) AT=435.025n

.meas tran vdout0_37ck860 FIND v(dout0_37) AT=435.025n

.meas tran vdout0_38ck860 FIND v(dout0_38) AT=435.025n

.meas tran vdout0_39ck860 FIND v(dout0_39) AT=435.025n

.meas tran vdout0_40ck860 FIND v(dout0_40) AT=435.025n

.meas tran vdout0_41ck860 FIND v(dout0_41) AT=435.025n

.meas tran vdout0_42ck860 FIND v(dout0_42) AT=435.025n

.meas tran vdout0_43ck860 FIND v(dout0_43) AT=435.025n

.meas tran vdout0_44ck860 FIND v(dout0_44) AT=435.025n

.meas tran vdout0_45ck860 FIND v(dout0_45) AT=435.025n

.meas tran vdout0_46ck860 FIND v(dout0_46) AT=435.025n

.meas tran vdout0_47ck860 FIND v(dout0_47) AT=435.025n

.meas tran vdout0_48ck860 FIND v(dout0_48) AT=435.025n

.meas tran vdout0_49ck860 FIND v(dout0_49) AT=435.025n

.meas tran vdout0_50ck860 FIND v(dout0_50) AT=435.025n

.meas tran vdout0_51ck860 FIND v(dout0_51) AT=435.025n

.meas tran vdout0_52ck860 FIND v(dout0_52) AT=435.025n

.meas tran vdout0_53ck860 FIND v(dout0_53) AT=435.025n

.meas tran vdout0_54ck860 FIND v(dout0_54) AT=435.025n

.meas tran vdout0_55ck860 FIND v(dout0_55) AT=435.025n

.meas tran vdout0_56ck860 FIND v(dout0_56) AT=435.025n

.meas tran vdout0_57ck860 FIND v(dout0_57) AT=435.025n

.meas tran vdout0_58ck860 FIND v(dout0_58) AT=435.025n

.meas tran vdout0_59ck860 FIND v(dout0_59) AT=435.025n

.meas tran vdout0_60ck860 FIND v(dout0_60) AT=435.025n

.meas tran vdout0_61ck860 FIND v(dout0_61) AT=435.025n

.meas tran vdout0_62ck860 FIND v(dout0_62) AT=435.025n

.meas tran vdout0_63ck860 FIND v(dout0_63) AT=435.025n

.meas tran vdout1_0ck860 FIND v(dout1_0) AT=435.025n

.meas tran vdout1_1ck860 FIND v(dout1_1) AT=435.025n

.meas tran vdout1_2ck860 FIND v(dout1_2) AT=435.025n

.meas tran vdout1_3ck860 FIND v(dout1_3) AT=435.025n

.meas tran vdout1_4ck860 FIND v(dout1_4) AT=435.025n

.meas tran vdout1_5ck860 FIND v(dout1_5) AT=435.025n

.meas tran vdout1_6ck860 FIND v(dout1_6) AT=435.025n

.meas tran vdout1_7ck860 FIND v(dout1_7) AT=435.025n

.meas tran vdout1_8ck860 FIND v(dout1_8) AT=435.025n

.meas tran vdout1_9ck860 FIND v(dout1_9) AT=435.025n

.meas tran vdout1_10ck860 FIND v(dout1_10) AT=435.025n

.meas tran vdout1_11ck860 FIND v(dout1_11) AT=435.025n

.meas tran vdout1_12ck860 FIND v(dout1_12) AT=435.025n

.meas tran vdout1_13ck860 FIND v(dout1_13) AT=435.025n

.meas tran vdout1_14ck860 FIND v(dout1_14) AT=435.025n

.meas tran vdout1_15ck860 FIND v(dout1_15) AT=435.025n

.meas tran vdout1_16ck860 FIND v(dout1_16) AT=435.025n

.meas tran vdout1_17ck860 FIND v(dout1_17) AT=435.025n

.meas tran vdout1_18ck860 FIND v(dout1_18) AT=435.025n

.meas tran vdout1_19ck860 FIND v(dout1_19) AT=435.025n

.meas tran vdout1_20ck860 FIND v(dout1_20) AT=435.025n

.meas tran vdout1_21ck860 FIND v(dout1_21) AT=435.025n

.meas tran vdout1_22ck860 FIND v(dout1_22) AT=435.025n

.meas tran vdout1_23ck860 FIND v(dout1_23) AT=435.025n

.meas tran vdout1_24ck860 FIND v(dout1_24) AT=435.025n

.meas tran vdout1_25ck860 FIND v(dout1_25) AT=435.025n

.meas tran vdout1_26ck860 FIND v(dout1_26) AT=435.025n

.meas tran vdout1_27ck860 FIND v(dout1_27) AT=435.025n

.meas tran vdout1_28ck860 FIND v(dout1_28) AT=435.025n

.meas tran vdout1_29ck860 FIND v(dout1_29) AT=435.025n

.meas tran vdout1_30ck860 FIND v(dout1_30) AT=435.025n

.meas tran vdout1_31ck860 FIND v(dout1_31) AT=435.025n

.meas tran vdout1_32ck860 FIND v(dout1_32) AT=435.025n

.meas tran vdout1_33ck860 FIND v(dout1_33) AT=435.025n

.meas tran vdout1_34ck860 FIND v(dout1_34) AT=435.025n

.meas tran vdout1_35ck860 FIND v(dout1_35) AT=435.025n

.meas tran vdout1_36ck860 FIND v(dout1_36) AT=435.025n

.meas tran vdout1_37ck860 FIND v(dout1_37) AT=435.025n

.meas tran vdout1_38ck860 FIND v(dout1_38) AT=435.025n

.meas tran vdout1_39ck860 FIND v(dout1_39) AT=435.025n

.meas tran vdout1_40ck860 FIND v(dout1_40) AT=435.025n

.meas tran vdout1_41ck860 FIND v(dout1_41) AT=435.025n

.meas tran vdout1_42ck860 FIND v(dout1_42) AT=435.025n

.meas tran vdout1_43ck860 FIND v(dout1_43) AT=435.025n

.meas tran vdout1_44ck860 FIND v(dout1_44) AT=435.025n

.meas tran vdout1_45ck860 FIND v(dout1_45) AT=435.025n

.meas tran vdout1_46ck860 FIND v(dout1_46) AT=435.025n

.meas tran vdout1_47ck860 FIND v(dout1_47) AT=435.025n

.meas tran vdout1_48ck860 FIND v(dout1_48) AT=435.025n

.meas tran vdout1_49ck860 FIND v(dout1_49) AT=435.025n

.meas tran vdout1_50ck860 FIND v(dout1_50) AT=435.025n

.meas tran vdout1_51ck860 FIND v(dout1_51) AT=435.025n

.meas tran vdout1_52ck860 FIND v(dout1_52) AT=435.025n

.meas tran vdout1_53ck860 FIND v(dout1_53) AT=435.025n

.meas tran vdout1_54ck860 FIND v(dout1_54) AT=435.025n

.meas tran vdout1_55ck860 FIND v(dout1_55) AT=435.025n

.meas tran vdout1_56ck860 FIND v(dout1_56) AT=435.025n

.meas tran vdout1_57ck860 FIND v(dout1_57) AT=435.025n

.meas tran vdout1_58ck860 FIND v(dout1_58) AT=435.025n

.meas tran vdout1_59ck860 FIND v(dout1_59) AT=435.025n

.meas tran vdout1_60ck860 FIND v(dout1_60) AT=435.025n

.meas tran vdout1_61ck860 FIND v(dout1_61) AT=435.025n

.meas tran vdout1_62ck860 FIND v(dout1_62) AT=435.025n

.meas tran vdout1_63ck860 FIND v(dout1_63) AT=435.025n

.meas tran vdout1_0ck880 FIND v(dout1_0) AT=445.025n

.meas tran vdout1_1ck880 FIND v(dout1_1) AT=445.025n

.meas tran vdout1_2ck880 FIND v(dout1_2) AT=445.025n

.meas tran vdout1_3ck880 FIND v(dout1_3) AT=445.025n

.meas tran vdout1_4ck880 FIND v(dout1_4) AT=445.025n

.meas tran vdout1_5ck880 FIND v(dout1_5) AT=445.025n

.meas tran vdout1_6ck880 FIND v(dout1_6) AT=445.025n

.meas tran vdout1_7ck880 FIND v(dout1_7) AT=445.025n

.meas tran vdout1_8ck880 FIND v(dout1_8) AT=445.025n

.meas tran vdout1_9ck880 FIND v(dout1_9) AT=445.025n

.meas tran vdout1_10ck880 FIND v(dout1_10) AT=445.025n

.meas tran vdout1_11ck880 FIND v(dout1_11) AT=445.025n

.meas tran vdout1_12ck880 FIND v(dout1_12) AT=445.025n

.meas tran vdout1_13ck880 FIND v(dout1_13) AT=445.025n

.meas tran vdout1_14ck880 FIND v(dout1_14) AT=445.025n

.meas tran vdout1_15ck880 FIND v(dout1_15) AT=445.025n

.meas tran vdout1_16ck880 FIND v(dout1_16) AT=445.025n

.meas tran vdout1_17ck880 FIND v(dout1_17) AT=445.025n

.meas tran vdout1_18ck880 FIND v(dout1_18) AT=445.025n

.meas tran vdout1_19ck880 FIND v(dout1_19) AT=445.025n

.meas tran vdout1_20ck880 FIND v(dout1_20) AT=445.025n

.meas tran vdout1_21ck880 FIND v(dout1_21) AT=445.025n

.meas tran vdout1_22ck880 FIND v(dout1_22) AT=445.025n

.meas tran vdout1_23ck880 FIND v(dout1_23) AT=445.025n

.meas tran vdout1_24ck880 FIND v(dout1_24) AT=445.025n

.meas tran vdout1_25ck880 FIND v(dout1_25) AT=445.025n

.meas tran vdout1_26ck880 FIND v(dout1_26) AT=445.025n

.meas tran vdout1_27ck880 FIND v(dout1_27) AT=445.025n

.meas tran vdout1_28ck880 FIND v(dout1_28) AT=445.025n

.meas tran vdout1_29ck880 FIND v(dout1_29) AT=445.025n

.meas tran vdout1_30ck880 FIND v(dout1_30) AT=445.025n

.meas tran vdout1_31ck880 FIND v(dout1_31) AT=445.025n

.meas tran vdout1_32ck880 FIND v(dout1_32) AT=445.025n

.meas tran vdout1_33ck880 FIND v(dout1_33) AT=445.025n

.meas tran vdout1_34ck880 FIND v(dout1_34) AT=445.025n

.meas tran vdout1_35ck880 FIND v(dout1_35) AT=445.025n

.meas tran vdout1_36ck880 FIND v(dout1_36) AT=445.025n

.meas tran vdout1_37ck880 FIND v(dout1_37) AT=445.025n

.meas tran vdout1_38ck880 FIND v(dout1_38) AT=445.025n

.meas tran vdout1_39ck880 FIND v(dout1_39) AT=445.025n

.meas tran vdout1_40ck880 FIND v(dout1_40) AT=445.025n

.meas tran vdout1_41ck880 FIND v(dout1_41) AT=445.025n

.meas tran vdout1_42ck880 FIND v(dout1_42) AT=445.025n

.meas tran vdout1_43ck880 FIND v(dout1_43) AT=445.025n

.meas tran vdout1_44ck880 FIND v(dout1_44) AT=445.025n

.meas tran vdout1_45ck880 FIND v(dout1_45) AT=445.025n

.meas tran vdout1_46ck880 FIND v(dout1_46) AT=445.025n

.meas tran vdout1_47ck880 FIND v(dout1_47) AT=445.025n

.meas tran vdout1_48ck880 FIND v(dout1_48) AT=445.025n

.meas tran vdout1_49ck880 FIND v(dout1_49) AT=445.025n

.meas tran vdout1_50ck880 FIND v(dout1_50) AT=445.025n

.meas tran vdout1_51ck880 FIND v(dout1_51) AT=445.025n

.meas tran vdout1_52ck880 FIND v(dout1_52) AT=445.025n

.meas tran vdout1_53ck880 FIND v(dout1_53) AT=445.025n

.meas tran vdout1_54ck880 FIND v(dout1_54) AT=445.025n

.meas tran vdout1_55ck880 FIND v(dout1_55) AT=445.025n

.meas tran vdout1_56ck880 FIND v(dout1_56) AT=445.025n

.meas tran vdout1_57ck880 FIND v(dout1_57) AT=445.025n

.meas tran vdout1_58ck880 FIND v(dout1_58) AT=445.025n

.meas tran vdout1_59ck880 FIND v(dout1_59) AT=445.025n

.meas tran vdout1_60ck880 FIND v(dout1_60) AT=445.025n

.meas tran vdout1_61ck880 FIND v(dout1_61) AT=445.025n

.meas tran vdout1_62ck880 FIND v(dout1_62) AT=445.025n

.meas tran vdout1_63ck880 FIND v(dout1_63) AT=445.025n

.meas tran vdout0_0ck900 FIND v(dout0_0) AT=455.025n

.meas tran vdout0_1ck900 FIND v(dout0_1) AT=455.025n

.meas tran vdout0_2ck900 FIND v(dout0_2) AT=455.025n

.meas tran vdout0_3ck900 FIND v(dout0_3) AT=455.025n

.meas tran vdout0_4ck900 FIND v(dout0_4) AT=455.025n

.meas tran vdout0_5ck900 FIND v(dout0_5) AT=455.025n

.meas tran vdout0_6ck900 FIND v(dout0_6) AT=455.025n

.meas tran vdout0_7ck900 FIND v(dout0_7) AT=455.025n

.meas tran vdout0_8ck900 FIND v(dout0_8) AT=455.025n

.meas tran vdout0_9ck900 FIND v(dout0_9) AT=455.025n

.meas tran vdout0_10ck900 FIND v(dout0_10) AT=455.025n

.meas tran vdout0_11ck900 FIND v(dout0_11) AT=455.025n

.meas tran vdout0_12ck900 FIND v(dout0_12) AT=455.025n

.meas tran vdout0_13ck900 FIND v(dout0_13) AT=455.025n

.meas tran vdout0_14ck900 FIND v(dout0_14) AT=455.025n

.meas tran vdout0_15ck900 FIND v(dout0_15) AT=455.025n

.meas tran vdout0_16ck900 FIND v(dout0_16) AT=455.025n

.meas tran vdout0_17ck900 FIND v(dout0_17) AT=455.025n

.meas tran vdout0_18ck900 FIND v(dout0_18) AT=455.025n

.meas tran vdout0_19ck900 FIND v(dout0_19) AT=455.025n

.meas tran vdout0_20ck900 FIND v(dout0_20) AT=455.025n

.meas tran vdout0_21ck900 FIND v(dout0_21) AT=455.025n

.meas tran vdout0_22ck900 FIND v(dout0_22) AT=455.025n

.meas tran vdout0_23ck900 FIND v(dout0_23) AT=455.025n

.meas tran vdout0_24ck900 FIND v(dout0_24) AT=455.025n

.meas tran vdout0_25ck900 FIND v(dout0_25) AT=455.025n

.meas tran vdout0_26ck900 FIND v(dout0_26) AT=455.025n

.meas tran vdout0_27ck900 FIND v(dout0_27) AT=455.025n

.meas tran vdout0_28ck900 FIND v(dout0_28) AT=455.025n

.meas tran vdout0_29ck900 FIND v(dout0_29) AT=455.025n

.meas tran vdout0_30ck900 FIND v(dout0_30) AT=455.025n

.meas tran vdout0_31ck900 FIND v(dout0_31) AT=455.025n

.meas tran vdout0_32ck900 FIND v(dout0_32) AT=455.025n

.meas tran vdout0_33ck900 FIND v(dout0_33) AT=455.025n

.meas tran vdout0_34ck900 FIND v(dout0_34) AT=455.025n

.meas tran vdout0_35ck900 FIND v(dout0_35) AT=455.025n

.meas tran vdout0_36ck900 FIND v(dout0_36) AT=455.025n

.meas tran vdout0_37ck900 FIND v(dout0_37) AT=455.025n

.meas tran vdout0_38ck900 FIND v(dout0_38) AT=455.025n

.meas tran vdout0_39ck900 FIND v(dout0_39) AT=455.025n

.meas tran vdout0_40ck900 FIND v(dout0_40) AT=455.025n

.meas tran vdout0_41ck900 FIND v(dout0_41) AT=455.025n

.meas tran vdout0_42ck900 FIND v(dout0_42) AT=455.025n

.meas tran vdout0_43ck900 FIND v(dout0_43) AT=455.025n

.meas tran vdout0_44ck900 FIND v(dout0_44) AT=455.025n

.meas tran vdout0_45ck900 FIND v(dout0_45) AT=455.025n

.meas tran vdout0_46ck900 FIND v(dout0_46) AT=455.025n

.meas tran vdout0_47ck900 FIND v(dout0_47) AT=455.025n

.meas tran vdout0_48ck900 FIND v(dout0_48) AT=455.025n

.meas tran vdout0_49ck900 FIND v(dout0_49) AT=455.025n

.meas tran vdout0_50ck900 FIND v(dout0_50) AT=455.025n

.meas tran vdout0_51ck900 FIND v(dout0_51) AT=455.025n

.meas tran vdout0_52ck900 FIND v(dout0_52) AT=455.025n

.meas tran vdout0_53ck900 FIND v(dout0_53) AT=455.025n

.meas tran vdout0_54ck900 FIND v(dout0_54) AT=455.025n

.meas tran vdout0_55ck900 FIND v(dout0_55) AT=455.025n

.meas tran vdout0_56ck900 FIND v(dout0_56) AT=455.025n

.meas tran vdout0_57ck900 FIND v(dout0_57) AT=455.025n

.meas tran vdout0_58ck900 FIND v(dout0_58) AT=455.025n

.meas tran vdout0_59ck900 FIND v(dout0_59) AT=455.025n

.meas tran vdout0_60ck900 FIND v(dout0_60) AT=455.025n

.meas tran vdout0_61ck900 FIND v(dout0_61) AT=455.025n

.meas tran vdout0_62ck900 FIND v(dout0_62) AT=455.025n

.meas tran vdout0_63ck900 FIND v(dout0_63) AT=455.025n

.meas tran vdout0_0ck910 FIND v(dout0_0) AT=460.025n

.meas tran vdout0_1ck910 FIND v(dout0_1) AT=460.025n

.meas tran vdout0_2ck910 FIND v(dout0_2) AT=460.025n

.meas tran vdout0_3ck910 FIND v(dout0_3) AT=460.025n

.meas tran vdout0_4ck910 FIND v(dout0_4) AT=460.025n

.meas tran vdout0_5ck910 FIND v(dout0_5) AT=460.025n

.meas tran vdout0_6ck910 FIND v(dout0_6) AT=460.025n

.meas tran vdout0_7ck910 FIND v(dout0_7) AT=460.025n

.meas tran vdout0_8ck910 FIND v(dout0_8) AT=460.025n

.meas tran vdout0_9ck910 FIND v(dout0_9) AT=460.025n

.meas tran vdout0_10ck910 FIND v(dout0_10) AT=460.025n

.meas tran vdout0_11ck910 FIND v(dout0_11) AT=460.025n

.meas tran vdout0_12ck910 FIND v(dout0_12) AT=460.025n

.meas tran vdout0_13ck910 FIND v(dout0_13) AT=460.025n

.meas tran vdout0_14ck910 FIND v(dout0_14) AT=460.025n

.meas tran vdout0_15ck910 FIND v(dout0_15) AT=460.025n

.meas tran vdout0_16ck910 FIND v(dout0_16) AT=460.025n

.meas tran vdout0_17ck910 FIND v(dout0_17) AT=460.025n

.meas tran vdout0_18ck910 FIND v(dout0_18) AT=460.025n

.meas tran vdout0_19ck910 FIND v(dout0_19) AT=460.025n

.meas tran vdout0_20ck910 FIND v(dout0_20) AT=460.025n

.meas tran vdout0_21ck910 FIND v(dout0_21) AT=460.025n

.meas tran vdout0_22ck910 FIND v(dout0_22) AT=460.025n

.meas tran vdout0_23ck910 FIND v(dout0_23) AT=460.025n

.meas tran vdout0_24ck910 FIND v(dout0_24) AT=460.025n

.meas tran vdout0_25ck910 FIND v(dout0_25) AT=460.025n

.meas tran vdout0_26ck910 FIND v(dout0_26) AT=460.025n

.meas tran vdout0_27ck910 FIND v(dout0_27) AT=460.025n

.meas tran vdout0_28ck910 FIND v(dout0_28) AT=460.025n

.meas tran vdout0_29ck910 FIND v(dout0_29) AT=460.025n

.meas tran vdout0_30ck910 FIND v(dout0_30) AT=460.025n

.meas tran vdout0_31ck910 FIND v(dout0_31) AT=460.025n

.meas tran vdout0_32ck910 FIND v(dout0_32) AT=460.025n

.meas tran vdout0_33ck910 FIND v(dout0_33) AT=460.025n

.meas tran vdout0_34ck910 FIND v(dout0_34) AT=460.025n

.meas tran vdout0_35ck910 FIND v(dout0_35) AT=460.025n

.meas tran vdout0_36ck910 FIND v(dout0_36) AT=460.025n

.meas tran vdout0_37ck910 FIND v(dout0_37) AT=460.025n

.meas tran vdout0_38ck910 FIND v(dout0_38) AT=460.025n

.meas tran vdout0_39ck910 FIND v(dout0_39) AT=460.025n

.meas tran vdout0_40ck910 FIND v(dout0_40) AT=460.025n

.meas tran vdout0_41ck910 FIND v(dout0_41) AT=460.025n

.meas tran vdout0_42ck910 FIND v(dout0_42) AT=460.025n

.meas tran vdout0_43ck910 FIND v(dout0_43) AT=460.025n

.meas tran vdout0_44ck910 FIND v(dout0_44) AT=460.025n

.meas tran vdout0_45ck910 FIND v(dout0_45) AT=460.025n

.meas tran vdout0_46ck910 FIND v(dout0_46) AT=460.025n

.meas tran vdout0_47ck910 FIND v(dout0_47) AT=460.025n

.meas tran vdout0_48ck910 FIND v(dout0_48) AT=460.025n

.meas tran vdout0_49ck910 FIND v(dout0_49) AT=460.025n

.meas tran vdout0_50ck910 FIND v(dout0_50) AT=460.025n

.meas tran vdout0_51ck910 FIND v(dout0_51) AT=460.025n

.meas tran vdout0_52ck910 FIND v(dout0_52) AT=460.025n

.meas tran vdout0_53ck910 FIND v(dout0_53) AT=460.025n

.meas tran vdout0_54ck910 FIND v(dout0_54) AT=460.025n

.meas tran vdout0_55ck910 FIND v(dout0_55) AT=460.025n

.meas tran vdout0_56ck910 FIND v(dout0_56) AT=460.025n

.meas tran vdout0_57ck910 FIND v(dout0_57) AT=460.025n

.meas tran vdout0_58ck910 FIND v(dout0_58) AT=460.025n

.meas tran vdout0_59ck910 FIND v(dout0_59) AT=460.025n

.meas tran vdout0_60ck910 FIND v(dout0_60) AT=460.025n

.meas tran vdout0_61ck910 FIND v(dout0_61) AT=460.025n

.meas tran vdout0_62ck910 FIND v(dout0_62) AT=460.025n

.meas tran vdout0_63ck910 FIND v(dout0_63) AT=460.025n

.meas tran vdout1_0ck910 FIND v(dout1_0) AT=460.025n

.meas tran vdout1_1ck910 FIND v(dout1_1) AT=460.025n

.meas tran vdout1_2ck910 FIND v(dout1_2) AT=460.025n

.meas tran vdout1_3ck910 FIND v(dout1_3) AT=460.025n

.meas tran vdout1_4ck910 FIND v(dout1_4) AT=460.025n

.meas tran vdout1_5ck910 FIND v(dout1_5) AT=460.025n

.meas tran vdout1_6ck910 FIND v(dout1_6) AT=460.025n

.meas tran vdout1_7ck910 FIND v(dout1_7) AT=460.025n

.meas tran vdout1_8ck910 FIND v(dout1_8) AT=460.025n

.meas tran vdout1_9ck910 FIND v(dout1_9) AT=460.025n

.meas tran vdout1_10ck910 FIND v(dout1_10) AT=460.025n

.meas tran vdout1_11ck910 FIND v(dout1_11) AT=460.025n

.meas tran vdout1_12ck910 FIND v(dout1_12) AT=460.025n

.meas tran vdout1_13ck910 FIND v(dout1_13) AT=460.025n

.meas tran vdout1_14ck910 FIND v(dout1_14) AT=460.025n

.meas tran vdout1_15ck910 FIND v(dout1_15) AT=460.025n

.meas tran vdout1_16ck910 FIND v(dout1_16) AT=460.025n

.meas tran vdout1_17ck910 FIND v(dout1_17) AT=460.025n

.meas tran vdout1_18ck910 FIND v(dout1_18) AT=460.025n

.meas tran vdout1_19ck910 FIND v(dout1_19) AT=460.025n

.meas tran vdout1_20ck910 FIND v(dout1_20) AT=460.025n

.meas tran vdout1_21ck910 FIND v(dout1_21) AT=460.025n

.meas tran vdout1_22ck910 FIND v(dout1_22) AT=460.025n

.meas tran vdout1_23ck910 FIND v(dout1_23) AT=460.025n

.meas tran vdout1_24ck910 FIND v(dout1_24) AT=460.025n

.meas tran vdout1_25ck910 FIND v(dout1_25) AT=460.025n

.meas tran vdout1_26ck910 FIND v(dout1_26) AT=460.025n

.meas tran vdout1_27ck910 FIND v(dout1_27) AT=460.025n

.meas tran vdout1_28ck910 FIND v(dout1_28) AT=460.025n

.meas tran vdout1_29ck910 FIND v(dout1_29) AT=460.025n

.meas tran vdout1_30ck910 FIND v(dout1_30) AT=460.025n

.meas tran vdout1_31ck910 FIND v(dout1_31) AT=460.025n

.meas tran vdout1_32ck910 FIND v(dout1_32) AT=460.025n

.meas tran vdout1_33ck910 FIND v(dout1_33) AT=460.025n

.meas tran vdout1_34ck910 FIND v(dout1_34) AT=460.025n

.meas tran vdout1_35ck910 FIND v(dout1_35) AT=460.025n

.meas tran vdout1_36ck910 FIND v(dout1_36) AT=460.025n

.meas tran vdout1_37ck910 FIND v(dout1_37) AT=460.025n

.meas tran vdout1_38ck910 FIND v(dout1_38) AT=460.025n

.meas tran vdout1_39ck910 FIND v(dout1_39) AT=460.025n

.meas tran vdout1_40ck910 FIND v(dout1_40) AT=460.025n

.meas tran vdout1_41ck910 FIND v(dout1_41) AT=460.025n

.meas tran vdout1_42ck910 FIND v(dout1_42) AT=460.025n

.meas tran vdout1_43ck910 FIND v(dout1_43) AT=460.025n

.meas tran vdout1_44ck910 FIND v(dout1_44) AT=460.025n

.meas tran vdout1_45ck910 FIND v(dout1_45) AT=460.025n

.meas tran vdout1_46ck910 FIND v(dout1_46) AT=460.025n

.meas tran vdout1_47ck910 FIND v(dout1_47) AT=460.025n

.meas tran vdout1_48ck910 FIND v(dout1_48) AT=460.025n

.meas tran vdout1_49ck910 FIND v(dout1_49) AT=460.025n

.meas tran vdout1_50ck910 FIND v(dout1_50) AT=460.025n

.meas tran vdout1_51ck910 FIND v(dout1_51) AT=460.025n

.meas tran vdout1_52ck910 FIND v(dout1_52) AT=460.025n

.meas tran vdout1_53ck910 FIND v(dout1_53) AT=460.025n

.meas tran vdout1_54ck910 FIND v(dout1_54) AT=460.025n

.meas tran vdout1_55ck910 FIND v(dout1_55) AT=460.025n

.meas tran vdout1_56ck910 FIND v(dout1_56) AT=460.025n

.meas tran vdout1_57ck910 FIND v(dout1_57) AT=460.025n

.meas tran vdout1_58ck910 FIND v(dout1_58) AT=460.025n

.meas tran vdout1_59ck910 FIND v(dout1_59) AT=460.025n

.meas tran vdout1_60ck910 FIND v(dout1_60) AT=460.025n

.meas tran vdout1_61ck910 FIND v(dout1_61) AT=460.025n

.meas tran vdout1_62ck910 FIND v(dout1_62) AT=460.025n

.meas tran vdout1_63ck910 FIND v(dout1_63) AT=460.025n

.meas tran vdout0_0ck920 FIND v(dout0_0) AT=465.025n

.meas tran vdout0_1ck920 FIND v(dout0_1) AT=465.025n

.meas tran vdout0_2ck920 FIND v(dout0_2) AT=465.025n

.meas tran vdout0_3ck920 FIND v(dout0_3) AT=465.025n

.meas tran vdout0_4ck920 FIND v(dout0_4) AT=465.025n

.meas tran vdout0_5ck920 FIND v(dout0_5) AT=465.025n

.meas tran vdout0_6ck920 FIND v(dout0_6) AT=465.025n

.meas tran vdout0_7ck920 FIND v(dout0_7) AT=465.025n

.meas tran vdout0_8ck920 FIND v(dout0_8) AT=465.025n

.meas tran vdout0_9ck920 FIND v(dout0_9) AT=465.025n

.meas tran vdout0_10ck920 FIND v(dout0_10) AT=465.025n

.meas tran vdout0_11ck920 FIND v(dout0_11) AT=465.025n

.meas tran vdout0_12ck920 FIND v(dout0_12) AT=465.025n

.meas tran vdout0_13ck920 FIND v(dout0_13) AT=465.025n

.meas tran vdout0_14ck920 FIND v(dout0_14) AT=465.025n

.meas tran vdout0_15ck920 FIND v(dout0_15) AT=465.025n

.meas tran vdout0_16ck920 FIND v(dout0_16) AT=465.025n

.meas tran vdout0_17ck920 FIND v(dout0_17) AT=465.025n

.meas tran vdout0_18ck920 FIND v(dout0_18) AT=465.025n

.meas tran vdout0_19ck920 FIND v(dout0_19) AT=465.025n

.meas tran vdout0_20ck920 FIND v(dout0_20) AT=465.025n

.meas tran vdout0_21ck920 FIND v(dout0_21) AT=465.025n

.meas tran vdout0_22ck920 FIND v(dout0_22) AT=465.025n

.meas tran vdout0_23ck920 FIND v(dout0_23) AT=465.025n

.meas tran vdout0_24ck920 FIND v(dout0_24) AT=465.025n

.meas tran vdout0_25ck920 FIND v(dout0_25) AT=465.025n

.meas tran vdout0_26ck920 FIND v(dout0_26) AT=465.025n

.meas tran vdout0_27ck920 FIND v(dout0_27) AT=465.025n

.meas tran vdout0_28ck920 FIND v(dout0_28) AT=465.025n

.meas tran vdout0_29ck920 FIND v(dout0_29) AT=465.025n

.meas tran vdout0_30ck920 FIND v(dout0_30) AT=465.025n

.meas tran vdout0_31ck920 FIND v(dout0_31) AT=465.025n

.meas tran vdout0_32ck920 FIND v(dout0_32) AT=465.025n

.meas tran vdout0_33ck920 FIND v(dout0_33) AT=465.025n

.meas tran vdout0_34ck920 FIND v(dout0_34) AT=465.025n

.meas tran vdout0_35ck920 FIND v(dout0_35) AT=465.025n

.meas tran vdout0_36ck920 FIND v(dout0_36) AT=465.025n

.meas tran vdout0_37ck920 FIND v(dout0_37) AT=465.025n

.meas tran vdout0_38ck920 FIND v(dout0_38) AT=465.025n

.meas tran vdout0_39ck920 FIND v(dout0_39) AT=465.025n

.meas tran vdout0_40ck920 FIND v(dout0_40) AT=465.025n

.meas tran vdout0_41ck920 FIND v(dout0_41) AT=465.025n

.meas tran vdout0_42ck920 FIND v(dout0_42) AT=465.025n

.meas tran vdout0_43ck920 FIND v(dout0_43) AT=465.025n

.meas tran vdout0_44ck920 FIND v(dout0_44) AT=465.025n

.meas tran vdout0_45ck920 FIND v(dout0_45) AT=465.025n

.meas tran vdout0_46ck920 FIND v(dout0_46) AT=465.025n

.meas tran vdout0_47ck920 FIND v(dout0_47) AT=465.025n

.meas tran vdout0_48ck920 FIND v(dout0_48) AT=465.025n

.meas tran vdout0_49ck920 FIND v(dout0_49) AT=465.025n

.meas tran vdout0_50ck920 FIND v(dout0_50) AT=465.025n

.meas tran vdout0_51ck920 FIND v(dout0_51) AT=465.025n

.meas tran vdout0_52ck920 FIND v(dout0_52) AT=465.025n

.meas tran vdout0_53ck920 FIND v(dout0_53) AT=465.025n

.meas tran vdout0_54ck920 FIND v(dout0_54) AT=465.025n

.meas tran vdout0_55ck920 FIND v(dout0_55) AT=465.025n

.meas tran vdout0_56ck920 FIND v(dout0_56) AT=465.025n

.meas tran vdout0_57ck920 FIND v(dout0_57) AT=465.025n

.meas tran vdout0_58ck920 FIND v(dout0_58) AT=465.025n

.meas tran vdout0_59ck920 FIND v(dout0_59) AT=465.025n

.meas tran vdout0_60ck920 FIND v(dout0_60) AT=465.025n

.meas tran vdout0_61ck920 FIND v(dout0_61) AT=465.025n

.meas tran vdout0_62ck920 FIND v(dout0_62) AT=465.025n

.meas tran vdout0_63ck920 FIND v(dout0_63) AT=465.025n

.meas tran vdout1_0ck920 FIND v(dout1_0) AT=465.025n

.meas tran vdout1_1ck920 FIND v(dout1_1) AT=465.025n

.meas tran vdout1_2ck920 FIND v(dout1_2) AT=465.025n

.meas tran vdout1_3ck920 FIND v(dout1_3) AT=465.025n

.meas tran vdout1_4ck920 FIND v(dout1_4) AT=465.025n

.meas tran vdout1_5ck920 FIND v(dout1_5) AT=465.025n

.meas tran vdout1_6ck920 FIND v(dout1_6) AT=465.025n

.meas tran vdout1_7ck920 FIND v(dout1_7) AT=465.025n

.meas tran vdout1_8ck920 FIND v(dout1_8) AT=465.025n

.meas tran vdout1_9ck920 FIND v(dout1_9) AT=465.025n

.meas tran vdout1_10ck920 FIND v(dout1_10) AT=465.025n

.meas tran vdout1_11ck920 FIND v(dout1_11) AT=465.025n

.meas tran vdout1_12ck920 FIND v(dout1_12) AT=465.025n

.meas tran vdout1_13ck920 FIND v(dout1_13) AT=465.025n

.meas tran vdout1_14ck920 FIND v(dout1_14) AT=465.025n

.meas tran vdout1_15ck920 FIND v(dout1_15) AT=465.025n

.meas tran vdout1_16ck920 FIND v(dout1_16) AT=465.025n

.meas tran vdout1_17ck920 FIND v(dout1_17) AT=465.025n

.meas tran vdout1_18ck920 FIND v(dout1_18) AT=465.025n

.meas tran vdout1_19ck920 FIND v(dout1_19) AT=465.025n

.meas tran vdout1_20ck920 FIND v(dout1_20) AT=465.025n

.meas tran vdout1_21ck920 FIND v(dout1_21) AT=465.025n

.meas tran vdout1_22ck920 FIND v(dout1_22) AT=465.025n

.meas tran vdout1_23ck920 FIND v(dout1_23) AT=465.025n

.meas tran vdout1_24ck920 FIND v(dout1_24) AT=465.025n

.meas tran vdout1_25ck920 FIND v(dout1_25) AT=465.025n

.meas tran vdout1_26ck920 FIND v(dout1_26) AT=465.025n

.meas tran vdout1_27ck920 FIND v(dout1_27) AT=465.025n

.meas tran vdout1_28ck920 FIND v(dout1_28) AT=465.025n

.meas tran vdout1_29ck920 FIND v(dout1_29) AT=465.025n

.meas tran vdout1_30ck920 FIND v(dout1_30) AT=465.025n

.meas tran vdout1_31ck920 FIND v(dout1_31) AT=465.025n

.meas tran vdout1_32ck920 FIND v(dout1_32) AT=465.025n

.meas tran vdout1_33ck920 FIND v(dout1_33) AT=465.025n

.meas tran vdout1_34ck920 FIND v(dout1_34) AT=465.025n

.meas tran vdout1_35ck920 FIND v(dout1_35) AT=465.025n

.meas tran vdout1_36ck920 FIND v(dout1_36) AT=465.025n

.meas tran vdout1_37ck920 FIND v(dout1_37) AT=465.025n

.meas tran vdout1_38ck920 FIND v(dout1_38) AT=465.025n

.meas tran vdout1_39ck920 FIND v(dout1_39) AT=465.025n

.meas tran vdout1_40ck920 FIND v(dout1_40) AT=465.025n

.meas tran vdout1_41ck920 FIND v(dout1_41) AT=465.025n

.meas tran vdout1_42ck920 FIND v(dout1_42) AT=465.025n

.meas tran vdout1_43ck920 FIND v(dout1_43) AT=465.025n

.meas tran vdout1_44ck920 FIND v(dout1_44) AT=465.025n

.meas tran vdout1_45ck920 FIND v(dout1_45) AT=465.025n

.meas tran vdout1_46ck920 FIND v(dout1_46) AT=465.025n

.meas tran vdout1_47ck920 FIND v(dout1_47) AT=465.025n

.meas tran vdout1_48ck920 FIND v(dout1_48) AT=465.025n

.meas tran vdout1_49ck920 FIND v(dout1_49) AT=465.025n

.meas tran vdout1_50ck920 FIND v(dout1_50) AT=465.025n

.meas tran vdout1_51ck920 FIND v(dout1_51) AT=465.025n

.meas tran vdout1_52ck920 FIND v(dout1_52) AT=465.025n

.meas tran vdout1_53ck920 FIND v(dout1_53) AT=465.025n

.meas tran vdout1_54ck920 FIND v(dout1_54) AT=465.025n

.meas tran vdout1_55ck920 FIND v(dout1_55) AT=465.025n

.meas tran vdout1_56ck920 FIND v(dout1_56) AT=465.025n

.meas tran vdout1_57ck920 FIND v(dout1_57) AT=465.025n

.meas tran vdout1_58ck920 FIND v(dout1_58) AT=465.025n

.meas tran vdout1_59ck920 FIND v(dout1_59) AT=465.025n

.meas tran vdout1_60ck920 FIND v(dout1_60) AT=465.025n

.meas tran vdout1_61ck920 FIND v(dout1_61) AT=465.025n

.meas tran vdout1_62ck920 FIND v(dout1_62) AT=465.025n

.meas tran vdout1_63ck920 FIND v(dout1_63) AT=465.025n

.meas tran vdout0_0ck930 FIND v(dout0_0) AT=470.025n

.meas tran vdout0_1ck930 FIND v(dout0_1) AT=470.025n

.meas tran vdout0_2ck930 FIND v(dout0_2) AT=470.025n

.meas tran vdout0_3ck930 FIND v(dout0_3) AT=470.025n

.meas tran vdout0_4ck930 FIND v(dout0_4) AT=470.025n

.meas tran vdout0_5ck930 FIND v(dout0_5) AT=470.025n

.meas tran vdout0_6ck930 FIND v(dout0_6) AT=470.025n

.meas tran vdout0_7ck930 FIND v(dout0_7) AT=470.025n

.meas tran vdout0_8ck930 FIND v(dout0_8) AT=470.025n

.meas tran vdout0_9ck930 FIND v(dout0_9) AT=470.025n

.meas tran vdout0_10ck930 FIND v(dout0_10) AT=470.025n

.meas tran vdout0_11ck930 FIND v(dout0_11) AT=470.025n

.meas tran vdout0_12ck930 FIND v(dout0_12) AT=470.025n

.meas tran vdout0_13ck930 FIND v(dout0_13) AT=470.025n

.meas tran vdout0_14ck930 FIND v(dout0_14) AT=470.025n

.meas tran vdout0_15ck930 FIND v(dout0_15) AT=470.025n

.meas tran vdout0_16ck930 FIND v(dout0_16) AT=470.025n

.meas tran vdout0_17ck930 FIND v(dout0_17) AT=470.025n

.meas tran vdout0_18ck930 FIND v(dout0_18) AT=470.025n

.meas tran vdout0_19ck930 FIND v(dout0_19) AT=470.025n

.meas tran vdout0_20ck930 FIND v(dout0_20) AT=470.025n

.meas tran vdout0_21ck930 FIND v(dout0_21) AT=470.025n

.meas tran vdout0_22ck930 FIND v(dout0_22) AT=470.025n

.meas tran vdout0_23ck930 FIND v(dout0_23) AT=470.025n

.meas tran vdout0_24ck930 FIND v(dout0_24) AT=470.025n

.meas tran vdout0_25ck930 FIND v(dout0_25) AT=470.025n

.meas tran vdout0_26ck930 FIND v(dout0_26) AT=470.025n

.meas tran vdout0_27ck930 FIND v(dout0_27) AT=470.025n

.meas tran vdout0_28ck930 FIND v(dout0_28) AT=470.025n

.meas tran vdout0_29ck930 FIND v(dout0_29) AT=470.025n

.meas tran vdout0_30ck930 FIND v(dout0_30) AT=470.025n

.meas tran vdout0_31ck930 FIND v(dout0_31) AT=470.025n

.meas tran vdout0_32ck930 FIND v(dout0_32) AT=470.025n

.meas tran vdout0_33ck930 FIND v(dout0_33) AT=470.025n

.meas tran vdout0_34ck930 FIND v(dout0_34) AT=470.025n

.meas tran vdout0_35ck930 FIND v(dout0_35) AT=470.025n

.meas tran vdout0_36ck930 FIND v(dout0_36) AT=470.025n

.meas tran vdout0_37ck930 FIND v(dout0_37) AT=470.025n

.meas tran vdout0_38ck930 FIND v(dout0_38) AT=470.025n

.meas tran vdout0_39ck930 FIND v(dout0_39) AT=470.025n

.meas tran vdout0_40ck930 FIND v(dout0_40) AT=470.025n

.meas tran vdout0_41ck930 FIND v(dout0_41) AT=470.025n

.meas tran vdout0_42ck930 FIND v(dout0_42) AT=470.025n

.meas tran vdout0_43ck930 FIND v(dout0_43) AT=470.025n

.meas tran vdout0_44ck930 FIND v(dout0_44) AT=470.025n

.meas tran vdout0_45ck930 FIND v(dout0_45) AT=470.025n

.meas tran vdout0_46ck930 FIND v(dout0_46) AT=470.025n

.meas tran vdout0_47ck930 FIND v(dout0_47) AT=470.025n

.meas tran vdout0_48ck930 FIND v(dout0_48) AT=470.025n

.meas tran vdout0_49ck930 FIND v(dout0_49) AT=470.025n

.meas tran vdout0_50ck930 FIND v(dout0_50) AT=470.025n

.meas tran vdout0_51ck930 FIND v(dout0_51) AT=470.025n

.meas tran vdout0_52ck930 FIND v(dout0_52) AT=470.025n

.meas tran vdout0_53ck930 FIND v(dout0_53) AT=470.025n

.meas tran vdout0_54ck930 FIND v(dout0_54) AT=470.025n

.meas tran vdout0_55ck930 FIND v(dout0_55) AT=470.025n

.meas tran vdout0_56ck930 FIND v(dout0_56) AT=470.025n

.meas tran vdout0_57ck930 FIND v(dout0_57) AT=470.025n

.meas tran vdout0_58ck930 FIND v(dout0_58) AT=470.025n

.meas tran vdout0_59ck930 FIND v(dout0_59) AT=470.025n

.meas tran vdout0_60ck930 FIND v(dout0_60) AT=470.025n

.meas tran vdout0_61ck930 FIND v(dout0_61) AT=470.025n

.meas tran vdout0_62ck930 FIND v(dout0_62) AT=470.025n

.meas tran vdout0_63ck930 FIND v(dout0_63) AT=470.025n

.meas tran vdout0_0ck940 FIND v(dout0_0) AT=475.025n

.meas tran vdout0_1ck940 FIND v(dout0_1) AT=475.025n

.meas tran vdout0_2ck940 FIND v(dout0_2) AT=475.025n

.meas tran vdout0_3ck940 FIND v(dout0_3) AT=475.025n

.meas tran vdout0_4ck940 FIND v(dout0_4) AT=475.025n

.meas tran vdout0_5ck940 FIND v(dout0_5) AT=475.025n

.meas tran vdout0_6ck940 FIND v(dout0_6) AT=475.025n

.meas tran vdout0_7ck940 FIND v(dout0_7) AT=475.025n

.meas tran vdout0_8ck940 FIND v(dout0_8) AT=475.025n

.meas tran vdout0_9ck940 FIND v(dout0_9) AT=475.025n

.meas tran vdout0_10ck940 FIND v(dout0_10) AT=475.025n

.meas tran vdout0_11ck940 FIND v(dout0_11) AT=475.025n

.meas tran vdout0_12ck940 FIND v(dout0_12) AT=475.025n

.meas tran vdout0_13ck940 FIND v(dout0_13) AT=475.025n

.meas tran vdout0_14ck940 FIND v(dout0_14) AT=475.025n

.meas tran vdout0_15ck940 FIND v(dout0_15) AT=475.025n

.meas tran vdout0_16ck940 FIND v(dout0_16) AT=475.025n

.meas tran vdout0_17ck940 FIND v(dout0_17) AT=475.025n

.meas tran vdout0_18ck940 FIND v(dout0_18) AT=475.025n

.meas tran vdout0_19ck940 FIND v(dout0_19) AT=475.025n

.meas tran vdout0_20ck940 FIND v(dout0_20) AT=475.025n

.meas tran vdout0_21ck940 FIND v(dout0_21) AT=475.025n

.meas tran vdout0_22ck940 FIND v(dout0_22) AT=475.025n

.meas tran vdout0_23ck940 FIND v(dout0_23) AT=475.025n

.meas tran vdout0_24ck940 FIND v(dout0_24) AT=475.025n

.meas tran vdout0_25ck940 FIND v(dout0_25) AT=475.025n

.meas tran vdout0_26ck940 FIND v(dout0_26) AT=475.025n

.meas tran vdout0_27ck940 FIND v(dout0_27) AT=475.025n

.meas tran vdout0_28ck940 FIND v(dout0_28) AT=475.025n

.meas tran vdout0_29ck940 FIND v(dout0_29) AT=475.025n

.meas tran vdout0_30ck940 FIND v(dout0_30) AT=475.025n

.meas tran vdout0_31ck940 FIND v(dout0_31) AT=475.025n

.meas tran vdout0_32ck940 FIND v(dout0_32) AT=475.025n

.meas tran vdout0_33ck940 FIND v(dout0_33) AT=475.025n

.meas tran vdout0_34ck940 FIND v(dout0_34) AT=475.025n

.meas tran vdout0_35ck940 FIND v(dout0_35) AT=475.025n

.meas tran vdout0_36ck940 FIND v(dout0_36) AT=475.025n

.meas tran vdout0_37ck940 FIND v(dout0_37) AT=475.025n

.meas tran vdout0_38ck940 FIND v(dout0_38) AT=475.025n

.meas tran vdout0_39ck940 FIND v(dout0_39) AT=475.025n

.meas tran vdout0_40ck940 FIND v(dout0_40) AT=475.025n

.meas tran vdout0_41ck940 FIND v(dout0_41) AT=475.025n

.meas tran vdout0_42ck940 FIND v(dout0_42) AT=475.025n

.meas tran vdout0_43ck940 FIND v(dout0_43) AT=475.025n

.meas tran vdout0_44ck940 FIND v(dout0_44) AT=475.025n

.meas tran vdout0_45ck940 FIND v(dout0_45) AT=475.025n

.meas tran vdout0_46ck940 FIND v(dout0_46) AT=475.025n

.meas tran vdout0_47ck940 FIND v(dout0_47) AT=475.025n

.meas tran vdout0_48ck940 FIND v(dout0_48) AT=475.025n

.meas tran vdout0_49ck940 FIND v(dout0_49) AT=475.025n

.meas tran vdout0_50ck940 FIND v(dout0_50) AT=475.025n

.meas tran vdout0_51ck940 FIND v(dout0_51) AT=475.025n

.meas tran vdout0_52ck940 FIND v(dout0_52) AT=475.025n

.meas tran vdout0_53ck940 FIND v(dout0_53) AT=475.025n

.meas tran vdout0_54ck940 FIND v(dout0_54) AT=475.025n

.meas tran vdout0_55ck940 FIND v(dout0_55) AT=475.025n

.meas tran vdout0_56ck940 FIND v(dout0_56) AT=475.025n

.meas tran vdout0_57ck940 FIND v(dout0_57) AT=475.025n

.meas tran vdout0_58ck940 FIND v(dout0_58) AT=475.025n

.meas tran vdout0_59ck940 FIND v(dout0_59) AT=475.025n

.meas tran vdout0_60ck940 FIND v(dout0_60) AT=475.025n

.meas tran vdout0_61ck940 FIND v(dout0_61) AT=475.025n

.meas tran vdout0_62ck940 FIND v(dout0_62) AT=475.025n

.meas tran vdout0_63ck940 FIND v(dout0_63) AT=475.025n

.meas tran vdout1_0ck940 FIND v(dout1_0) AT=475.025n

.meas tran vdout1_1ck940 FIND v(dout1_1) AT=475.025n

.meas tran vdout1_2ck940 FIND v(dout1_2) AT=475.025n

.meas tran vdout1_3ck940 FIND v(dout1_3) AT=475.025n

.meas tran vdout1_4ck940 FIND v(dout1_4) AT=475.025n

.meas tran vdout1_5ck940 FIND v(dout1_5) AT=475.025n

.meas tran vdout1_6ck940 FIND v(dout1_6) AT=475.025n

.meas tran vdout1_7ck940 FIND v(dout1_7) AT=475.025n

.meas tran vdout1_8ck940 FIND v(dout1_8) AT=475.025n

.meas tran vdout1_9ck940 FIND v(dout1_9) AT=475.025n

.meas tran vdout1_10ck940 FIND v(dout1_10) AT=475.025n

.meas tran vdout1_11ck940 FIND v(dout1_11) AT=475.025n

.meas tran vdout1_12ck940 FIND v(dout1_12) AT=475.025n

.meas tran vdout1_13ck940 FIND v(dout1_13) AT=475.025n

.meas tran vdout1_14ck940 FIND v(dout1_14) AT=475.025n

.meas tran vdout1_15ck940 FIND v(dout1_15) AT=475.025n

.meas tran vdout1_16ck940 FIND v(dout1_16) AT=475.025n

.meas tran vdout1_17ck940 FIND v(dout1_17) AT=475.025n

.meas tran vdout1_18ck940 FIND v(dout1_18) AT=475.025n

.meas tran vdout1_19ck940 FIND v(dout1_19) AT=475.025n

.meas tran vdout1_20ck940 FIND v(dout1_20) AT=475.025n

.meas tran vdout1_21ck940 FIND v(dout1_21) AT=475.025n

.meas tran vdout1_22ck940 FIND v(dout1_22) AT=475.025n

.meas tran vdout1_23ck940 FIND v(dout1_23) AT=475.025n

.meas tran vdout1_24ck940 FIND v(dout1_24) AT=475.025n

.meas tran vdout1_25ck940 FIND v(dout1_25) AT=475.025n

.meas tran vdout1_26ck940 FIND v(dout1_26) AT=475.025n

.meas tran vdout1_27ck940 FIND v(dout1_27) AT=475.025n

.meas tran vdout1_28ck940 FIND v(dout1_28) AT=475.025n

.meas tran vdout1_29ck940 FIND v(dout1_29) AT=475.025n

.meas tran vdout1_30ck940 FIND v(dout1_30) AT=475.025n

.meas tran vdout1_31ck940 FIND v(dout1_31) AT=475.025n

.meas tran vdout1_32ck940 FIND v(dout1_32) AT=475.025n

.meas tran vdout1_33ck940 FIND v(dout1_33) AT=475.025n

.meas tran vdout1_34ck940 FIND v(dout1_34) AT=475.025n

.meas tran vdout1_35ck940 FIND v(dout1_35) AT=475.025n

.meas tran vdout1_36ck940 FIND v(dout1_36) AT=475.025n

.meas tran vdout1_37ck940 FIND v(dout1_37) AT=475.025n

.meas tran vdout1_38ck940 FIND v(dout1_38) AT=475.025n

.meas tran vdout1_39ck940 FIND v(dout1_39) AT=475.025n

.meas tran vdout1_40ck940 FIND v(dout1_40) AT=475.025n

.meas tran vdout1_41ck940 FIND v(dout1_41) AT=475.025n

.meas tran vdout1_42ck940 FIND v(dout1_42) AT=475.025n

.meas tran vdout1_43ck940 FIND v(dout1_43) AT=475.025n

.meas tran vdout1_44ck940 FIND v(dout1_44) AT=475.025n

.meas tran vdout1_45ck940 FIND v(dout1_45) AT=475.025n

.meas tran vdout1_46ck940 FIND v(dout1_46) AT=475.025n

.meas tran vdout1_47ck940 FIND v(dout1_47) AT=475.025n

.meas tran vdout1_48ck940 FIND v(dout1_48) AT=475.025n

.meas tran vdout1_49ck940 FIND v(dout1_49) AT=475.025n

.meas tran vdout1_50ck940 FIND v(dout1_50) AT=475.025n

.meas tran vdout1_51ck940 FIND v(dout1_51) AT=475.025n

.meas tran vdout1_52ck940 FIND v(dout1_52) AT=475.025n

.meas tran vdout1_53ck940 FIND v(dout1_53) AT=475.025n

.meas tran vdout1_54ck940 FIND v(dout1_54) AT=475.025n

.meas tran vdout1_55ck940 FIND v(dout1_55) AT=475.025n

.meas tran vdout1_56ck940 FIND v(dout1_56) AT=475.025n

.meas tran vdout1_57ck940 FIND v(dout1_57) AT=475.025n

.meas tran vdout1_58ck940 FIND v(dout1_58) AT=475.025n

.meas tran vdout1_59ck940 FIND v(dout1_59) AT=475.025n

.meas tran vdout1_60ck940 FIND v(dout1_60) AT=475.025n

.meas tran vdout1_61ck940 FIND v(dout1_61) AT=475.025n

.meas tran vdout1_62ck940 FIND v(dout1_62) AT=475.025n

.meas tran vdout1_63ck940 FIND v(dout1_63) AT=475.025n

.meas tran vdout0_0ck950 FIND v(dout0_0) AT=480.025n

.meas tran vdout0_1ck950 FIND v(dout0_1) AT=480.025n

.meas tran vdout0_2ck950 FIND v(dout0_2) AT=480.025n

.meas tran vdout0_3ck950 FIND v(dout0_3) AT=480.025n

.meas tran vdout0_4ck950 FIND v(dout0_4) AT=480.025n

.meas tran vdout0_5ck950 FIND v(dout0_5) AT=480.025n

.meas tran vdout0_6ck950 FIND v(dout0_6) AT=480.025n

.meas tran vdout0_7ck950 FIND v(dout0_7) AT=480.025n

.meas tran vdout0_8ck950 FIND v(dout0_8) AT=480.025n

.meas tran vdout0_9ck950 FIND v(dout0_9) AT=480.025n

.meas tran vdout0_10ck950 FIND v(dout0_10) AT=480.025n

.meas tran vdout0_11ck950 FIND v(dout0_11) AT=480.025n

.meas tran vdout0_12ck950 FIND v(dout0_12) AT=480.025n

.meas tran vdout0_13ck950 FIND v(dout0_13) AT=480.025n

.meas tran vdout0_14ck950 FIND v(dout0_14) AT=480.025n

.meas tran vdout0_15ck950 FIND v(dout0_15) AT=480.025n

.meas tran vdout0_16ck950 FIND v(dout0_16) AT=480.025n

.meas tran vdout0_17ck950 FIND v(dout0_17) AT=480.025n

.meas tran vdout0_18ck950 FIND v(dout0_18) AT=480.025n

.meas tran vdout0_19ck950 FIND v(dout0_19) AT=480.025n

.meas tran vdout0_20ck950 FIND v(dout0_20) AT=480.025n

.meas tran vdout0_21ck950 FIND v(dout0_21) AT=480.025n

.meas tran vdout0_22ck950 FIND v(dout0_22) AT=480.025n

.meas tran vdout0_23ck950 FIND v(dout0_23) AT=480.025n

.meas tran vdout0_24ck950 FIND v(dout0_24) AT=480.025n

.meas tran vdout0_25ck950 FIND v(dout0_25) AT=480.025n

.meas tran vdout0_26ck950 FIND v(dout0_26) AT=480.025n

.meas tran vdout0_27ck950 FIND v(dout0_27) AT=480.025n

.meas tran vdout0_28ck950 FIND v(dout0_28) AT=480.025n

.meas tran vdout0_29ck950 FIND v(dout0_29) AT=480.025n

.meas tran vdout0_30ck950 FIND v(dout0_30) AT=480.025n

.meas tran vdout0_31ck950 FIND v(dout0_31) AT=480.025n

.meas tran vdout0_32ck950 FIND v(dout0_32) AT=480.025n

.meas tran vdout0_33ck950 FIND v(dout0_33) AT=480.025n

.meas tran vdout0_34ck950 FIND v(dout0_34) AT=480.025n

.meas tran vdout0_35ck950 FIND v(dout0_35) AT=480.025n

.meas tran vdout0_36ck950 FIND v(dout0_36) AT=480.025n

.meas tran vdout0_37ck950 FIND v(dout0_37) AT=480.025n

.meas tran vdout0_38ck950 FIND v(dout0_38) AT=480.025n

.meas tran vdout0_39ck950 FIND v(dout0_39) AT=480.025n

.meas tran vdout0_40ck950 FIND v(dout0_40) AT=480.025n

.meas tran vdout0_41ck950 FIND v(dout0_41) AT=480.025n

.meas tran vdout0_42ck950 FIND v(dout0_42) AT=480.025n

.meas tran vdout0_43ck950 FIND v(dout0_43) AT=480.025n

.meas tran vdout0_44ck950 FIND v(dout0_44) AT=480.025n

.meas tran vdout0_45ck950 FIND v(dout0_45) AT=480.025n

.meas tran vdout0_46ck950 FIND v(dout0_46) AT=480.025n

.meas tran vdout0_47ck950 FIND v(dout0_47) AT=480.025n

.meas tran vdout0_48ck950 FIND v(dout0_48) AT=480.025n

.meas tran vdout0_49ck950 FIND v(dout0_49) AT=480.025n

.meas tran vdout0_50ck950 FIND v(dout0_50) AT=480.025n

.meas tran vdout0_51ck950 FIND v(dout0_51) AT=480.025n

.meas tran vdout0_52ck950 FIND v(dout0_52) AT=480.025n

.meas tran vdout0_53ck950 FIND v(dout0_53) AT=480.025n

.meas tran vdout0_54ck950 FIND v(dout0_54) AT=480.025n

.meas tran vdout0_55ck950 FIND v(dout0_55) AT=480.025n

.meas tran vdout0_56ck950 FIND v(dout0_56) AT=480.025n

.meas tran vdout0_57ck950 FIND v(dout0_57) AT=480.025n

.meas tran vdout0_58ck950 FIND v(dout0_58) AT=480.025n

.meas tran vdout0_59ck950 FIND v(dout0_59) AT=480.025n

.meas tran vdout0_60ck950 FIND v(dout0_60) AT=480.025n

.meas tran vdout0_61ck950 FIND v(dout0_61) AT=480.025n

.meas tran vdout0_62ck950 FIND v(dout0_62) AT=480.025n

.meas tran vdout0_63ck950 FIND v(dout0_63) AT=480.025n

.meas tran vdout1_0ck950 FIND v(dout1_0) AT=480.025n

.meas tran vdout1_1ck950 FIND v(dout1_1) AT=480.025n

.meas tran vdout1_2ck950 FIND v(dout1_2) AT=480.025n

.meas tran vdout1_3ck950 FIND v(dout1_3) AT=480.025n

.meas tran vdout1_4ck950 FIND v(dout1_4) AT=480.025n

.meas tran vdout1_5ck950 FIND v(dout1_5) AT=480.025n

.meas tran vdout1_6ck950 FIND v(dout1_6) AT=480.025n

.meas tran vdout1_7ck950 FIND v(dout1_7) AT=480.025n

.meas tran vdout1_8ck950 FIND v(dout1_8) AT=480.025n

.meas tran vdout1_9ck950 FIND v(dout1_9) AT=480.025n

.meas tran vdout1_10ck950 FIND v(dout1_10) AT=480.025n

.meas tran vdout1_11ck950 FIND v(dout1_11) AT=480.025n

.meas tran vdout1_12ck950 FIND v(dout1_12) AT=480.025n

.meas tran vdout1_13ck950 FIND v(dout1_13) AT=480.025n

.meas tran vdout1_14ck950 FIND v(dout1_14) AT=480.025n

.meas tran vdout1_15ck950 FIND v(dout1_15) AT=480.025n

.meas tran vdout1_16ck950 FIND v(dout1_16) AT=480.025n

.meas tran vdout1_17ck950 FIND v(dout1_17) AT=480.025n

.meas tran vdout1_18ck950 FIND v(dout1_18) AT=480.025n

.meas tran vdout1_19ck950 FIND v(dout1_19) AT=480.025n

.meas tran vdout1_20ck950 FIND v(dout1_20) AT=480.025n

.meas tran vdout1_21ck950 FIND v(dout1_21) AT=480.025n

.meas tran vdout1_22ck950 FIND v(dout1_22) AT=480.025n

.meas tran vdout1_23ck950 FIND v(dout1_23) AT=480.025n

.meas tran vdout1_24ck950 FIND v(dout1_24) AT=480.025n

.meas tran vdout1_25ck950 FIND v(dout1_25) AT=480.025n

.meas tran vdout1_26ck950 FIND v(dout1_26) AT=480.025n

.meas tran vdout1_27ck950 FIND v(dout1_27) AT=480.025n

.meas tran vdout1_28ck950 FIND v(dout1_28) AT=480.025n

.meas tran vdout1_29ck950 FIND v(dout1_29) AT=480.025n

.meas tran vdout1_30ck950 FIND v(dout1_30) AT=480.025n

.meas tran vdout1_31ck950 FIND v(dout1_31) AT=480.025n

.meas tran vdout1_32ck950 FIND v(dout1_32) AT=480.025n

.meas tran vdout1_33ck950 FIND v(dout1_33) AT=480.025n

.meas tran vdout1_34ck950 FIND v(dout1_34) AT=480.025n

.meas tran vdout1_35ck950 FIND v(dout1_35) AT=480.025n

.meas tran vdout1_36ck950 FIND v(dout1_36) AT=480.025n

.meas tran vdout1_37ck950 FIND v(dout1_37) AT=480.025n

.meas tran vdout1_38ck950 FIND v(dout1_38) AT=480.025n

.meas tran vdout1_39ck950 FIND v(dout1_39) AT=480.025n

.meas tran vdout1_40ck950 FIND v(dout1_40) AT=480.025n

.meas tran vdout1_41ck950 FIND v(dout1_41) AT=480.025n

.meas tran vdout1_42ck950 FIND v(dout1_42) AT=480.025n

.meas tran vdout1_43ck950 FIND v(dout1_43) AT=480.025n

.meas tran vdout1_44ck950 FIND v(dout1_44) AT=480.025n

.meas tran vdout1_45ck950 FIND v(dout1_45) AT=480.025n

.meas tran vdout1_46ck950 FIND v(dout1_46) AT=480.025n

.meas tran vdout1_47ck950 FIND v(dout1_47) AT=480.025n

.meas tran vdout1_48ck950 FIND v(dout1_48) AT=480.025n

.meas tran vdout1_49ck950 FIND v(dout1_49) AT=480.025n

.meas tran vdout1_50ck950 FIND v(dout1_50) AT=480.025n

.meas tran vdout1_51ck950 FIND v(dout1_51) AT=480.025n

.meas tran vdout1_52ck950 FIND v(dout1_52) AT=480.025n

.meas tran vdout1_53ck950 FIND v(dout1_53) AT=480.025n

.meas tran vdout1_54ck950 FIND v(dout1_54) AT=480.025n

.meas tran vdout1_55ck950 FIND v(dout1_55) AT=480.025n

.meas tran vdout1_56ck950 FIND v(dout1_56) AT=480.025n

.meas tran vdout1_57ck950 FIND v(dout1_57) AT=480.025n

.meas tran vdout1_58ck950 FIND v(dout1_58) AT=480.025n

.meas tran vdout1_59ck950 FIND v(dout1_59) AT=480.025n

.meas tran vdout1_60ck950 FIND v(dout1_60) AT=480.025n

.meas tran vdout1_61ck950 FIND v(dout1_61) AT=480.025n

.meas tran vdout1_62ck950 FIND v(dout1_62) AT=480.025n

.meas tran vdout1_63ck950 FIND v(dout1_63) AT=480.025n

.meas tran vdout0_0ck960 FIND v(dout0_0) AT=485.025n

.meas tran vdout0_1ck960 FIND v(dout0_1) AT=485.025n

.meas tran vdout0_2ck960 FIND v(dout0_2) AT=485.025n

.meas tran vdout0_3ck960 FIND v(dout0_3) AT=485.025n

.meas tran vdout0_4ck960 FIND v(dout0_4) AT=485.025n

.meas tran vdout0_5ck960 FIND v(dout0_5) AT=485.025n

.meas tran vdout0_6ck960 FIND v(dout0_6) AT=485.025n

.meas tran vdout0_7ck960 FIND v(dout0_7) AT=485.025n

.meas tran vdout0_8ck960 FIND v(dout0_8) AT=485.025n

.meas tran vdout0_9ck960 FIND v(dout0_9) AT=485.025n

.meas tran vdout0_10ck960 FIND v(dout0_10) AT=485.025n

.meas tran vdout0_11ck960 FIND v(dout0_11) AT=485.025n

.meas tran vdout0_12ck960 FIND v(dout0_12) AT=485.025n

.meas tran vdout0_13ck960 FIND v(dout0_13) AT=485.025n

.meas tran vdout0_14ck960 FIND v(dout0_14) AT=485.025n

.meas tran vdout0_15ck960 FIND v(dout0_15) AT=485.025n

.meas tran vdout0_16ck960 FIND v(dout0_16) AT=485.025n

.meas tran vdout0_17ck960 FIND v(dout0_17) AT=485.025n

.meas tran vdout0_18ck960 FIND v(dout0_18) AT=485.025n

.meas tran vdout0_19ck960 FIND v(dout0_19) AT=485.025n

.meas tran vdout0_20ck960 FIND v(dout0_20) AT=485.025n

.meas tran vdout0_21ck960 FIND v(dout0_21) AT=485.025n

.meas tran vdout0_22ck960 FIND v(dout0_22) AT=485.025n

.meas tran vdout0_23ck960 FIND v(dout0_23) AT=485.025n

.meas tran vdout0_24ck960 FIND v(dout0_24) AT=485.025n

.meas tran vdout0_25ck960 FIND v(dout0_25) AT=485.025n

.meas tran vdout0_26ck960 FIND v(dout0_26) AT=485.025n

.meas tran vdout0_27ck960 FIND v(dout0_27) AT=485.025n

.meas tran vdout0_28ck960 FIND v(dout0_28) AT=485.025n

.meas tran vdout0_29ck960 FIND v(dout0_29) AT=485.025n

.meas tran vdout0_30ck960 FIND v(dout0_30) AT=485.025n

.meas tran vdout0_31ck960 FIND v(dout0_31) AT=485.025n

.meas tran vdout0_32ck960 FIND v(dout0_32) AT=485.025n

.meas tran vdout0_33ck960 FIND v(dout0_33) AT=485.025n

.meas tran vdout0_34ck960 FIND v(dout0_34) AT=485.025n

.meas tran vdout0_35ck960 FIND v(dout0_35) AT=485.025n

.meas tran vdout0_36ck960 FIND v(dout0_36) AT=485.025n

.meas tran vdout0_37ck960 FIND v(dout0_37) AT=485.025n

.meas tran vdout0_38ck960 FIND v(dout0_38) AT=485.025n

.meas tran vdout0_39ck960 FIND v(dout0_39) AT=485.025n

.meas tran vdout0_40ck960 FIND v(dout0_40) AT=485.025n

.meas tran vdout0_41ck960 FIND v(dout0_41) AT=485.025n

.meas tran vdout0_42ck960 FIND v(dout0_42) AT=485.025n

.meas tran vdout0_43ck960 FIND v(dout0_43) AT=485.025n

.meas tran vdout0_44ck960 FIND v(dout0_44) AT=485.025n

.meas tran vdout0_45ck960 FIND v(dout0_45) AT=485.025n

.meas tran vdout0_46ck960 FIND v(dout0_46) AT=485.025n

.meas tran vdout0_47ck960 FIND v(dout0_47) AT=485.025n

.meas tran vdout0_48ck960 FIND v(dout0_48) AT=485.025n

.meas tran vdout0_49ck960 FIND v(dout0_49) AT=485.025n

.meas tran vdout0_50ck960 FIND v(dout0_50) AT=485.025n

.meas tran vdout0_51ck960 FIND v(dout0_51) AT=485.025n

.meas tran vdout0_52ck960 FIND v(dout0_52) AT=485.025n

.meas tran vdout0_53ck960 FIND v(dout0_53) AT=485.025n

.meas tran vdout0_54ck960 FIND v(dout0_54) AT=485.025n

.meas tran vdout0_55ck960 FIND v(dout0_55) AT=485.025n

.meas tran vdout0_56ck960 FIND v(dout0_56) AT=485.025n

.meas tran vdout0_57ck960 FIND v(dout0_57) AT=485.025n

.meas tran vdout0_58ck960 FIND v(dout0_58) AT=485.025n

.meas tran vdout0_59ck960 FIND v(dout0_59) AT=485.025n

.meas tran vdout0_60ck960 FIND v(dout0_60) AT=485.025n

.meas tran vdout0_61ck960 FIND v(dout0_61) AT=485.025n

.meas tran vdout0_62ck960 FIND v(dout0_62) AT=485.025n

.meas tran vdout0_63ck960 FIND v(dout0_63) AT=485.025n

.meas tran vdout1_0ck980 FIND v(dout1_0) AT=495.025n

.meas tran vdout1_1ck980 FIND v(dout1_1) AT=495.025n

.meas tran vdout1_2ck980 FIND v(dout1_2) AT=495.025n

.meas tran vdout1_3ck980 FIND v(dout1_3) AT=495.025n

.meas tran vdout1_4ck980 FIND v(dout1_4) AT=495.025n

.meas tran vdout1_5ck980 FIND v(dout1_5) AT=495.025n

.meas tran vdout1_6ck980 FIND v(dout1_6) AT=495.025n

.meas tran vdout1_7ck980 FIND v(dout1_7) AT=495.025n

.meas tran vdout1_8ck980 FIND v(dout1_8) AT=495.025n

.meas tran vdout1_9ck980 FIND v(dout1_9) AT=495.025n

.meas tran vdout1_10ck980 FIND v(dout1_10) AT=495.025n

.meas tran vdout1_11ck980 FIND v(dout1_11) AT=495.025n

.meas tran vdout1_12ck980 FIND v(dout1_12) AT=495.025n

.meas tran vdout1_13ck980 FIND v(dout1_13) AT=495.025n

.meas tran vdout1_14ck980 FIND v(dout1_14) AT=495.025n

.meas tran vdout1_15ck980 FIND v(dout1_15) AT=495.025n

.meas tran vdout1_16ck980 FIND v(dout1_16) AT=495.025n

.meas tran vdout1_17ck980 FIND v(dout1_17) AT=495.025n

.meas tran vdout1_18ck980 FIND v(dout1_18) AT=495.025n

.meas tran vdout1_19ck980 FIND v(dout1_19) AT=495.025n

.meas tran vdout1_20ck980 FIND v(dout1_20) AT=495.025n

.meas tran vdout1_21ck980 FIND v(dout1_21) AT=495.025n

.meas tran vdout1_22ck980 FIND v(dout1_22) AT=495.025n

.meas tran vdout1_23ck980 FIND v(dout1_23) AT=495.025n

.meas tran vdout1_24ck980 FIND v(dout1_24) AT=495.025n

.meas tran vdout1_25ck980 FIND v(dout1_25) AT=495.025n

.meas tran vdout1_26ck980 FIND v(dout1_26) AT=495.025n

.meas tran vdout1_27ck980 FIND v(dout1_27) AT=495.025n

.meas tran vdout1_28ck980 FIND v(dout1_28) AT=495.025n

.meas tran vdout1_29ck980 FIND v(dout1_29) AT=495.025n

.meas tran vdout1_30ck980 FIND v(dout1_30) AT=495.025n

.meas tran vdout1_31ck980 FIND v(dout1_31) AT=495.025n

.meas tran vdout1_32ck980 FIND v(dout1_32) AT=495.025n

.meas tran vdout1_33ck980 FIND v(dout1_33) AT=495.025n

.meas tran vdout1_34ck980 FIND v(dout1_34) AT=495.025n

.meas tran vdout1_35ck980 FIND v(dout1_35) AT=495.025n

.meas tran vdout1_36ck980 FIND v(dout1_36) AT=495.025n

.meas tran vdout1_37ck980 FIND v(dout1_37) AT=495.025n

.meas tran vdout1_38ck980 FIND v(dout1_38) AT=495.025n

.meas tran vdout1_39ck980 FIND v(dout1_39) AT=495.025n

.meas tran vdout1_40ck980 FIND v(dout1_40) AT=495.025n

.meas tran vdout1_41ck980 FIND v(dout1_41) AT=495.025n

.meas tran vdout1_42ck980 FIND v(dout1_42) AT=495.025n

.meas tran vdout1_43ck980 FIND v(dout1_43) AT=495.025n

.meas tran vdout1_44ck980 FIND v(dout1_44) AT=495.025n

.meas tran vdout1_45ck980 FIND v(dout1_45) AT=495.025n

.meas tran vdout1_46ck980 FIND v(dout1_46) AT=495.025n

.meas tran vdout1_47ck980 FIND v(dout1_47) AT=495.025n

.meas tran vdout1_48ck980 FIND v(dout1_48) AT=495.025n

.meas tran vdout1_49ck980 FIND v(dout1_49) AT=495.025n

.meas tran vdout1_50ck980 FIND v(dout1_50) AT=495.025n

.meas tran vdout1_51ck980 FIND v(dout1_51) AT=495.025n

.meas tran vdout1_52ck980 FIND v(dout1_52) AT=495.025n

.meas tran vdout1_53ck980 FIND v(dout1_53) AT=495.025n

.meas tran vdout1_54ck980 FIND v(dout1_54) AT=495.025n

.meas tran vdout1_55ck980 FIND v(dout1_55) AT=495.025n

.meas tran vdout1_56ck980 FIND v(dout1_56) AT=495.025n

.meas tran vdout1_57ck980 FIND v(dout1_57) AT=495.025n

.meas tran vdout1_58ck980 FIND v(dout1_58) AT=495.025n

.meas tran vdout1_59ck980 FIND v(dout1_59) AT=495.025n

.meas tran vdout1_60ck980 FIND v(dout1_60) AT=495.025n

.meas tran vdout1_61ck980 FIND v(dout1_61) AT=495.025n

.meas tran vdout1_62ck980 FIND v(dout1_62) AT=495.025n

.meas tran vdout1_63ck980 FIND v(dout1_63) AT=495.025n

.meas tran vdout0_0ck990 FIND v(dout0_0) AT=500.025n

.meas tran vdout0_1ck990 FIND v(dout0_1) AT=500.025n

.meas tran vdout0_2ck990 FIND v(dout0_2) AT=500.025n

.meas tran vdout0_3ck990 FIND v(dout0_3) AT=500.025n

.meas tran vdout0_4ck990 FIND v(dout0_4) AT=500.025n

.meas tran vdout0_5ck990 FIND v(dout0_5) AT=500.025n

.meas tran vdout0_6ck990 FIND v(dout0_6) AT=500.025n

.meas tran vdout0_7ck990 FIND v(dout0_7) AT=500.025n

.meas tran vdout0_8ck990 FIND v(dout0_8) AT=500.025n

.meas tran vdout0_9ck990 FIND v(dout0_9) AT=500.025n

.meas tran vdout0_10ck990 FIND v(dout0_10) AT=500.025n

.meas tran vdout0_11ck990 FIND v(dout0_11) AT=500.025n

.meas tran vdout0_12ck990 FIND v(dout0_12) AT=500.025n

.meas tran vdout0_13ck990 FIND v(dout0_13) AT=500.025n

.meas tran vdout0_14ck990 FIND v(dout0_14) AT=500.025n

.meas tran vdout0_15ck990 FIND v(dout0_15) AT=500.025n

.meas tran vdout0_16ck990 FIND v(dout0_16) AT=500.025n

.meas tran vdout0_17ck990 FIND v(dout0_17) AT=500.025n

.meas tran vdout0_18ck990 FIND v(dout0_18) AT=500.025n

.meas tran vdout0_19ck990 FIND v(dout0_19) AT=500.025n

.meas tran vdout0_20ck990 FIND v(dout0_20) AT=500.025n

.meas tran vdout0_21ck990 FIND v(dout0_21) AT=500.025n

.meas tran vdout0_22ck990 FIND v(dout0_22) AT=500.025n

.meas tran vdout0_23ck990 FIND v(dout0_23) AT=500.025n

.meas tran vdout0_24ck990 FIND v(dout0_24) AT=500.025n

.meas tran vdout0_25ck990 FIND v(dout0_25) AT=500.025n

.meas tran vdout0_26ck990 FIND v(dout0_26) AT=500.025n

.meas tran vdout0_27ck990 FIND v(dout0_27) AT=500.025n

.meas tran vdout0_28ck990 FIND v(dout0_28) AT=500.025n

.meas tran vdout0_29ck990 FIND v(dout0_29) AT=500.025n

.meas tran vdout0_30ck990 FIND v(dout0_30) AT=500.025n

.meas tran vdout0_31ck990 FIND v(dout0_31) AT=500.025n

.meas tran vdout0_32ck990 FIND v(dout0_32) AT=500.025n

.meas tran vdout0_33ck990 FIND v(dout0_33) AT=500.025n

.meas tran vdout0_34ck990 FIND v(dout0_34) AT=500.025n

.meas tran vdout0_35ck990 FIND v(dout0_35) AT=500.025n

.meas tran vdout0_36ck990 FIND v(dout0_36) AT=500.025n

.meas tran vdout0_37ck990 FIND v(dout0_37) AT=500.025n

.meas tran vdout0_38ck990 FIND v(dout0_38) AT=500.025n

.meas tran vdout0_39ck990 FIND v(dout0_39) AT=500.025n

.meas tran vdout0_40ck990 FIND v(dout0_40) AT=500.025n

.meas tran vdout0_41ck990 FIND v(dout0_41) AT=500.025n

.meas tran vdout0_42ck990 FIND v(dout0_42) AT=500.025n

.meas tran vdout0_43ck990 FIND v(dout0_43) AT=500.025n

.meas tran vdout0_44ck990 FIND v(dout0_44) AT=500.025n

.meas tran vdout0_45ck990 FIND v(dout0_45) AT=500.025n

.meas tran vdout0_46ck990 FIND v(dout0_46) AT=500.025n

.meas tran vdout0_47ck990 FIND v(dout0_47) AT=500.025n

.meas tran vdout0_48ck990 FIND v(dout0_48) AT=500.025n

.meas tran vdout0_49ck990 FIND v(dout0_49) AT=500.025n

.meas tran vdout0_50ck990 FIND v(dout0_50) AT=500.025n

.meas tran vdout0_51ck990 FIND v(dout0_51) AT=500.025n

.meas tran vdout0_52ck990 FIND v(dout0_52) AT=500.025n

.meas tran vdout0_53ck990 FIND v(dout0_53) AT=500.025n

.meas tran vdout0_54ck990 FIND v(dout0_54) AT=500.025n

.meas tran vdout0_55ck990 FIND v(dout0_55) AT=500.025n

.meas tran vdout0_56ck990 FIND v(dout0_56) AT=500.025n

.meas tran vdout0_57ck990 FIND v(dout0_57) AT=500.025n

.meas tran vdout0_58ck990 FIND v(dout0_58) AT=500.025n

.meas tran vdout0_59ck990 FIND v(dout0_59) AT=500.025n

.meas tran vdout0_60ck990 FIND v(dout0_60) AT=500.025n

.meas tran vdout0_61ck990 FIND v(dout0_61) AT=500.025n

.meas tran vdout0_62ck990 FIND v(dout0_62) AT=500.025n

.meas tran vdout0_63ck990 FIND v(dout0_63) AT=500.025n

.meas tran vdout1_0ck990 FIND v(dout1_0) AT=500.025n

.meas tran vdout1_1ck990 FIND v(dout1_1) AT=500.025n

.meas tran vdout1_2ck990 FIND v(dout1_2) AT=500.025n

.meas tran vdout1_3ck990 FIND v(dout1_3) AT=500.025n

.meas tran vdout1_4ck990 FIND v(dout1_4) AT=500.025n

.meas tran vdout1_5ck990 FIND v(dout1_5) AT=500.025n

.meas tran vdout1_6ck990 FIND v(dout1_6) AT=500.025n

.meas tran vdout1_7ck990 FIND v(dout1_7) AT=500.025n

.meas tran vdout1_8ck990 FIND v(dout1_8) AT=500.025n

.meas tran vdout1_9ck990 FIND v(dout1_9) AT=500.025n

.meas tran vdout1_10ck990 FIND v(dout1_10) AT=500.025n

.meas tran vdout1_11ck990 FIND v(dout1_11) AT=500.025n

.meas tran vdout1_12ck990 FIND v(dout1_12) AT=500.025n

.meas tran vdout1_13ck990 FIND v(dout1_13) AT=500.025n

.meas tran vdout1_14ck990 FIND v(dout1_14) AT=500.025n

.meas tran vdout1_15ck990 FIND v(dout1_15) AT=500.025n

.meas tran vdout1_16ck990 FIND v(dout1_16) AT=500.025n

.meas tran vdout1_17ck990 FIND v(dout1_17) AT=500.025n

.meas tran vdout1_18ck990 FIND v(dout1_18) AT=500.025n

.meas tran vdout1_19ck990 FIND v(dout1_19) AT=500.025n

.meas tran vdout1_20ck990 FIND v(dout1_20) AT=500.025n

.meas tran vdout1_21ck990 FIND v(dout1_21) AT=500.025n

.meas tran vdout1_22ck990 FIND v(dout1_22) AT=500.025n

.meas tran vdout1_23ck990 FIND v(dout1_23) AT=500.025n

.meas tran vdout1_24ck990 FIND v(dout1_24) AT=500.025n

.meas tran vdout1_25ck990 FIND v(dout1_25) AT=500.025n

.meas tran vdout1_26ck990 FIND v(dout1_26) AT=500.025n

.meas tran vdout1_27ck990 FIND v(dout1_27) AT=500.025n

.meas tran vdout1_28ck990 FIND v(dout1_28) AT=500.025n

.meas tran vdout1_29ck990 FIND v(dout1_29) AT=500.025n

.meas tran vdout1_30ck990 FIND v(dout1_30) AT=500.025n

.meas tran vdout1_31ck990 FIND v(dout1_31) AT=500.025n

.meas tran vdout1_32ck990 FIND v(dout1_32) AT=500.025n

.meas tran vdout1_33ck990 FIND v(dout1_33) AT=500.025n

.meas tran vdout1_34ck990 FIND v(dout1_34) AT=500.025n

.meas tran vdout1_35ck990 FIND v(dout1_35) AT=500.025n

.meas tran vdout1_36ck990 FIND v(dout1_36) AT=500.025n

.meas tran vdout1_37ck990 FIND v(dout1_37) AT=500.025n

.meas tran vdout1_38ck990 FIND v(dout1_38) AT=500.025n

.meas tran vdout1_39ck990 FIND v(dout1_39) AT=500.025n

.meas tran vdout1_40ck990 FIND v(dout1_40) AT=500.025n

.meas tran vdout1_41ck990 FIND v(dout1_41) AT=500.025n

.meas tran vdout1_42ck990 FIND v(dout1_42) AT=500.025n

.meas tran vdout1_43ck990 FIND v(dout1_43) AT=500.025n

.meas tran vdout1_44ck990 FIND v(dout1_44) AT=500.025n

.meas tran vdout1_45ck990 FIND v(dout1_45) AT=500.025n

.meas tran vdout1_46ck990 FIND v(dout1_46) AT=500.025n

.meas tran vdout1_47ck990 FIND v(dout1_47) AT=500.025n

.meas tran vdout1_48ck990 FIND v(dout1_48) AT=500.025n

.meas tran vdout1_49ck990 FIND v(dout1_49) AT=500.025n

.meas tran vdout1_50ck990 FIND v(dout1_50) AT=500.025n

.meas tran vdout1_51ck990 FIND v(dout1_51) AT=500.025n

.meas tran vdout1_52ck990 FIND v(dout1_52) AT=500.025n

.meas tran vdout1_53ck990 FIND v(dout1_53) AT=500.025n

.meas tran vdout1_54ck990 FIND v(dout1_54) AT=500.025n

.meas tran vdout1_55ck990 FIND v(dout1_55) AT=500.025n

.meas tran vdout1_56ck990 FIND v(dout1_56) AT=500.025n

.meas tran vdout1_57ck990 FIND v(dout1_57) AT=500.025n

.meas tran vdout1_58ck990 FIND v(dout1_58) AT=500.025n

.meas tran vdout1_59ck990 FIND v(dout1_59) AT=500.025n

.meas tran vdout1_60ck990 FIND v(dout1_60) AT=500.025n

.meas tran vdout1_61ck990 FIND v(dout1_61) AT=500.025n

.meas tran vdout1_62ck990 FIND v(dout1_62) AT=500.025n

.meas tran vdout1_63ck990 FIND v(dout1_63) AT=500.025n

.meas tran vdout1_0ck1000 FIND v(dout1_0) AT=505.025n

.meas tran vdout1_1ck1000 FIND v(dout1_1) AT=505.025n

.meas tran vdout1_2ck1000 FIND v(dout1_2) AT=505.025n

.meas tran vdout1_3ck1000 FIND v(dout1_3) AT=505.025n

.meas tran vdout1_4ck1000 FIND v(dout1_4) AT=505.025n

.meas tran vdout1_5ck1000 FIND v(dout1_5) AT=505.025n

.meas tran vdout1_6ck1000 FIND v(dout1_6) AT=505.025n

.meas tran vdout1_7ck1000 FIND v(dout1_7) AT=505.025n

.meas tran vdout1_8ck1000 FIND v(dout1_8) AT=505.025n

.meas tran vdout1_9ck1000 FIND v(dout1_9) AT=505.025n

.meas tran vdout1_10ck1000 FIND v(dout1_10) AT=505.025n

.meas tran vdout1_11ck1000 FIND v(dout1_11) AT=505.025n

.meas tran vdout1_12ck1000 FIND v(dout1_12) AT=505.025n

.meas tran vdout1_13ck1000 FIND v(dout1_13) AT=505.025n

.meas tran vdout1_14ck1000 FIND v(dout1_14) AT=505.025n

.meas tran vdout1_15ck1000 FIND v(dout1_15) AT=505.025n

.meas tran vdout1_16ck1000 FIND v(dout1_16) AT=505.025n

.meas tran vdout1_17ck1000 FIND v(dout1_17) AT=505.025n

.meas tran vdout1_18ck1000 FIND v(dout1_18) AT=505.025n

.meas tran vdout1_19ck1000 FIND v(dout1_19) AT=505.025n

.meas tran vdout1_20ck1000 FIND v(dout1_20) AT=505.025n

.meas tran vdout1_21ck1000 FIND v(dout1_21) AT=505.025n

.meas tran vdout1_22ck1000 FIND v(dout1_22) AT=505.025n

.meas tran vdout1_23ck1000 FIND v(dout1_23) AT=505.025n

.meas tran vdout1_24ck1000 FIND v(dout1_24) AT=505.025n

.meas tran vdout1_25ck1000 FIND v(dout1_25) AT=505.025n

.meas tran vdout1_26ck1000 FIND v(dout1_26) AT=505.025n

.meas tran vdout1_27ck1000 FIND v(dout1_27) AT=505.025n

.meas tran vdout1_28ck1000 FIND v(dout1_28) AT=505.025n

.meas tran vdout1_29ck1000 FIND v(dout1_29) AT=505.025n

.meas tran vdout1_30ck1000 FIND v(dout1_30) AT=505.025n

.meas tran vdout1_31ck1000 FIND v(dout1_31) AT=505.025n

.meas tran vdout1_32ck1000 FIND v(dout1_32) AT=505.025n

.meas tran vdout1_33ck1000 FIND v(dout1_33) AT=505.025n

.meas tran vdout1_34ck1000 FIND v(dout1_34) AT=505.025n

.meas tran vdout1_35ck1000 FIND v(dout1_35) AT=505.025n

.meas tran vdout1_36ck1000 FIND v(dout1_36) AT=505.025n

.meas tran vdout1_37ck1000 FIND v(dout1_37) AT=505.025n

.meas tran vdout1_38ck1000 FIND v(dout1_38) AT=505.025n

.meas tran vdout1_39ck1000 FIND v(dout1_39) AT=505.025n

.meas tran vdout1_40ck1000 FIND v(dout1_40) AT=505.025n

.meas tran vdout1_41ck1000 FIND v(dout1_41) AT=505.025n

.meas tran vdout1_42ck1000 FIND v(dout1_42) AT=505.025n

.meas tran vdout1_43ck1000 FIND v(dout1_43) AT=505.025n

.meas tran vdout1_44ck1000 FIND v(dout1_44) AT=505.025n

.meas tran vdout1_45ck1000 FIND v(dout1_45) AT=505.025n

.meas tran vdout1_46ck1000 FIND v(dout1_46) AT=505.025n

.meas tran vdout1_47ck1000 FIND v(dout1_47) AT=505.025n

.meas tran vdout1_48ck1000 FIND v(dout1_48) AT=505.025n

.meas tran vdout1_49ck1000 FIND v(dout1_49) AT=505.025n

.meas tran vdout1_50ck1000 FIND v(dout1_50) AT=505.025n

.meas tran vdout1_51ck1000 FIND v(dout1_51) AT=505.025n

.meas tran vdout1_52ck1000 FIND v(dout1_52) AT=505.025n

.meas tran vdout1_53ck1000 FIND v(dout1_53) AT=505.025n

.meas tran vdout1_54ck1000 FIND v(dout1_54) AT=505.025n

.meas tran vdout1_55ck1000 FIND v(dout1_55) AT=505.025n

.meas tran vdout1_56ck1000 FIND v(dout1_56) AT=505.025n

.meas tran vdout1_57ck1000 FIND v(dout1_57) AT=505.025n

.meas tran vdout1_58ck1000 FIND v(dout1_58) AT=505.025n

.meas tran vdout1_59ck1000 FIND v(dout1_59) AT=505.025n

.meas tran vdout1_60ck1000 FIND v(dout1_60) AT=505.025n

.meas tran vdout1_61ck1000 FIND v(dout1_61) AT=505.025n

.meas tran vdout1_62ck1000 FIND v(dout1_62) AT=505.025n

.meas tran vdout1_63ck1000 FIND v(dout1_63) AT=505.025n

.meas tran vdout0_0ck1010 FIND v(dout0_0) AT=510.025n

.meas tran vdout0_1ck1010 FIND v(dout0_1) AT=510.025n

.meas tran vdout0_2ck1010 FIND v(dout0_2) AT=510.025n

.meas tran vdout0_3ck1010 FIND v(dout0_3) AT=510.025n

.meas tran vdout0_4ck1010 FIND v(dout0_4) AT=510.025n

.meas tran vdout0_5ck1010 FIND v(dout0_5) AT=510.025n

.meas tran vdout0_6ck1010 FIND v(dout0_6) AT=510.025n

.meas tran vdout0_7ck1010 FIND v(dout0_7) AT=510.025n

.meas tran vdout0_8ck1010 FIND v(dout0_8) AT=510.025n

.meas tran vdout0_9ck1010 FIND v(dout0_9) AT=510.025n

.meas tran vdout0_10ck1010 FIND v(dout0_10) AT=510.025n

.meas tran vdout0_11ck1010 FIND v(dout0_11) AT=510.025n

.meas tran vdout0_12ck1010 FIND v(dout0_12) AT=510.025n

.meas tran vdout0_13ck1010 FIND v(dout0_13) AT=510.025n

.meas tran vdout0_14ck1010 FIND v(dout0_14) AT=510.025n

.meas tran vdout0_15ck1010 FIND v(dout0_15) AT=510.025n

.meas tran vdout0_16ck1010 FIND v(dout0_16) AT=510.025n

.meas tran vdout0_17ck1010 FIND v(dout0_17) AT=510.025n

.meas tran vdout0_18ck1010 FIND v(dout0_18) AT=510.025n

.meas tran vdout0_19ck1010 FIND v(dout0_19) AT=510.025n

.meas tran vdout0_20ck1010 FIND v(dout0_20) AT=510.025n

.meas tran vdout0_21ck1010 FIND v(dout0_21) AT=510.025n

.meas tran vdout0_22ck1010 FIND v(dout0_22) AT=510.025n

.meas tran vdout0_23ck1010 FIND v(dout0_23) AT=510.025n

.meas tran vdout0_24ck1010 FIND v(dout0_24) AT=510.025n

.meas tran vdout0_25ck1010 FIND v(dout0_25) AT=510.025n

.meas tran vdout0_26ck1010 FIND v(dout0_26) AT=510.025n

.meas tran vdout0_27ck1010 FIND v(dout0_27) AT=510.025n

.meas tran vdout0_28ck1010 FIND v(dout0_28) AT=510.025n

.meas tran vdout0_29ck1010 FIND v(dout0_29) AT=510.025n

.meas tran vdout0_30ck1010 FIND v(dout0_30) AT=510.025n

.meas tran vdout0_31ck1010 FIND v(dout0_31) AT=510.025n

.meas tran vdout0_32ck1010 FIND v(dout0_32) AT=510.025n

.meas tran vdout0_33ck1010 FIND v(dout0_33) AT=510.025n

.meas tran vdout0_34ck1010 FIND v(dout0_34) AT=510.025n

.meas tran vdout0_35ck1010 FIND v(dout0_35) AT=510.025n

.meas tran vdout0_36ck1010 FIND v(dout0_36) AT=510.025n

.meas tran vdout0_37ck1010 FIND v(dout0_37) AT=510.025n

.meas tran vdout0_38ck1010 FIND v(dout0_38) AT=510.025n

.meas tran vdout0_39ck1010 FIND v(dout0_39) AT=510.025n

.meas tran vdout0_40ck1010 FIND v(dout0_40) AT=510.025n

.meas tran vdout0_41ck1010 FIND v(dout0_41) AT=510.025n

.meas tran vdout0_42ck1010 FIND v(dout0_42) AT=510.025n

.meas tran vdout0_43ck1010 FIND v(dout0_43) AT=510.025n

.meas tran vdout0_44ck1010 FIND v(dout0_44) AT=510.025n

.meas tran vdout0_45ck1010 FIND v(dout0_45) AT=510.025n

.meas tran vdout0_46ck1010 FIND v(dout0_46) AT=510.025n

.meas tran vdout0_47ck1010 FIND v(dout0_47) AT=510.025n

.meas tran vdout0_48ck1010 FIND v(dout0_48) AT=510.025n

.meas tran vdout0_49ck1010 FIND v(dout0_49) AT=510.025n

.meas tran vdout0_50ck1010 FIND v(dout0_50) AT=510.025n

.meas tran vdout0_51ck1010 FIND v(dout0_51) AT=510.025n

.meas tran vdout0_52ck1010 FIND v(dout0_52) AT=510.025n

.meas tran vdout0_53ck1010 FIND v(dout0_53) AT=510.025n

.meas tran vdout0_54ck1010 FIND v(dout0_54) AT=510.025n

.meas tran vdout0_55ck1010 FIND v(dout0_55) AT=510.025n

.meas tran vdout0_56ck1010 FIND v(dout0_56) AT=510.025n

.meas tran vdout0_57ck1010 FIND v(dout0_57) AT=510.025n

.meas tran vdout0_58ck1010 FIND v(dout0_58) AT=510.025n

.meas tran vdout0_59ck1010 FIND v(dout0_59) AT=510.025n

.meas tran vdout0_60ck1010 FIND v(dout0_60) AT=510.025n

.meas tran vdout0_61ck1010 FIND v(dout0_61) AT=510.025n

.meas tran vdout0_62ck1010 FIND v(dout0_62) AT=510.025n

.meas tran vdout0_63ck1010 FIND v(dout0_63) AT=510.025n

.meas tran vdout1_0ck1020 FIND v(dout1_0) AT=515.025n

.meas tran vdout1_1ck1020 FIND v(dout1_1) AT=515.025n

.meas tran vdout1_2ck1020 FIND v(dout1_2) AT=515.025n

.meas tran vdout1_3ck1020 FIND v(dout1_3) AT=515.025n

.meas tran vdout1_4ck1020 FIND v(dout1_4) AT=515.025n

.meas tran vdout1_5ck1020 FIND v(dout1_5) AT=515.025n

.meas tran vdout1_6ck1020 FIND v(dout1_6) AT=515.025n

.meas tran vdout1_7ck1020 FIND v(dout1_7) AT=515.025n

.meas tran vdout1_8ck1020 FIND v(dout1_8) AT=515.025n

.meas tran vdout1_9ck1020 FIND v(dout1_9) AT=515.025n

.meas tran vdout1_10ck1020 FIND v(dout1_10) AT=515.025n

.meas tran vdout1_11ck1020 FIND v(dout1_11) AT=515.025n

.meas tran vdout1_12ck1020 FIND v(dout1_12) AT=515.025n

.meas tran vdout1_13ck1020 FIND v(dout1_13) AT=515.025n

.meas tran vdout1_14ck1020 FIND v(dout1_14) AT=515.025n

.meas tran vdout1_15ck1020 FIND v(dout1_15) AT=515.025n

.meas tran vdout1_16ck1020 FIND v(dout1_16) AT=515.025n

.meas tran vdout1_17ck1020 FIND v(dout1_17) AT=515.025n

.meas tran vdout1_18ck1020 FIND v(dout1_18) AT=515.025n

.meas tran vdout1_19ck1020 FIND v(dout1_19) AT=515.025n

.meas tran vdout1_20ck1020 FIND v(dout1_20) AT=515.025n

.meas tran vdout1_21ck1020 FIND v(dout1_21) AT=515.025n

.meas tran vdout1_22ck1020 FIND v(dout1_22) AT=515.025n

.meas tran vdout1_23ck1020 FIND v(dout1_23) AT=515.025n

.meas tran vdout1_24ck1020 FIND v(dout1_24) AT=515.025n

.meas tran vdout1_25ck1020 FIND v(dout1_25) AT=515.025n

.meas tran vdout1_26ck1020 FIND v(dout1_26) AT=515.025n

.meas tran vdout1_27ck1020 FIND v(dout1_27) AT=515.025n

.meas tran vdout1_28ck1020 FIND v(dout1_28) AT=515.025n

.meas tran vdout1_29ck1020 FIND v(dout1_29) AT=515.025n

.meas tran vdout1_30ck1020 FIND v(dout1_30) AT=515.025n

.meas tran vdout1_31ck1020 FIND v(dout1_31) AT=515.025n

.meas tran vdout1_32ck1020 FIND v(dout1_32) AT=515.025n

.meas tran vdout1_33ck1020 FIND v(dout1_33) AT=515.025n

.meas tran vdout1_34ck1020 FIND v(dout1_34) AT=515.025n

.meas tran vdout1_35ck1020 FIND v(dout1_35) AT=515.025n

.meas tran vdout1_36ck1020 FIND v(dout1_36) AT=515.025n

.meas tran vdout1_37ck1020 FIND v(dout1_37) AT=515.025n

.meas tran vdout1_38ck1020 FIND v(dout1_38) AT=515.025n

.meas tran vdout1_39ck1020 FIND v(dout1_39) AT=515.025n

.meas tran vdout1_40ck1020 FIND v(dout1_40) AT=515.025n

.meas tran vdout1_41ck1020 FIND v(dout1_41) AT=515.025n

.meas tran vdout1_42ck1020 FIND v(dout1_42) AT=515.025n

.meas tran vdout1_43ck1020 FIND v(dout1_43) AT=515.025n

.meas tran vdout1_44ck1020 FIND v(dout1_44) AT=515.025n

.meas tran vdout1_45ck1020 FIND v(dout1_45) AT=515.025n

.meas tran vdout1_46ck1020 FIND v(dout1_46) AT=515.025n

.meas tran vdout1_47ck1020 FIND v(dout1_47) AT=515.025n

.meas tran vdout1_48ck1020 FIND v(dout1_48) AT=515.025n

.meas tran vdout1_49ck1020 FIND v(dout1_49) AT=515.025n

.meas tran vdout1_50ck1020 FIND v(dout1_50) AT=515.025n

.meas tran vdout1_51ck1020 FIND v(dout1_51) AT=515.025n

.meas tran vdout1_52ck1020 FIND v(dout1_52) AT=515.025n

.meas tran vdout1_53ck1020 FIND v(dout1_53) AT=515.025n

.meas tran vdout1_54ck1020 FIND v(dout1_54) AT=515.025n

.meas tran vdout1_55ck1020 FIND v(dout1_55) AT=515.025n

.meas tran vdout1_56ck1020 FIND v(dout1_56) AT=515.025n

.meas tran vdout1_57ck1020 FIND v(dout1_57) AT=515.025n

.meas tran vdout1_58ck1020 FIND v(dout1_58) AT=515.025n

.meas tran vdout1_59ck1020 FIND v(dout1_59) AT=515.025n

.meas tran vdout1_60ck1020 FIND v(dout1_60) AT=515.025n

.meas tran vdout1_61ck1020 FIND v(dout1_61) AT=515.025n

.meas tran vdout1_62ck1020 FIND v(dout1_62) AT=515.025n

.meas tran vdout1_63ck1020 FIND v(dout1_63) AT=515.025n

.meas tran vdout1_0ck1030 FIND v(dout1_0) AT=520.025n

.meas tran vdout1_1ck1030 FIND v(dout1_1) AT=520.025n

.meas tran vdout1_2ck1030 FIND v(dout1_2) AT=520.025n

.meas tran vdout1_3ck1030 FIND v(dout1_3) AT=520.025n

.meas tran vdout1_4ck1030 FIND v(dout1_4) AT=520.025n

.meas tran vdout1_5ck1030 FIND v(dout1_5) AT=520.025n

.meas tran vdout1_6ck1030 FIND v(dout1_6) AT=520.025n

.meas tran vdout1_7ck1030 FIND v(dout1_7) AT=520.025n

.meas tran vdout1_8ck1030 FIND v(dout1_8) AT=520.025n

.meas tran vdout1_9ck1030 FIND v(dout1_9) AT=520.025n

.meas tran vdout1_10ck1030 FIND v(dout1_10) AT=520.025n

.meas tran vdout1_11ck1030 FIND v(dout1_11) AT=520.025n

.meas tran vdout1_12ck1030 FIND v(dout1_12) AT=520.025n

.meas tran vdout1_13ck1030 FIND v(dout1_13) AT=520.025n

.meas tran vdout1_14ck1030 FIND v(dout1_14) AT=520.025n

.meas tran vdout1_15ck1030 FIND v(dout1_15) AT=520.025n

.meas tran vdout1_16ck1030 FIND v(dout1_16) AT=520.025n

.meas tran vdout1_17ck1030 FIND v(dout1_17) AT=520.025n

.meas tran vdout1_18ck1030 FIND v(dout1_18) AT=520.025n

.meas tran vdout1_19ck1030 FIND v(dout1_19) AT=520.025n

.meas tran vdout1_20ck1030 FIND v(dout1_20) AT=520.025n

.meas tran vdout1_21ck1030 FIND v(dout1_21) AT=520.025n

.meas tran vdout1_22ck1030 FIND v(dout1_22) AT=520.025n

.meas tran vdout1_23ck1030 FIND v(dout1_23) AT=520.025n

.meas tran vdout1_24ck1030 FIND v(dout1_24) AT=520.025n

.meas tran vdout1_25ck1030 FIND v(dout1_25) AT=520.025n

.meas tran vdout1_26ck1030 FIND v(dout1_26) AT=520.025n

.meas tran vdout1_27ck1030 FIND v(dout1_27) AT=520.025n

.meas tran vdout1_28ck1030 FIND v(dout1_28) AT=520.025n

.meas tran vdout1_29ck1030 FIND v(dout1_29) AT=520.025n

.meas tran vdout1_30ck1030 FIND v(dout1_30) AT=520.025n

.meas tran vdout1_31ck1030 FIND v(dout1_31) AT=520.025n

.meas tran vdout1_32ck1030 FIND v(dout1_32) AT=520.025n

.meas tran vdout1_33ck1030 FIND v(dout1_33) AT=520.025n

.meas tran vdout1_34ck1030 FIND v(dout1_34) AT=520.025n

.meas tran vdout1_35ck1030 FIND v(dout1_35) AT=520.025n

.meas tran vdout1_36ck1030 FIND v(dout1_36) AT=520.025n

.meas tran vdout1_37ck1030 FIND v(dout1_37) AT=520.025n

.meas tran vdout1_38ck1030 FIND v(dout1_38) AT=520.025n

.meas tran vdout1_39ck1030 FIND v(dout1_39) AT=520.025n

.meas tran vdout1_40ck1030 FIND v(dout1_40) AT=520.025n

.meas tran vdout1_41ck1030 FIND v(dout1_41) AT=520.025n

.meas tran vdout1_42ck1030 FIND v(dout1_42) AT=520.025n

.meas tran vdout1_43ck1030 FIND v(dout1_43) AT=520.025n

.meas tran vdout1_44ck1030 FIND v(dout1_44) AT=520.025n

.meas tran vdout1_45ck1030 FIND v(dout1_45) AT=520.025n

.meas tran vdout1_46ck1030 FIND v(dout1_46) AT=520.025n

.meas tran vdout1_47ck1030 FIND v(dout1_47) AT=520.025n

.meas tran vdout1_48ck1030 FIND v(dout1_48) AT=520.025n

.meas tran vdout1_49ck1030 FIND v(dout1_49) AT=520.025n

.meas tran vdout1_50ck1030 FIND v(dout1_50) AT=520.025n

.meas tran vdout1_51ck1030 FIND v(dout1_51) AT=520.025n

.meas tran vdout1_52ck1030 FIND v(dout1_52) AT=520.025n

.meas tran vdout1_53ck1030 FIND v(dout1_53) AT=520.025n

.meas tran vdout1_54ck1030 FIND v(dout1_54) AT=520.025n

.meas tran vdout1_55ck1030 FIND v(dout1_55) AT=520.025n

.meas tran vdout1_56ck1030 FIND v(dout1_56) AT=520.025n

.meas tran vdout1_57ck1030 FIND v(dout1_57) AT=520.025n

.meas tran vdout1_58ck1030 FIND v(dout1_58) AT=520.025n

.meas tran vdout1_59ck1030 FIND v(dout1_59) AT=520.025n

.meas tran vdout1_60ck1030 FIND v(dout1_60) AT=520.025n

.meas tran vdout1_61ck1030 FIND v(dout1_61) AT=520.025n

.meas tran vdout1_62ck1030 FIND v(dout1_62) AT=520.025n

.meas tran vdout1_63ck1030 FIND v(dout1_63) AT=520.025n

.meas tran vdout0_0ck1040 FIND v(dout0_0) AT=525.025n

.meas tran vdout0_1ck1040 FIND v(dout0_1) AT=525.025n

.meas tran vdout0_2ck1040 FIND v(dout0_2) AT=525.025n

.meas tran vdout0_3ck1040 FIND v(dout0_3) AT=525.025n

.meas tran vdout0_4ck1040 FIND v(dout0_4) AT=525.025n

.meas tran vdout0_5ck1040 FIND v(dout0_5) AT=525.025n

.meas tran vdout0_6ck1040 FIND v(dout0_6) AT=525.025n

.meas tran vdout0_7ck1040 FIND v(dout0_7) AT=525.025n

.meas tran vdout0_8ck1040 FIND v(dout0_8) AT=525.025n

.meas tran vdout0_9ck1040 FIND v(dout0_9) AT=525.025n

.meas tran vdout0_10ck1040 FIND v(dout0_10) AT=525.025n

.meas tran vdout0_11ck1040 FIND v(dout0_11) AT=525.025n

.meas tran vdout0_12ck1040 FIND v(dout0_12) AT=525.025n

.meas tran vdout0_13ck1040 FIND v(dout0_13) AT=525.025n

.meas tran vdout0_14ck1040 FIND v(dout0_14) AT=525.025n

.meas tran vdout0_15ck1040 FIND v(dout0_15) AT=525.025n

.meas tran vdout0_16ck1040 FIND v(dout0_16) AT=525.025n

.meas tran vdout0_17ck1040 FIND v(dout0_17) AT=525.025n

.meas tran vdout0_18ck1040 FIND v(dout0_18) AT=525.025n

.meas tran vdout0_19ck1040 FIND v(dout0_19) AT=525.025n

.meas tran vdout0_20ck1040 FIND v(dout0_20) AT=525.025n

.meas tran vdout0_21ck1040 FIND v(dout0_21) AT=525.025n

.meas tran vdout0_22ck1040 FIND v(dout0_22) AT=525.025n

.meas tran vdout0_23ck1040 FIND v(dout0_23) AT=525.025n

.meas tran vdout0_24ck1040 FIND v(dout0_24) AT=525.025n

.meas tran vdout0_25ck1040 FIND v(dout0_25) AT=525.025n

.meas tran vdout0_26ck1040 FIND v(dout0_26) AT=525.025n

.meas tran vdout0_27ck1040 FIND v(dout0_27) AT=525.025n

.meas tran vdout0_28ck1040 FIND v(dout0_28) AT=525.025n

.meas tran vdout0_29ck1040 FIND v(dout0_29) AT=525.025n

.meas tran vdout0_30ck1040 FIND v(dout0_30) AT=525.025n

.meas tran vdout0_31ck1040 FIND v(dout0_31) AT=525.025n

.meas tran vdout0_32ck1040 FIND v(dout0_32) AT=525.025n

.meas tran vdout0_33ck1040 FIND v(dout0_33) AT=525.025n

.meas tran vdout0_34ck1040 FIND v(dout0_34) AT=525.025n

.meas tran vdout0_35ck1040 FIND v(dout0_35) AT=525.025n

.meas tran vdout0_36ck1040 FIND v(dout0_36) AT=525.025n

.meas tran vdout0_37ck1040 FIND v(dout0_37) AT=525.025n

.meas tran vdout0_38ck1040 FIND v(dout0_38) AT=525.025n

.meas tran vdout0_39ck1040 FIND v(dout0_39) AT=525.025n

.meas tran vdout0_40ck1040 FIND v(dout0_40) AT=525.025n

.meas tran vdout0_41ck1040 FIND v(dout0_41) AT=525.025n

.meas tran vdout0_42ck1040 FIND v(dout0_42) AT=525.025n

.meas tran vdout0_43ck1040 FIND v(dout0_43) AT=525.025n

.meas tran vdout0_44ck1040 FIND v(dout0_44) AT=525.025n

.meas tran vdout0_45ck1040 FIND v(dout0_45) AT=525.025n

.meas tran vdout0_46ck1040 FIND v(dout0_46) AT=525.025n

.meas tran vdout0_47ck1040 FIND v(dout0_47) AT=525.025n

.meas tran vdout0_48ck1040 FIND v(dout0_48) AT=525.025n

.meas tran vdout0_49ck1040 FIND v(dout0_49) AT=525.025n

.meas tran vdout0_50ck1040 FIND v(dout0_50) AT=525.025n

.meas tran vdout0_51ck1040 FIND v(dout0_51) AT=525.025n

.meas tran vdout0_52ck1040 FIND v(dout0_52) AT=525.025n

.meas tran vdout0_53ck1040 FIND v(dout0_53) AT=525.025n

.meas tran vdout0_54ck1040 FIND v(dout0_54) AT=525.025n

.meas tran vdout0_55ck1040 FIND v(dout0_55) AT=525.025n

.meas tran vdout0_56ck1040 FIND v(dout0_56) AT=525.025n

.meas tran vdout0_57ck1040 FIND v(dout0_57) AT=525.025n

.meas tran vdout0_58ck1040 FIND v(dout0_58) AT=525.025n

.meas tran vdout0_59ck1040 FIND v(dout0_59) AT=525.025n

.meas tran vdout0_60ck1040 FIND v(dout0_60) AT=525.025n

.meas tran vdout0_61ck1040 FIND v(dout0_61) AT=525.025n

.meas tran vdout0_62ck1040 FIND v(dout0_62) AT=525.025n

.meas tran vdout0_63ck1040 FIND v(dout0_63) AT=525.025n

.meas tran vdout0_0ck1050 FIND v(dout0_0) AT=530.025n

.meas tran vdout0_1ck1050 FIND v(dout0_1) AT=530.025n

.meas tran vdout0_2ck1050 FIND v(dout0_2) AT=530.025n

.meas tran vdout0_3ck1050 FIND v(dout0_3) AT=530.025n

.meas tran vdout0_4ck1050 FIND v(dout0_4) AT=530.025n

.meas tran vdout0_5ck1050 FIND v(dout0_5) AT=530.025n

.meas tran vdout0_6ck1050 FIND v(dout0_6) AT=530.025n

.meas tran vdout0_7ck1050 FIND v(dout0_7) AT=530.025n

.meas tran vdout0_8ck1050 FIND v(dout0_8) AT=530.025n

.meas tran vdout0_9ck1050 FIND v(dout0_9) AT=530.025n

.meas tran vdout0_10ck1050 FIND v(dout0_10) AT=530.025n

.meas tran vdout0_11ck1050 FIND v(dout0_11) AT=530.025n

.meas tran vdout0_12ck1050 FIND v(dout0_12) AT=530.025n

.meas tran vdout0_13ck1050 FIND v(dout0_13) AT=530.025n

.meas tran vdout0_14ck1050 FIND v(dout0_14) AT=530.025n

.meas tran vdout0_15ck1050 FIND v(dout0_15) AT=530.025n

.meas tran vdout0_16ck1050 FIND v(dout0_16) AT=530.025n

.meas tran vdout0_17ck1050 FIND v(dout0_17) AT=530.025n

.meas tran vdout0_18ck1050 FIND v(dout0_18) AT=530.025n

.meas tran vdout0_19ck1050 FIND v(dout0_19) AT=530.025n

.meas tran vdout0_20ck1050 FIND v(dout0_20) AT=530.025n

.meas tran vdout0_21ck1050 FIND v(dout0_21) AT=530.025n

.meas tran vdout0_22ck1050 FIND v(dout0_22) AT=530.025n

.meas tran vdout0_23ck1050 FIND v(dout0_23) AT=530.025n

.meas tran vdout0_24ck1050 FIND v(dout0_24) AT=530.025n

.meas tran vdout0_25ck1050 FIND v(dout0_25) AT=530.025n

.meas tran vdout0_26ck1050 FIND v(dout0_26) AT=530.025n

.meas tran vdout0_27ck1050 FIND v(dout0_27) AT=530.025n

.meas tran vdout0_28ck1050 FIND v(dout0_28) AT=530.025n

.meas tran vdout0_29ck1050 FIND v(dout0_29) AT=530.025n

.meas tran vdout0_30ck1050 FIND v(dout0_30) AT=530.025n

.meas tran vdout0_31ck1050 FIND v(dout0_31) AT=530.025n

.meas tran vdout0_32ck1050 FIND v(dout0_32) AT=530.025n

.meas tran vdout0_33ck1050 FIND v(dout0_33) AT=530.025n

.meas tran vdout0_34ck1050 FIND v(dout0_34) AT=530.025n

.meas tran vdout0_35ck1050 FIND v(dout0_35) AT=530.025n

.meas tran vdout0_36ck1050 FIND v(dout0_36) AT=530.025n

.meas tran vdout0_37ck1050 FIND v(dout0_37) AT=530.025n

.meas tran vdout0_38ck1050 FIND v(dout0_38) AT=530.025n

.meas tran vdout0_39ck1050 FIND v(dout0_39) AT=530.025n

.meas tran vdout0_40ck1050 FIND v(dout0_40) AT=530.025n

.meas tran vdout0_41ck1050 FIND v(dout0_41) AT=530.025n

.meas tran vdout0_42ck1050 FIND v(dout0_42) AT=530.025n

.meas tran vdout0_43ck1050 FIND v(dout0_43) AT=530.025n

.meas tran vdout0_44ck1050 FIND v(dout0_44) AT=530.025n

.meas tran vdout0_45ck1050 FIND v(dout0_45) AT=530.025n

.meas tran vdout0_46ck1050 FIND v(dout0_46) AT=530.025n

.meas tran vdout0_47ck1050 FIND v(dout0_47) AT=530.025n

.meas tran vdout0_48ck1050 FIND v(dout0_48) AT=530.025n

.meas tran vdout0_49ck1050 FIND v(dout0_49) AT=530.025n

.meas tran vdout0_50ck1050 FIND v(dout0_50) AT=530.025n

.meas tran vdout0_51ck1050 FIND v(dout0_51) AT=530.025n

.meas tran vdout0_52ck1050 FIND v(dout0_52) AT=530.025n

.meas tran vdout0_53ck1050 FIND v(dout0_53) AT=530.025n

.meas tran vdout0_54ck1050 FIND v(dout0_54) AT=530.025n

.meas tran vdout0_55ck1050 FIND v(dout0_55) AT=530.025n

.meas tran vdout0_56ck1050 FIND v(dout0_56) AT=530.025n

.meas tran vdout0_57ck1050 FIND v(dout0_57) AT=530.025n

.meas tran vdout0_58ck1050 FIND v(dout0_58) AT=530.025n

.meas tran vdout0_59ck1050 FIND v(dout0_59) AT=530.025n

.meas tran vdout0_60ck1050 FIND v(dout0_60) AT=530.025n

.meas tran vdout0_61ck1050 FIND v(dout0_61) AT=530.025n

.meas tran vdout0_62ck1050 FIND v(dout0_62) AT=530.025n

.meas tran vdout0_63ck1050 FIND v(dout0_63) AT=530.025n

.meas tran vdout1_0ck1070 FIND v(dout1_0) AT=540.025n

.meas tran vdout1_1ck1070 FIND v(dout1_1) AT=540.025n

.meas tran vdout1_2ck1070 FIND v(dout1_2) AT=540.025n

.meas tran vdout1_3ck1070 FIND v(dout1_3) AT=540.025n

.meas tran vdout1_4ck1070 FIND v(dout1_4) AT=540.025n

.meas tran vdout1_5ck1070 FIND v(dout1_5) AT=540.025n

.meas tran vdout1_6ck1070 FIND v(dout1_6) AT=540.025n

.meas tran vdout1_7ck1070 FIND v(dout1_7) AT=540.025n

.meas tran vdout1_8ck1070 FIND v(dout1_8) AT=540.025n

.meas tran vdout1_9ck1070 FIND v(dout1_9) AT=540.025n

.meas tran vdout1_10ck1070 FIND v(dout1_10) AT=540.025n

.meas tran vdout1_11ck1070 FIND v(dout1_11) AT=540.025n

.meas tran vdout1_12ck1070 FIND v(dout1_12) AT=540.025n

.meas tran vdout1_13ck1070 FIND v(dout1_13) AT=540.025n

.meas tran vdout1_14ck1070 FIND v(dout1_14) AT=540.025n

.meas tran vdout1_15ck1070 FIND v(dout1_15) AT=540.025n

.meas tran vdout1_16ck1070 FIND v(dout1_16) AT=540.025n

.meas tran vdout1_17ck1070 FIND v(dout1_17) AT=540.025n

.meas tran vdout1_18ck1070 FIND v(dout1_18) AT=540.025n

.meas tran vdout1_19ck1070 FIND v(dout1_19) AT=540.025n

.meas tran vdout1_20ck1070 FIND v(dout1_20) AT=540.025n

.meas tran vdout1_21ck1070 FIND v(dout1_21) AT=540.025n

.meas tran vdout1_22ck1070 FIND v(dout1_22) AT=540.025n

.meas tran vdout1_23ck1070 FIND v(dout1_23) AT=540.025n

.meas tran vdout1_24ck1070 FIND v(dout1_24) AT=540.025n

.meas tran vdout1_25ck1070 FIND v(dout1_25) AT=540.025n

.meas tran vdout1_26ck1070 FIND v(dout1_26) AT=540.025n

.meas tran vdout1_27ck1070 FIND v(dout1_27) AT=540.025n

.meas tran vdout1_28ck1070 FIND v(dout1_28) AT=540.025n

.meas tran vdout1_29ck1070 FIND v(dout1_29) AT=540.025n

.meas tran vdout1_30ck1070 FIND v(dout1_30) AT=540.025n

.meas tran vdout1_31ck1070 FIND v(dout1_31) AT=540.025n

.meas tran vdout1_32ck1070 FIND v(dout1_32) AT=540.025n

.meas tran vdout1_33ck1070 FIND v(dout1_33) AT=540.025n

.meas tran vdout1_34ck1070 FIND v(dout1_34) AT=540.025n

.meas tran vdout1_35ck1070 FIND v(dout1_35) AT=540.025n

.meas tran vdout1_36ck1070 FIND v(dout1_36) AT=540.025n

.meas tran vdout1_37ck1070 FIND v(dout1_37) AT=540.025n

.meas tran vdout1_38ck1070 FIND v(dout1_38) AT=540.025n

.meas tran vdout1_39ck1070 FIND v(dout1_39) AT=540.025n

.meas tran vdout1_40ck1070 FIND v(dout1_40) AT=540.025n

.meas tran vdout1_41ck1070 FIND v(dout1_41) AT=540.025n

.meas tran vdout1_42ck1070 FIND v(dout1_42) AT=540.025n

.meas tran vdout1_43ck1070 FIND v(dout1_43) AT=540.025n

.meas tran vdout1_44ck1070 FIND v(dout1_44) AT=540.025n

.meas tran vdout1_45ck1070 FIND v(dout1_45) AT=540.025n

.meas tran vdout1_46ck1070 FIND v(dout1_46) AT=540.025n

.meas tran vdout1_47ck1070 FIND v(dout1_47) AT=540.025n

.meas tran vdout1_48ck1070 FIND v(dout1_48) AT=540.025n

.meas tran vdout1_49ck1070 FIND v(dout1_49) AT=540.025n

.meas tran vdout1_50ck1070 FIND v(dout1_50) AT=540.025n

.meas tran vdout1_51ck1070 FIND v(dout1_51) AT=540.025n

.meas tran vdout1_52ck1070 FIND v(dout1_52) AT=540.025n

.meas tran vdout1_53ck1070 FIND v(dout1_53) AT=540.025n

.meas tran vdout1_54ck1070 FIND v(dout1_54) AT=540.025n

.meas tran vdout1_55ck1070 FIND v(dout1_55) AT=540.025n

.meas tran vdout1_56ck1070 FIND v(dout1_56) AT=540.025n

.meas tran vdout1_57ck1070 FIND v(dout1_57) AT=540.025n

.meas tran vdout1_58ck1070 FIND v(dout1_58) AT=540.025n

.meas tran vdout1_59ck1070 FIND v(dout1_59) AT=540.025n

.meas tran vdout1_60ck1070 FIND v(dout1_60) AT=540.025n

.meas tran vdout1_61ck1070 FIND v(dout1_61) AT=540.025n

.meas tran vdout1_62ck1070 FIND v(dout1_62) AT=540.025n

.meas tran vdout1_63ck1070 FIND v(dout1_63) AT=540.025n

.meas tran vdout0_0ck1110 FIND v(dout0_0) AT=560.025n

.meas tran vdout0_1ck1110 FIND v(dout0_1) AT=560.025n

.meas tran vdout0_2ck1110 FIND v(dout0_2) AT=560.025n

.meas tran vdout0_3ck1110 FIND v(dout0_3) AT=560.025n

.meas tran vdout0_4ck1110 FIND v(dout0_4) AT=560.025n

.meas tran vdout0_5ck1110 FIND v(dout0_5) AT=560.025n

.meas tran vdout0_6ck1110 FIND v(dout0_6) AT=560.025n

.meas tran vdout0_7ck1110 FIND v(dout0_7) AT=560.025n

.meas tran vdout0_8ck1110 FIND v(dout0_8) AT=560.025n

.meas tran vdout0_9ck1110 FIND v(dout0_9) AT=560.025n

.meas tran vdout0_10ck1110 FIND v(dout0_10) AT=560.025n

.meas tran vdout0_11ck1110 FIND v(dout0_11) AT=560.025n

.meas tran vdout0_12ck1110 FIND v(dout0_12) AT=560.025n

.meas tran vdout0_13ck1110 FIND v(dout0_13) AT=560.025n

.meas tran vdout0_14ck1110 FIND v(dout0_14) AT=560.025n

.meas tran vdout0_15ck1110 FIND v(dout0_15) AT=560.025n

.meas tran vdout0_16ck1110 FIND v(dout0_16) AT=560.025n

.meas tran vdout0_17ck1110 FIND v(dout0_17) AT=560.025n

.meas tran vdout0_18ck1110 FIND v(dout0_18) AT=560.025n

.meas tran vdout0_19ck1110 FIND v(dout0_19) AT=560.025n

.meas tran vdout0_20ck1110 FIND v(dout0_20) AT=560.025n

.meas tran vdout0_21ck1110 FIND v(dout0_21) AT=560.025n

.meas tran vdout0_22ck1110 FIND v(dout0_22) AT=560.025n

.meas tran vdout0_23ck1110 FIND v(dout0_23) AT=560.025n

.meas tran vdout0_24ck1110 FIND v(dout0_24) AT=560.025n

.meas tran vdout0_25ck1110 FIND v(dout0_25) AT=560.025n

.meas tran vdout0_26ck1110 FIND v(dout0_26) AT=560.025n

.meas tran vdout0_27ck1110 FIND v(dout0_27) AT=560.025n

.meas tran vdout0_28ck1110 FIND v(dout0_28) AT=560.025n

.meas tran vdout0_29ck1110 FIND v(dout0_29) AT=560.025n

.meas tran vdout0_30ck1110 FIND v(dout0_30) AT=560.025n

.meas tran vdout0_31ck1110 FIND v(dout0_31) AT=560.025n

.meas tran vdout0_32ck1110 FIND v(dout0_32) AT=560.025n

.meas tran vdout0_33ck1110 FIND v(dout0_33) AT=560.025n

.meas tran vdout0_34ck1110 FIND v(dout0_34) AT=560.025n

.meas tran vdout0_35ck1110 FIND v(dout0_35) AT=560.025n

.meas tran vdout0_36ck1110 FIND v(dout0_36) AT=560.025n

.meas tran vdout0_37ck1110 FIND v(dout0_37) AT=560.025n

.meas tran vdout0_38ck1110 FIND v(dout0_38) AT=560.025n

.meas tran vdout0_39ck1110 FIND v(dout0_39) AT=560.025n

.meas tran vdout0_40ck1110 FIND v(dout0_40) AT=560.025n

.meas tran vdout0_41ck1110 FIND v(dout0_41) AT=560.025n

.meas tran vdout0_42ck1110 FIND v(dout0_42) AT=560.025n

.meas tran vdout0_43ck1110 FIND v(dout0_43) AT=560.025n

.meas tran vdout0_44ck1110 FIND v(dout0_44) AT=560.025n

.meas tran vdout0_45ck1110 FIND v(dout0_45) AT=560.025n

.meas tran vdout0_46ck1110 FIND v(dout0_46) AT=560.025n

.meas tran vdout0_47ck1110 FIND v(dout0_47) AT=560.025n

.meas tran vdout0_48ck1110 FIND v(dout0_48) AT=560.025n

.meas tran vdout0_49ck1110 FIND v(dout0_49) AT=560.025n

.meas tran vdout0_50ck1110 FIND v(dout0_50) AT=560.025n

.meas tran vdout0_51ck1110 FIND v(dout0_51) AT=560.025n

.meas tran vdout0_52ck1110 FIND v(dout0_52) AT=560.025n

.meas tran vdout0_53ck1110 FIND v(dout0_53) AT=560.025n

.meas tran vdout0_54ck1110 FIND v(dout0_54) AT=560.025n

.meas tran vdout0_55ck1110 FIND v(dout0_55) AT=560.025n

.meas tran vdout0_56ck1110 FIND v(dout0_56) AT=560.025n

.meas tran vdout0_57ck1110 FIND v(dout0_57) AT=560.025n

.meas tran vdout0_58ck1110 FIND v(dout0_58) AT=560.025n

.meas tran vdout0_59ck1110 FIND v(dout0_59) AT=560.025n

.meas tran vdout0_60ck1110 FIND v(dout0_60) AT=560.025n

.meas tran vdout0_61ck1110 FIND v(dout0_61) AT=560.025n

.meas tran vdout0_62ck1110 FIND v(dout0_62) AT=560.025n

.meas tran vdout0_63ck1110 FIND v(dout0_63) AT=560.025n

.meas tran vdout1_0ck1110 FIND v(dout1_0) AT=560.025n

.meas tran vdout1_1ck1110 FIND v(dout1_1) AT=560.025n

.meas tran vdout1_2ck1110 FIND v(dout1_2) AT=560.025n

.meas tran vdout1_3ck1110 FIND v(dout1_3) AT=560.025n

.meas tran vdout1_4ck1110 FIND v(dout1_4) AT=560.025n

.meas tran vdout1_5ck1110 FIND v(dout1_5) AT=560.025n

.meas tran vdout1_6ck1110 FIND v(dout1_6) AT=560.025n

.meas tran vdout1_7ck1110 FIND v(dout1_7) AT=560.025n

.meas tran vdout1_8ck1110 FIND v(dout1_8) AT=560.025n

.meas tran vdout1_9ck1110 FIND v(dout1_9) AT=560.025n

.meas tran vdout1_10ck1110 FIND v(dout1_10) AT=560.025n

.meas tran vdout1_11ck1110 FIND v(dout1_11) AT=560.025n

.meas tran vdout1_12ck1110 FIND v(dout1_12) AT=560.025n

.meas tran vdout1_13ck1110 FIND v(dout1_13) AT=560.025n

.meas tran vdout1_14ck1110 FIND v(dout1_14) AT=560.025n

.meas tran vdout1_15ck1110 FIND v(dout1_15) AT=560.025n

.meas tran vdout1_16ck1110 FIND v(dout1_16) AT=560.025n

.meas tran vdout1_17ck1110 FIND v(dout1_17) AT=560.025n

.meas tran vdout1_18ck1110 FIND v(dout1_18) AT=560.025n

.meas tran vdout1_19ck1110 FIND v(dout1_19) AT=560.025n

.meas tran vdout1_20ck1110 FIND v(dout1_20) AT=560.025n

.meas tran vdout1_21ck1110 FIND v(dout1_21) AT=560.025n

.meas tran vdout1_22ck1110 FIND v(dout1_22) AT=560.025n

.meas tran vdout1_23ck1110 FIND v(dout1_23) AT=560.025n

.meas tran vdout1_24ck1110 FIND v(dout1_24) AT=560.025n

.meas tran vdout1_25ck1110 FIND v(dout1_25) AT=560.025n

.meas tran vdout1_26ck1110 FIND v(dout1_26) AT=560.025n

.meas tran vdout1_27ck1110 FIND v(dout1_27) AT=560.025n

.meas tran vdout1_28ck1110 FIND v(dout1_28) AT=560.025n

.meas tran vdout1_29ck1110 FIND v(dout1_29) AT=560.025n

.meas tran vdout1_30ck1110 FIND v(dout1_30) AT=560.025n

.meas tran vdout1_31ck1110 FIND v(dout1_31) AT=560.025n

.meas tran vdout1_32ck1110 FIND v(dout1_32) AT=560.025n

.meas tran vdout1_33ck1110 FIND v(dout1_33) AT=560.025n

.meas tran vdout1_34ck1110 FIND v(dout1_34) AT=560.025n

.meas tran vdout1_35ck1110 FIND v(dout1_35) AT=560.025n

.meas tran vdout1_36ck1110 FIND v(dout1_36) AT=560.025n

.meas tran vdout1_37ck1110 FIND v(dout1_37) AT=560.025n

.meas tran vdout1_38ck1110 FIND v(dout1_38) AT=560.025n

.meas tran vdout1_39ck1110 FIND v(dout1_39) AT=560.025n

.meas tran vdout1_40ck1110 FIND v(dout1_40) AT=560.025n

.meas tran vdout1_41ck1110 FIND v(dout1_41) AT=560.025n

.meas tran vdout1_42ck1110 FIND v(dout1_42) AT=560.025n

.meas tran vdout1_43ck1110 FIND v(dout1_43) AT=560.025n

.meas tran vdout1_44ck1110 FIND v(dout1_44) AT=560.025n

.meas tran vdout1_45ck1110 FIND v(dout1_45) AT=560.025n

.meas tran vdout1_46ck1110 FIND v(dout1_46) AT=560.025n

.meas tran vdout1_47ck1110 FIND v(dout1_47) AT=560.025n

.meas tran vdout1_48ck1110 FIND v(dout1_48) AT=560.025n

.meas tran vdout1_49ck1110 FIND v(dout1_49) AT=560.025n

.meas tran vdout1_50ck1110 FIND v(dout1_50) AT=560.025n

.meas tran vdout1_51ck1110 FIND v(dout1_51) AT=560.025n

.meas tran vdout1_52ck1110 FIND v(dout1_52) AT=560.025n

.meas tran vdout1_53ck1110 FIND v(dout1_53) AT=560.025n

.meas tran vdout1_54ck1110 FIND v(dout1_54) AT=560.025n

.meas tran vdout1_55ck1110 FIND v(dout1_55) AT=560.025n

.meas tran vdout1_56ck1110 FIND v(dout1_56) AT=560.025n

.meas tran vdout1_57ck1110 FIND v(dout1_57) AT=560.025n

.meas tran vdout1_58ck1110 FIND v(dout1_58) AT=560.025n

.meas tran vdout1_59ck1110 FIND v(dout1_59) AT=560.025n

.meas tran vdout1_60ck1110 FIND v(dout1_60) AT=560.025n

.meas tran vdout1_61ck1110 FIND v(dout1_61) AT=560.025n

.meas tran vdout1_62ck1110 FIND v(dout1_62) AT=560.025n

.meas tran vdout1_63ck1110 FIND v(dout1_63) AT=560.025n

.meas tran vdout1_0ck1120 FIND v(dout1_0) AT=565.025n

.meas tran vdout1_1ck1120 FIND v(dout1_1) AT=565.025n

.meas tran vdout1_2ck1120 FIND v(dout1_2) AT=565.025n

.meas tran vdout1_3ck1120 FIND v(dout1_3) AT=565.025n

.meas tran vdout1_4ck1120 FIND v(dout1_4) AT=565.025n

.meas tran vdout1_5ck1120 FIND v(dout1_5) AT=565.025n

.meas tran vdout1_6ck1120 FIND v(dout1_6) AT=565.025n

.meas tran vdout1_7ck1120 FIND v(dout1_7) AT=565.025n

.meas tran vdout1_8ck1120 FIND v(dout1_8) AT=565.025n

.meas tran vdout1_9ck1120 FIND v(dout1_9) AT=565.025n

.meas tran vdout1_10ck1120 FIND v(dout1_10) AT=565.025n

.meas tran vdout1_11ck1120 FIND v(dout1_11) AT=565.025n

.meas tran vdout1_12ck1120 FIND v(dout1_12) AT=565.025n

.meas tran vdout1_13ck1120 FIND v(dout1_13) AT=565.025n

.meas tran vdout1_14ck1120 FIND v(dout1_14) AT=565.025n

.meas tran vdout1_15ck1120 FIND v(dout1_15) AT=565.025n

.meas tran vdout1_16ck1120 FIND v(dout1_16) AT=565.025n

.meas tran vdout1_17ck1120 FIND v(dout1_17) AT=565.025n

.meas tran vdout1_18ck1120 FIND v(dout1_18) AT=565.025n

.meas tran vdout1_19ck1120 FIND v(dout1_19) AT=565.025n

.meas tran vdout1_20ck1120 FIND v(dout1_20) AT=565.025n

.meas tran vdout1_21ck1120 FIND v(dout1_21) AT=565.025n

.meas tran vdout1_22ck1120 FIND v(dout1_22) AT=565.025n

.meas tran vdout1_23ck1120 FIND v(dout1_23) AT=565.025n

.meas tran vdout1_24ck1120 FIND v(dout1_24) AT=565.025n

.meas tran vdout1_25ck1120 FIND v(dout1_25) AT=565.025n

.meas tran vdout1_26ck1120 FIND v(dout1_26) AT=565.025n

.meas tran vdout1_27ck1120 FIND v(dout1_27) AT=565.025n

.meas tran vdout1_28ck1120 FIND v(dout1_28) AT=565.025n

.meas tran vdout1_29ck1120 FIND v(dout1_29) AT=565.025n

.meas tran vdout1_30ck1120 FIND v(dout1_30) AT=565.025n

.meas tran vdout1_31ck1120 FIND v(dout1_31) AT=565.025n

.meas tran vdout1_32ck1120 FIND v(dout1_32) AT=565.025n

.meas tran vdout1_33ck1120 FIND v(dout1_33) AT=565.025n

.meas tran vdout1_34ck1120 FIND v(dout1_34) AT=565.025n

.meas tran vdout1_35ck1120 FIND v(dout1_35) AT=565.025n

.meas tran vdout1_36ck1120 FIND v(dout1_36) AT=565.025n

.meas tran vdout1_37ck1120 FIND v(dout1_37) AT=565.025n

.meas tran vdout1_38ck1120 FIND v(dout1_38) AT=565.025n

.meas tran vdout1_39ck1120 FIND v(dout1_39) AT=565.025n

.meas tran vdout1_40ck1120 FIND v(dout1_40) AT=565.025n

.meas tran vdout1_41ck1120 FIND v(dout1_41) AT=565.025n

.meas tran vdout1_42ck1120 FIND v(dout1_42) AT=565.025n

.meas tran vdout1_43ck1120 FIND v(dout1_43) AT=565.025n

.meas tran vdout1_44ck1120 FIND v(dout1_44) AT=565.025n

.meas tran vdout1_45ck1120 FIND v(dout1_45) AT=565.025n

.meas tran vdout1_46ck1120 FIND v(dout1_46) AT=565.025n

.meas tran vdout1_47ck1120 FIND v(dout1_47) AT=565.025n

.meas tran vdout1_48ck1120 FIND v(dout1_48) AT=565.025n

.meas tran vdout1_49ck1120 FIND v(dout1_49) AT=565.025n

.meas tran vdout1_50ck1120 FIND v(dout1_50) AT=565.025n

.meas tran vdout1_51ck1120 FIND v(dout1_51) AT=565.025n

.meas tran vdout1_52ck1120 FIND v(dout1_52) AT=565.025n

.meas tran vdout1_53ck1120 FIND v(dout1_53) AT=565.025n

.meas tran vdout1_54ck1120 FIND v(dout1_54) AT=565.025n

.meas tran vdout1_55ck1120 FIND v(dout1_55) AT=565.025n

.meas tran vdout1_56ck1120 FIND v(dout1_56) AT=565.025n

.meas tran vdout1_57ck1120 FIND v(dout1_57) AT=565.025n

.meas tran vdout1_58ck1120 FIND v(dout1_58) AT=565.025n

.meas tran vdout1_59ck1120 FIND v(dout1_59) AT=565.025n

.meas tran vdout1_60ck1120 FIND v(dout1_60) AT=565.025n

.meas tran vdout1_61ck1120 FIND v(dout1_61) AT=565.025n

.meas tran vdout1_62ck1120 FIND v(dout1_62) AT=565.025n

.meas tran vdout1_63ck1120 FIND v(dout1_63) AT=565.025n

.meas tran vdout0_0ck1130 FIND v(dout0_0) AT=570.025n

.meas tran vdout0_1ck1130 FIND v(dout0_1) AT=570.025n

.meas tran vdout0_2ck1130 FIND v(dout0_2) AT=570.025n

.meas tran vdout0_3ck1130 FIND v(dout0_3) AT=570.025n

.meas tran vdout0_4ck1130 FIND v(dout0_4) AT=570.025n

.meas tran vdout0_5ck1130 FIND v(dout0_5) AT=570.025n

.meas tran vdout0_6ck1130 FIND v(dout0_6) AT=570.025n

.meas tran vdout0_7ck1130 FIND v(dout0_7) AT=570.025n

.meas tran vdout0_8ck1130 FIND v(dout0_8) AT=570.025n

.meas tran vdout0_9ck1130 FIND v(dout0_9) AT=570.025n

.meas tran vdout0_10ck1130 FIND v(dout0_10) AT=570.025n

.meas tran vdout0_11ck1130 FIND v(dout0_11) AT=570.025n

.meas tran vdout0_12ck1130 FIND v(dout0_12) AT=570.025n

.meas tran vdout0_13ck1130 FIND v(dout0_13) AT=570.025n

.meas tran vdout0_14ck1130 FIND v(dout0_14) AT=570.025n

.meas tran vdout0_15ck1130 FIND v(dout0_15) AT=570.025n

.meas tran vdout0_16ck1130 FIND v(dout0_16) AT=570.025n

.meas tran vdout0_17ck1130 FIND v(dout0_17) AT=570.025n

.meas tran vdout0_18ck1130 FIND v(dout0_18) AT=570.025n

.meas tran vdout0_19ck1130 FIND v(dout0_19) AT=570.025n

.meas tran vdout0_20ck1130 FIND v(dout0_20) AT=570.025n

.meas tran vdout0_21ck1130 FIND v(dout0_21) AT=570.025n

.meas tran vdout0_22ck1130 FIND v(dout0_22) AT=570.025n

.meas tran vdout0_23ck1130 FIND v(dout0_23) AT=570.025n

.meas tran vdout0_24ck1130 FIND v(dout0_24) AT=570.025n

.meas tran vdout0_25ck1130 FIND v(dout0_25) AT=570.025n

.meas tran vdout0_26ck1130 FIND v(dout0_26) AT=570.025n

.meas tran vdout0_27ck1130 FIND v(dout0_27) AT=570.025n

.meas tran vdout0_28ck1130 FIND v(dout0_28) AT=570.025n

.meas tran vdout0_29ck1130 FIND v(dout0_29) AT=570.025n

.meas tran vdout0_30ck1130 FIND v(dout0_30) AT=570.025n

.meas tran vdout0_31ck1130 FIND v(dout0_31) AT=570.025n

.meas tran vdout0_32ck1130 FIND v(dout0_32) AT=570.025n

.meas tran vdout0_33ck1130 FIND v(dout0_33) AT=570.025n

.meas tran vdout0_34ck1130 FIND v(dout0_34) AT=570.025n

.meas tran vdout0_35ck1130 FIND v(dout0_35) AT=570.025n

.meas tran vdout0_36ck1130 FIND v(dout0_36) AT=570.025n

.meas tran vdout0_37ck1130 FIND v(dout0_37) AT=570.025n

.meas tran vdout0_38ck1130 FIND v(dout0_38) AT=570.025n

.meas tran vdout0_39ck1130 FIND v(dout0_39) AT=570.025n

.meas tran vdout0_40ck1130 FIND v(dout0_40) AT=570.025n

.meas tran vdout0_41ck1130 FIND v(dout0_41) AT=570.025n

.meas tran vdout0_42ck1130 FIND v(dout0_42) AT=570.025n

.meas tran vdout0_43ck1130 FIND v(dout0_43) AT=570.025n

.meas tran vdout0_44ck1130 FIND v(dout0_44) AT=570.025n

.meas tran vdout0_45ck1130 FIND v(dout0_45) AT=570.025n

.meas tran vdout0_46ck1130 FIND v(dout0_46) AT=570.025n

.meas tran vdout0_47ck1130 FIND v(dout0_47) AT=570.025n

.meas tran vdout0_48ck1130 FIND v(dout0_48) AT=570.025n

.meas tran vdout0_49ck1130 FIND v(dout0_49) AT=570.025n

.meas tran vdout0_50ck1130 FIND v(dout0_50) AT=570.025n

.meas tran vdout0_51ck1130 FIND v(dout0_51) AT=570.025n

.meas tran vdout0_52ck1130 FIND v(dout0_52) AT=570.025n

.meas tran vdout0_53ck1130 FIND v(dout0_53) AT=570.025n

.meas tran vdout0_54ck1130 FIND v(dout0_54) AT=570.025n

.meas tran vdout0_55ck1130 FIND v(dout0_55) AT=570.025n

.meas tran vdout0_56ck1130 FIND v(dout0_56) AT=570.025n

.meas tran vdout0_57ck1130 FIND v(dout0_57) AT=570.025n

.meas tran vdout0_58ck1130 FIND v(dout0_58) AT=570.025n

.meas tran vdout0_59ck1130 FIND v(dout0_59) AT=570.025n

.meas tran vdout0_60ck1130 FIND v(dout0_60) AT=570.025n

.meas tran vdout0_61ck1130 FIND v(dout0_61) AT=570.025n

.meas tran vdout0_62ck1130 FIND v(dout0_62) AT=570.025n

.meas tran vdout0_63ck1130 FIND v(dout0_63) AT=570.025n

.meas tran vdout1_0ck1130 FIND v(dout1_0) AT=570.025n

.meas tran vdout1_1ck1130 FIND v(dout1_1) AT=570.025n

.meas tran vdout1_2ck1130 FIND v(dout1_2) AT=570.025n

.meas tran vdout1_3ck1130 FIND v(dout1_3) AT=570.025n

.meas tran vdout1_4ck1130 FIND v(dout1_4) AT=570.025n

.meas tran vdout1_5ck1130 FIND v(dout1_5) AT=570.025n

.meas tran vdout1_6ck1130 FIND v(dout1_6) AT=570.025n

.meas tran vdout1_7ck1130 FIND v(dout1_7) AT=570.025n

.meas tran vdout1_8ck1130 FIND v(dout1_8) AT=570.025n

.meas tran vdout1_9ck1130 FIND v(dout1_9) AT=570.025n

.meas tran vdout1_10ck1130 FIND v(dout1_10) AT=570.025n

.meas tran vdout1_11ck1130 FIND v(dout1_11) AT=570.025n

.meas tran vdout1_12ck1130 FIND v(dout1_12) AT=570.025n

.meas tran vdout1_13ck1130 FIND v(dout1_13) AT=570.025n

.meas tran vdout1_14ck1130 FIND v(dout1_14) AT=570.025n

.meas tran vdout1_15ck1130 FIND v(dout1_15) AT=570.025n

.meas tran vdout1_16ck1130 FIND v(dout1_16) AT=570.025n

.meas tran vdout1_17ck1130 FIND v(dout1_17) AT=570.025n

.meas tran vdout1_18ck1130 FIND v(dout1_18) AT=570.025n

.meas tran vdout1_19ck1130 FIND v(dout1_19) AT=570.025n

.meas tran vdout1_20ck1130 FIND v(dout1_20) AT=570.025n

.meas tran vdout1_21ck1130 FIND v(dout1_21) AT=570.025n

.meas tran vdout1_22ck1130 FIND v(dout1_22) AT=570.025n

.meas tran vdout1_23ck1130 FIND v(dout1_23) AT=570.025n

.meas tran vdout1_24ck1130 FIND v(dout1_24) AT=570.025n

.meas tran vdout1_25ck1130 FIND v(dout1_25) AT=570.025n

.meas tran vdout1_26ck1130 FIND v(dout1_26) AT=570.025n

.meas tran vdout1_27ck1130 FIND v(dout1_27) AT=570.025n

.meas tran vdout1_28ck1130 FIND v(dout1_28) AT=570.025n

.meas tran vdout1_29ck1130 FIND v(dout1_29) AT=570.025n

.meas tran vdout1_30ck1130 FIND v(dout1_30) AT=570.025n

.meas tran vdout1_31ck1130 FIND v(dout1_31) AT=570.025n

.meas tran vdout1_32ck1130 FIND v(dout1_32) AT=570.025n

.meas tran vdout1_33ck1130 FIND v(dout1_33) AT=570.025n

.meas tran vdout1_34ck1130 FIND v(dout1_34) AT=570.025n

.meas tran vdout1_35ck1130 FIND v(dout1_35) AT=570.025n

.meas tran vdout1_36ck1130 FIND v(dout1_36) AT=570.025n

.meas tran vdout1_37ck1130 FIND v(dout1_37) AT=570.025n

.meas tran vdout1_38ck1130 FIND v(dout1_38) AT=570.025n

.meas tran vdout1_39ck1130 FIND v(dout1_39) AT=570.025n

.meas tran vdout1_40ck1130 FIND v(dout1_40) AT=570.025n

.meas tran vdout1_41ck1130 FIND v(dout1_41) AT=570.025n

.meas tran vdout1_42ck1130 FIND v(dout1_42) AT=570.025n

.meas tran vdout1_43ck1130 FIND v(dout1_43) AT=570.025n

.meas tran vdout1_44ck1130 FIND v(dout1_44) AT=570.025n

.meas tran vdout1_45ck1130 FIND v(dout1_45) AT=570.025n

.meas tran vdout1_46ck1130 FIND v(dout1_46) AT=570.025n

.meas tran vdout1_47ck1130 FIND v(dout1_47) AT=570.025n

.meas tran vdout1_48ck1130 FIND v(dout1_48) AT=570.025n

.meas tran vdout1_49ck1130 FIND v(dout1_49) AT=570.025n

.meas tran vdout1_50ck1130 FIND v(dout1_50) AT=570.025n

.meas tran vdout1_51ck1130 FIND v(dout1_51) AT=570.025n

.meas tran vdout1_52ck1130 FIND v(dout1_52) AT=570.025n

.meas tran vdout1_53ck1130 FIND v(dout1_53) AT=570.025n

.meas tran vdout1_54ck1130 FIND v(dout1_54) AT=570.025n

.meas tran vdout1_55ck1130 FIND v(dout1_55) AT=570.025n

.meas tran vdout1_56ck1130 FIND v(dout1_56) AT=570.025n

.meas tran vdout1_57ck1130 FIND v(dout1_57) AT=570.025n

.meas tran vdout1_58ck1130 FIND v(dout1_58) AT=570.025n

.meas tran vdout1_59ck1130 FIND v(dout1_59) AT=570.025n

.meas tran vdout1_60ck1130 FIND v(dout1_60) AT=570.025n

.meas tran vdout1_61ck1130 FIND v(dout1_61) AT=570.025n

.meas tran vdout1_62ck1130 FIND v(dout1_62) AT=570.025n

.meas tran vdout1_63ck1130 FIND v(dout1_63) AT=570.025n

.meas tran vdout0_0ck1140 FIND v(dout0_0) AT=575.025n

.meas tran vdout0_1ck1140 FIND v(dout0_1) AT=575.025n

.meas tran vdout0_2ck1140 FIND v(dout0_2) AT=575.025n

.meas tran vdout0_3ck1140 FIND v(dout0_3) AT=575.025n

.meas tran vdout0_4ck1140 FIND v(dout0_4) AT=575.025n

.meas tran vdout0_5ck1140 FIND v(dout0_5) AT=575.025n

.meas tran vdout0_6ck1140 FIND v(dout0_6) AT=575.025n

.meas tran vdout0_7ck1140 FIND v(dout0_7) AT=575.025n

.meas tran vdout0_8ck1140 FIND v(dout0_8) AT=575.025n

.meas tran vdout0_9ck1140 FIND v(dout0_9) AT=575.025n

.meas tran vdout0_10ck1140 FIND v(dout0_10) AT=575.025n

.meas tran vdout0_11ck1140 FIND v(dout0_11) AT=575.025n

.meas tran vdout0_12ck1140 FIND v(dout0_12) AT=575.025n

.meas tran vdout0_13ck1140 FIND v(dout0_13) AT=575.025n

.meas tran vdout0_14ck1140 FIND v(dout0_14) AT=575.025n

.meas tran vdout0_15ck1140 FIND v(dout0_15) AT=575.025n

.meas tran vdout0_16ck1140 FIND v(dout0_16) AT=575.025n

.meas tran vdout0_17ck1140 FIND v(dout0_17) AT=575.025n

.meas tran vdout0_18ck1140 FIND v(dout0_18) AT=575.025n

.meas tran vdout0_19ck1140 FIND v(dout0_19) AT=575.025n

.meas tran vdout0_20ck1140 FIND v(dout0_20) AT=575.025n

.meas tran vdout0_21ck1140 FIND v(dout0_21) AT=575.025n

.meas tran vdout0_22ck1140 FIND v(dout0_22) AT=575.025n

.meas tran vdout0_23ck1140 FIND v(dout0_23) AT=575.025n

.meas tran vdout0_24ck1140 FIND v(dout0_24) AT=575.025n

.meas tran vdout0_25ck1140 FIND v(dout0_25) AT=575.025n

.meas tran vdout0_26ck1140 FIND v(dout0_26) AT=575.025n

.meas tran vdout0_27ck1140 FIND v(dout0_27) AT=575.025n

.meas tran vdout0_28ck1140 FIND v(dout0_28) AT=575.025n

.meas tran vdout0_29ck1140 FIND v(dout0_29) AT=575.025n

.meas tran vdout0_30ck1140 FIND v(dout0_30) AT=575.025n

.meas tran vdout0_31ck1140 FIND v(dout0_31) AT=575.025n

.meas tran vdout0_32ck1140 FIND v(dout0_32) AT=575.025n

.meas tran vdout0_33ck1140 FIND v(dout0_33) AT=575.025n

.meas tran vdout0_34ck1140 FIND v(dout0_34) AT=575.025n

.meas tran vdout0_35ck1140 FIND v(dout0_35) AT=575.025n

.meas tran vdout0_36ck1140 FIND v(dout0_36) AT=575.025n

.meas tran vdout0_37ck1140 FIND v(dout0_37) AT=575.025n

.meas tran vdout0_38ck1140 FIND v(dout0_38) AT=575.025n

.meas tran vdout0_39ck1140 FIND v(dout0_39) AT=575.025n

.meas tran vdout0_40ck1140 FIND v(dout0_40) AT=575.025n

.meas tran vdout0_41ck1140 FIND v(dout0_41) AT=575.025n

.meas tran vdout0_42ck1140 FIND v(dout0_42) AT=575.025n

.meas tran vdout0_43ck1140 FIND v(dout0_43) AT=575.025n

.meas tran vdout0_44ck1140 FIND v(dout0_44) AT=575.025n

.meas tran vdout0_45ck1140 FIND v(dout0_45) AT=575.025n

.meas tran vdout0_46ck1140 FIND v(dout0_46) AT=575.025n

.meas tran vdout0_47ck1140 FIND v(dout0_47) AT=575.025n

.meas tran vdout0_48ck1140 FIND v(dout0_48) AT=575.025n

.meas tran vdout0_49ck1140 FIND v(dout0_49) AT=575.025n

.meas tran vdout0_50ck1140 FIND v(dout0_50) AT=575.025n

.meas tran vdout0_51ck1140 FIND v(dout0_51) AT=575.025n

.meas tran vdout0_52ck1140 FIND v(dout0_52) AT=575.025n

.meas tran vdout0_53ck1140 FIND v(dout0_53) AT=575.025n

.meas tran vdout0_54ck1140 FIND v(dout0_54) AT=575.025n

.meas tran vdout0_55ck1140 FIND v(dout0_55) AT=575.025n

.meas tran vdout0_56ck1140 FIND v(dout0_56) AT=575.025n

.meas tran vdout0_57ck1140 FIND v(dout0_57) AT=575.025n

.meas tran vdout0_58ck1140 FIND v(dout0_58) AT=575.025n

.meas tran vdout0_59ck1140 FIND v(dout0_59) AT=575.025n

.meas tran vdout0_60ck1140 FIND v(dout0_60) AT=575.025n

.meas tran vdout0_61ck1140 FIND v(dout0_61) AT=575.025n

.meas tran vdout0_62ck1140 FIND v(dout0_62) AT=575.025n

.meas tran vdout0_63ck1140 FIND v(dout0_63) AT=575.025n

.meas tran vdout1_0ck1140 FIND v(dout1_0) AT=575.025n

.meas tran vdout1_1ck1140 FIND v(dout1_1) AT=575.025n

.meas tran vdout1_2ck1140 FIND v(dout1_2) AT=575.025n

.meas tran vdout1_3ck1140 FIND v(dout1_3) AT=575.025n

.meas tran vdout1_4ck1140 FIND v(dout1_4) AT=575.025n

.meas tran vdout1_5ck1140 FIND v(dout1_5) AT=575.025n

.meas tran vdout1_6ck1140 FIND v(dout1_6) AT=575.025n

.meas tran vdout1_7ck1140 FIND v(dout1_7) AT=575.025n

.meas tran vdout1_8ck1140 FIND v(dout1_8) AT=575.025n

.meas tran vdout1_9ck1140 FIND v(dout1_9) AT=575.025n

.meas tran vdout1_10ck1140 FIND v(dout1_10) AT=575.025n

.meas tran vdout1_11ck1140 FIND v(dout1_11) AT=575.025n

.meas tran vdout1_12ck1140 FIND v(dout1_12) AT=575.025n

.meas tran vdout1_13ck1140 FIND v(dout1_13) AT=575.025n

.meas tran vdout1_14ck1140 FIND v(dout1_14) AT=575.025n

.meas tran vdout1_15ck1140 FIND v(dout1_15) AT=575.025n

.meas tran vdout1_16ck1140 FIND v(dout1_16) AT=575.025n

.meas tran vdout1_17ck1140 FIND v(dout1_17) AT=575.025n

.meas tran vdout1_18ck1140 FIND v(dout1_18) AT=575.025n

.meas tran vdout1_19ck1140 FIND v(dout1_19) AT=575.025n

.meas tran vdout1_20ck1140 FIND v(dout1_20) AT=575.025n

.meas tran vdout1_21ck1140 FIND v(dout1_21) AT=575.025n

.meas tran vdout1_22ck1140 FIND v(dout1_22) AT=575.025n

.meas tran vdout1_23ck1140 FIND v(dout1_23) AT=575.025n

.meas tran vdout1_24ck1140 FIND v(dout1_24) AT=575.025n

.meas tran vdout1_25ck1140 FIND v(dout1_25) AT=575.025n

.meas tran vdout1_26ck1140 FIND v(dout1_26) AT=575.025n

.meas tran vdout1_27ck1140 FIND v(dout1_27) AT=575.025n

.meas tran vdout1_28ck1140 FIND v(dout1_28) AT=575.025n

.meas tran vdout1_29ck1140 FIND v(dout1_29) AT=575.025n

.meas tran vdout1_30ck1140 FIND v(dout1_30) AT=575.025n

.meas tran vdout1_31ck1140 FIND v(dout1_31) AT=575.025n

.meas tran vdout1_32ck1140 FIND v(dout1_32) AT=575.025n

.meas tran vdout1_33ck1140 FIND v(dout1_33) AT=575.025n

.meas tran vdout1_34ck1140 FIND v(dout1_34) AT=575.025n

.meas tran vdout1_35ck1140 FIND v(dout1_35) AT=575.025n

.meas tran vdout1_36ck1140 FIND v(dout1_36) AT=575.025n

.meas tran vdout1_37ck1140 FIND v(dout1_37) AT=575.025n

.meas tran vdout1_38ck1140 FIND v(dout1_38) AT=575.025n

.meas tran vdout1_39ck1140 FIND v(dout1_39) AT=575.025n

.meas tran vdout1_40ck1140 FIND v(dout1_40) AT=575.025n

.meas tran vdout1_41ck1140 FIND v(dout1_41) AT=575.025n

.meas tran vdout1_42ck1140 FIND v(dout1_42) AT=575.025n

.meas tran vdout1_43ck1140 FIND v(dout1_43) AT=575.025n

.meas tran vdout1_44ck1140 FIND v(dout1_44) AT=575.025n

.meas tran vdout1_45ck1140 FIND v(dout1_45) AT=575.025n

.meas tran vdout1_46ck1140 FIND v(dout1_46) AT=575.025n

.meas tran vdout1_47ck1140 FIND v(dout1_47) AT=575.025n

.meas tran vdout1_48ck1140 FIND v(dout1_48) AT=575.025n

.meas tran vdout1_49ck1140 FIND v(dout1_49) AT=575.025n

.meas tran vdout1_50ck1140 FIND v(dout1_50) AT=575.025n

.meas tran vdout1_51ck1140 FIND v(dout1_51) AT=575.025n

.meas tran vdout1_52ck1140 FIND v(dout1_52) AT=575.025n

.meas tran vdout1_53ck1140 FIND v(dout1_53) AT=575.025n

.meas tran vdout1_54ck1140 FIND v(dout1_54) AT=575.025n

.meas tran vdout1_55ck1140 FIND v(dout1_55) AT=575.025n

.meas tran vdout1_56ck1140 FIND v(dout1_56) AT=575.025n

.meas tran vdout1_57ck1140 FIND v(dout1_57) AT=575.025n

.meas tran vdout1_58ck1140 FIND v(dout1_58) AT=575.025n

.meas tran vdout1_59ck1140 FIND v(dout1_59) AT=575.025n

.meas tran vdout1_60ck1140 FIND v(dout1_60) AT=575.025n

.meas tran vdout1_61ck1140 FIND v(dout1_61) AT=575.025n

.meas tran vdout1_62ck1140 FIND v(dout1_62) AT=575.025n

.meas tran vdout1_63ck1140 FIND v(dout1_63) AT=575.025n

.meas tran vdout0_0ck1150 FIND v(dout0_0) AT=580.025n

.meas tran vdout0_1ck1150 FIND v(dout0_1) AT=580.025n

.meas tran vdout0_2ck1150 FIND v(dout0_2) AT=580.025n

.meas tran vdout0_3ck1150 FIND v(dout0_3) AT=580.025n

.meas tran vdout0_4ck1150 FIND v(dout0_4) AT=580.025n

.meas tran vdout0_5ck1150 FIND v(dout0_5) AT=580.025n

.meas tran vdout0_6ck1150 FIND v(dout0_6) AT=580.025n

.meas tran vdout0_7ck1150 FIND v(dout0_7) AT=580.025n

.meas tran vdout0_8ck1150 FIND v(dout0_8) AT=580.025n

.meas tran vdout0_9ck1150 FIND v(dout0_9) AT=580.025n

.meas tran vdout0_10ck1150 FIND v(dout0_10) AT=580.025n

.meas tran vdout0_11ck1150 FIND v(dout0_11) AT=580.025n

.meas tran vdout0_12ck1150 FIND v(dout0_12) AT=580.025n

.meas tran vdout0_13ck1150 FIND v(dout0_13) AT=580.025n

.meas tran vdout0_14ck1150 FIND v(dout0_14) AT=580.025n

.meas tran vdout0_15ck1150 FIND v(dout0_15) AT=580.025n

.meas tran vdout0_16ck1150 FIND v(dout0_16) AT=580.025n

.meas tran vdout0_17ck1150 FIND v(dout0_17) AT=580.025n

.meas tran vdout0_18ck1150 FIND v(dout0_18) AT=580.025n

.meas tran vdout0_19ck1150 FIND v(dout0_19) AT=580.025n

.meas tran vdout0_20ck1150 FIND v(dout0_20) AT=580.025n

.meas tran vdout0_21ck1150 FIND v(dout0_21) AT=580.025n

.meas tran vdout0_22ck1150 FIND v(dout0_22) AT=580.025n

.meas tran vdout0_23ck1150 FIND v(dout0_23) AT=580.025n

.meas tran vdout0_24ck1150 FIND v(dout0_24) AT=580.025n

.meas tran vdout0_25ck1150 FIND v(dout0_25) AT=580.025n

.meas tran vdout0_26ck1150 FIND v(dout0_26) AT=580.025n

.meas tran vdout0_27ck1150 FIND v(dout0_27) AT=580.025n

.meas tran vdout0_28ck1150 FIND v(dout0_28) AT=580.025n

.meas tran vdout0_29ck1150 FIND v(dout0_29) AT=580.025n

.meas tran vdout0_30ck1150 FIND v(dout0_30) AT=580.025n

.meas tran vdout0_31ck1150 FIND v(dout0_31) AT=580.025n

.meas tran vdout0_32ck1150 FIND v(dout0_32) AT=580.025n

.meas tran vdout0_33ck1150 FIND v(dout0_33) AT=580.025n

.meas tran vdout0_34ck1150 FIND v(dout0_34) AT=580.025n

.meas tran vdout0_35ck1150 FIND v(dout0_35) AT=580.025n

.meas tran vdout0_36ck1150 FIND v(dout0_36) AT=580.025n

.meas tran vdout0_37ck1150 FIND v(dout0_37) AT=580.025n

.meas tran vdout0_38ck1150 FIND v(dout0_38) AT=580.025n

.meas tran vdout0_39ck1150 FIND v(dout0_39) AT=580.025n

.meas tran vdout0_40ck1150 FIND v(dout0_40) AT=580.025n

.meas tran vdout0_41ck1150 FIND v(dout0_41) AT=580.025n

.meas tran vdout0_42ck1150 FIND v(dout0_42) AT=580.025n

.meas tran vdout0_43ck1150 FIND v(dout0_43) AT=580.025n

.meas tran vdout0_44ck1150 FIND v(dout0_44) AT=580.025n

.meas tran vdout0_45ck1150 FIND v(dout0_45) AT=580.025n

.meas tran vdout0_46ck1150 FIND v(dout0_46) AT=580.025n

.meas tran vdout0_47ck1150 FIND v(dout0_47) AT=580.025n

.meas tran vdout0_48ck1150 FIND v(dout0_48) AT=580.025n

.meas tran vdout0_49ck1150 FIND v(dout0_49) AT=580.025n

.meas tran vdout0_50ck1150 FIND v(dout0_50) AT=580.025n

.meas tran vdout0_51ck1150 FIND v(dout0_51) AT=580.025n

.meas tran vdout0_52ck1150 FIND v(dout0_52) AT=580.025n

.meas tran vdout0_53ck1150 FIND v(dout0_53) AT=580.025n

.meas tran vdout0_54ck1150 FIND v(dout0_54) AT=580.025n

.meas tran vdout0_55ck1150 FIND v(dout0_55) AT=580.025n

.meas tran vdout0_56ck1150 FIND v(dout0_56) AT=580.025n

.meas tran vdout0_57ck1150 FIND v(dout0_57) AT=580.025n

.meas tran vdout0_58ck1150 FIND v(dout0_58) AT=580.025n

.meas tran vdout0_59ck1150 FIND v(dout0_59) AT=580.025n

.meas tran vdout0_60ck1150 FIND v(dout0_60) AT=580.025n

.meas tran vdout0_61ck1150 FIND v(dout0_61) AT=580.025n

.meas tran vdout0_62ck1150 FIND v(dout0_62) AT=580.025n

.meas tran vdout0_63ck1150 FIND v(dout0_63) AT=580.025n

.meas tran vdout1_0ck1180 FIND v(dout1_0) AT=595.025n

.meas tran vdout1_1ck1180 FIND v(dout1_1) AT=595.025n

.meas tran vdout1_2ck1180 FIND v(dout1_2) AT=595.025n

.meas tran vdout1_3ck1180 FIND v(dout1_3) AT=595.025n

.meas tran vdout1_4ck1180 FIND v(dout1_4) AT=595.025n

.meas tran vdout1_5ck1180 FIND v(dout1_5) AT=595.025n

.meas tran vdout1_6ck1180 FIND v(dout1_6) AT=595.025n

.meas tran vdout1_7ck1180 FIND v(dout1_7) AT=595.025n

.meas tran vdout1_8ck1180 FIND v(dout1_8) AT=595.025n

.meas tran vdout1_9ck1180 FIND v(dout1_9) AT=595.025n

.meas tran vdout1_10ck1180 FIND v(dout1_10) AT=595.025n

.meas tran vdout1_11ck1180 FIND v(dout1_11) AT=595.025n

.meas tran vdout1_12ck1180 FIND v(dout1_12) AT=595.025n

.meas tran vdout1_13ck1180 FIND v(dout1_13) AT=595.025n

.meas tran vdout1_14ck1180 FIND v(dout1_14) AT=595.025n

.meas tran vdout1_15ck1180 FIND v(dout1_15) AT=595.025n

.meas tran vdout1_16ck1180 FIND v(dout1_16) AT=595.025n

.meas tran vdout1_17ck1180 FIND v(dout1_17) AT=595.025n

.meas tran vdout1_18ck1180 FIND v(dout1_18) AT=595.025n

.meas tran vdout1_19ck1180 FIND v(dout1_19) AT=595.025n

.meas tran vdout1_20ck1180 FIND v(dout1_20) AT=595.025n

.meas tran vdout1_21ck1180 FIND v(dout1_21) AT=595.025n

.meas tran vdout1_22ck1180 FIND v(dout1_22) AT=595.025n

.meas tran vdout1_23ck1180 FIND v(dout1_23) AT=595.025n

.meas tran vdout1_24ck1180 FIND v(dout1_24) AT=595.025n

.meas tran vdout1_25ck1180 FIND v(dout1_25) AT=595.025n

.meas tran vdout1_26ck1180 FIND v(dout1_26) AT=595.025n

.meas tran vdout1_27ck1180 FIND v(dout1_27) AT=595.025n

.meas tran vdout1_28ck1180 FIND v(dout1_28) AT=595.025n

.meas tran vdout1_29ck1180 FIND v(dout1_29) AT=595.025n

.meas tran vdout1_30ck1180 FIND v(dout1_30) AT=595.025n

.meas tran vdout1_31ck1180 FIND v(dout1_31) AT=595.025n

.meas tran vdout1_32ck1180 FIND v(dout1_32) AT=595.025n

.meas tran vdout1_33ck1180 FIND v(dout1_33) AT=595.025n

.meas tran vdout1_34ck1180 FIND v(dout1_34) AT=595.025n

.meas tran vdout1_35ck1180 FIND v(dout1_35) AT=595.025n

.meas tran vdout1_36ck1180 FIND v(dout1_36) AT=595.025n

.meas tran vdout1_37ck1180 FIND v(dout1_37) AT=595.025n

.meas tran vdout1_38ck1180 FIND v(dout1_38) AT=595.025n

.meas tran vdout1_39ck1180 FIND v(dout1_39) AT=595.025n

.meas tran vdout1_40ck1180 FIND v(dout1_40) AT=595.025n

.meas tran vdout1_41ck1180 FIND v(dout1_41) AT=595.025n

.meas tran vdout1_42ck1180 FIND v(dout1_42) AT=595.025n

.meas tran vdout1_43ck1180 FIND v(dout1_43) AT=595.025n

.meas tran vdout1_44ck1180 FIND v(dout1_44) AT=595.025n

.meas tran vdout1_45ck1180 FIND v(dout1_45) AT=595.025n

.meas tran vdout1_46ck1180 FIND v(dout1_46) AT=595.025n

.meas tran vdout1_47ck1180 FIND v(dout1_47) AT=595.025n

.meas tran vdout1_48ck1180 FIND v(dout1_48) AT=595.025n

.meas tran vdout1_49ck1180 FIND v(dout1_49) AT=595.025n

.meas tran vdout1_50ck1180 FIND v(dout1_50) AT=595.025n

.meas tran vdout1_51ck1180 FIND v(dout1_51) AT=595.025n

.meas tran vdout1_52ck1180 FIND v(dout1_52) AT=595.025n

.meas tran vdout1_53ck1180 FIND v(dout1_53) AT=595.025n

.meas tran vdout1_54ck1180 FIND v(dout1_54) AT=595.025n

.meas tran vdout1_55ck1180 FIND v(dout1_55) AT=595.025n

.meas tran vdout1_56ck1180 FIND v(dout1_56) AT=595.025n

.meas tran vdout1_57ck1180 FIND v(dout1_57) AT=595.025n

.meas tran vdout1_58ck1180 FIND v(dout1_58) AT=595.025n

.meas tran vdout1_59ck1180 FIND v(dout1_59) AT=595.025n

.meas tran vdout1_60ck1180 FIND v(dout1_60) AT=595.025n

.meas tran vdout1_61ck1180 FIND v(dout1_61) AT=595.025n

.meas tran vdout1_62ck1180 FIND v(dout1_62) AT=595.025n

.meas tran vdout1_63ck1180 FIND v(dout1_63) AT=595.025n

.meas tran vdout0_0ck1190 FIND v(dout0_0) AT=600.025n

.meas tran vdout0_1ck1190 FIND v(dout0_1) AT=600.025n

.meas tran vdout0_2ck1190 FIND v(dout0_2) AT=600.025n

.meas tran vdout0_3ck1190 FIND v(dout0_3) AT=600.025n

.meas tran vdout0_4ck1190 FIND v(dout0_4) AT=600.025n

.meas tran vdout0_5ck1190 FIND v(dout0_5) AT=600.025n

.meas tran vdout0_6ck1190 FIND v(dout0_6) AT=600.025n

.meas tran vdout0_7ck1190 FIND v(dout0_7) AT=600.025n

.meas tran vdout0_8ck1190 FIND v(dout0_8) AT=600.025n

.meas tran vdout0_9ck1190 FIND v(dout0_9) AT=600.025n

.meas tran vdout0_10ck1190 FIND v(dout0_10) AT=600.025n

.meas tran vdout0_11ck1190 FIND v(dout0_11) AT=600.025n

.meas tran vdout0_12ck1190 FIND v(dout0_12) AT=600.025n

.meas tran vdout0_13ck1190 FIND v(dout0_13) AT=600.025n

.meas tran vdout0_14ck1190 FIND v(dout0_14) AT=600.025n

.meas tran vdout0_15ck1190 FIND v(dout0_15) AT=600.025n

.meas tran vdout0_16ck1190 FIND v(dout0_16) AT=600.025n

.meas tran vdout0_17ck1190 FIND v(dout0_17) AT=600.025n

.meas tran vdout0_18ck1190 FIND v(dout0_18) AT=600.025n

.meas tran vdout0_19ck1190 FIND v(dout0_19) AT=600.025n

.meas tran vdout0_20ck1190 FIND v(dout0_20) AT=600.025n

.meas tran vdout0_21ck1190 FIND v(dout0_21) AT=600.025n

.meas tran vdout0_22ck1190 FIND v(dout0_22) AT=600.025n

.meas tran vdout0_23ck1190 FIND v(dout0_23) AT=600.025n

.meas tran vdout0_24ck1190 FIND v(dout0_24) AT=600.025n

.meas tran vdout0_25ck1190 FIND v(dout0_25) AT=600.025n

.meas tran vdout0_26ck1190 FIND v(dout0_26) AT=600.025n

.meas tran vdout0_27ck1190 FIND v(dout0_27) AT=600.025n

.meas tran vdout0_28ck1190 FIND v(dout0_28) AT=600.025n

.meas tran vdout0_29ck1190 FIND v(dout0_29) AT=600.025n

.meas tran vdout0_30ck1190 FIND v(dout0_30) AT=600.025n

.meas tran vdout0_31ck1190 FIND v(dout0_31) AT=600.025n

.meas tran vdout0_32ck1190 FIND v(dout0_32) AT=600.025n

.meas tran vdout0_33ck1190 FIND v(dout0_33) AT=600.025n

.meas tran vdout0_34ck1190 FIND v(dout0_34) AT=600.025n

.meas tran vdout0_35ck1190 FIND v(dout0_35) AT=600.025n

.meas tran vdout0_36ck1190 FIND v(dout0_36) AT=600.025n

.meas tran vdout0_37ck1190 FIND v(dout0_37) AT=600.025n

.meas tran vdout0_38ck1190 FIND v(dout0_38) AT=600.025n

.meas tran vdout0_39ck1190 FIND v(dout0_39) AT=600.025n

.meas tran vdout0_40ck1190 FIND v(dout0_40) AT=600.025n

.meas tran vdout0_41ck1190 FIND v(dout0_41) AT=600.025n

.meas tran vdout0_42ck1190 FIND v(dout0_42) AT=600.025n

.meas tran vdout0_43ck1190 FIND v(dout0_43) AT=600.025n

.meas tran vdout0_44ck1190 FIND v(dout0_44) AT=600.025n

.meas tran vdout0_45ck1190 FIND v(dout0_45) AT=600.025n

.meas tran vdout0_46ck1190 FIND v(dout0_46) AT=600.025n

.meas tran vdout0_47ck1190 FIND v(dout0_47) AT=600.025n

.meas tran vdout0_48ck1190 FIND v(dout0_48) AT=600.025n

.meas tran vdout0_49ck1190 FIND v(dout0_49) AT=600.025n

.meas tran vdout0_50ck1190 FIND v(dout0_50) AT=600.025n

.meas tran vdout0_51ck1190 FIND v(dout0_51) AT=600.025n

.meas tran vdout0_52ck1190 FIND v(dout0_52) AT=600.025n

.meas tran vdout0_53ck1190 FIND v(dout0_53) AT=600.025n

.meas tran vdout0_54ck1190 FIND v(dout0_54) AT=600.025n

.meas tran vdout0_55ck1190 FIND v(dout0_55) AT=600.025n

.meas tran vdout0_56ck1190 FIND v(dout0_56) AT=600.025n

.meas tran vdout0_57ck1190 FIND v(dout0_57) AT=600.025n

.meas tran vdout0_58ck1190 FIND v(dout0_58) AT=600.025n

.meas tran vdout0_59ck1190 FIND v(dout0_59) AT=600.025n

.meas tran vdout0_60ck1190 FIND v(dout0_60) AT=600.025n

.meas tran vdout0_61ck1190 FIND v(dout0_61) AT=600.025n

.meas tran vdout0_62ck1190 FIND v(dout0_62) AT=600.025n

.meas tran vdout0_63ck1190 FIND v(dout0_63) AT=600.025n

.meas tran vdout1_0ck1190 FIND v(dout1_0) AT=600.025n

.meas tran vdout1_1ck1190 FIND v(dout1_1) AT=600.025n

.meas tran vdout1_2ck1190 FIND v(dout1_2) AT=600.025n

.meas tran vdout1_3ck1190 FIND v(dout1_3) AT=600.025n

.meas tran vdout1_4ck1190 FIND v(dout1_4) AT=600.025n

.meas tran vdout1_5ck1190 FIND v(dout1_5) AT=600.025n

.meas tran vdout1_6ck1190 FIND v(dout1_6) AT=600.025n

.meas tran vdout1_7ck1190 FIND v(dout1_7) AT=600.025n

.meas tran vdout1_8ck1190 FIND v(dout1_8) AT=600.025n

.meas tran vdout1_9ck1190 FIND v(dout1_9) AT=600.025n

.meas tran vdout1_10ck1190 FIND v(dout1_10) AT=600.025n

.meas tran vdout1_11ck1190 FIND v(dout1_11) AT=600.025n

.meas tran vdout1_12ck1190 FIND v(dout1_12) AT=600.025n

.meas tran vdout1_13ck1190 FIND v(dout1_13) AT=600.025n

.meas tran vdout1_14ck1190 FIND v(dout1_14) AT=600.025n

.meas tran vdout1_15ck1190 FIND v(dout1_15) AT=600.025n

.meas tran vdout1_16ck1190 FIND v(dout1_16) AT=600.025n

.meas tran vdout1_17ck1190 FIND v(dout1_17) AT=600.025n

.meas tran vdout1_18ck1190 FIND v(dout1_18) AT=600.025n

.meas tran vdout1_19ck1190 FIND v(dout1_19) AT=600.025n

.meas tran vdout1_20ck1190 FIND v(dout1_20) AT=600.025n

.meas tran vdout1_21ck1190 FIND v(dout1_21) AT=600.025n

.meas tran vdout1_22ck1190 FIND v(dout1_22) AT=600.025n

.meas tran vdout1_23ck1190 FIND v(dout1_23) AT=600.025n

.meas tran vdout1_24ck1190 FIND v(dout1_24) AT=600.025n

.meas tran vdout1_25ck1190 FIND v(dout1_25) AT=600.025n

.meas tran vdout1_26ck1190 FIND v(dout1_26) AT=600.025n

.meas tran vdout1_27ck1190 FIND v(dout1_27) AT=600.025n

.meas tran vdout1_28ck1190 FIND v(dout1_28) AT=600.025n

.meas tran vdout1_29ck1190 FIND v(dout1_29) AT=600.025n

.meas tran vdout1_30ck1190 FIND v(dout1_30) AT=600.025n

.meas tran vdout1_31ck1190 FIND v(dout1_31) AT=600.025n

.meas tran vdout1_32ck1190 FIND v(dout1_32) AT=600.025n

.meas tran vdout1_33ck1190 FIND v(dout1_33) AT=600.025n

.meas tran vdout1_34ck1190 FIND v(dout1_34) AT=600.025n

.meas tran vdout1_35ck1190 FIND v(dout1_35) AT=600.025n

.meas tran vdout1_36ck1190 FIND v(dout1_36) AT=600.025n

.meas tran vdout1_37ck1190 FIND v(dout1_37) AT=600.025n

.meas tran vdout1_38ck1190 FIND v(dout1_38) AT=600.025n

.meas tran vdout1_39ck1190 FIND v(dout1_39) AT=600.025n

.meas tran vdout1_40ck1190 FIND v(dout1_40) AT=600.025n

.meas tran vdout1_41ck1190 FIND v(dout1_41) AT=600.025n

.meas tran vdout1_42ck1190 FIND v(dout1_42) AT=600.025n

.meas tran vdout1_43ck1190 FIND v(dout1_43) AT=600.025n

.meas tran vdout1_44ck1190 FIND v(dout1_44) AT=600.025n

.meas tran vdout1_45ck1190 FIND v(dout1_45) AT=600.025n

.meas tran vdout1_46ck1190 FIND v(dout1_46) AT=600.025n

.meas tran vdout1_47ck1190 FIND v(dout1_47) AT=600.025n

.meas tran vdout1_48ck1190 FIND v(dout1_48) AT=600.025n

.meas tran vdout1_49ck1190 FIND v(dout1_49) AT=600.025n

.meas tran vdout1_50ck1190 FIND v(dout1_50) AT=600.025n

.meas tran vdout1_51ck1190 FIND v(dout1_51) AT=600.025n

.meas tran vdout1_52ck1190 FIND v(dout1_52) AT=600.025n

.meas tran vdout1_53ck1190 FIND v(dout1_53) AT=600.025n

.meas tran vdout1_54ck1190 FIND v(dout1_54) AT=600.025n

.meas tran vdout1_55ck1190 FIND v(dout1_55) AT=600.025n

.meas tran vdout1_56ck1190 FIND v(dout1_56) AT=600.025n

.meas tran vdout1_57ck1190 FIND v(dout1_57) AT=600.025n

.meas tran vdout1_58ck1190 FIND v(dout1_58) AT=600.025n

.meas tran vdout1_59ck1190 FIND v(dout1_59) AT=600.025n

.meas tran vdout1_60ck1190 FIND v(dout1_60) AT=600.025n

.meas tran vdout1_61ck1190 FIND v(dout1_61) AT=600.025n

.meas tran vdout1_62ck1190 FIND v(dout1_62) AT=600.025n

.meas tran vdout1_63ck1190 FIND v(dout1_63) AT=600.025n

.meas tran vdout1_0ck1200 FIND v(dout1_0) AT=605.025n

.meas tran vdout1_1ck1200 FIND v(dout1_1) AT=605.025n

.meas tran vdout1_2ck1200 FIND v(dout1_2) AT=605.025n

.meas tran vdout1_3ck1200 FIND v(dout1_3) AT=605.025n

.meas tran vdout1_4ck1200 FIND v(dout1_4) AT=605.025n

.meas tran vdout1_5ck1200 FIND v(dout1_5) AT=605.025n

.meas tran vdout1_6ck1200 FIND v(dout1_6) AT=605.025n

.meas tran vdout1_7ck1200 FIND v(dout1_7) AT=605.025n

.meas tran vdout1_8ck1200 FIND v(dout1_8) AT=605.025n

.meas tran vdout1_9ck1200 FIND v(dout1_9) AT=605.025n

.meas tran vdout1_10ck1200 FIND v(dout1_10) AT=605.025n

.meas tran vdout1_11ck1200 FIND v(dout1_11) AT=605.025n

.meas tran vdout1_12ck1200 FIND v(dout1_12) AT=605.025n

.meas tran vdout1_13ck1200 FIND v(dout1_13) AT=605.025n

.meas tran vdout1_14ck1200 FIND v(dout1_14) AT=605.025n

.meas tran vdout1_15ck1200 FIND v(dout1_15) AT=605.025n

.meas tran vdout1_16ck1200 FIND v(dout1_16) AT=605.025n

.meas tran vdout1_17ck1200 FIND v(dout1_17) AT=605.025n

.meas tran vdout1_18ck1200 FIND v(dout1_18) AT=605.025n

.meas tran vdout1_19ck1200 FIND v(dout1_19) AT=605.025n

.meas tran vdout1_20ck1200 FIND v(dout1_20) AT=605.025n

.meas tran vdout1_21ck1200 FIND v(dout1_21) AT=605.025n

.meas tran vdout1_22ck1200 FIND v(dout1_22) AT=605.025n

.meas tran vdout1_23ck1200 FIND v(dout1_23) AT=605.025n

.meas tran vdout1_24ck1200 FIND v(dout1_24) AT=605.025n

.meas tran vdout1_25ck1200 FIND v(dout1_25) AT=605.025n

.meas tran vdout1_26ck1200 FIND v(dout1_26) AT=605.025n

.meas tran vdout1_27ck1200 FIND v(dout1_27) AT=605.025n

.meas tran vdout1_28ck1200 FIND v(dout1_28) AT=605.025n

.meas tran vdout1_29ck1200 FIND v(dout1_29) AT=605.025n

.meas tran vdout1_30ck1200 FIND v(dout1_30) AT=605.025n

.meas tran vdout1_31ck1200 FIND v(dout1_31) AT=605.025n

.meas tran vdout1_32ck1200 FIND v(dout1_32) AT=605.025n

.meas tran vdout1_33ck1200 FIND v(dout1_33) AT=605.025n

.meas tran vdout1_34ck1200 FIND v(dout1_34) AT=605.025n

.meas tran vdout1_35ck1200 FIND v(dout1_35) AT=605.025n

.meas tran vdout1_36ck1200 FIND v(dout1_36) AT=605.025n

.meas tran vdout1_37ck1200 FIND v(dout1_37) AT=605.025n

.meas tran vdout1_38ck1200 FIND v(dout1_38) AT=605.025n

.meas tran vdout1_39ck1200 FIND v(dout1_39) AT=605.025n

.meas tran vdout1_40ck1200 FIND v(dout1_40) AT=605.025n

.meas tran vdout1_41ck1200 FIND v(dout1_41) AT=605.025n

.meas tran vdout1_42ck1200 FIND v(dout1_42) AT=605.025n

.meas tran vdout1_43ck1200 FIND v(dout1_43) AT=605.025n

.meas tran vdout1_44ck1200 FIND v(dout1_44) AT=605.025n

.meas tran vdout1_45ck1200 FIND v(dout1_45) AT=605.025n

.meas tran vdout1_46ck1200 FIND v(dout1_46) AT=605.025n

.meas tran vdout1_47ck1200 FIND v(dout1_47) AT=605.025n

.meas tran vdout1_48ck1200 FIND v(dout1_48) AT=605.025n

.meas tran vdout1_49ck1200 FIND v(dout1_49) AT=605.025n

.meas tran vdout1_50ck1200 FIND v(dout1_50) AT=605.025n

.meas tran vdout1_51ck1200 FIND v(dout1_51) AT=605.025n

.meas tran vdout1_52ck1200 FIND v(dout1_52) AT=605.025n

.meas tran vdout1_53ck1200 FIND v(dout1_53) AT=605.025n

.meas tran vdout1_54ck1200 FIND v(dout1_54) AT=605.025n

.meas tran vdout1_55ck1200 FIND v(dout1_55) AT=605.025n

.meas tran vdout1_56ck1200 FIND v(dout1_56) AT=605.025n

.meas tran vdout1_57ck1200 FIND v(dout1_57) AT=605.025n

.meas tran vdout1_58ck1200 FIND v(dout1_58) AT=605.025n

.meas tran vdout1_59ck1200 FIND v(dout1_59) AT=605.025n

.meas tran vdout1_60ck1200 FIND v(dout1_60) AT=605.025n

.meas tran vdout1_61ck1200 FIND v(dout1_61) AT=605.025n

.meas tran vdout1_62ck1200 FIND v(dout1_62) AT=605.025n

.meas tran vdout1_63ck1200 FIND v(dout1_63) AT=605.025n

.meas tran vdout0_0ck1210 FIND v(dout0_0) AT=610.025n

.meas tran vdout0_1ck1210 FIND v(dout0_1) AT=610.025n

.meas tran vdout0_2ck1210 FIND v(dout0_2) AT=610.025n

.meas tran vdout0_3ck1210 FIND v(dout0_3) AT=610.025n

.meas tran vdout0_4ck1210 FIND v(dout0_4) AT=610.025n

.meas tran vdout0_5ck1210 FIND v(dout0_5) AT=610.025n

.meas tran vdout0_6ck1210 FIND v(dout0_6) AT=610.025n

.meas tran vdout0_7ck1210 FIND v(dout0_7) AT=610.025n

.meas tran vdout0_8ck1210 FIND v(dout0_8) AT=610.025n

.meas tran vdout0_9ck1210 FIND v(dout0_9) AT=610.025n

.meas tran vdout0_10ck1210 FIND v(dout0_10) AT=610.025n

.meas tran vdout0_11ck1210 FIND v(dout0_11) AT=610.025n

.meas tran vdout0_12ck1210 FIND v(dout0_12) AT=610.025n

.meas tran vdout0_13ck1210 FIND v(dout0_13) AT=610.025n

.meas tran vdout0_14ck1210 FIND v(dout0_14) AT=610.025n

.meas tran vdout0_15ck1210 FIND v(dout0_15) AT=610.025n

.meas tran vdout0_16ck1210 FIND v(dout0_16) AT=610.025n

.meas tran vdout0_17ck1210 FIND v(dout0_17) AT=610.025n

.meas tran vdout0_18ck1210 FIND v(dout0_18) AT=610.025n

.meas tran vdout0_19ck1210 FIND v(dout0_19) AT=610.025n

.meas tran vdout0_20ck1210 FIND v(dout0_20) AT=610.025n

.meas tran vdout0_21ck1210 FIND v(dout0_21) AT=610.025n

.meas tran vdout0_22ck1210 FIND v(dout0_22) AT=610.025n

.meas tran vdout0_23ck1210 FIND v(dout0_23) AT=610.025n

.meas tran vdout0_24ck1210 FIND v(dout0_24) AT=610.025n

.meas tran vdout0_25ck1210 FIND v(dout0_25) AT=610.025n

.meas tran vdout0_26ck1210 FIND v(dout0_26) AT=610.025n

.meas tran vdout0_27ck1210 FIND v(dout0_27) AT=610.025n

.meas tran vdout0_28ck1210 FIND v(dout0_28) AT=610.025n

.meas tran vdout0_29ck1210 FIND v(dout0_29) AT=610.025n

.meas tran vdout0_30ck1210 FIND v(dout0_30) AT=610.025n

.meas tran vdout0_31ck1210 FIND v(dout0_31) AT=610.025n

.meas tran vdout0_32ck1210 FIND v(dout0_32) AT=610.025n

.meas tran vdout0_33ck1210 FIND v(dout0_33) AT=610.025n

.meas tran vdout0_34ck1210 FIND v(dout0_34) AT=610.025n

.meas tran vdout0_35ck1210 FIND v(dout0_35) AT=610.025n

.meas tran vdout0_36ck1210 FIND v(dout0_36) AT=610.025n

.meas tran vdout0_37ck1210 FIND v(dout0_37) AT=610.025n

.meas tran vdout0_38ck1210 FIND v(dout0_38) AT=610.025n

.meas tran vdout0_39ck1210 FIND v(dout0_39) AT=610.025n

.meas tran vdout0_40ck1210 FIND v(dout0_40) AT=610.025n

.meas tran vdout0_41ck1210 FIND v(dout0_41) AT=610.025n

.meas tran vdout0_42ck1210 FIND v(dout0_42) AT=610.025n

.meas tran vdout0_43ck1210 FIND v(dout0_43) AT=610.025n

.meas tran vdout0_44ck1210 FIND v(dout0_44) AT=610.025n

.meas tran vdout0_45ck1210 FIND v(dout0_45) AT=610.025n

.meas tran vdout0_46ck1210 FIND v(dout0_46) AT=610.025n

.meas tran vdout0_47ck1210 FIND v(dout0_47) AT=610.025n

.meas tran vdout0_48ck1210 FIND v(dout0_48) AT=610.025n

.meas tran vdout0_49ck1210 FIND v(dout0_49) AT=610.025n

.meas tran vdout0_50ck1210 FIND v(dout0_50) AT=610.025n

.meas tran vdout0_51ck1210 FIND v(dout0_51) AT=610.025n

.meas tran vdout0_52ck1210 FIND v(dout0_52) AT=610.025n

.meas tran vdout0_53ck1210 FIND v(dout0_53) AT=610.025n

.meas tran vdout0_54ck1210 FIND v(dout0_54) AT=610.025n

.meas tran vdout0_55ck1210 FIND v(dout0_55) AT=610.025n

.meas tran vdout0_56ck1210 FIND v(dout0_56) AT=610.025n

.meas tran vdout0_57ck1210 FIND v(dout0_57) AT=610.025n

.meas tran vdout0_58ck1210 FIND v(dout0_58) AT=610.025n

.meas tran vdout0_59ck1210 FIND v(dout0_59) AT=610.025n

.meas tran vdout0_60ck1210 FIND v(dout0_60) AT=610.025n

.meas tran vdout0_61ck1210 FIND v(dout0_61) AT=610.025n

.meas tran vdout0_62ck1210 FIND v(dout0_62) AT=610.025n

.meas tran vdout0_63ck1210 FIND v(dout0_63) AT=610.025n

.meas tran vdout1_0ck1220 FIND v(dout1_0) AT=615.025n

.meas tran vdout1_1ck1220 FIND v(dout1_1) AT=615.025n

.meas tran vdout1_2ck1220 FIND v(dout1_2) AT=615.025n

.meas tran vdout1_3ck1220 FIND v(dout1_3) AT=615.025n

.meas tran vdout1_4ck1220 FIND v(dout1_4) AT=615.025n

.meas tran vdout1_5ck1220 FIND v(dout1_5) AT=615.025n

.meas tran vdout1_6ck1220 FIND v(dout1_6) AT=615.025n

.meas tran vdout1_7ck1220 FIND v(dout1_7) AT=615.025n

.meas tran vdout1_8ck1220 FIND v(dout1_8) AT=615.025n

.meas tran vdout1_9ck1220 FIND v(dout1_9) AT=615.025n

.meas tran vdout1_10ck1220 FIND v(dout1_10) AT=615.025n

.meas tran vdout1_11ck1220 FIND v(dout1_11) AT=615.025n

.meas tran vdout1_12ck1220 FIND v(dout1_12) AT=615.025n

.meas tran vdout1_13ck1220 FIND v(dout1_13) AT=615.025n

.meas tran vdout1_14ck1220 FIND v(dout1_14) AT=615.025n

.meas tran vdout1_15ck1220 FIND v(dout1_15) AT=615.025n

.meas tran vdout1_16ck1220 FIND v(dout1_16) AT=615.025n

.meas tran vdout1_17ck1220 FIND v(dout1_17) AT=615.025n

.meas tran vdout1_18ck1220 FIND v(dout1_18) AT=615.025n

.meas tran vdout1_19ck1220 FIND v(dout1_19) AT=615.025n

.meas tran vdout1_20ck1220 FIND v(dout1_20) AT=615.025n

.meas tran vdout1_21ck1220 FIND v(dout1_21) AT=615.025n

.meas tran vdout1_22ck1220 FIND v(dout1_22) AT=615.025n

.meas tran vdout1_23ck1220 FIND v(dout1_23) AT=615.025n

.meas tran vdout1_24ck1220 FIND v(dout1_24) AT=615.025n

.meas tran vdout1_25ck1220 FIND v(dout1_25) AT=615.025n

.meas tran vdout1_26ck1220 FIND v(dout1_26) AT=615.025n

.meas tran vdout1_27ck1220 FIND v(dout1_27) AT=615.025n

.meas tran vdout1_28ck1220 FIND v(dout1_28) AT=615.025n

.meas tran vdout1_29ck1220 FIND v(dout1_29) AT=615.025n

.meas tran vdout1_30ck1220 FIND v(dout1_30) AT=615.025n

.meas tran vdout1_31ck1220 FIND v(dout1_31) AT=615.025n

.meas tran vdout1_32ck1220 FIND v(dout1_32) AT=615.025n

.meas tran vdout1_33ck1220 FIND v(dout1_33) AT=615.025n

.meas tran vdout1_34ck1220 FIND v(dout1_34) AT=615.025n

.meas tran vdout1_35ck1220 FIND v(dout1_35) AT=615.025n

.meas tran vdout1_36ck1220 FIND v(dout1_36) AT=615.025n

.meas tran vdout1_37ck1220 FIND v(dout1_37) AT=615.025n

.meas tran vdout1_38ck1220 FIND v(dout1_38) AT=615.025n

.meas tran vdout1_39ck1220 FIND v(dout1_39) AT=615.025n

.meas tran vdout1_40ck1220 FIND v(dout1_40) AT=615.025n

.meas tran vdout1_41ck1220 FIND v(dout1_41) AT=615.025n

.meas tran vdout1_42ck1220 FIND v(dout1_42) AT=615.025n

.meas tran vdout1_43ck1220 FIND v(dout1_43) AT=615.025n

.meas tran vdout1_44ck1220 FIND v(dout1_44) AT=615.025n

.meas tran vdout1_45ck1220 FIND v(dout1_45) AT=615.025n

.meas tran vdout1_46ck1220 FIND v(dout1_46) AT=615.025n

.meas tran vdout1_47ck1220 FIND v(dout1_47) AT=615.025n

.meas tran vdout1_48ck1220 FIND v(dout1_48) AT=615.025n

.meas tran vdout1_49ck1220 FIND v(dout1_49) AT=615.025n

.meas tran vdout1_50ck1220 FIND v(dout1_50) AT=615.025n

.meas tran vdout1_51ck1220 FIND v(dout1_51) AT=615.025n

.meas tran vdout1_52ck1220 FIND v(dout1_52) AT=615.025n

.meas tran vdout1_53ck1220 FIND v(dout1_53) AT=615.025n

.meas tran vdout1_54ck1220 FIND v(dout1_54) AT=615.025n

.meas tran vdout1_55ck1220 FIND v(dout1_55) AT=615.025n

.meas tran vdout1_56ck1220 FIND v(dout1_56) AT=615.025n

.meas tran vdout1_57ck1220 FIND v(dout1_57) AT=615.025n

.meas tran vdout1_58ck1220 FIND v(dout1_58) AT=615.025n

.meas tran vdout1_59ck1220 FIND v(dout1_59) AT=615.025n

.meas tran vdout1_60ck1220 FIND v(dout1_60) AT=615.025n

.meas tran vdout1_61ck1220 FIND v(dout1_61) AT=615.025n

.meas tran vdout1_62ck1220 FIND v(dout1_62) AT=615.025n

.meas tran vdout1_63ck1220 FIND v(dout1_63) AT=615.025n

.meas tran vdout0_0ck1230 FIND v(dout0_0) AT=620.025n

.meas tran vdout0_1ck1230 FIND v(dout0_1) AT=620.025n

.meas tran vdout0_2ck1230 FIND v(dout0_2) AT=620.025n

.meas tran vdout0_3ck1230 FIND v(dout0_3) AT=620.025n

.meas tran vdout0_4ck1230 FIND v(dout0_4) AT=620.025n

.meas tran vdout0_5ck1230 FIND v(dout0_5) AT=620.025n

.meas tran vdout0_6ck1230 FIND v(dout0_6) AT=620.025n

.meas tran vdout0_7ck1230 FIND v(dout0_7) AT=620.025n

.meas tran vdout0_8ck1230 FIND v(dout0_8) AT=620.025n

.meas tran vdout0_9ck1230 FIND v(dout0_9) AT=620.025n

.meas tran vdout0_10ck1230 FIND v(dout0_10) AT=620.025n

.meas tran vdout0_11ck1230 FIND v(dout0_11) AT=620.025n

.meas tran vdout0_12ck1230 FIND v(dout0_12) AT=620.025n

.meas tran vdout0_13ck1230 FIND v(dout0_13) AT=620.025n

.meas tran vdout0_14ck1230 FIND v(dout0_14) AT=620.025n

.meas tran vdout0_15ck1230 FIND v(dout0_15) AT=620.025n

.meas tran vdout0_16ck1230 FIND v(dout0_16) AT=620.025n

.meas tran vdout0_17ck1230 FIND v(dout0_17) AT=620.025n

.meas tran vdout0_18ck1230 FIND v(dout0_18) AT=620.025n

.meas tran vdout0_19ck1230 FIND v(dout0_19) AT=620.025n

.meas tran vdout0_20ck1230 FIND v(dout0_20) AT=620.025n

.meas tran vdout0_21ck1230 FIND v(dout0_21) AT=620.025n

.meas tran vdout0_22ck1230 FIND v(dout0_22) AT=620.025n

.meas tran vdout0_23ck1230 FIND v(dout0_23) AT=620.025n

.meas tran vdout0_24ck1230 FIND v(dout0_24) AT=620.025n

.meas tran vdout0_25ck1230 FIND v(dout0_25) AT=620.025n

.meas tran vdout0_26ck1230 FIND v(dout0_26) AT=620.025n

.meas tran vdout0_27ck1230 FIND v(dout0_27) AT=620.025n

.meas tran vdout0_28ck1230 FIND v(dout0_28) AT=620.025n

.meas tran vdout0_29ck1230 FIND v(dout0_29) AT=620.025n

.meas tran vdout0_30ck1230 FIND v(dout0_30) AT=620.025n

.meas tran vdout0_31ck1230 FIND v(dout0_31) AT=620.025n

.meas tran vdout0_32ck1230 FIND v(dout0_32) AT=620.025n

.meas tran vdout0_33ck1230 FIND v(dout0_33) AT=620.025n

.meas tran vdout0_34ck1230 FIND v(dout0_34) AT=620.025n

.meas tran vdout0_35ck1230 FIND v(dout0_35) AT=620.025n

.meas tran vdout0_36ck1230 FIND v(dout0_36) AT=620.025n

.meas tran vdout0_37ck1230 FIND v(dout0_37) AT=620.025n

.meas tran vdout0_38ck1230 FIND v(dout0_38) AT=620.025n

.meas tran vdout0_39ck1230 FIND v(dout0_39) AT=620.025n

.meas tran vdout0_40ck1230 FIND v(dout0_40) AT=620.025n

.meas tran vdout0_41ck1230 FIND v(dout0_41) AT=620.025n

.meas tran vdout0_42ck1230 FIND v(dout0_42) AT=620.025n

.meas tran vdout0_43ck1230 FIND v(dout0_43) AT=620.025n

.meas tran vdout0_44ck1230 FIND v(dout0_44) AT=620.025n

.meas tran vdout0_45ck1230 FIND v(dout0_45) AT=620.025n

.meas tran vdout0_46ck1230 FIND v(dout0_46) AT=620.025n

.meas tran vdout0_47ck1230 FIND v(dout0_47) AT=620.025n

.meas tran vdout0_48ck1230 FIND v(dout0_48) AT=620.025n

.meas tran vdout0_49ck1230 FIND v(dout0_49) AT=620.025n

.meas tran vdout0_50ck1230 FIND v(dout0_50) AT=620.025n

.meas tran vdout0_51ck1230 FIND v(dout0_51) AT=620.025n

.meas tran vdout0_52ck1230 FIND v(dout0_52) AT=620.025n

.meas tran vdout0_53ck1230 FIND v(dout0_53) AT=620.025n

.meas tran vdout0_54ck1230 FIND v(dout0_54) AT=620.025n

.meas tran vdout0_55ck1230 FIND v(dout0_55) AT=620.025n

.meas tran vdout0_56ck1230 FIND v(dout0_56) AT=620.025n

.meas tran vdout0_57ck1230 FIND v(dout0_57) AT=620.025n

.meas tran vdout0_58ck1230 FIND v(dout0_58) AT=620.025n

.meas tran vdout0_59ck1230 FIND v(dout0_59) AT=620.025n

.meas tran vdout0_60ck1230 FIND v(dout0_60) AT=620.025n

.meas tran vdout0_61ck1230 FIND v(dout0_61) AT=620.025n

.meas tran vdout0_62ck1230 FIND v(dout0_62) AT=620.025n

.meas tran vdout0_63ck1230 FIND v(dout0_63) AT=620.025n

.meas tran vdout1_0ck1240 FIND v(dout1_0) AT=625.025n

.meas tran vdout1_1ck1240 FIND v(dout1_1) AT=625.025n

.meas tran vdout1_2ck1240 FIND v(dout1_2) AT=625.025n

.meas tran vdout1_3ck1240 FIND v(dout1_3) AT=625.025n

.meas tran vdout1_4ck1240 FIND v(dout1_4) AT=625.025n

.meas tran vdout1_5ck1240 FIND v(dout1_5) AT=625.025n

.meas tran vdout1_6ck1240 FIND v(dout1_6) AT=625.025n

.meas tran vdout1_7ck1240 FIND v(dout1_7) AT=625.025n

.meas tran vdout1_8ck1240 FIND v(dout1_8) AT=625.025n

.meas tran vdout1_9ck1240 FIND v(dout1_9) AT=625.025n

.meas tran vdout1_10ck1240 FIND v(dout1_10) AT=625.025n

.meas tran vdout1_11ck1240 FIND v(dout1_11) AT=625.025n

.meas tran vdout1_12ck1240 FIND v(dout1_12) AT=625.025n

.meas tran vdout1_13ck1240 FIND v(dout1_13) AT=625.025n

.meas tran vdout1_14ck1240 FIND v(dout1_14) AT=625.025n

.meas tran vdout1_15ck1240 FIND v(dout1_15) AT=625.025n

.meas tran vdout1_16ck1240 FIND v(dout1_16) AT=625.025n

.meas tran vdout1_17ck1240 FIND v(dout1_17) AT=625.025n

.meas tran vdout1_18ck1240 FIND v(dout1_18) AT=625.025n

.meas tran vdout1_19ck1240 FIND v(dout1_19) AT=625.025n

.meas tran vdout1_20ck1240 FIND v(dout1_20) AT=625.025n

.meas tran vdout1_21ck1240 FIND v(dout1_21) AT=625.025n

.meas tran vdout1_22ck1240 FIND v(dout1_22) AT=625.025n

.meas tran vdout1_23ck1240 FIND v(dout1_23) AT=625.025n

.meas tran vdout1_24ck1240 FIND v(dout1_24) AT=625.025n

.meas tran vdout1_25ck1240 FIND v(dout1_25) AT=625.025n

.meas tran vdout1_26ck1240 FIND v(dout1_26) AT=625.025n

.meas tran vdout1_27ck1240 FIND v(dout1_27) AT=625.025n

.meas tran vdout1_28ck1240 FIND v(dout1_28) AT=625.025n

.meas tran vdout1_29ck1240 FIND v(dout1_29) AT=625.025n

.meas tran vdout1_30ck1240 FIND v(dout1_30) AT=625.025n

.meas tran vdout1_31ck1240 FIND v(dout1_31) AT=625.025n

.meas tran vdout1_32ck1240 FIND v(dout1_32) AT=625.025n

.meas tran vdout1_33ck1240 FIND v(dout1_33) AT=625.025n

.meas tran vdout1_34ck1240 FIND v(dout1_34) AT=625.025n

.meas tran vdout1_35ck1240 FIND v(dout1_35) AT=625.025n

.meas tran vdout1_36ck1240 FIND v(dout1_36) AT=625.025n

.meas tran vdout1_37ck1240 FIND v(dout1_37) AT=625.025n

.meas tran vdout1_38ck1240 FIND v(dout1_38) AT=625.025n

.meas tran vdout1_39ck1240 FIND v(dout1_39) AT=625.025n

.meas tran vdout1_40ck1240 FIND v(dout1_40) AT=625.025n

.meas tran vdout1_41ck1240 FIND v(dout1_41) AT=625.025n

.meas tran vdout1_42ck1240 FIND v(dout1_42) AT=625.025n

.meas tran vdout1_43ck1240 FIND v(dout1_43) AT=625.025n

.meas tran vdout1_44ck1240 FIND v(dout1_44) AT=625.025n

.meas tran vdout1_45ck1240 FIND v(dout1_45) AT=625.025n

.meas tran vdout1_46ck1240 FIND v(dout1_46) AT=625.025n

.meas tran vdout1_47ck1240 FIND v(dout1_47) AT=625.025n

.meas tran vdout1_48ck1240 FIND v(dout1_48) AT=625.025n

.meas tran vdout1_49ck1240 FIND v(dout1_49) AT=625.025n

.meas tran vdout1_50ck1240 FIND v(dout1_50) AT=625.025n

.meas tran vdout1_51ck1240 FIND v(dout1_51) AT=625.025n

.meas tran vdout1_52ck1240 FIND v(dout1_52) AT=625.025n

.meas tran vdout1_53ck1240 FIND v(dout1_53) AT=625.025n

.meas tran vdout1_54ck1240 FIND v(dout1_54) AT=625.025n

.meas tran vdout1_55ck1240 FIND v(dout1_55) AT=625.025n

.meas tran vdout1_56ck1240 FIND v(dout1_56) AT=625.025n

.meas tran vdout1_57ck1240 FIND v(dout1_57) AT=625.025n

.meas tran vdout1_58ck1240 FIND v(dout1_58) AT=625.025n

.meas tran vdout1_59ck1240 FIND v(dout1_59) AT=625.025n

.meas tran vdout1_60ck1240 FIND v(dout1_60) AT=625.025n

.meas tran vdout1_61ck1240 FIND v(dout1_61) AT=625.025n

.meas tran vdout1_62ck1240 FIND v(dout1_62) AT=625.025n

.meas tran vdout1_63ck1240 FIND v(dout1_63) AT=625.025n

.meas tran vdout0_0ck1250 FIND v(dout0_0) AT=630.025n

.meas tran vdout0_1ck1250 FIND v(dout0_1) AT=630.025n

.meas tran vdout0_2ck1250 FIND v(dout0_2) AT=630.025n

.meas tran vdout0_3ck1250 FIND v(dout0_3) AT=630.025n

.meas tran vdout0_4ck1250 FIND v(dout0_4) AT=630.025n

.meas tran vdout0_5ck1250 FIND v(dout0_5) AT=630.025n

.meas tran vdout0_6ck1250 FIND v(dout0_6) AT=630.025n

.meas tran vdout0_7ck1250 FIND v(dout0_7) AT=630.025n

.meas tran vdout0_8ck1250 FIND v(dout0_8) AT=630.025n

.meas tran vdout0_9ck1250 FIND v(dout0_9) AT=630.025n

.meas tran vdout0_10ck1250 FIND v(dout0_10) AT=630.025n

.meas tran vdout0_11ck1250 FIND v(dout0_11) AT=630.025n

.meas tran vdout0_12ck1250 FIND v(dout0_12) AT=630.025n

.meas tran vdout0_13ck1250 FIND v(dout0_13) AT=630.025n

.meas tran vdout0_14ck1250 FIND v(dout0_14) AT=630.025n

.meas tran vdout0_15ck1250 FIND v(dout0_15) AT=630.025n

.meas tran vdout0_16ck1250 FIND v(dout0_16) AT=630.025n

.meas tran vdout0_17ck1250 FIND v(dout0_17) AT=630.025n

.meas tran vdout0_18ck1250 FIND v(dout0_18) AT=630.025n

.meas tran vdout0_19ck1250 FIND v(dout0_19) AT=630.025n

.meas tran vdout0_20ck1250 FIND v(dout0_20) AT=630.025n

.meas tran vdout0_21ck1250 FIND v(dout0_21) AT=630.025n

.meas tran vdout0_22ck1250 FIND v(dout0_22) AT=630.025n

.meas tran vdout0_23ck1250 FIND v(dout0_23) AT=630.025n

.meas tran vdout0_24ck1250 FIND v(dout0_24) AT=630.025n

.meas tran vdout0_25ck1250 FIND v(dout0_25) AT=630.025n

.meas tran vdout0_26ck1250 FIND v(dout0_26) AT=630.025n

.meas tran vdout0_27ck1250 FIND v(dout0_27) AT=630.025n

.meas tran vdout0_28ck1250 FIND v(dout0_28) AT=630.025n

.meas tran vdout0_29ck1250 FIND v(dout0_29) AT=630.025n

.meas tran vdout0_30ck1250 FIND v(dout0_30) AT=630.025n

.meas tran vdout0_31ck1250 FIND v(dout0_31) AT=630.025n

.meas tran vdout0_32ck1250 FIND v(dout0_32) AT=630.025n

.meas tran vdout0_33ck1250 FIND v(dout0_33) AT=630.025n

.meas tran vdout0_34ck1250 FIND v(dout0_34) AT=630.025n

.meas tran vdout0_35ck1250 FIND v(dout0_35) AT=630.025n

.meas tran vdout0_36ck1250 FIND v(dout0_36) AT=630.025n

.meas tran vdout0_37ck1250 FIND v(dout0_37) AT=630.025n

.meas tran vdout0_38ck1250 FIND v(dout0_38) AT=630.025n

.meas tran vdout0_39ck1250 FIND v(dout0_39) AT=630.025n

.meas tran vdout0_40ck1250 FIND v(dout0_40) AT=630.025n

.meas tran vdout0_41ck1250 FIND v(dout0_41) AT=630.025n

.meas tran vdout0_42ck1250 FIND v(dout0_42) AT=630.025n

.meas tran vdout0_43ck1250 FIND v(dout0_43) AT=630.025n

.meas tran vdout0_44ck1250 FIND v(dout0_44) AT=630.025n

.meas tran vdout0_45ck1250 FIND v(dout0_45) AT=630.025n

.meas tran vdout0_46ck1250 FIND v(dout0_46) AT=630.025n

.meas tran vdout0_47ck1250 FIND v(dout0_47) AT=630.025n

.meas tran vdout0_48ck1250 FIND v(dout0_48) AT=630.025n

.meas tran vdout0_49ck1250 FIND v(dout0_49) AT=630.025n

.meas tran vdout0_50ck1250 FIND v(dout0_50) AT=630.025n

.meas tran vdout0_51ck1250 FIND v(dout0_51) AT=630.025n

.meas tran vdout0_52ck1250 FIND v(dout0_52) AT=630.025n

.meas tran vdout0_53ck1250 FIND v(dout0_53) AT=630.025n

.meas tran vdout0_54ck1250 FIND v(dout0_54) AT=630.025n

.meas tran vdout0_55ck1250 FIND v(dout0_55) AT=630.025n

.meas tran vdout0_56ck1250 FIND v(dout0_56) AT=630.025n

.meas tran vdout0_57ck1250 FIND v(dout0_57) AT=630.025n

.meas tran vdout0_58ck1250 FIND v(dout0_58) AT=630.025n

.meas tran vdout0_59ck1250 FIND v(dout0_59) AT=630.025n

.meas tran vdout0_60ck1250 FIND v(dout0_60) AT=630.025n

.meas tran vdout0_61ck1250 FIND v(dout0_61) AT=630.025n

.meas tran vdout0_62ck1250 FIND v(dout0_62) AT=630.025n

.meas tran vdout0_63ck1250 FIND v(dout0_63) AT=630.025n

.meas tran vdout0_0ck1260 FIND v(dout0_0) AT=635.025n

.meas tran vdout0_1ck1260 FIND v(dout0_1) AT=635.025n

.meas tran vdout0_2ck1260 FIND v(dout0_2) AT=635.025n

.meas tran vdout0_3ck1260 FIND v(dout0_3) AT=635.025n

.meas tran vdout0_4ck1260 FIND v(dout0_4) AT=635.025n

.meas tran vdout0_5ck1260 FIND v(dout0_5) AT=635.025n

.meas tran vdout0_6ck1260 FIND v(dout0_6) AT=635.025n

.meas tran vdout0_7ck1260 FIND v(dout0_7) AT=635.025n

.meas tran vdout0_8ck1260 FIND v(dout0_8) AT=635.025n

.meas tran vdout0_9ck1260 FIND v(dout0_9) AT=635.025n

.meas tran vdout0_10ck1260 FIND v(dout0_10) AT=635.025n

.meas tran vdout0_11ck1260 FIND v(dout0_11) AT=635.025n

.meas tran vdout0_12ck1260 FIND v(dout0_12) AT=635.025n

.meas tran vdout0_13ck1260 FIND v(dout0_13) AT=635.025n

.meas tran vdout0_14ck1260 FIND v(dout0_14) AT=635.025n

.meas tran vdout0_15ck1260 FIND v(dout0_15) AT=635.025n

.meas tran vdout0_16ck1260 FIND v(dout0_16) AT=635.025n

.meas tran vdout0_17ck1260 FIND v(dout0_17) AT=635.025n

.meas tran vdout0_18ck1260 FIND v(dout0_18) AT=635.025n

.meas tran vdout0_19ck1260 FIND v(dout0_19) AT=635.025n

.meas tran vdout0_20ck1260 FIND v(dout0_20) AT=635.025n

.meas tran vdout0_21ck1260 FIND v(dout0_21) AT=635.025n

.meas tran vdout0_22ck1260 FIND v(dout0_22) AT=635.025n

.meas tran vdout0_23ck1260 FIND v(dout0_23) AT=635.025n

.meas tran vdout0_24ck1260 FIND v(dout0_24) AT=635.025n

.meas tran vdout0_25ck1260 FIND v(dout0_25) AT=635.025n

.meas tran vdout0_26ck1260 FIND v(dout0_26) AT=635.025n

.meas tran vdout0_27ck1260 FIND v(dout0_27) AT=635.025n

.meas tran vdout0_28ck1260 FIND v(dout0_28) AT=635.025n

.meas tran vdout0_29ck1260 FIND v(dout0_29) AT=635.025n

.meas tran vdout0_30ck1260 FIND v(dout0_30) AT=635.025n

.meas tran vdout0_31ck1260 FIND v(dout0_31) AT=635.025n

.meas tran vdout0_32ck1260 FIND v(dout0_32) AT=635.025n

.meas tran vdout0_33ck1260 FIND v(dout0_33) AT=635.025n

.meas tran vdout0_34ck1260 FIND v(dout0_34) AT=635.025n

.meas tran vdout0_35ck1260 FIND v(dout0_35) AT=635.025n

.meas tran vdout0_36ck1260 FIND v(dout0_36) AT=635.025n

.meas tran vdout0_37ck1260 FIND v(dout0_37) AT=635.025n

.meas tran vdout0_38ck1260 FIND v(dout0_38) AT=635.025n

.meas tran vdout0_39ck1260 FIND v(dout0_39) AT=635.025n

.meas tran vdout0_40ck1260 FIND v(dout0_40) AT=635.025n

.meas tran vdout0_41ck1260 FIND v(dout0_41) AT=635.025n

.meas tran vdout0_42ck1260 FIND v(dout0_42) AT=635.025n

.meas tran vdout0_43ck1260 FIND v(dout0_43) AT=635.025n

.meas tran vdout0_44ck1260 FIND v(dout0_44) AT=635.025n

.meas tran vdout0_45ck1260 FIND v(dout0_45) AT=635.025n

.meas tran vdout0_46ck1260 FIND v(dout0_46) AT=635.025n

.meas tran vdout0_47ck1260 FIND v(dout0_47) AT=635.025n

.meas tran vdout0_48ck1260 FIND v(dout0_48) AT=635.025n

.meas tran vdout0_49ck1260 FIND v(dout0_49) AT=635.025n

.meas tran vdout0_50ck1260 FIND v(dout0_50) AT=635.025n

.meas tran vdout0_51ck1260 FIND v(dout0_51) AT=635.025n

.meas tran vdout0_52ck1260 FIND v(dout0_52) AT=635.025n

.meas tran vdout0_53ck1260 FIND v(dout0_53) AT=635.025n

.meas tran vdout0_54ck1260 FIND v(dout0_54) AT=635.025n

.meas tran vdout0_55ck1260 FIND v(dout0_55) AT=635.025n

.meas tran vdout0_56ck1260 FIND v(dout0_56) AT=635.025n

.meas tran vdout0_57ck1260 FIND v(dout0_57) AT=635.025n

.meas tran vdout0_58ck1260 FIND v(dout0_58) AT=635.025n

.meas tran vdout0_59ck1260 FIND v(dout0_59) AT=635.025n

.meas tran vdout0_60ck1260 FIND v(dout0_60) AT=635.025n

.meas tran vdout0_61ck1260 FIND v(dout0_61) AT=635.025n

.meas tran vdout0_62ck1260 FIND v(dout0_62) AT=635.025n

.meas tran vdout0_63ck1260 FIND v(dout0_63) AT=635.025n

.meas tran vdout1_0ck1280 FIND v(dout1_0) AT=645.025n

.meas tran vdout1_1ck1280 FIND v(dout1_1) AT=645.025n

.meas tran vdout1_2ck1280 FIND v(dout1_2) AT=645.025n

.meas tran vdout1_3ck1280 FIND v(dout1_3) AT=645.025n

.meas tran vdout1_4ck1280 FIND v(dout1_4) AT=645.025n

.meas tran vdout1_5ck1280 FIND v(dout1_5) AT=645.025n

.meas tran vdout1_6ck1280 FIND v(dout1_6) AT=645.025n

.meas tran vdout1_7ck1280 FIND v(dout1_7) AT=645.025n

.meas tran vdout1_8ck1280 FIND v(dout1_8) AT=645.025n

.meas tran vdout1_9ck1280 FIND v(dout1_9) AT=645.025n

.meas tran vdout1_10ck1280 FIND v(dout1_10) AT=645.025n

.meas tran vdout1_11ck1280 FIND v(dout1_11) AT=645.025n

.meas tran vdout1_12ck1280 FIND v(dout1_12) AT=645.025n

.meas tran vdout1_13ck1280 FIND v(dout1_13) AT=645.025n

.meas tran vdout1_14ck1280 FIND v(dout1_14) AT=645.025n

.meas tran vdout1_15ck1280 FIND v(dout1_15) AT=645.025n

.meas tran vdout1_16ck1280 FIND v(dout1_16) AT=645.025n

.meas tran vdout1_17ck1280 FIND v(dout1_17) AT=645.025n

.meas tran vdout1_18ck1280 FIND v(dout1_18) AT=645.025n

.meas tran vdout1_19ck1280 FIND v(dout1_19) AT=645.025n

.meas tran vdout1_20ck1280 FIND v(dout1_20) AT=645.025n

.meas tran vdout1_21ck1280 FIND v(dout1_21) AT=645.025n

.meas tran vdout1_22ck1280 FIND v(dout1_22) AT=645.025n

.meas tran vdout1_23ck1280 FIND v(dout1_23) AT=645.025n

.meas tran vdout1_24ck1280 FIND v(dout1_24) AT=645.025n

.meas tran vdout1_25ck1280 FIND v(dout1_25) AT=645.025n

.meas tran vdout1_26ck1280 FIND v(dout1_26) AT=645.025n

.meas tran vdout1_27ck1280 FIND v(dout1_27) AT=645.025n

.meas tran vdout1_28ck1280 FIND v(dout1_28) AT=645.025n

.meas tran vdout1_29ck1280 FIND v(dout1_29) AT=645.025n

.meas tran vdout1_30ck1280 FIND v(dout1_30) AT=645.025n

.meas tran vdout1_31ck1280 FIND v(dout1_31) AT=645.025n

.meas tran vdout1_32ck1280 FIND v(dout1_32) AT=645.025n

.meas tran vdout1_33ck1280 FIND v(dout1_33) AT=645.025n

.meas tran vdout1_34ck1280 FIND v(dout1_34) AT=645.025n

.meas tran vdout1_35ck1280 FIND v(dout1_35) AT=645.025n

.meas tran vdout1_36ck1280 FIND v(dout1_36) AT=645.025n

.meas tran vdout1_37ck1280 FIND v(dout1_37) AT=645.025n

.meas tran vdout1_38ck1280 FIND v(dout1_38) AT=645.025n

.meas tran vdout1_39ck1280 FIND v(dout1_39) AT=645.025n

.meas tran vdout1_40ck1280 FIND v(dout1_40) AT=645.025n

.meas tran vdout1_41ck1280 FIND v(dout1_41) AT=645.025n

.meas tran vdout1_42ck1280 FIND v(dout1_42) AT=645.025n

.meas tran vdout1_43ck1280 FIND v(dout1_43) AT=645.025n

.meas tran vdout1_44ck1280 FIND v(dout1_44) AT=645.025n

.meas tran vdout1_45ck1280 FIND v(dout1_45) AT=645.025n

.meas tran vdout1_46ck1280 FIND v(dout1_46) AT=645.025n

.meas tran vdout1_47ck1280 FIND v(dout1_47) AT=645.025n

.meas tran vdout1_48ck1280 FIND v(dout1_48) AT=645.025n

.meas tran vdout1_49ck1280 FIND v(dout1_49) AT=645.025n

.meas tran vdout1_50ck1280 FIND v(dout1_50) AT=645.025n

.meas tran vdout1_51ck1280 FIND v(dout1_51) AT=645.025n

.meas tran vdout1_52ck1280 FIND v(dout1_52) AT=645.025n

.meas tran vdout1_53ck1280 FIND v(dout1_53) AT=645.025n

.meas tran vdout1_54ck1280 FIND v(dout1_54) AT=645.025n

.meas tran vdout1_55ck1280 FIND v(dout1_55) AT=645.025n

.meas tran vdout1_56ck1280 FIND v(dout1_56) AT=645.025n

.meas tran vdout1_57ck1280 FIND v(dout1_57) AT=645.025n

.meas tran vdout1_58ck1280 FIND v(dout1_58) AT=645.025n

.meas tran vdout1_59ck1280 FIND v(dout1_59) AT=645.025n

.meas tran vdout1_60ck1280 FIND v(dout1_60) AT=645.025n

.meas tran vdout1_61ck1280 FIND v(dout1_61) AT=645.025n

.meas tran vdout1_62ck1280 FIND v(dout1_62) AT=645.025n

.meas tran vdout1_63ck1280 FIND v(dout1_63) AT=645.025n

.meas tran vdout1_0ck1300 FIND v(dout1_0) AT=655.025n

.meas tran vdout1_1ck1300 FIND v(dout1_1) AT=655.025n

.meas tran vdout1_2ck1300 FIND v(dout1_2) AT=655.025n

.meas tran vdout1_3ck1300 FIND v(dout1_3) AT=655.025n

.meas tran vdout1_4ck1300 FIND v(dout1_4) AT=655.025n

.meas tran vdout1_5ck1300 FIND v(dout1_5) AT=655.025n

.meas tran vdout1_6ck1300 FIND v(dout1_6) AT=655.025n

.meas tran vdout1_7ck1300 FIND v(dout1_7) AT=655.025n

.meas tran vdout1_8ck1300 FIND v(dout1_8) AT=655.025n

.meas tran vdout1_9ck1300 FIND v(dout1_9) AT=655.025n

.meas tran vdout1_10ck1300 FIND v(dout1_10) AT=655.025n

.meas tran vdout1_11ck1300 FIND v(dout1_11) AT=655.025n

.meas tran vdout1_12ck1300 FIND v(dout1_12) AT=655.025n

.meas tran vdout1_13ck1300 FIND v(dout1_13) AT=655.025n

.meas tran vdout1_14ck1300 FIND v(dout1_14) AT=655.025n

.meas tran vdout1_15ck1300 FIND v(dout1_15) AT=655.025n

.meas tran vdout1_16ck1300 FIND v(dout1_16) AT=655.025n

.meas tran vdout1_17ck1300 FIND v(dout1_17) AT=655.025n

.meas tran vdout1_18ck1300 FIND v(dout1_18) AT=655.025n

.meas tran vdout1_19ck1300 FIND v(dout1_19) AT=655.025n

.meas tran vdout1_20ck1300 FIND v(dout1_20) AT=655.025n

.meas tran vdout1_21ck1300 FIND v(dout1_21) AT=655.025n

.meas tran vdout1_22ck1300 FIND v(dout1_22) AT=655.025n

.meas tran vdout1_23ck1300 FIND v(dout1_23) AT=655.025n

.meas tran vdout1_24ck1300 FIND v(dout1_24) AT=655.025n

.meas tran vdout1_25ck1300 FIND v(dout1_25) AT=655.025n

.meas tran vdout1_26ck1300 FIND v(dout1_26) AT=655.025n

.meas tran vdout1_27ck1300 FIND v(dout1_27) AT=655.025n

.meas tran vdout1_28ck1300 FIND v(dout1_28) AT=655.025n

.meas tran vdout1_29ck1300 FIND v(dout1_29) AT=655.025n

.meas tran vdout1_30ck1300 FIND v(dout1_30) AT=655.025n

.meas tran vdout1_31ck1300 FIND v(dout1_31) AT=655.025n

.meas tran vdout1_32ck1300 FIND v(dout1_32) AT=655.025n

.meas tran vdout1_33ck1300 FIND v(dout1_33) AT=655.025n

.meas tran vdout1_34ck1300 FIND v(dout1_34) AT=655.025n

.meas tran vdout1_35ck1300 FIND v(dout1_35) AT=655.025n

.meas tran vdout1_36ck1300 FIND v(dout1_36) AT=655.025n

.meas tran vdout1_37ck1300 FIND v(dout1_37) AT=655.025n

.meas tran vdout1_38ck1300 FIND v(dout1_38) AT=655.025n

.meas tran vdout1_39ck1300 FIND v(dout1_39) AT=655.025n

.meas tran vdout1_40ck1300 FIND v(dout1_40) AT=655.025n

.meas tran vdout1_41ck1300 FIND v(dout1_41) AT=655.025n

.meas tran vdout1_42ck1300 FIND v(dout1_42) AT=655.025n

.meas tran vdout1_43ck1300 FIND v(dout1_43) AT=655.025n

.meas tran vdout1_44ck1300 FIND v(dout1_44) AT=655.025n

.meas tran vdout1_45ck1300 FIND v(dout1_45) AT=655.025n

.meas tran vdout1_46ck1300 FIND v(dout1_46) AT=655.025n

.meas tran vdout1_47ck1300 FIND v(dout1_47) AT=655.025n

.meas tran vdout1_48ck1300 FIND v(dout1_48) AT=655.025n

.meas tran vdout1_49ck1300 FIND v(dout1_49) AT=655.025n

.meas tran vdout1_50ck1300 FIND v(dout1_50) AT=655.025n

.meas tran vdout1_51ck1300 FIND v(dout1_51) AT=655.025n

.meas tran vdout1_52ck1300 FIND v(dout1_52) AT=655.025n

.meas tran vdout1_53ck1300 FIND v(dout1_53) AT=655.025n

.meas tran vdout1_54ck1300 FIND v(dout1_54) AT=655.025n

.meas tran vdout1_55ck1300 FIND v(dout1_55) AT=655.025n

.meas tran vdout1_56ck1300 FIND v(dout1_56) AT=655.025n

.meas tran vdout1_57ck1300 FIND v(dout1_57) AT=655.025n

.meas tran vdout1_58ck1300 FIND v(dout1_58) AT=655.025n

.meas tran vdout1_59ck1300 FIND v(dout1_59) AT=655.025n

.meas tran vdout1_60ck1300 FIND v(dout1_60) AT=655.025n

.meas tran vdout1_61ck1300 FIND v(dout1_61) AT=655.025n

.meas tran vdout1_62ck1300 FIND v(dout1_62) AT=655.025n

.meas tran vdout1_63ck1300 FIND v(dout1_63) AT=655.025n

.meas tran vdout1_0ck1310 FIND v(dout1_0) AT=660.025n

.meas tran vdout1_1ck1310 FIND v(dout1_1) AT=660.025n

.meas tran vdout1_2ck1310 FIND v(dout1_2) AT=660.025n

.meas tran vdout1_3ck1310 FIND v(dout1_3) AT=660.025n

.meas tran vdout1_4ck1310 FIND v(dout1_4) AT=660.025n

.meas tran vdout1_5ck1310 FIND v(dout1_5) AT=660.025n

.meas tran vdout1_6ck1310 FIND v(dout1_6) AT=660.025n

.meas tran vdout1_7ck1310 FIND v(dout1_7) AT=660.025n

.meas tran vdout1_8ck1310 FIND v(dout1_8) AT=660.025n

.meas tran vdout1_9ck1310 FIND v(dout1_9) AT=660.025n

.meas tran vdout1_10ck1310 FIND v(dout1_10) AT=660.025n

.meas tran vdout1_11ck1310 FIND v(dout1_11) AT=660.025n

.meas tran vdout1_12ck1310 FIND v(dout1_12) AT=660.025n

.meas tran vdout1_13ck1310 FIND v(dout1_13) AT=660.025n

.meas tran vdout1_14ck1310 FIND v(dout1_14) AT=660.025n

.meas tran vdout1_15ck1310 FIND v(dout1_15) AT=660.025n

.meas tran vdout1_16ck1310 FIND v(dout1_16) AT=660.025n

.meas tran vdout1_17ck1310 FIND v(dout1_17) AT=660.025n

.meas tran vdout1_18ck1310 FIND v(dout1_18) AT=660.025n

.meas tran vdout1_19ck1310 FIND v(dout1_19) AT=660.025n

.meas tran vdout1_20ck1310 FIND v(dout1_20) AT=660.025n

.meas tran vdout1_21ck1310 FIND v(dout1_21) AT=660.025n

.meas tran vdout1_22ck1310 FIND v(dout1_22) AT=660.025n

.meas tran vdout1_23ck1310 FIND v(dout1_23) AT=660.025n

.meas tran vdout1_24ck1310 FIND v(dout1_24) AT=660.025n

.meas tran vdout1_25ck1310 FIND v(dout1_25) AT=660.025n

.meas tran vdout1_26ck1310 FIND v(dout1_26) AT=660.025n

.meas tran vdout1_27ck1310 FIND v(dout1_27) AT=660.025n

.meas tran vdout1_28ck1310 FIND v(dout1_28) AT=660.025n

.meas tran vdout1_29ck1310 FIND v(dout1_29) AT=660.025n

.meas tran vdout1_30ck1310 FIND v(dout1_30) AT=660.025n

.meas tran vdout1_31ck1310 FIND v(dout1_31) AT=660.025n

.meas tran vdout1_32ck1310 FIND v(dout1_32) AT=660.025n

.meas tran vdout1_33ck1310 FIND v(dout1_33) AT=660.025n

.meas tran vdout1_34ck1310 FIND v(dout1_34) AT=660.025n

.meas tran vdout1_35ck1310 FIND v(dout1_35) AT=660.025n

.meas tran vdout1_36ck1310 FIND v(dout1_36) AT=660.025n

.meas tran vdout1_37ck1310 FIND v(dout1_37) AT=660.025n

.meas tran vdout1_38ck1310 FIND v(dout1_38) AT=660.025n

.meas tran vdout1_39ck1310 FIND v(dout1_39) AT=660.025n

.meas tran vdout1_40ck1310 FIND v(dout1_40) AT=660.025n

.meas tran vdout1_41ck1310 FIND v(dout1_41) AT=660.025n

.meas tran vdout1_42ck1310 FIND v(dout1_42) AT=660.025n

.meas tran vdout1_43ck1310 FIND v(dout1_43) AT=660.025n

.meas tran vdout1_44ck1310 FIND v(dout1_44) AT=660.025n

.meas tran vdout1_45ck1310 FIND v(dout1_45) AT=660.025n

.meas tran vdout1_46ck1310 FIND v(dout1_46) AT=660.025n

.meas tran vdout1_47ck1310 FIND v(dout1_47) AT=660.025n

.meas tran vdout1_48ck1310 FIND v(dout1_48) AT=660.025n

.meas tran vdout1_49ck1310 FIND v(dout1_49) AT=660.025n

.meas tran vdout1_50ck1310 FIND v(dout1_50) AT=660.025n

.meas tran vdout1_51ck1310 FIND v(dout1_51) AT=660.025n

.meas tran vdout1_52ck1310 FIND v(dout1_52) AT=660.025n

.meas tran vdout1_53ck1310 FIND v(dout1_53) AT=660.025n

.meas tran vdout1_54ck1310 FIND v(dout1_54) AT=660.025n

.meas tran vdout1_55ck1310 FIND v(dout1_55) AT=660.025n

.meas tran vdout1_56ck1310 FIND v(dout1_56) AT=660.025n

.meas tran vdout1_57ck1310 FIND v(dout1_57) AT=660.025n

.meas tran vdout1_58ck1310 FIND v(dout1_58) AT=660.025n

.meas tran vdout1_59ck1310 FIND v(dout1_59) AT=660.025n

.meas tran vdout1_60ck1310 FIND v(dout1_60) AT=660.025n

.meas tran vdout1_61ck1310 FIND v(dout1_61) AT=660.025n

.meas tran vdout1_62ck1310 FIND v(dout1_62) AT=660.025n

.meas tran vdout1_63ck1310 FIND v(dout1_63) AT=660.025n

.meas tran vdout0_0ck1330 FIND v(dout0_0) AT=670.025n

.meas tran vdout0_1ck1330 FIND v(dout0_1) AT=670.025n

.meas tran vdout0_2ck1330 FIND v(dout0_2) AT=670.025n

.meas tran vdout0_3ck1330 FIND v(dout0_3) AT=670.025n

.meas tran vdout0_4ck1330 FIND v(dout0_4) AT=670.025n

.meas tran vdout0_5ck1330 FIND v(dout0_5) AT=670.025n

.meas tran vdout0_6ck1330 FIND v(dout0_6) AT=670.025n

.meas tran vdout0_7ck1330 FIND v(dout0_7) AT=670.025n

.meas tran vdout0_8ck1330 FIND v(dout0_8) AT=670.025n

.meas tran vdout0_9ck1330 FIND v(dout0_9) AT=670.025n

.meas tran vdout0_10ck1330 FIND v(dout0_10) AT=670.025n

.meas tran vdout0_11ck1330 FIND v(dout0_11) AT=670.025n

.meas tran vdout0_12ck1330 FIND v(dout0_12) AT=670.025n

.meas tran vdout0_13ck1330 FIND v(dout0_13) AT=670.025n

.meas tran vdout0_14ck1330 FIND v(dout0_14) AT=670.025n

.meas tran vdout0_15ck1330 FIND v(dout0_15) AT=670.025n

.meas tran vdout0_16ck1330 FIND v(dout0_16) AT=670.025n

.meas tran vdout0_17ck1330 FIND v(dout0_17) AT=670.025n

.meas tran vdout0_18ck1330 FIND v(dout0_18) AT=670.025n

.meas tran vdout0_19ck1330 FIND v(dout0_19) AT=670.025n

.meas tran vdout0_20ck1330 FIND v(dout0_20) AT=670.025n

.meas tran vdout0_21ck1330 FIND v(dout0_21) AT=670.025n

.meas tran vdout0_22ck1330 FIND v(dout0_22) AT=670.025n

.meas tran vdout0_23ck1330 FIND v(dout0_23) AT=670.025n

.meas tran vdout0_24ck1330 FIND v(dout0_24) AT=670.025n

.meas tran vdout0_25ck1330 FIND v(dout0_25) AT=670.025n

.meas tran vdout0_26ck1330 FIND v(dout0_26) AT=670.025n

.meas tran vdout0_27ck1330 FIND v(dout0_27) AT=670.025n

.meas tran vdout0_28ck1330 FIND v(dout0_28) AT=670.025n

.meas tran vdout0_29ck1330 FIND v(dout0_29) AT=670.025n

.meas tran vdout0_30ck1330 FIND v(dout0_30) AT=670.025n

.meas tran vdout0_31ck1330 FIND v(dout0_31) AT=670.025n

.meas tran vdout0_32ck1330 FIND v(dout0_32) AT=670.025n

.meas tran vdout0_33ck1330 FIND v(dout0_33) AT=670.025n

.meas tran vdout0_34ck1330 FIND v(dout0_34) AT=670.025n

.meas tran vdout0_35ck1330 FIND v(dout0_35) AT=670.025n

.meas tran vdout0_36ck1330 FIND v(dout0_36) AT=670.025n

.meas tran vdout0_37ck1330 FIND v(dout0_37) AT=670.025n

.meas tran vdout0_38ck1330 FIND v(dout0_38) AT=670.025n

.meas tran vdout0_39ck1330 FIND v(dout0_39) AT=670.025n

.meas tran vdout0_40ck1330 FIND v(dout0_40) AT=670.025n

.meas tran vdout0_41ck1330 FIND v(dout0_41) AT=670.025n

.meas tran vdout0_42ck1330 FIND v(dout0_42) AT=670.025n

.meas tran vdout0_43ck1330 FIND v(dout0_43) AT=670.025n

.meas tran vdout0_44ck1330 FIND v(dout0_44) AT=670.025n

.meas tran vdout0_45ck1330 FIND v(dout0_45) AT=670.025n

.meas tran vdout0_46ck1330 FIND v(dout0_46) AT=670.025n

.meas tran vdout0_47ck1330 FIND v(dout0_47) AT=670.025n

.meas tran vdout0_48ck1330 FIND v(dout0_48) AT=670.025n

.meas tran vdout0_49ck1330 FIND v(dout0_49) AT=670.025n

.meas tran vdout0_50ck1330 FIND v(dout0_50) AT=670.025n

.meas tran vdout0_51ck1330 FIND v(dout0_51) AT=670.025n

.meas tran vdout0_52ck1330 FIND v(dout0_52) AT=670.025n

.meas tran vdout0_53ck1330 FIND v(dout0_53) AT=670.025n

.meas tran vdout0_54ck1330 FIND v(dout0_54) AT=670.025n

.meas tran vdout0_55ck1330 FIND v(dout0_55) AT=670.025n

.meas tran vdout0_56ck1330 FIND v(dout0_56) AT=670.025n

.meas tran vdout0_57ck1330 FIND v(dout0_57) AT=670.025n

.meas tran vdout0_58ck1330 FIND v(dout0_58) AT=670.025n

.meas tran vdout0_59ck1330 FIND v(dout0_59) AT=670.025n

.meas tran vdout0_60ck1330 FIND v(dout0_60) AT=670.025n

.meas tran vdout0_61ck1330 FIND v(dout0_61) AT=670.025n

.meas tran vdout0_62ck1330 FIND v(dout0_62) AT=670.025n

.meas tran vdout0_63ck1330 FIND v(dout0_63) AT=670.025n

.meas tran vdout1_0ck1330 FIND v(dout1_0) AT=670.025n

.meas tran vdout1_1ck1330 FIND v(dout1_1) AT=670.025n

.meas tran vdout1_2ck1330 FIND v(dout1_2) AT=670.025n

.meas tran vdout1_3ck1330 FIND v(dout1_3) AT=670.025n

.meas tran vdout1_4ck1330 FIND v(dout1_4) AT=670.025n

.meas tran vdout1_5ck1330 FIND v(dout1_5) AT=670.025n

.meas tran vdout1_6ck1330 FIND v(dout1_6) AT=670.025n

.meas tran vdout1_7ck1330 FIND v(dout1_7) AT=670.025n

.meas tran vdout1_8ck1330 FIND v(dout1_8) AT=670.025n

.meas tran vdout1_9ck1330 FIND v(dout1_9) AT=670.025n

.meas tran vdout1_10ck1330 FIND v(dout1_10) AT=670.025n

.meas tran vdout1_11ck1330 FIND v(dout1_11) AT=670.025n

.meas tran vdout1_12ck1330 FIND v(dout1_12) AT=670.025n

.meas tran vdout1_13ck1330 FIND v(dout1_13) AT=670.025n

.meas tran vdout1_14ck1330 FIND v(dout1_14) AT=670.025n

.meas tran vdout1_15ck1330 FIND v(dout1_15) AT=670.025n

.meas tran vdout1_16ck1330 FIND v(dout1_16) AT=670.025n

.meas tran vdout1_17ck1330 FIND v(dout1_17) AT=670.025n

.meas tran vdout1_18ck1330 FIND v(dout1_18) AT=670.025n

.meas tran vdout1_19ck1330 FIND v(dout1_19) AT=670.025n

.meas tran vdout1_20ck1330 FIND v(dout1_20) AT=670.025n

.meas tran vdout1_21ck1330 FIND v(dout1_21) AT=670.025n

.meas tran vdout1_22ck1330 FIND v(dout1_22) AT=670.025n

.meas tran vdout1_23ck1330 FIND v(dout1_23) AT=670.025n

.meas tran vdout1_24ck1330 FIND v(dout1_24) AT=670.025n

.meas tran vdout1_25ck1330 FIND v(dout1_25) AT=670.025n

.meas tran vdout1_26ck1330 FIND v(dout1_26) AT=670.025n

.meas tran vdout1_27ck1330 FIND v(dout1_27) AT=670.025n

.meas tran vdout1_28ck1330 FIND v(dout1_28) AT=670.025n

.meas tran vdout1_29ck1330 FIND v(dout1_29) AT=670.025n

.meas tran vdout1_30ck1330 FIND v(dout1_30) AT=670.025n

.meas tran vdout1_31ck1330 FIND v(dout1_31) AT=670.025n

.meas tran vdout1_32ck1330 FIND v(dout1_32) AT=670.025n

.meas tran vdout1_33ck1330 FIND v(dout1_33) AT=670.025n

.meas tran vdout1_34ck1330 FIND v(dout1_34) AT=670.025n

.meas tran vdout1_35ck1330 FIND v(dout1_35) AT=670.025n

.meas tran vdout1_36ck1330 FIND v(dout1_36) AT=670.025n

.meas tran vdout1_37ck1330 FIND v(dout1_37) AT=670.025n

.meas tran vdout1_38ck1330 FIND v(dout1_38) AT=670.025n

.meas tran vdout1_39ck1330 FIND v(dout1_39) AT=670.025n

.meas tran vdout1_40ck1330 FIND v(dout1_40) AT=670.025n

.meas tran vdout1_41ck1330 FIND v(dout1_41) AT=670.025n

.meas tran vdout1_42ck1330 FIND v(dout1_42) AT=670.025n

.meas tran vdout1_43ck1330 FIND v(dout1_43) AT=670.025n

.meas tran vdout1_44ck1330 FIND v(dout1_44) AT=670.025n

.meas tran vdout1_45ck1330 FIND v(dout1_45) AT=670.025n

.meas tran vdout1_46ck1330 FIND v(dout1_46) AT=670.025n

.meas tran vdout1_47ck1330 FIND v(dout1_47) AT=670.025n

.meas tran vdout1_48ck1330 FIND v(dout1_48) AT=670.025n

.meas tran vdout1_49ck1330 FIND v(dout1_49) AT=670.025n

.meas tran vdout1_50ck1330 FIND v(dout1_50) AT=670.025n

.meas tran vdout1_51ck1330 FIND v(dout1_51) AT=670.025n

.meas tran vdout1_52ck1330 FIND v(dout1_52) AT=670.025n

.meas tran vdout1_53ck1330 FIND v(dout1_53) AT=670.025n

.meas tran vdout1_54ck1330 FIND v(dout1_54) AT=670.025n

.meas tran vdout1_55ck1330 FIND v(dout1_55) AT=670.025n

.meas tran vdout1_56ck1330 FIND v(dout1_56) AT=670.025n

.meas tran vdout1_57ck1330 FIND v(dout1_57) AT=670.025n

.meas tran vdout1_58ck1330 FIND v(dout1_58) AT=670.025n

.meas tran vdout1_59ck1330 FIND v(dout1_59) AT=670.025n

.meas tran vdout1_60ck1330 FIND v(dout1_60) AT=670.025n

.meas tran vdout1_61ck1330 FIND v(dout1_61) AT=670.025n

.meas tran vdout1_62ck1330 FIND v(dout1_62) AT=670.025n

.meas tran vdout1_63ck1330 FIND v(dout1_63) AT=670.025n

.meas tran vdout0_0ck1350 FIND v(dout0_0) AT=680.025n

.meas tran vdout0_1ck1350 FIND v(dout0_1) AT=680.025n

.meas tran vdout0_2ck1350 FIND v(dout0_2) AT=680.025n

.meas tran vdout0_3ck1350 FIND v(dout0_3) AT=680.025n

.meas tran vdout0_4ck1350 FIND v(dout0_4) AT=680.025n

.meas tran vdout0_5ck1350 FIND v(dout0_5) AT=680.025n

.meas tran vdout0_6ck1350 FIND v(dout0_6) AT=680.025n

.meas tran vdout0_7ck1350 FIND v(dout0_7) AT=680.025n

.meas tran vdout0_8ck1350 FIND v(dout0_8) AT=680.025n

.meas tran vdout0_9ck1350 FIND v(dout0_9) AT=680.025n

.meas tran vdout0_10ck1350 FIND v(dout0_10) AT=680.025n

.meas tran vdout0_11ck1350 FIND v(dout0_11) AT=680.025n

.meas tran vdout0_12ck1350 FIND v(dout0_12) AT=680.025n

.meas tran vdout0_13ck1350 FIND v(dout0_13) AT=680.025n

.meas tran vdout0_14ck1350 FIND v(dout0_14) AT=680.025n

.meas tran vdout0_15ck1350 FIND v(dout0_15) AT=680.025n

.meas tran vdout0_16ck1350 FIND v(dout0_16) AT=680.025n

.meas tran vdout0_17ck1350 FIND v(dout0_17) AT=680.025n

.meas tran vdout0_18ck1350 FIND v(dout0_18) AT=680.025n

.meas tran vdout0_19ck1350 FIND v(dout0_19) AT=680.025n

.meas tran vdout0_20ck1350 FIND v(dout0_20) AT=680.025n

.meas tran vdout0_21ck1350 FIND v(dout0_21) AT=680.025n

.meas tran vdout0_22ck1350 FIND v(dout0_22) AT=680.025n

.meas tran vdout0_23ck1350 FIND v(dout0_23) AT=680.025n

.meas tran vdout0_24ck1350 FIND v(dout0_24) AT=680.025n

.meas tran vdout0_25ck1350 FIND v(dout0_25) AT=680.025n

.meas tran vdout0_26ck1350 FIND v(dout0_26) AT=680.025n

.meas tran vdout0_27ck1350 FIND v(dout0_27) AT=680.025n

.meas tran vdout0_28ck1350 FIND v(dout0_28) AT=680.025n

.meas tran vdout0_29ck1350 FIND v(dout0_29) AT=680.025n

.meas tran vdout0_30ck1350 FIND v(dout0_30) AT=680.025n

.meas tran vdout0_31ck1350 FIND v(dout0_31) AT=680.025n

.meas tran vdout0_32ck1350 FIND v(dout0_32) AT=680.025n

.meas tran vdout0_33ck1350 FIND v(dout0_33) AT=680.025n

.meas tran vdout0_34ck1350 FIND v(dout0_34) AT=680.025n

.meas tran vdout0_35ck1350 FIND v(dout0_35) AT=680.025n

.meas tran vdout0_36ck1350 FIND v(dout0_36) AT=680.025n

.meas tran vdout0_37ck1350 FIND v(dout0_37) AT=680.025n

.meas tran vdout0_38ck1350 FIND v(dout0_38) AT=680.025n

.meas tran vdout0_39ck1350 FIND v(dout0_39) AT=680.025n

.meas tran vdout0_40ck1350 FIND v(dout0_40) AT=680.025n

.meas tran vdout0_41ck1350 FIND v(dout0_41) AT=680.025n

.meas tran vdout0_42ck1350 FIND v(dout0_42) AT=680.025n

.meas tran vdout0_43ck1350 FIND v(dout0_43) AT=680.025n

.meas tran vdout0_44ck1350 FIND v(dout0_44) AT=680.025n

.meas tran vdout0_45ck1350 FIND v(dout0_45) AT=680.025n

.meas tran vdout0_46ck1350 FIND v(dout0_46) AT=680.025n

.meas tran vdout0_47ck1350 FIND v(dout0_47) AT=680.025n

.meas tran vdout0_48ck1350 FIND v(dout0_48) AT=680.025n

.meas tran vdout0_49ck1350 FIND v(dout0_49) AT=680.025n

.meas tran vdout0_50ck1350 FIND v(dout0_50) AT=680.025n

.meas tran vdout0_51ck1350 FIND v(dout0_51) AT=680.025n

.meas tran vdout0_52ck1350 FIND v(dout0_52) AT=680.025n

.meas tran vdout0_53ck1350 FIND v(dout0_53) AT=680.025n

.meas tran vdout0_54ck1350 FIND v(dout0_54) AT=680.025n

.meas tran vdout0_55ck1350 FIND v(dout0_55) AT=680.025n

.meas tran vdout0_56ck1350 FIND v(dout0_56) AT=680.025n

.meas tran vdout0_57ck1350 FIND v(dout0_57) AT=680.025n

.meas tran vdout0_58ck1350 FIND v(dout0_58) AT=680.025n

.meas tran vdout0_59ck1350 FIND v(dout0_59) AT=680.025n

.meas tran vdout0_60ck1350 FIND v(dout0_60) AT=680.025n

.meas tran vdout0_61ck1350 FIND v(dout0_61) AT=680.025n

.meas tran vdout0_62ck1350 FIND v(dout0_62) AT=680.025n

.meas tran vdout0_63ck1350 FIND v(dout0_63) AT=680.025n

.meas tran vdout1_0ck1350 FIND v(dout1_0) AT=680.025n

.meas tran vdout1_1ck1350 FIND v(dout1_1) AT=680.025n

.meas tran vdout1_2ck1350 FIND v(dout1_2) AT=680.025n

.meas tran vdout1_3ck1350 FIND v(dout1_3) AT=680.025n

.meas tran vdout1_4ck1350 FIND v(dout1_4) AT=680.025n

.meas tran vdout1_5ck1350 FIND v(dout1_5) AT=680.025n

.meas tran vdout1_6ck1350 FIND v(dout1_6) AT=680.025n

.meas tran vdout1_7ck1350 FIND v(dout1_7) AT=680.025n

.meas tran vdout1_8ck1350 FIND v(dout1_8) AT=680.025n

.meas tran vdout1_9ck1350 FIND v(dout1_9) AT=680.025n

.meas tran vdout1_10ck1350 FIND v(dout1_10) AT=680.025n

.meas tran vdout1_11ck1350 FIND v(dout1_11) AT=680.025n

.meas tran vdout1_12ck1350 FIND v(dout1_12) AT=680.025n

.meas tran vdout1_13ck1350 FIND v(dout1_13) AT=680.025n

.meas tran vdout1_14ck1350 FIND v(dout1_14) AT=680.025n

.meas tran vdout1_15ck1350 FIND v(dout1_15) AT=680.025n

.meas tran vdout1_16ck1350 FIND v(dout1_16) AT=680.025n

.meas tran vdout1_17ck1350 FIND v(dout1_17) AT=680.025n

.meas tran vdout1_18ck1350 FIND v(dout1_18) AT=680.025n

.meas tran vdout1_19ck1350 FIND v(dout1_19) AT=680.025n

.meas tran vdout1_20ck1350 FIND v(dout1_20) AT=680.025n

.meas tran vdout1_21ck1350 FIND v(dout1_21) AT=680.025n

.meas tran vdout1_22ck1350 FIND v(dout1_22) AT=680.025n

.meas tran vdout1_23ck1350 FIND v(dout1_23) AT=680.025n

.meas tran vdout1_24ck1350 FIND v(dout1_24) AT=680.025n

.meas tran vdout1_25ck1350 FIND v(dout1_25) AT=680.025n

.meas tran vdout1_26ck1350 FIND v(dout1_26) AT=680.025n

.meas tran vdout1_27ck1350 FIND v(dout1_27) AT=680.025n

.meas tran vdout1_28ck1350 FIND v(dout1_28) AT=680.025n

.meas tran vdout1_29ck1350 FIND v(dout1_29) AT=680.025n

.meas tran vdout1_30ck1350 FIND v(dout1_30) AT=680.025n

.meas tran vdout1_31ck1350 FIND v(dout1_31) AT=680.025n

.meas tran vdout1_32ck1350 FIND v(dout1_32) AT=680.025n

.meas tran vdout1_33ck1350 FIND v(dout1_33) AT=680.025n

.meas tran vdout1_34ck1350 FIND v(dout1_34) AT=680.025n

.meas tran vdout1_35ck1350 FIND v(dout1_35) AT=680.025n

.meas tran vdout1_36ck1350 FIND v(dout1_36) AT=680.025n

.meas tran vdout1_37ck1350 FIND v(dout1_37) AT=680.025n

.meas tran vdout1_38ck1350 FIND v(dout1_38) AT=680.025n

.meas tran vdout1_39ck1350 FIND v(dout1_39) AT=680.025n

.meas tran vdout1_40ck1350 FIND v(dout1_40) AT=680.025n

.meas tran vdout1_41ck1350 FIND v(dout1_41) AT=680.025n

.meas tran vdout1_42ck1350 FIND v(dout1_42) AT=680.025n

.meas tran vdout1_43ck1350 FIND v(dout1_43) AT=680.025n

.meas tran vdout1_44ck1350 FIND v(dout1_44) AT=680.025n

.meas tran vdout1_45ck1350 FIND v(dout1_45) AT=680.025n

.meas tran vdout1_46ck1350 FIND v(dout1_46) AT=680.025n

.meas tran vdout1_47ck1350 FIND v(dout1_47) AT=680.025n

.meas tran vdout1_48ck1350 FIND v(dout1_48) AT=680.025n

.meas tran vdout1_49ck1350 FIND v(dout1_49) AT=680.025n

.meas tran vdout1_50ck1350 FIND v(dout1_50) AT=680.025n

.meas tran vdout1_51ck1350 FIND v(dout1_51) AT=680.025n

.meas tran vdout1_52ck1350 FIND v(dout1_52) AT=680.025n

.meas tran vdout1_53ck1350 FIND v(dout1_53) AT=680.025n

.meas tran vdout1_54ck1350 FIND v(dout1_54) AT=680.025n

.meas tran vdout1_55ck1350 FIND v(dout1_55) AT=680.025n

.meas tran vdout1_56ck1350 FIND v(dout1_56) AT=680.025n

.meas tran vdout1_57ck1350 FIND v(dout1_57) AT=680.025n

.meas tran vdout1_58ck1350 FIND v(dout1_58) AT=680.025n

.meas tran vdout1_59ck1350 FIND v(dout1_59) AT=680.025n

.meas tran vdout1_60ck1350 FIND v(dout1_60) AT=680.025n

.meas tran vdout1_61ck1350 FIND v(dout1_61) AT=680.025n

.meas tran vdout1_62ck1350 FIND v(dout1_62) AT=680.025n

.meas tran vdout1_63ck1350 FIND v(dout1_63) AT=680.025n

.meas tran vdout0_0ck1360 FIND v(dout0_0) AT=685.025n

.meas tran vdout0_1ck1360 FIND v(dout0_1) AT=685.025n

.meas tran vdout0_2ck1360 FIND v(dout0_2) AT=685.025n

.meas tran vdout0_3ck1360 FIND v(dout0_3) AT=685.025n

.meas tran vdout0_4ck1360 FIND v(dout0_4) AT=685.025n

.meas tran vdout0_5ck1360 FIND v(dout0_5) AT=685.025n

.meas tran vdout0_6ck1360 FIND v(dout0_6) AT=685.025n

.meas tran vdout0_7ck1360 FIND v(dout0_7) AT=685.025n

.meas tran vdout0_8ck1360 FIND v(dout0_8) AT=685.025n

.meas tran vdout0_9ck1360 FIND v(dout0_9) AT=685.025n

.meas tran vdout0_10ck1360 FIND v(dout0_10) AT=685.025n

.meas tran vdout0_11ck1360 FIND v(dout0_11) AT=685.025n

.meas tran vdout0_12ck1360 FIND v(dout0_12) AT=685.025n

.meas tran vdout0_13ck1360 FIND v(dout0_13) AT=685.025n

.meas tran vdout0_14ck1360 FIND v(dout0_14) AT=685.025n

.meas tran vdout0_15ck1360 FIND v(dout0_15) AT=685.025n

.meas tran vdout0_16ck1360 FIND v(dout0_16) AT=685.025n

.meas tran vdout0_17ck1360 FIND v(dout0_17) AT=685.025n

.meas tran vdout0_18ck1360 FIND v(dout0_18) AT=685.025n

.meas tran vdout0_19ck1360 FIND v(dout0_19) AT=685.025n

.meas tran vdout0_20ck1360 FIND v(dout0_20) AT=685.025n

.meas tran vdout0_21ck1360 FIND v(dout0_21) AT=685.025n

.meas tran vdout0_22ck1360 FIND v(dout0_22) AT=685.025n

.meas tran vdout0_23ck1360 FIND v(dout0_23) AT=685.025n

.meas tran vdout0_24ck1360 FIND v(dout0_24) AT=685.025n

.meas tran vdout0_25ck1360 FIND v(dout0_25) AT=685.025n

.meas tran vdout0_26ck1360 FIND v(dout0_26) AT=685.025n

.meas tran vdout0_27ck1360 FIND v(dout0_27) AT=685.025n

.meas tran vdout0_28ck1360 FIND v(dout0_28) AT=685.025n

.meas tran vdout0_29ck1360 FIND v(dout0_29) AT=685.025n

.meas tran vdout0_30ck1360 FIND v(dout0_30) AT=685.025n

.meas tran vdout0_31ck1360 FIND v(dout0_31) AT=685.025n

.meas tran vdout0_32ck1360 FIND v(dout0_32) AT=685.025n

.meas tran vdout0_33ck1360 FIND v(dout0_33) AT=685.025n

.meas tran vdout0_34ck1360 FIND v(dout0_34) AT=685.025n

.meas tran vdout0_35ck1360 FIND v(dout0_35) AT=685.025n

.meas tran vdout0_36ck1360 FIND v(dout0_36) AT=685.025n

.meas tran vdout0_37ck1360 FIND v(dout0_37) AT=685.025n

.meas tran vdout0_38ck1360 FIND v(dout0_38) AT=685.025n

.meas tran vdout0_39ck1360 FIND v(dout0_39) AT=685.025n

.meas tran vdout0_40ck1360 FIND v(dout0_40) AT=685.025n

.meas tran vdout0_41ck1360 FIND v(dout0_41) AT=685.025n

.meas tran vdout0_42ck1360 FIND v(dout0_42) AT=685.025n

.meas tran vdout0_43ck1360 FIND v(dout0_43) AT=685.025n

.meas tran vdout0_44ck1360 FIND v(dout0_44) AT=685.025n

.meas tran vdout0_45ck1360 FIND v(dout0_45) AT=685.025n

.meas tran vdout0_46ck1360 FIND v(dout0_46) AT=685.025n

.meas tran vdout0_47ck1360 FIND v(dout0_47) AT=685.025n

.meas tran vdout0_48ck1360 FIND v(dout0_48) AT=685.025n

.meas tran vdout0_49ck1360 FIND v(dout0_49) AT=685.025n

.meas tran vdout0_50ck1360 FIND v(dout0_50) AT=685.025n

.meas tran vdout0_51ck1360 FIND v(dout0_51) AT=685.025n

.meas tran vdout0_52ck1360 FIND v(dout0_52) AT=685.025n

.meas tran vdout0_53ck1360 FIND v(dout0_53) AT=685.025n

.meas tran vdout0_54ck1360 FIND v(dout0_54) AT=685.025n

.meas tran vdout0_55ck1360 FIND v(dout0_55) AT=685.025n

.meas tran vdout0_56ck1360 FIND v(dout0_56) AT=685.025n

.meas tran vdout0_57ck1360 FIND v(dout0_57) AT=685.025n

.meas tran vdout0_58ck1360 FIND v(dout0_58) AT=685.025n

.meas tran vdout0_59ck1360 FIND v(dout0_59) AT=685.025n

.meas tran vdout0_60ck1360 FIND v(dout0_60) AT=685.025n

.meas tran vdout0_61ck1360 FIND v(dout0_61) AT=685.025n

.meas tran vdout0_62ck1360 FIND v(dout0_62) AT=685.025n

.meas tran vdout0_63ck1360 FIND v(dout0_63) AT=685.025n

.meas tran vdout1_0ck1360 FIND v(dout1_0) AT=685.025n

.meas tran vdout1_1ck1360 FIND v(dout1_1) AT=685.025n

.meas tran vdout1_2ck1360 FIND v(dout1_2) AT=685.025n

.meas tran vdout1_3ck1360 FIND v(dout1_3) AT=685.025n

.meas tran vdout1_4ck1360 FIND v(dout1_4) AT=685.025n

.meas tran vdout1_5ck1360 FIND v(dout1_5) AT=685.025n

.meas tran vdout1_6ck1360 FIND v(dout1_6) AT=685.025n

.meas tran vdout1_7ck1360 FIND v(dout1_7) AT=685.025n

.meas tran vdout1_8ck1360 FIND v(dout1_8) AT=685.025n

.meas tran vdout1_9ck1360 FIND v(dout1_9) AT=685.025n

.meas tran vdout1_10ck1360 FIND v(dout1_10) AT=685.025n

.meas tran vdout1_11ck1360 FIND v(dout1_11) AT=685.025n

.meas tran vdout1_12ck1360 FIND v(dout1_12) AT=685.025n

.meas tran vdout1_13ck1360 FIND v(dout1_13) AT=685.025n

.meas tran vdout1_14ck1360 FIND v(dout1_14) AT=685.025n

.meas tran vdout1_15ck1360 FIND v(dout1_15) AT=685.025n

.meas tran vdout1_16ck1360 FIND v(dout1_16) AT=685.025n

.meas tran vdout1_17ck1360 FIND v(dout1_17) AT=685.025n

.meas tran vdout1_18ck1360 FIND v(dout1_18) AT=685.025n

.meas tran vdout1_19ck1360 FIND v(dout1_19) AT=685.025n

.meas tran vdout1_20ck1360 FIND v(dout1_20) AT=685.025n

.meas tran vdout1_21ck1360 FIND v(dout1_21) AT=685.025n

.meas tran vdout1_22ck1360 FIND v(dout1_22) AT=685.025n

.meas tran vdout1_23ck1360 FIND v(dout1_23) AT=685.025n

.meas tran vdout1_24ck1360 FIND v(dout1_24) AT=685.025n

.meas tran vdout1_25ck1360 FIND v(dout1_25) AT=685.025n

.meas tran vdout1_26ck1360 FIND v(dout1_26) AT=685.025n

.meas tran vdout1_27ck1360 FIND v(dout1_27) AT=685.025n

.meas tran vdout1_28ck1360 FIND v(dout1_28) AT=685.025n

.meas tran vdout1_29ck1360 FIND v(dout1_29) AT=685.025n

.meas tran vdout1_30ck1360 FIND v(dout1_30) AT=685.025n

.meas tran vdout1_31ck1360 FIND v(dout1_31) AT=685.025n

.meas tran vdout1_32ck1360 FIND v(dout1_32) AT=685.025n

.meas tran vdout1_33ck1360 FIND v(dout1_33) AT=685.025n

.meas tran vdout1_34ck1360 FIND v(dout1_34) AT=685.025n

.meas tran vdout1_35ck1360 FIND v(dout1_35) AT=685.025n

.meas tran vdout1_36ck1360 FIND v(dout1_36) AT=685.025n

.meas tran vdout1_37ck1360 FIND v(dout1_37) AT=685.025n

.meas tran vdout1_38ck1360 FIND v(dout1_38) AT=685.025n

.meas tran vdout1_39ck1360 FIND v(dout1_39) AT=685.025n

.meas tran vdout1_40ck1360 FIND v(dout1_40) AT=685.025n

.meas tran vdout1_41ck1360 FIND v(dout1_41) AT=685.025n

.meas tran vdout1_42ck1360 FIND v(dout1_42) AT=685.025n

.meas tran vdout1_43ck1360 FIND v(dout1_43) AT=685.025n

.meas tran vdout1_44ck1360 FIND v(dout1_44) AT=685.025n

.meas tran vdout1_45ck1360 FIND v(dout1_45) AT=685.025n

.meas tran vdout1_46ck1360 FIND v(dout1_46) AT=685.025n

.meas tran vdout1_47ck1360 FIND v(dout1_47) AT=685.025n

.meas tran vdout1_48ck1360 FIND v(dout1_48) AT=685.025n

.meas tran vdout1_49ck1360 FIND v(dout1_49) AT=685.025n

.meas tran vdout1_50ck1360 FIND v(dout1_50) AT=685.025n

.meas tran vdout1_51ck1360 FIND v(dout1_51) AT=685.025n

.meas tran vdout1_52ck1360 FIND v(dout1_52) AT=685.025n

.meas tran vdout1_53ck1360 FIND v(dout1_53) AT=685.025n

.meas tran vdout1_54ck1360 FIND v(dout1_54) AT=685.025n

.meas tran vdout1_55ck1360 FIND v(dout1_55) AT=685.025n

.meas tran vdout1_56ck1360 FIND v(dout1_56) AT=685.025n

.meas tran vdout1_57ck1360 FIND v(dout1_57) AT=685.025n

.meas tran vdout1_58ck1360 FIND v(dout1_58) AT=685.025n

.meas tran vdout1_59ck1360 FIND v(dout1_59) AT=685.025n

.meas tran vdout1_60ck1360 FIND v(dout1_60) AT=685.025n

.meas tran vdout1_61ck1360 FIND v(dout1_61) AT=685.025n

.meas tran vdout1_62ck1360 FIND v(dout1_62) AT=685.025n

.meas tran vdout1_63ck1360 FIND v(dout1_63) AT=685.025n

.meas tran vdout0_0ck1370 FIND v(dout0_0) AT=690.025n

.meas tran vdout0_1ck1370 FIND v(dout0_1) AT=690.025n

.meas tran vdout0_2ck1370 FIND v(dout0_2) AT=690.025n

.meas tran vdout0_3ck1370 FIND v(dout0_3) AT=690.025n

.meas tran vdout0_4ck1370 FIND v(dout0_4) AT=690.025n

.meas tran vdout0_5ck1370 FIND v(dout0_5) AT=690.025n

.meas tran vdout0_6ck1370 FIND v(dout0_6) AT=690.025n

.meas tran vdout0_7ck1370 FIND v(dout0_7) AT=690.025n

.meas tran vdout0_8ck1370 FIND v(dout0_8) AT=690.025n

.meas tran vdout0_9ck1370 FIND v(dout0_9) AT=690.025n

.meas tran vdout0_10ck1370 FIND v(dout0_10) AT=690.025n

.meas tran vdout0_11ck1370 FIND v(dout0_11) AT=690.025n

.meas tran vdout0_12ck1370 FIND v(dout0_12) AT=690.025n

.meas tran vdout0_13ck1370 FIND v(dout0_13) AT=690.025n

.meas tran vdout0_14ck1370 FIND v(dout0_14) AT=690.025n

.meas tran vdout0_15ck1370 FIND v(dout0_15) AT=690.025n

.meas tran vdout0_16ck1370 FIND v(dout0_16) AT=690.025n

.meas tran vdout0_17ck1370 FIND v(dout0_17) AT=690.025n

.meas tran vdout0_18ck1370 FIND v(dout0_18) AT=690.025n

.meas tran vdout0_19ck1370 FIND v(dout0_19) AT=690.025n

.meas tran vdout0_20ck1370 FIND v(dout0_20) AT=690.025n

.meas tran vdout0_21ck1370 FIND v(dout0_21) AT=690.025n

.meas tran vdout0_22ck1370 FIND v(dout0_22) AT=690.025n

.meas tran vdout0_23ck1370 FIND v(dout0_23) AT=690.025n

.meas tran vdout0_24ck1370 FIND v(dout0_24) AT=690.025n

.meas tran vdout0_25ck1370 FIND v(dout0_25) AT=690.025n

.meas tran vdout0_26ck1370 FIND v(dout0_26) AT=690.025n

.meas tran vdout0_27ck1370 FIND v(dout0_27) AT=690.025n

.meas tran vdout0_28ck1370 FIND v(dout0_28) AT=690.025n

.meas tran vdout0_29ck1370 FIND v(dout0_29) AT=690.025n

.meas tran vdout0_30ck1370 FIND v(dout0_30) AT=690.025n

.meas tran vdout0_31ck1370 FIND v(dout0_31) AT=690.025n

.meas tran vdout0_32ck1370 FIND v(dout0_32) AT=690.025n

.meas tran vdout0_33ck1370 FIND v(dout0_33) AT=690.025n

.meas tran vdout0_34ck1370 FIND v(dout0_34) AT=690.025n

.meas tran vdout0_35ck1370 FIND v(dout0_35) AT=690.025n

.meas tran vdout0_36ck1370 FIND v(dout0_36) AT=690.025n

.meas tran vdout0_37ck1370 FIND v(dout0_37) AT=690.025n

.meas tran vdout0_38ck1370 FIND v(dout0_38) AT=690.025n

.meas tran vdout0_39ck1370 FIND v(dout0_39) AT=690.025n

.meas tran vdout0_40ck1370 FIND v(dout0_40) AT=690.025n

.meas tran vdout0_41ck1370 FIND v(dout0_41) AT=690.025n

.meas tran vdout0_42ck1370 FIND v(dout0_42) AT=690.025n

.meas tran vdout0_43ck1370 FIND v(dout0_43) AT=690.025n

.meas tran vdout0_44ck1370 FIND v(dout0_44) AT=690.025n

.meas tran vdout0_45ck1370 FIND v(dout0_45) AT=690.025n

.meas tran vdout0_46ck1370 FIND v(dout0_46) AT=690.025n

.meas tran vdout0_47ck1370 FIND v(dout0_47) AT=690.025n

.meas tran vdout0_48ck1370 FIND v(dout0_48) AT=690.025n

.meas tran vdout0_49ck1370 FIND v(dout0_49) AT=690.025n

.meas tran vdout0_50ck1370 FIND v(dout0_50) AT=690.025n

.meas tran vdout0_51ck1370 FIND v(dout0_51) AT=690.025n

.meas tran vdout0_52ck1370 FIND v(dout0_52) AT=690.025n

.meas tran vdout0_53ck1370 FIND v(dout0_53) AT=690.025n

.meas tran vdout0_54ck1370 FIND v(dout0_54) AT=690.025n

.meas tran vdout0_55ck1370 FIND v(dout0_55) AT=690.025n

.meas tran vdout0_56ck1370 FIND v(dout0_56) AT=690.025n

.meas tran vdout0_57ck1370 FIND v(dout0_57) AT=690.025n

.meas tran vdout0_58ck1370 FIND v(dout0_58) AT=690.025n

.meas tran vdout0_59ck1370 FIND v(dout0_59) AT=690.025n

.meas tran vdout0_60ck1370 FIND v(dout0_60) AT=690.025n

.meas tran vdout0_61ck1370 FIND v(dout0_61) AT=690.025n

.meas tran vdout0_62ck1370 FIND v(dout0_62) AT=690.025n

.meas tran vdout0_63ck1370 FIND v(dout0_63) AT=690.025n

.meas tran vdout1_0ck1370 FIND v(dout1_0) AT=690.025n

.meas tran vdout1_1ck1370 FIND v(dout1_1) AT=690.025n

.meas tran vdout1_2ck1370 FIND v(dout1_2) AT=690.025n

.meas tran vdout1_3ck1370 FIND v(dout1_3) AT=690.025n

.meas tran vdout1_4ck1370 FIND v(dout1_4) AT=690.025n

.meas tran vdout1_5ck1370 FIND v(dout1_5) AT=690.025n

.meas tran vdout1_6ck1370 FIND v(dout1_6) AT=690.025n

.meas tran vdout1_7ck1370 FIND v(dout1_7) AT=690.025n

.meas tran vdout1_8ck1370 FIND v(dout1_8) AT=690.025n

.meas tran vdout1_9ck1370 FIND v(dout1_9) AT=690.025n

.meas tran vdout1_10ck1370 FIND v(dout1_10) AT=690.025n

.meas tran vdout1_11ck1370 FIND v(dout1_11) AT=690.025n

.meas tran vdout1_12ck1370 FIND v(dout1_12) AT=690.025n

.meas tran vdout1_13ck1370 FIND v(dout1_13) AT=690.025n

.meas tran vdout1_14ck1370 FIND v(dout1_14) AT=690.025n

.meas tran vdout1_15ck1370 FIND v(dout1_15) AT=690.025n

.meas tran vdout1_16ck1370 FIND v(dout1_16) AT=690.025n

.meas tran vdout1_17ck1370 FIND v(dout1_17) AT=690.025n

.meas tran vdout1_18ck1370 FIND v(dout1_18) AT=690.025n

.meas tran vdout1_19ck1370 FIND v(dout1_19) AT=690.025n

.meas tran vdout1_20ck1370 FIND v(dout1_20) AT=690.025n

.meas tran vdout1_21ck1370 FIND v(dout1_21) AT=690.025n

.meas tran vdout1_22ck1370 FIND v(dout1_22) AT=690.025n

.meas tran vdout1_23ck1370 FIND v(dout1_23) AT=690.025n

.meas tran vdout1_24ck1370 FIND v(dout1_24) AT=690.025n

.meas tran vdout1_25ck1370 FIND v(dout1_25) AT=690.025n

.meas tran vdout1_26ck1370 FIND v(dout1_26) AT=690.025n

.meas tran vdout1_27ck1370 FIND v(dout1_27) AT=690.025n

.meas tran vdout1_28ck1370 FIND v(dout1_28) AT=690.025n

.meas tran vdout1_29ck1370 FIND v(dout1_29) AT=690.025n

.meas tran vdout1_30ck1370 FIND v(dout1_30) AT=690.025n

.meas tran vdout1_31ck1370 FIND v(dout1_31) AT=690.025n

.meas tran vdout1_32ck1370 FIND v(dout1_32) AT=690.025n

.meas tran vdout1_33ck1370 FIND v(dout1_33) AT=690.025n

.meas tran vdout1_34ck1370 FIND v(dout1_34) AT=690.025n

.meas tran vdout1_35ck1370 FIND v(dout1_35) AT=690.025n

.meas tran vdout1_36ck1370 FIND v(dout1_36) AT=690.025n

.meas tran vdout1_37ck1370 FIND v(dout1_37) AT=690.025n

.meas tran vdout1_38ck1370 FIND v(dout1_38) AT=690.025n

.meas tran vdout1_39ck1370 FIND v(dout1_39) AT=690.025n

.meas tran vdout1_40ck1370 FIND v(dout1_40) AT=690.025n

.meas tran vdout1_41ck1370 FIND v(dout1_41) AT=690.025n

.meas tran vdout1_42ck1370 FIND v(dout1_42) AT=690.025n

.meas tran vdout1_43ck1370 FIND v(dout1_43) AT=690.025n

.meas tran vdout1_44ck1370 FIND v(dout1_44) AT=690.025n

.meas tran vdout1_45ck1370 FIND v(dout1_45) AT=690.025n

.meas tran vdout1_46ck1370 FIND v(dout1_46) AT=690.025n

.meas tran vdout1_47ck1370 FIND v(dout1_47) AT=690.025n

.meas tran vdout1_48ck1370 FIND v(dout1_48) AT=690.025n

.meas tran vdout1_49ck1370 FIND v(dout1_49) AT=690.025n

.meas tran vdout1_50ck1370 FIND v(dout1_50) AT=690.025n

.meas tran vdout1_51ck1370 FIND v(dout1_51) AT=690.025n

.meas tran vdout1_52ck1370 FIND v(dout1_52) AT=690.025n

.meas tran vdout1_53ck1370 FIND v(dout1_53) AT=690.025n

.meas tran vdout1_54ck1370 FIND v(dout1_54) AT=690.025n

.meas tran vdout1_55ck1370 FIND v(dout1_55) AT=690.025n

.meas tran vdout1_56ck1370 FIND v(dout1_56) AT=690.025n

.meas tran vdout1_57ck1370 FIND v(dout1_57) AT=690.025n

.meas tran vdout1_58ck1370 FIND v(dout1_58) AT=690.025n

.meas tran vdout1_59ck1370 FIND v(dout1_59) AT=690.025n

.meas tran vdout1_60ck1370 FIND v(dout1_60) AT=690.025n

.meas tran vdout1_61ck1370 FIND v(dout1_61) AT=690.025n

.meas tran vdout1_62ck1370 FIND v(dout1_62) AT=690.025n

.meas tran vdout1_63ck1370 FIND v(dout1_63) AT=690.025n

.meas tran vdout0_0ck1380 FIND v(dout0_0) AT=695.025n

.meas tran vdout0_1ck1380 FIND v(dout0_1) AT=695.025n

.meas tran vdout0_2ck1380 FIND v(dout0_2) AT=695.025n

.meas tran vdout0_3ck1380 FIND v(dout0_3) AT=695.025n

.meas tran vdout0_4ck1380 FIND v(dout0_4) AT=695.025n

.meas tran vdout0_5ck1380 FIND v(dout0_5) AT=695.025n

.meas tran vdout0_6ck1380 FIND v(dout0_6) AT=695.025n

.meas tran vdout0_7ck1380 FIND v(dout0_7) AT=695.025n

.meas tran vdout0_8ck1380 FIND v(dout0_8) AT=695.025n

.meas tran vdout0_9ck1380 FIND v(dout0_9) AT=695.025n

.meas tran vdout0_10ck1380 FIND v(dout0_10) AT=695.025n

.meas tran vdout0_11ck1380 FIND v(dout0_11) AT=695.025n

.meas tran vdout0_12ck1380 FIND v(dout0_12) AT=695.025n

.meas tran vdout0_13ck1380 FIND v(dout0_13) AT=695.025n

.meas tran vdout0_14ck1380 FIND v(dout0_14) AT=695.025n

.meas tran vdout0_15ck1380 FIND v(dout0_15) AT=695.025n

.meas tran vdout0_16ck1380 FIND v(dout0_16) AT=695.025n

.meas tran vdout0_17ck1380 FIND v(dout0_17) AT=695.025n

.meas tran vdout0_18ck1380 FIND v(dout0_18) AT=695.025n

.meas tran vdout0_19ck1380 FIND v(dout0_19) AT=695.025n

.meas tran vdout0_20ck1380 FIND v(dout0_20) AT=695.025n

.meas tran vdout0_21ck1380 FIND v(dout0_21) AT=695.025n

.meas tran vdout0_22ck1380 FIND v(dout0_22) AT=695.025n

.meas tran vdout0_23ck1380 FIND v(dout0_23) AT=695.025n

.meas tran vdout0_24ck1380 FIND v(dout0_24) AT=695.025n

.meas tran vdout0_25ck1380 FIND v(dout0_25) AT=695.025n

.meas tran vdout0_26ck1380 FIND v(dout0_26) AT=695.025n

.meas tran vdout0_27ck1380 FIND v(dout0_27) AT=695.025n

.meas tran vdout0_28ck1380 FIND v(dout0_28) AT=695.025n

.meas tran vdout0_29ck1380 FIND v(dout0_29) AT=695.025n

.meas tran vdout0_30ck1380 FIND v(dout0_30) AT=695.025n

.meas tran vdout0_31ck1380 FIND v(dout0_31) AT=695.025n

.meas tran vdout0_32ck1380 FIND v(dout0_32) AT=695.025n

.meas tran vdout0_33ck1380 FIND v(dout0_33) AT=695.025n

.meas tran vdout0_34ck1380 FIND v(dout0_34) AT=695.025n

.meas tran vdout0_35ck1380 FIND v(dout0_35) AT=695.025n

.meas tran vdout0_36ck1380 FIND v(dout0_36) AT=695.025n

.meas tran vdout0_37ck1380 FIND v(dout0_37) AT=695.025n

.meas tran vdout0_38ck1380 FIND v(dout0_38) AT=695.025n

.meas tran vdout0_39ck1380 FIND v(dout0_39) AT=695.025n

.meas tran vdout0_40ck1380 FIND v(dout0_40) AT=695.025n

.meas tran vdout0_41ck1380 FIND v(dout0_41) AT=695.025n

.meas tran vdout0_42ck1380 FIND v(dout0_42) AT=695.025n

.meas tran vdout0_43ck1380 FIND v(dout0_43) AT=695.025n

.meas tran vdout0_44ck1380 FIND v(dout0_44) AT=695.025n

.meas tran vdout0_45ck1380 FIND v(dout0_45) AT=695.025n

.meas tran vdout0_46ck1380 FIND v(dout0_46) AT=695.025n

.meas tran vdout0_47ck1380 FIND v(dout0_47) AT=695.025n

.meas tran vdout0_48ck1380 FIND v(dout0_48) AT=695.025n

.meas tran vdout0_49ck1380 FIND v(dout0_49) AT=695.025n

.meas tran vdout0_50ck1380 FIND v(dout0_50) AT=695.025n

.meas tran vdout0_51ck1380 FIND v(dout0_51) AT=695.025n

.meas tran vdout0_52ck1380 FIND v(dout0_52) AT=695.025n

.meas tran vdout0_53ck1380 FIND v(dout0_53) AT=695.025n

.meas tran vdout0_54ck1380 FIND v(dout0_54) AT=695.025n

.meas tran vdout0_55ck1380 FIND v(dout0_55) AT=695.025n

.meas tran vdout0_56ck1380 FIND v(dout0_56) AT=695.025n

.meas tran vdout0_57ck1380 FIND v(dout0_57) AT=695.025n

.meas tran vdout0_58ck1380 FIND v(dout0_58) AT=695.025n

.meas tran vdout0_59ck1380 FIND v(dout0_59) AT=695.025n

.meas tran vdout0_60ck1380 FIND v(dout0_60) AT=695.025n

.meas tran vdout0_61ck1380 FIND v(dout0_61) AT=695.025n

.meas tran vdout0_62ck1380 FIND v(dout0_62) AT=695.025n

.meas tran vdout0_63ck1380 FIND v(dout0_63) AT=695.025n

.meas tran vdout0_0ck1390 FIND v(dout0_0) AT=700.025n

.meas tran vdout0_1ck1390 FIND v(dout0_1) AT=700.025n

.meas tran vdout0_2ck1390 FIND v(dout0_2) AT=700.025n

.meas tran vdout0_3ck1390 FIND v(dout0_3) AT=700.025n

.meas tran vdout0_4ck1390 FIND v(dout0_4) AT=700.025n

.meas tran vdout0_5ck1390 FIND v(dout0_5) AT=700.025n

.meas tran vdout0_6ck1390 FIND v(dout0_6) AT=700.025n

.meas tran vdout0_7ck1390 FIND v(dout0_7) AT=700.025n

.meas tran vdout0_8ck1390 FIND v(dout0_8) AT=700.025n

.meas tran vdout0_9ck1390 FIND v(dout0_9) AT=700.025n

.meas tran vdout0_10ck1390 FIND v(dout0_10) AT=700.025n

.meas tran vdout0_11ck1390 FIND v(dout0_11) AT=700.025n

.meas tran vdout0_12ck1390 FIND v(dout0_12) AT=700.025n

.meas tran vdout0_13ck1390 FIND v(dout0_13) AT=700.025n

.meas tran vdout0_14ck1390 FIND v(dout0_14) AT=700.025n

.meas tran vdout0_15ck1390 FIND v(dout0_15) AT=700.025n

.meas tran vdout0_16ck1390 FIND v(dout0_16) AT=700.025n

.meas tran vdout0_17ck1390 FIND v(dout0_17) AT=700.025n

.meas tran vdout0_18ck1390 FIND v(dout0_18) AT=700.025n

.meas tran vdout0_19ck1390 FIND v(dout0_19) AT=700.025n

.meas tran vdout0_20ck1390 FIND v(dout0_20) AT=700.025n

.meas tran vdout0_21ck1390 FIND v(dout0_21) AT=700.025n

.meas tran vdout0_22ck1390 FIND v(dout0_22) AT=700.025n

.meas tran vdout0_23ck1390 FIND v(dout0_23) AT=700.025n

.meas tran vdout0_24ck1390 FIND v(dout0_24) AT=700.025n

.meas tran vdout0_25ck1390 FIND v(dout0_25) AT=700.025n

.meas tran vdout0_26ck1390 FIND v(dout0_26) AT=700.025n

.meas tran vdout0_27ck1390 FIND v(dout0_27) AT=700.025n

.meas tran vdout0_28ck1390 FIND v(dout0_28) AT=700.025n

.meas tran vdout0_29ck1390 FIND v(dout0_29) AT=700.025n

.meas tran vdout0_30ck1390 FIND v(dout0_30) AT=700.025n

.meas tran vdout0_31ck1390 FIND v(dout0_31) AT=700.025n

.meas tran vdout0_32ck1390 FIND v(dout0_32) AT=700.025n

.meas tran vdout0_33ck1390 FIND v(dout0_33) AT=700.025n

.meas tran vdout0_34ck1390 FIND v(dout0_34) AT=700.025n

.meas tran vdout0_35ck1390 FIND v(dout0_35) AT=700.025n

.meas tran vdout0_36ck1390 FIND v(dout0_36) AT=700.025n

.meas tran vdout0_37ck1390 FIND v(dout0_37) AT=700.025n

.meas tran vdout0_38ck1390 FIND v(dout0_38) AT=700.025n

.meas tran vdout0_39ck1390 FIND v(dout0_39) AT=700.025n

.meas tran vdout0_40ck1390 FIND v(dout0_40) AT=700.025n

.meas tran vdout0_41ck1390 FIND v(dout0_41) AT=700.025n

.meas tran vdout0_42ck1390 FIND v(dout0_42) AT=700.025n

.meas tran vdout0_43ck1390 FIND v(dout0_43) AT=700.025n

.meas tran vdout0_44ck1390 FIND v(dout0_44) AT=700.025n

.meas tran vdout0_45ck1390 FIND v(dout0_45) AT=700.025n

.meas tran vdout0_46ck1390 FIND v(dout0_46) AT=700.025n

.meas tran vdout0_47ck1390 FIND v(dout0_47) AT=700.025n

.meas tran vdout0_48ck1390 FIND v(dout0_48) AT=700.025n

.meas tran vdout0_49ck1390 FIND v(dout0_49) AT=700.025n

.meas tran vdout0_50ck1390 FIND v(dout0_50) AT=700.025n

.meas tran vdout0_51ck1390 FIND v(dout0_51) AT=700.025n

.meas tran vdout0_52ck1390 FIND v(dout0_52) AT=700.025n

.meas tran vdout0_53ck1390 FIND v(dout0_53) AT=700.025n

.meas tran vdout0_54ck1390 FIND v(dout0_54) AT=700.025n

.meas tran vdout0_55ck1390 FIND v(dout0_55) AT=700.025n

.meas tran vdout0_56ck1390 FIND v(dout0_56) AT=700.025n

.meas tran vdout0_57ck1390 FIND v(dout0_57) AT=700.025n

.meas tran vdout0_58ck1390 FIND v(dout0_58) AT=700.025n

.meas tran vdout0_59ck1390 FIND v(dout0_59) AT=700.025n

.meas tran vdout0_60ck1390 FIND v(dout0_60) AT=700.025n

.meas tran vdout0_61ck1390 FIND v(dout0_61) AT=700.025n

.meas tran vdout0_62ck1390 FIND v(dout0_62) AT=700.025n

.meas tran vdout0_63ck1390 FIND v(dout0_63) AT=700.025n

.meas tran vdout1_0ck1390 FIND v(dout1_0) AT=700.025n

.meas tran vdout1_1ck1390 FIND v(dout1_1) AT=700.025n

.meas tran vdout1_2ck1390 FIND v(dout1_2) AT=700.025n

.meas tran vdout1_3ck1390 FIND v(dout1_3) AT=700.025n

.meas tran vdout1_4ck1390 FIND v(dout1_4) AT=700.025n

.meas tran vdout1_5ck1390 FIND v(dout1_5) AT=700.025n

.meas tran vdout1_6ck1390 FIND v(dout1_6) AT=700.025n

.meas tran vdout1_7ck1390 FIND v(dout1_7) AT=700.025n

.meas tran vdout1_8ck1390 FIND v(dout1_8) AT=700.025n

.meas tran vdout1_9ck1390 FIND v(dout1_9) AT=700.025n

.meas tran vdout1_10ck1390 FIND v(dout1_10) AT=700.025n

.meas tran vdout1_11ck1390 FIND v(dout1_11) AT=700.025n

.meas tran vdout1_12ck1390 FIND v(dout1_12) AT=700.025n

.meas tran vdout1_13ck1390 FIND v(dout1_13) AT=700.025n

.meas tran vdout1_14ck1390 FIND v(dout1_14) AT=700.025n

.meas tran vdout1_15ck1390 FIND v(dout1_15) AT=700.025n

.meas tran vdout1_16ck1390 FIND v(dout1_16) AT=700.025n

.meas tran vdout1_17ck1390 FIND v(dout1_17) AT=700.025n

.meas tran vdout1_18ck1390 FIND v(dout1_18) AT=700.025n

.meas tran vdout1_19ck1390 FIND v(dout1_19) AT=700.025n

.meas tran vdout1_20ck1390 FIND v(dout1_20) AT=700.025n

.meas tran vdout1_21ck1390 FIND v(dout1_21) AT=700.025n

.meas tran vdout1_22ck1390 FIND v(dout1_22) AT=700.025n

.meas tran vdout1_23ck1390 FIND v(dout1_23) AT=700.025n

.meas tran vdout1_24ck1390 FIND v(dout1_24) AT=700.025n

.meas tran vdout1_25ck1390 FIND v(dout1_25) AT=700.025n

.meas tran vdout1_26ck1390 FIND v(dout1_26) AT=700.025n

.meas tran vdout1_27ck1390 FIND v(dout1_27) AT=700.025n

.meas tran vdout1_28ck1390 FIND v(dout1_28) AT=700.025n

.meas tran vdout1_29ck1390 FIND v(dout1_29) AT=700.025n

.meas tran vdout1_30ck1390 FIND v(dout1_30) AT=700.025n

.meas tran vdout1_31ck1390 FIND v(dout1_31) AT=700.025n

.meas tran vdout1_32ck1390 FIND v(dout1_32) AT=700.025n

.meas tran vdout1_33ck1390 FIND v(dout1_33) AT=700.025n

.meas tran vdout1_34ck1390 FIND v(dout1_34) AT=700.025n

.meas tran vdout1_35ck1390 FIND v(dout1_35) AT=700.025n

.meas tran vdout1_36ck1390 FIND v(dout1_36) AT=700.025n

.meas tran vdout1_37ck1390 FIND v(dout1_37) AT=700.025n

.meas tran vdout1_38ck1390 FIND v(dout1_38) AT=700.025n

.meas tran vdout1_39ck1390 FIND v(dout1_39) AT=700.025n

.meas tran vdout1_40ck1390 FIND v(dout1_40) AT=700.025n

.meas tran vdout1_41ck1390 FIND v(dout1_41) AT=700.025n

.meas tran vdout1_42ck1390 FIND v(dout1_42) AT=700.025n

.meas tran vdout1_43ck1390 FIND v(dout1_43) AT=700.025n

.meas tran vdout1_44ck1390 FIND v(dout1_44) AT=700.025n

.meas tran vdout1_45ck1390 FIND v(dout1_45) AT=700.025n

.meas tran vdout1_46ck1390 FIND v(dout1_46) AT=700.025n

.meas tran vdout1_47ck1390 FIND v(dout1_47) AT=700.025n

.meas tran vdout1_48ck1390 FIND v(dout1_48) AT=700.025n

.meas tran vdout1_49ck1390 FIND v(dout1_49) AT=700.025n

.meas tran vdout1_50ck1390 FIND v(dout1_50) AT=700.025n

.meas tran vdout1_51ck1390 FIND v(dout1_51) AT=700.025n

.meas tran vdout1_52ck1390 FIND v(dout1_52) AT=700.025n

.meas tran vdout1_53ck1390 FIND v(dout1_53) AT=700.025n

.meas tran vdout1_54ck1390 FIND v(dout1_54) AT=700.025n

.meas tran vdout1_55ck1390 FIND v(dout1_55) AT=700.025n

.meas tran vdout1_56ck1390 FIND v(dout1_56) AT=700.025n

.meas tran vdout1_57ck1390 FIND v(dout1_57) AT=700.025n

.meas tran vdout1_58ck1390 FIND v(dout1_58) AT=700.025n

.meas tran vdout1_59ck1390 FIND v(dout1_59) AT=700.025n

.meas tran vdout1_60ck1390 FIND v(dout1_60) AT=700.025n

.meas tran vdout1_61ck1390 FIND v(dout1_61) AT=700.025n

.meas tran vdout1_62ck1390 FIND v(dout1_62) AT=700.025n

.meas tran vdout1_63ck1390 FIND v(dout1_63) AT=700.025n

.meas tran vdout0_0ck1400 FIND v(dout0_0) AT=705.025n

.meas tran vdout0_1ck1400 FIND v(dout0_1) AT=705.025n

.meas tran vdout0_2ck1400 FIND v(dout0_2) AT=705.025n

.meas tran vdout0_3ck1400 FIND v(dout0_3) AT=705.025n

.meas tran vdout0_4ck1400 FIND v(dout0_4) AT=705.025n

.meas tran vdout0_5ck1400 FIND v(dout0_5) AT=705.025n

.meas tran vdout0_6ck1400 FIND v(dout0_6) AT=705.025n

.meas tran vdout0_7ck1400 FIND v(dout0_7) AT=705.025n

.meas tran vdout0_8ck1400 FIND v(dout0_8) AT=705.025n

.meas tran vdout0_9ck1400 FIND v(dout0_9) AT=705.025n

.meas tran vdout0_10ck1400 FIND v(dout0_10) AT=705.025n

.meas tran vdout0_11ck1400 FIND v(dout0_11) AT=705.025n

.meas tran vdout0_12ck1400 FIND v(dout0_12) AT=705.025n

.meas tran vdout0_13ck1400 FIND v(dout0_13) AT=705.025n

.meas tran vdout0_14ck1400 FIND v(dout0_14) AT=705.025n

.meas tran vdout0_15ck1400 FIND v(dout0_15) AT=705.025n

.meas tran vdout0_16ck1400 FIND v(dout0_16) AT=705.025n

.meas tran vdout0_17ck1400 FIND v(dout0_17) AT=705.025n

.meas tran vdout0_18ck1400 FIND v(dout0_18) AT=705.025n

.meas tran vdout0_19ck1400 FIND v(dout0_19) AT=705.025n

.meas tran vdout0_20ck1400 FIND v(dout0_20) AT=705.025n

.meas tran vdout0_21ck1400 FIND v(dout0_21) AT=705.025n

.meas tran vdout0_22ck1400 FIND v(dout0_22) AT=705.025n

.meas tran vdout0_23ck1400 FIND v(dout0_23) AT=705.025n

.meas tran vdout0_24ck1400 FIND v(dout0_24) AT=705.025n

.meas tran vdout0_25ck1400 FIND v(dout0_25) AT=705.025n

.meas tran vdout0_26ck1400 FIND v(dout0_26) AT=705.025n

.meas tran vdout0_27ck1400 FIND v(dout0_27) AT=705.025n

.meas tran vdout0_28ck1400 FIND v(dout0_28) AT=705.025n

.meas tran vdout0_29ck1400 FIND v(dout0_29) AT=705.025n

.meas tran vdout0_30ck1400 FIND v(dout0_30) AT=705.025n

.meas tran vdout0_31ck1400 FIND v(dout0_31) AT=705.025n

.meas tran vdout0_32ck1400 FIND v(dout0_32) AT=705.025n

.meas tran vdout0_33ck1400 FIND v(dout0_33) AT=705.025n

.meas tran vdout0_34ck1400 FIND v(dout0_34) AT=705.025n

.meas tran vdout0_35ck1400 FIND v(dout0_35) AT=705.025n

.meas tran vdout0_36ck1400 FIND v(dout0_36) AT=705.025n

.meas tran vdout0_37ck1400 FIND v(dout0_37) AT=705.025n

.meas tran vdout0_38ck1400 FIND v(dout0_38) AT=705.025n

.meas tran vdout0_39ck1400 FIND v(dout0_39) AT=705.025n

.meas tran vdout0_40ck1400 FIND v(dout0_40) AT=705.025n

.meas tran vdout0_41ck1400 FIND v(dout0_41) AT=705.025n

.meas tran vdout0_42ck1400 FIND v(dout0_42) AT=705.025n

.meas tran vdout0_43ck1400 FIND v(dout0_43) AT=705.025n

.meas tran vdout0_44ck1400 FIND v(dout0_44) AT=705.025n

.meas tran vdout0_45ck1400 FIND v(dout0_45) AT=705.025n

.meas tran vdout0_46ck1400 FIND v(dout0_46) AT=705.025n

.meas tran vdout0_47ck1400 FIND v(dout0_47) AT=705.025n

.meas tran vdout0_48ck1400 FIND v(dout0_48) AT=705.025n

.meas tran vdout0_49ck1400 FIND v(dout0_49) AT=705.025n

.meas tran vdout0_50ck1400 FIND v(dout0_50) AT=705.025n

.meas tran vdout0_51ck1400 FIND v(dout0_51) AT=705.025n

.meas tran vdout0_52ck1400 FIND v(dout0_52) AT=705.025n

.meas tran vdout0_53ck1400 FIND v(dout0_53) AT=705.025n

.meas tran vdout0_54ck1400 FIND v(dout0_54) AT=705.025n

.meas tran vdout0_55ck1400 FIND v(dout0_55) AT=705.025n

.meas tran vdout0_56ck1400 FIND v(dout0_56) AT=705.025n

.meas tran vdout0_57ck1400 FIND v(dout0_57) AT=705.025n

.meas tran vdout0_58ck1400 FIND v(dout0_58) AT=705.025n

.meas tran vdout0_59ck1400 FIND v(dout0_59) AT=705.025n

.meas tran vdout0_60ck1400 FIND v(dout0_60) AT=705.025n

.meas tran vdout0_61ck1400 FIND v(dout0_61) AT=705.025n

.meas tran vdout0_62ck1400 FIND v(dout0_62) AT=705.025n

.meas tran vdout0_63ck1400 FIND v(dout0_63) AT=705.025n

.meas tran vdout1_0ck1400 FIND v(dout1_0) AT=705.025n

.meas tran vdout1_1ck1400 FIND v(dout1_1) AT=705.025n

.meas tran vdout1_2ck1400 FIND v(dout1_2) AT=705.025n

.meas tran vdout1_3ck1400 FIND v(dout1_3) AT=705.025n

.meas tran vdout1_4ck1400 FIND v(dout1_4) AT=705.025n

.meas tran vdout1_5ck1400 FIND v(dout1_5) AT=705.025n

.meas tran vdout1_6ck1400 FIND v(dout1_6) AT=705.025n

.meas tran vdout1_7ck1400 FIND v(dout1_7) AT=705.025n

.meas tran vdout1_8ck1400 FIND v(dout1_8) AT=705.025n

.meas tran vdout1_9ck1400 FIND v(dout1_9) AT=705.025n

.meas tran vdout1_10ck1400 FIND v(dout1_10) AT=705.025n

.meas tran vdout1_11ck1400 FIND v(dout1_11) AT=705.025n

.meas tran vdout1_12ck1400 FIND v(dout1_12) AT=705.025n

.meas tran vdout1_13ck1400 FIND v(dout1_13) AT=705.025n

.meas tran vdout1_14ck1400 FIND v(dout1_14) AT=705.025n

.meas tran vdout1_15ck1400 FIND v(dout1_15) AT=705.025n

.meas tran vdout1_16ck1400 FIND v(dout1_16) AT=705.025n

.meas tran vdout1_17ck1400 FIND v(dout1_17) AT=705.025n

.meas tran vdout1_18ck1400 FIND v(dout1_18) AT=705.025n

.meas tran vdout1_19ck1400 FIND v(dout1_19) AT=705.025n

.meas tran vdout1_20ck1400 FIND v(dout1_20) AT=705.025n

.meas tran vdout1_21ck1400 FIND v(dout1_21) AT=705.025n

.meas tran vdout1_22ck1400 FIND v(dout1_22) AT=705.025n

.meas tran vdout1_23ck1400 FIND v(dout1_23) AT=705.025n

.meas tran vdout1_24ck1400 FIND v(dout1_24) AT=705.025n

.meas tran vdout1_25ck1400 FIND v(dout1_25) AT=705.025n

.meas tran vdout1_26ck1400 FIND v(dout1_26) AT=705.025n

.meas tran vdout1_27ck1400 FIND v(dout1_27) AT=705.025n

.meas tran vdout1_28ck1400 FIND v(dout1_28) AT=705.025n

.meas tran vdout1_29ck1400 FIND v(dout1_29) AT=705.025n

.meas tran vdout1_30ck1400 FIND v(dout1_30) AT=705.025n

.meas tran vdout1_31ck1400 FIND v(dout1_31) AT=705.025n

.meas tran vdout1_32ck1400 FIND v(dout1_32) AT=705.025n

.meas tran vdout1_33ck1400 FIND v(dout1_33) AT=705.025n

.meas tran vdout1_34ck1400 FIND v(dout1_34) AT=705.025n

.meas tran vdout1_35ck1400 FIND v(dout1_35) AT=705.025n

.meas tran vdout1_36ck1400 FIND v(dout1_36) AT=705.025n

.meas tran vdout1_37ck1400 FIND v(dout1_37) AT=705.025n

.meas tran vdout1_38ck1400 FIND v(dout1_38) AT=705.025n

.meas tran vdout1_39ck1400 FIND v(dout1_39) AT=705.025n

.meas tran vdout1_40ck1400 FIND v(dout1_40) AT=705.025n

.meas tran vdout1_41ck1400 FIND v(dout1_41) AT=705.025n

.meas tran vdout1_42ck1400 FIND v(dout1_42) AT=705.025n

.meas tran vdout1_43ck1400 FIND v(dout1_43) AT=705.025n

.meas tran vdout1_44ck1400 FIND v(dout1_44) AT=705.025n

.meas tran vdout1_45ck1400 FIND v(dout1_45) AT=705.025n

.meas tran vdout1_46ck1400 FIND v(dout1_46) AT=705.025n

.meas tran vdout1_47ck1400 FIND v(dout1_47) AT=705.025n

.meas tran vdout1_48ck1400 FIND v(dout1_48) AT=705.025n

.meas tran vdout1_49ck1400 FIND v(dout1_49) AT=705.025n

.meas tran vdout1_50ck1400 FIND v(dout1_50) AT=705.025n

.meas tran vdout1_51ck1400 FIND v(dout1_51) AT=705.025n

.meas tran vdout1_52ck1400 FIND v(dout1_52) AT=705.025n

.meas tran vdout1_53ck1400 FIND v(dout1_53) AT=705.025n

.meas tran vdout1_54ck1400 FIND v(dout1_54) AT=705.025n

.meas tran vdout1_55ck1400 FIND v(dout1_55) AT=705.025n

.meas tran vdout1_56ck1400 FIND v(dout1_56) AT=705.025n

.meas tran vdout1_57ck1400 FIND v(dout1_57) AT=705.025n

.meas tran vdout1_58ck1400 FIND v(dout1_58) AT=705.025n

.meas tran vdout1_59ck1400 FIND v(dout1_59) AT=705.025n

.meas tran vdout1_60ck1400 FIND v(dout1_60) AT=705.025n

.meas tran vdout1_61ck1400 FIND v(dout1_61) AT=705.025n

.meas tran vdout1_62ck1400 FIND v(dout1_62) AT=705.025n

.meas tran vdout1_63ck1400 FIND v(dout1_63) AT=705.025n

.meas tran vdout0_0ck1410 FIND v(dout0_0) AT=710.025n

.meas tran vdout0_1ck1410 FIND v(dout0_1) AT=710.025n

.meas tran vdout0_2ck1410 FIND v(dout0_2) AT=710.025n

.meas tran vdout0_3ck1410 FIND v(dout0_3) AT=710.025n

.meas tran vdout0_4ck1410 FIND v(dout0_4) AT=710.025n

.meas tran vdout0_5ck1410 FIND v(dout0_5) AT=710.025n

.meas tran vdout0_6ck1410 FIND v(dout0_6) AT=710.025n

.meas tran vdout0_7ck1410 FIND v(dout0_7) AT=710.025n

.meas tran vdout0_8ck1410 FIND v(dout0_8) AT=710.025n

.meas tran vdout0_9ck1410 FIND v(dout0_9) AT=710.025n

.meas tran vdout0_10ck1410 FIND v(dout0_10) AT=710.025n

.meas tran vdout0_11ck1410 FIND v(dout0_11) AT=710.025n

.meas tran vdout0_12ck1410 FIND v(dout0_12) AT=710.025n

.meas tran vdout0_13ck1410 FIND v(dout0_13) AT=710.025n

.meas tran vdout0_14ck1410 FIND v(dout0_14) AT=710.025n

.meas tran vdout0_15ck1410 FIND v(dout0_15) AT=710.025n

.meas tran vdout0_16ck1410 FIND v(dout0_16) AT=710.025n

.meas tran vdout0_17ck1410 FIND v(dout0_17) AT=710.025n

.meas tran vdout0_18ck1410 FIND v(dout0_18) AT=710.025n

.meas tran vdout0_19ck1410 FIND v(dout0_19) AT=710.025n

.meas tran vdout0_20ck1410 FIND v(dout0_20) AT=710.025n

.meas tran vdout0_21ck1410 FIND v(dout0_21) AT=710.025n

.meas tran vdout0_22ck1410 FIND v(dout0_22) AT=710.025n

.meas tran vdout0_23ck1410 FIND v(dout0_23) AT=710.025n

.meas tran vdout0_24ck1410 FIND v(dout0_24) AT=710.025n

.meas tran vdout0_25ck1410 FIND v(dout0_25) AT=710.025n

.meas tran vdout0_26ck1410 FIND v(dout0_26) AT=710.025n

.meas tran vdout0_27ck1410 FIND v(dout0_27) AT=710.025n

.meas tran vdout0_28ck1410 FIND v(dout0_28) AT=710.025n

.meas tran vdout0_29ck1410 FIND v(dout0_29) AT=710.025n

.meas tran vdout0_30ck1410 FIND v(dout0_30) AT=710.025n

.meas tran vdout0_31ck1410 FIND v(dout0_31) AT=710.025n

.meas tran vdout0_32ck1410 FIND v(dout0_32) AT=710.025n

.meas tran vdout0_33ck1410 FIND v(dout0_33) AT=710.025n

.meas tran vdout0_34ck1410 FIND v(dout0_34) AT=710.025n

.meas tran vdout0_35ck1410 FIND v(dout0_35) AT=710.025n

.meas tran vdout0_36ck1410 FIND v(dout0_36) AT=710.025n

.meas tran vdout0_37ck1410 FIND v(dout0_37) AT=710.025n

.meas tran vdout0_38ck1410 FIND v(dout0_38) AT=710.025n

.meas tran vdout0_39ck1410 FIND v(dout0_39) AT=710.025n

.meas tran vdout0_40ck1410 FIND v(dout0_40) AT=710.025n

.meas tran vdout0_41ck1410 FIND v(dout0_41) AT=710.025n

.meas tran vdout0_42ck1410 FIND v(dout0_42) AT=710.025n

.meas tran vdout0_43ck1410 FIND v(dout0_43) AT=710.025n

.meas tran vdout0_44ck1410 FIND v(dout0_44) AT=710.025n

.meas tran vdout0_45ck1410 FIND v(dout0_45) AT=710.025n

.meas tran vdout0_46ck1410 FIND v(dout0_46) AT=710.025n

.meas tran vdout0_47ck1410 FIND v(dout0_47) AT=710.025n

.meas tran vdout0_48ck1410 FIND v(dout0_48) AT=710.025n

.meas tran vdout0_49ck1410 FIND v(dout0_49) AT=710.025n

.meas tran vdout0_50ck1410 FIND v(dout0_50) AT=710.025n

.meas tran vdout0_51ck1410 FIND v(dout0_51) AT=710.025n

.meas tran vdout0_52ck1410 FIND v(dout0_52) AT=710.025n

.meas tran vdout0_53ck1410 FIND v(dout0_53) AT=710.025n

.meas tran vdout0_54ck1410 FIND v(dout0_54) AT=710.025n

.meas tran vdout0_55ck1410 FIND v(dout0_55) AT=710.025n

.meas tran vdout0_56ck1410 FIND v(dout0_56) AT=710.025n

.meas tran vdout0_57ck1410 FIND v(dout0_57) AT=710.025n

.meas tran vdout0_58ck1410 FIND v(dout0_58) AT=710.025n

.meas tran vdout0_59ck1410 FIND v(dout0_59) AT=710.025n

.meas tran vdout0_60ck1410 FIND v(dout0_60) AT=710.025n

.meas tran vdout0_61ck1410 FIND v(dout0_61) AT=710.025n

.meas tran vdout0_62ck1410 FIND v(dout0_62) AT=710.025n

.meas tran vdout0_63ck1410 FIND v(dout0_63) AT=710.025n

.meas tran vdout1_0ck1410 FIND v(dout1_0) AT=710.025n

.meas tran vdout1_1ck1410 FIND v(dout1_1) AT=710.025n

.meas tran vdout1_2ck1410 FIND v(dout1_2) AT=710.025n

.meas tran vdout1_3ck1410 FIND v(dout1_3) AT=710.025n

.meas tran vdout1_4ck1410 FIND v(dout1_4) AT=710.025n

.meas tran vdout1_5ck1410 FIND v(dout1_5) AT=710.025n

.meas tran vdout1_6ck1410 FIND v(dout1_6) AT=710.025n

.meas tran vdout1_7ck1410 FIND v(dout1_7) AT=710.025n

.meas tran vdout1_8ck1410 FIND v(dout1_8) AT=710.025n

.meas tran vdout1_9ck1410 FIND v(dout1_9) AT=710.025n

.meas tran vdout1_10ck1410 FIND v(dout1_10) AT=710.025n

.meas tran vdout1_11ck1410 FIND v(dout1_11) AT=710.025n

.meas tran vdout1_12ck1410 FIND v(dout1_12) AT=710.025n

.meas tran vdout1_13ck1410 FIND v(dout1_13) AT=710.025n

.meas tran vdout1_14ck1410 FIND v(dout1_14) AT=710.025n

.meas tran vdout1_15ck1410 FIND v(dout1_15) AT=710.025n

.meas tran vdout1_16ck1410 FIND v(dout1_16) AT=710.025n

.meas tran vdout1_17ck1410 FIND v(dout1_17) AT=710.025n

.meas tran vdout1_18ck1410 FIND v(dout1_18) AT=710.025n

.meas tran vdout1_19ck1410 FIND v(dout1_19) AT=710.025n

.meas tran vdout1_20ck1410 FIND v(dout1_20) AT=710.025n

.meas tran vdout1_21ck1410 FIND v(dout1_21) AT=710.025n

.meas tran vdout1_22ck1410 FIND v(dout1_22) AT=710.025n

.meas tran vdout1_23ck1410 FIND v(dout1_23) AT=710.025n

.meas tran vdout1_24ck1410 FIND v(dout1_24) AT=710.025n

.meas tran vdout1_25ck1410 FIND v(dout1_25) AT=710.025n

.meas tran vdout1_26ck1410 FIND v(dout1_26) AT=710.025n

.meas tran vdout1_27ck1410 FIND v(dout1_27) AT=710.025n

.meas tran vdout1_28ck1410 FIND v(dout1_28) AT=710.025n

.meas tran vdout1_29ck1410 FIND v(dout1_29) AT=710.025n

.meas tran vdout1_30ck1410 FIND v(dout1_30) AT=710.025n

.meas tran vdout1_31ck1410 FIND v(dout1_31) AT=710.025n

.meas tran vdout1_32ck1410 FIND v(dout1_32) AT=710.025n

.meas tran vdout1_33ck1410 FIND v(dout1_33) AT=710.025n

.meas tran vdout1_34ck1410 FIND v(dout1_34) AT=710.025n

.meas tran vdout1_35ck1410 FIND v(dout1_35) AT=710.025n

.meas tran vdout1_36ck1410 FIND v(dout1_36) AT=710.025n

.meas tran vdout1_37ck1410 FIND v(dout1_37) AT=710.025n

.meas tran vdout1_38ck1410 FIND v(dout1_38) AT=710.025n

.meas tran vdout1_39ck1410 FIND v(dout1_39) AT=710.025n

.meas tran vdout1_40ck1410 FIND v(dout1_40) AT=710.025n

.meas tran vdout1_41ck1410 FIND v(dout1_41) AT=710.025n

.meas tran vdout1_42ck1410 FIND v(dout1_42) AT=710.025n

.meas tran vdout1_43ck1410 FIND v(dout1_43) AT=710.025n

.meas tran vdout1_44ck1410 FIND v(dout1_44) AT=710.025n

.meas tran vdout1_45ck1410 FIND v(dout1_45) AT=710.025n

.meas tran vdout1_46ck1410 FIND v(dout1_46) AT=710.025n

.meas tran vdout1_47ck1410 FIND v(dout1_47) AT=710.025n

.meas tran vdout1_48ck1410 FIND v(dout1_48) AT=710.025n

.meas tran vdout1_49ck1410 FIND v(dout1_49) AT=710.025n

.meas tran vdout1_50ck1410 FIND v(dout1_50) AT=710.025n

.meas tran vdout1_51ck1410 FIND v(dout1_51) AT=710.025n

.meas tran vdout1_52ck1410 FIND v(dout1_52) AT=710.025n

.meas tran vdout1_53ck1410 FIND v(dout1_53) AT=710.025n

.meas tran vdout1_54ck1410 FIND v(dout1_54) AT=710.025n

.meas tran vdout1_55ck1410 FIND v(dout1_55) AT=710.025n

.meas tran vdout1_56ck1410 FIND v(dout1_56) AT=710.025n

.meas tran vdout1_57ck1410 FIND v(dout1_57) AT=710.025n

.meas tran vdout1_58ck1410 FIND v(dout1_58) AT=710.025n

.meas tran vdout1_59ck1410 FIND v(dout1_59) AT=710.025n

.meas tran vdout1_60ck1410 FIND v(dout1_60) AT=710.025n

.meas tran vdout1_61ck1410 FIND v(dout1_61) AT=710.025n

.meas tran vdout1_62ck1410 FIND v(dout1_62) AT=710.025n

.meas tran vdout1_63ck1410 FIND v(dout1_63) AT=710.025n

.meas tran vdout0_0ck1420 FIND v(dout0_0) AT=715.025n

.meas tran vdout0_1ck1420 FIND v(dout0_1) AT=715.025n

.meas tran vdout0_2ck1420 FIND v(dout0_2) AT=715.025n

.meas tran vdout0_3ck1420 FIND v(dout0_3) AT=715.025n

.meas tran vdout0_4ck1420 FIND v(dout0_4) AT=715.025n

.meas tran vdout0_5ck1420 FIND v(dout0_5) AT=715.025n

.meas tran vdout0_6ck1420 FIND v(dout0_6) AT=715.025n

.meas tran vdout0_7ck1420 FIND v(dout0_7) AT=715.025n

.meas tran vdout0_8ck1420 FIND v(dout0_8) AT=715.025n

.meas tran vdout0_9ck1420 FIND v(dout0_9) AT=715.025n

.meas tran vdout0_10ck1420 FIND v(dout0_10) AT=715.025n

.meas tran vdout0_11ck1420 FIND v(dout0_11) AT=715.025n

.meas tran vdout0_12ck1420 FIND v(dout0_12) AT=715.025n

.meas tran vdout0_13ck1420 FIND v(dout0_13) AT=715.025n

.meas tran vdout0_14ck1420 FIND v(dout0_14) AT=715.025n

.meas tran vdout0_15ck1420 FIND v(dout0_15) AT=715.025n

.meas tran vdout0_16ck1420 FIND v(dout0_16) AT=715.025n

.meas tran vdout0_17ck1420 FIND v(dout0_17) AT=715.025n

.meas tran vdout0_18ck1420 FIND v(dout0_18) AT=715.025n

.meas tran vdout0_19ck1420 FIND v(dout0_19) AT=715.025n

.meas tran vdout0_20ck1420 FIND v(dout0_20) AT=715.025n

.meas tran vdout0_21ck1420 FIND v(dout0_21) AT=715.025n

.meas tran vdout0_22ck1420 FIND v(dout0_22) AT=715.025n

.meas tran vdout0_23ck1420 FIND v(dout0_23) AT=715.025n

.meas tran vdout0_24ck1420 FIND v(dout0_24) AT=715.025n

.meas tran vdout0_25ck1420 FIND v(dout0_25) AT=715.025n

.meas tran vdout0_26ck1420 FIND v(dout0_26) AT=715.025n

.meas tran vdout0_27ck1420 FIND v(dout0_27) AT=715.025n

.meas tran vdout0_28ck1420 FIND v(dout0_28) AT=715.025n

.meas tran vdout0_29ck1420 FIND v(dout0_29) AT=715.025n

.meas tran vdout0_30ck1420 FIND v(dout0_30) AT=715.025n

.meas tran vdout0_31ck1420 FIND v(dout0_31) AT=715.025n

.meas tran vdout0_32ck1420 FIND v(dout0_32) AT=715.025n

.meas tran vdout0_33ck1420 FIND v(dout0_33) AT=715.025n

.meas tran vdout0_34ck1420 FIND v(dout0_34) AT=715.025n

.meas tran vdout0_35ck1420 FIND v(dout0_35) AT=715.025n

.meas tran vdout0_36ck1420 FIND v(dout0_36) AT=715.025n

.meas tran vdout0_37ck1420 FIND v(dout0_37) AT=715.025n

.meas tran vdout0_38ck1420 FIND v(dout0_38) AT=715.025n

.meas tran vdout0_39ck1420 FIND v(dout0_39) AT=715.025n

.meas tran vdout0_40ck1420 FIND v(dout0_40) AT=715.025n

.meas tran vdout0_41ck1420 FIND v(dout0_41) AT=715.025n

.meas tran vdout0_42ck1420 FIND v(dout0_42) AT=715.025n

.meas tran vdout0_43ck1420 FIND v(dout0_43) AT=715.025n

.meas tran vdout0_44ck1420 FIND v(dout0_44) AT=715.025n

.meas tran vdout0_45ck1420 FIND v(dout0_45) AT=715.025n

.meas tran vdout0_46ck1420 FIND v(dout0_46) AT=715.025n

.meas tran vdout0_47ck1420 FIND v(dout0_47) AT=715.025n

.meas tran vdout0_48ck1420 FIND v(dout0_48) AT=715.025n

.meas tran vdout0_49ck1420 FIND v(dout0_49) AT=715.025n

.meas tran vdout0_50ck1420 FIND v(dout0_50) AT=715.025n

.meas tran vdout0_51ck1420 FIND v(dout0_51) AT=715.025n

.meas tran vdout0_52ck1420 FIND v(dout0_52) AT=715.025n

.meas tran vdout0_53ck1420 FIND v(dout0_53) AT=715.025n

.meas tran vdout0_54ck1420 FIND v(dout0_54) AT=715.025n

.meas tran vdout0_55ck1420 FIND v(dout0_55) AT=715.025n

.meas tran vdout0_56ck1420 FIND v(dout0_56) AT=715.025n

.meas tran vdout0_57ck1420 FIND v(dout0_57) AT=715.025n

.meas tran vdout0_58ck1420 FIND v(dout0_58) AT=715.025n

.meas tran vdout0_59ck1420 FIND v(dout0_59) AT=715.025n

.meas tran vdout0_60ck1420 FIND v(dout0_60) AT=715.025n

.meas tran vdout0_61ck1420 FIND v(dout0_61) AT=715.025n

.meas tran vdout0_62ck1420 FIND v(dout0_62) AT=715.025n

.meas tran vdout0_63ck1420 FIND v(dout0_63) AT=715.025n

.meas tran vdout0_0ck1430 FIND v(dout0_0) AT=720.025n

.meas tran vdout0_1ck1430 FIND v(dout0_1) AT=720.025n

.meas tran vdout0_2ck1430 FIND v(dout0_2) AT=720.025n

.meas tran vdout0_3ck1430 FIND v(dout0_3) AT=720.025n

.meas tran vdout0_4ck1430 FIND v(dout0_4) AT=720.025n

.meas tran vdout0_5ck1430 FIND v(dout0_5) AT=720.025n

.meas tran vdout0_6ck1430 FIND v(dout0_6) AT=720.025n

.meas tran vdout0_7ck1430 FIND v(dout0_7) AT=720.025n

.meas tran vdout0_8ck1430 FIND v(dout0_8) AT=720.025n

.meas tran vdout0_9ck1430 FIND v(dout0_9) AT=720.025n

.meas tran vdout0_10ck1430 FIND v(dout0_10) AT=720.025n

.meas tran vdout0_11ck1430 FIND v(dout0_11) AT=720.025n

.meas tran vdout0_12ck1430 FIND v(dout0_12) AT=720.025n

.meas tran vdout0_13ck1430 FIND v(dout0_13) AT=720.025n

.meas tran vdout0_14ck1430 FIND v(dout0_14) AT=720.025n

.meas tran vdout0_15ck1430 FIND v(dout0_15) AT=720.025n

.meas tran vdout0_16ck1430 FIND v(dout0_16) AT=720.025n

.meas tran vdout0_17ck1430 FIND v(dout0_17) AT=720.025n

.meas tran vdout0_18ck1430 FIND v(dout0_18) AT=720.025n

.meas tran vdout0_19ck1430 FIND v(dout0_19) AT=720.025n

.meas tran vdout0_20ck1430 FIND v(dout0_20) AT=720.025n

.meas tran vdout0_21ck1430 FIND v(dout0_21) AT=720.025n

.meas tran vdout0_22ck1430 FIND v(dout0_22) AT=720.025n

.meas tran vdout0_23ck1430 FIND v(dout0_23) AT=720.025n

.meas tran vdout0_24ck1430 FIND v(dout0_24) AT=720.025n

.meas tran vdout0_25ck1430 FIND v(dout0_25) AT=720.025n

.meas tran vdout0_26ck1430 FIND v(dout0_26) AT=720.025n

.meas tran vdout0_27ck1430 FIND v(dout0_27) AT=720.025n

.meas tran vdout0_28ck1430 FIND v(dout0_28) AT=720.025n

.meas tran vdout0_29ck1430 FIND v(dout0_29) AT=720.025n

.meas tran vdout0_30ck1430 FIND v(dout0_30) AT=720.025n

.meas tran vdout0_31ck1430 FIND v(dout0_31) AT=720.025n

.meas tran vdout0_32ck1430 FIND v(dout0_32) AT=720.025n

.meas tran vdout0_33ck1430 FIND v(dout0_33) AT=720.025n

.meas tran vdout0_34ck1430 FIND v(dout0_34) AT=720.025n

.meas tran vdout0_35ck1430 FIND v(dout0_35) AT=720.025n

.meas tran vdout0_36ck1430 FIND v(dout0_36) AT=720.025n

.meas tran vdout0_37ck1430 FIND v(dout0_37) AT=720.025n

.meas tran vdout0_38ck1430 FIND v(dout0_38) AT=720.025n

.meas tran vdout0_39ck1430 FIND v(dout0_39) AT=720.025n

.meas tran vdout0_40ck1430 FIND v(dout0_40) AT=720.025n

.meas tran vdout0_41ck1430 FIND v(dout0_41) AT=720.025n

.meas tran vdout0_42ck1430 FIND v(dout0_42) AT=720.025n

.meas tran vdout0_43ck1430 FIND v(dout0_43) AT=720.025n

.meas tran vdout0_44ck1430 FIND v(dout0_44) AT=720.025n

.meas tran vdout0_45ck1430 FIND v(dout0_45) AT=720.025n

.meas tran vdout0_46ck1430 FIND v(dout0_46) AT=720.025n

.meas tran vdout0_47ck1430 FIND v(dout0_47) AT=720.025n

.meas tran vdout0_48ck1430 FIND v(dout0_48) AT=720.025n

.meas tran vdout0_49ck1430 FIND v(dout0_49) AT=720.025n

.meas tran vdout0_50ck1430 FIND v(dout0_50) AT=720.025n

.meas tran vdout0_51ck1430 FIND v(dout0_51) AT=720.025n

.meas tran vdout0_52ck1430 FIND v(dout0_52) AT=720.025n

.meas tran vdout0_53ck1430 FIND v(dout0_53) AT=720.025n

.meas tran vdout0_54ck1430 FIND v(dout0_54) AT=720.025n

.meas tran vdout0_55ck1430 FIND v(dout0_55) AT=720.025n

.meas tran vdout0_56ck1430 FIND v(dout0_56) AT=720.025n

.meas tran vdout0_57ck1430 FIND v(dout0_57) AT=720.025n

.meas tran vdout0_58ck1430 FIND v(dout0_58) AT=720.025n

.meas tran vdout0_59ck1430 FIND v(dout0_59) AT=720.025n

.meas tran vdout0_60ck1430 FIND v(dout0_60) AT=720.025n

.meas tran vdout0_61ck1430 FIND v(dout0_61) AT=720.025n

.meas tran vdout0_62ck1430 FIND v(dout0_62) AT=720.025n

.meas tran vdout0_63ck1430 FIND v(dout0_63) AT=720.025n

.meas tran vdout1_0ck1430 FIND v(dout1_0) AT=720.025n

.meas tran vdout1_1ck1430 FIND v(dout1_1) AT=720.025n

.meas tran vdout1_2ck1430 FIND v(dout1_2) AT=720.025n

.meas tran vdout1_3ck1430 FIND v(dout1_3) AT=720.025n

.meas tran vdout1_4ck1430 FIND v(dout1_4) AT=720.025n

.meas tran vdout1_5ck1430 FIND v(dout1_5) AT=720.025n

.meas tran vdout1_6ck1430 FIND v(dout1_6) AT=720.025n

.meas tran vdout1_7ck1430 FIND v(dout1_7) AT=720.025n

.meas tran vdout1_8ck1430 FIND v(dout1_8) AT=720.025n

.meas tran vdout1_9ck1430 FIND v(dout1_9) AT=720.025n

.meas tran vdout1_10ck1430 FIND v(dout1_10) AT=720.025n

.meas tran vdout1_11ck1430 FIND v(dout1_11) AT=720.025n

.meas tran vdout1_12ck1430 FIND v(dout1_12) AT=720.025n

.meas tran vdout1_13ck1430 FIND v(dout1_13) AT=720.025n

.meas tran vdout1_14ck1430 FIND v(dout1_14) AT=720.025n

.meas tran vdout1_15ck1430 FIND v(dout1_15) AT=720.025n

.meas tran vdout1_16ck1430 FIND v(dout1_16) AT=720.025n

.meas tran vdout1_17ck1430 FIND v(dout1_17) AT=720.025n

.meas tran vdout1_18ck1430 FIND v(dout1_18) AT=720.025n

.meas tran vdout1_19ck1430 FIND v(dout1_19) AT=720.025n

.meas tran vdout1_20ck1430 FIND v(dout1_20) AT=720.025n

.meas tran vdout1_21ck1430 FIND v(dout1_21) AT=720.025n

.meas tran vdout1_22ck1430 FIND v(dout1_22) AT=720.025n

.meas tran vdout1_23ck1430 FIND v(dout1_23) AT=720.025n

.meas tran vdout1_24ck1430 FIND v(dout1_24) AT=720.025n

.meas tran vdout1_25ck1430 FIND v(dout1_25) AT=720.025n

.meas tran vdout1_26ck1430 FIND v(dout1_26) AT=720.025n

.meas tran vdout1_27ck1430 FIND v(dout1_27) AT=720.025n

.meas tran vdout1_28ck1430 FIND v(dout1_28) AT=720.025n

.meas tran vdout1_29ck1430 FIND v(dout1_29) AT=720.025n

.meas tran vdout1_30ck1430 FIND v(dout1_30) AT=720.025n

.meas tran vdout1_31ck1430 FIND v(dout1_31) AT=720.025n

.meas tran vdout1_32ck1430 FIND v(dout1_32) AT=720.025n

.meas tran vdout1_33ck1430 FIND v(dout1_33) AT=720.025n

.meas tran vdout1_34ck1430 FIND v(dout1_34) AT=720.025n

.meas tran vdout1_35ck1430 FIND v(dout1_35) AT=720.025n

.meas tran vdout1_36ck1430 FIND v(dout1_36) AT=720.025n

.meas tran vdout1_37ck1430 FIND v(dout1_37) AT=720.025n

.meas tran vdout1_38ck1430 FIND v(dout1_38) AT=720.025n

.meas tran vdout1_39ck1430 FIND v(dout1_39) AT=720.025n

.meas tran vdout1_40ck1430 FIND v(dout1_40) AT=720.025n

.meas tran vdout1_41ck1430 FIND v(dout1_41) AT=720.025n

.meas tran vdout1_42ck1430 FIND v(dout1_42) AT=720.025n

.meas tran vdout1_43ck1430 FIND v(dout1_43) AT=720.025n

.meas tran vdout1_44ck1430 FIND v(dout1_44) AT=720.025n

.meas tran vdout1_45ck1430 FIND v(dout1_45) AT=720.025n

.meas tran vdout1_46ck1430 FIND v(dout1_46) AT=720.025n

.meas tran vdout1_47ck1430 FIND v(dout1_47) AT=720.025n

.meas tran vdout1_48ck1430 FIND v(dout1_48) AT=720.025n

.meas tran vdout1_49ck1430 FIND v(dout1_49) AT=720.025n

.meas tran vdout1_50ck1430 FIND v(dout1_50) AT=720.025n

.meas tran vdout1_51ck1430 FIND v(dout1_51) AT=720.025n

.meas tran vdout1_52ck1430 FIND v(dout1_52) AT=720.025n

.meas tran vdout1_53ck1430 FIND v(dout1_53) AT=720.025n

.meas tran vdout1_54ck1430 FIND v(dout1_54) AT=720.025n

.meas tran vdout1_55ck1430 FIND v(dout1_55) AT=720.025n

.meas tran vdout1_56ck1430 FIND v(dout1_56) AT=720.025n

.meas tran vdout1_57ck1430 FIND v(dout1_57) AT=720.025n

.meas tran vdout1_58ck1430 FIND v(dout1_58) AT=720.025n

.meas tran vdout1_59ck1430 FIND v(dout1_59) AT=720.025n

.meas tran vdout1_60ck1430 FIND v(dout1_60) AT=720.025n

.meas tran vdout1_61ck1430 FIND v(dout1_61) AT=720.025n

.meas tran vdout1_62ck1430 FIND v(dout1_62) AT=720.025n

.meas tran vdout1_63ck1430 FIND v(dout1_63) AT=720.025n

.meas tran vdout1_0ck1440 FIND v(dout1_0) AT=725.025n

.meas tran vdout1_1ck1440 FIND v(dout1_1) AT=725.025n

.meas tran vdout1_2ck1440 FIND v(dout1_2) AT=725.025n

.meas tran vdout1_3ck1440 FIND v(dout1_3) AT=725.025n

.meas tran vdout1_4ck1440 FIND v(dout1_4) AT=725.025n

.meas tran vdout1_5ck1440 FIND v(dout1_5) AT=725.025n

.meas tran vdout1_6ck1440 FIND v(dout1_6) AT=725.025n

.meas tran vdout1_7ck1440 FIND v(dout1_7) AT=725.025n

.meas tran vdout1_8ck1440 FIND v(dout1_8) AT=725.025n

.meas tran vdout1_9ck1440 FIND v(dout1_9) AT=725.025n

.meas tran vdout1_10ck1440 FIND v(dout1_10) AT=725.025n

.meas tran vdout1_11ck1440 FIND v(dout1_11) AT=725.025n

.meas tran vdout1_12ck1440 FIND v(dout1_12) AT=725.025n

.meas tran vdout1_13ck1440 FIND v(dout1_13) AT=725.025n

.meas tran vdout1_14ck1440 FIND v(dout1_14) AT=725.025n

.meas tran vdout1_15ck1440 FIND v(dout1_15) AT=725.025n

.meas tran vdout1_16ck1440 FIND v(dout1_16) AT=725.025n

.meas tran vdout1_17ck1440 FIND v(dout1_17) AT=725.025n

.meas tran vdout1_18ck1440 FIND v(dout1_18) AT=725.025n

.meas tran vdout1_19ck1440 FIND v(dout1_19) AT=725.025n

.meas tran vdout1_20ck1440 FIND v(dout1_20) AT=725.025n

.meas tran vdout1_21ck1440 FIND v(dout1_21) AT=725.025n

.meas tran vdout1_22ck1440 FIND v(dout1_22) AT=725.025n

.meas tran vdout1_23ck1440 FIND v(dout1_23) AT=725.025n

.meas tran vdout1_24ck1440 FIND v(dout1_24) AT=725.025n

.meas tran vdout1_25ck1440 FIND v(dout1_25) AT=725.025n

.meas tran vdout1_26ck1440 FIND v(dout1_26) AT=725.025n

.meas tran vdout1_27ck1440 FIND v(dout1_27) AT=725.025n

.meas tran vdout1_28ck1440 FIND v(dout1_28) AT=725.025n

.meas tran vdout1_29ck1440 FIND v(dout1_29) AT=725.025n

.meas tran vdout1_30ck1440 FIND v(dout1_30) AT=725.025n

.meas tran vdout1_31ck1440 FIND v(dout1_31) AT=725.025n

.meas tran vdout1_32ck1440 FIND v(dout1_32) AT=725.025n

.meas tran vdout1_33ck1440 FIND v(dout1_33) AT=725.025n

.meas tran vdout1_34ck1440 FIND v(dout1_34) AT=725.025n

.meas tran vdout1_35ck1440 FIND v(dout1_35) AT=725.025n

.meas tran vdout1_36ck1440 FIND v(dout1_36) AT=725.025n

.meas tran vdout1_37ck1440 FIND v(dout1_37) AT=725.025n

.meas tran vdout1_38ck1440 FIND v(dout1_38) AT=725.025n

.meas tran vdout1_39ck1440 FIND v(dout1_39) AT=725.025n

.meas tran vdout1_40ck1440 FIND v(dout1_40) AT=725.025n

.meas tran vdout1_41ck1440 FIND v(dout1_41) AT=725.025n

.meas tran vdout1_42ck1440 FIND v(dout1_42) AT=725.025n

.meas tran vdout1_43ck1440 FIND v(dout1_43) AT=725.025n

.meas tran vdout1_44ck1440 FIND v(dout1_44) AT=725.025n

.meas tran vdout1_45ck1440 FIND v(dout1_45) AT=725.025n

.meas tran vdout1_46ck1440 FIND v(dout1_46) AT=725.025n

.meas tran vdout1_47ck1440 FIND v(dout1_47) AT=725.025n

.meas tran vdout1_48ck1440 FIND v(dout1_48) AT=725.025n

.meas tran vdout1_49ck1440 FIND v(dout1_49) AT=725.025n

.meas tran vdout1_50ck1440 FIND v(dout1_50) AT=725.025n

.meas tran vdout1_51ck1440 FIND v(dout1_51) AT=725.025n

.meas tran vdout1_52ck1440 FIND v(dout1_52) AT=725.025n

.meas tran vdout1_53ck1440 FIND v(dout1_53) AT=725.025n

.meas tran vdout1_54ck1440 FIND v(dout1_54) AT=725.025n

.meas tran vdout1_55ck1440 FIND v(dout1_55) AT=725.025n

.meas tran vdout1_56ck1440 FIND v(dout1_56) AT=725.025n

.meas tran vdout1_57ck1440 FIND v(dout1_57) AT=725.025n

.meas tran vdout1_58ck1440 FIND v(dout1_58) AT=725.025n

.meas tran vdout1_59ck1440 FIND v(dout1_59) AT=725.025n

.meas tran vdout1_60ck1440 FIND v(dout1_60) AT=725.025n

.meas tran vdout1_61ck1440 FIND v(dout1_61) AT=725.025n

.meas tran vdout1_62ck1440 FIND v(dout1_62) AT=725.025n

.meas tran vdout1_63ck1440 FIND v(dout1_63) AT=725.025n

.meas tran vdout0_0ck1450 FIND v(dout0_0) AT=730.025n

.meas tran vdout0_1ck1450 FIND v(dout0_1) AT=730.025n

.meas tran vdout0_2ck1450 FIND v(dout0_2) AT=730.025n

.meas tran vdout0_3ck1450 FIND v(dout0_3) AT=730.025n

.meas tran vdout0_4ck1450 FIND v(dout0_4) AT=730.025n

.meas tran vdout0_5ck1450 FIND v(dout0_5) AT=730.025n

.meas tran vdout0_6ck1450 FIND v(dout0_6) AT=730.025n

.meas tran vdout0_7ck1450 FIND v(dout0_7) AT=730.025n

.meas tran vdout0_8ck1450 FIND v(dout0_8) AT=730.025n

.meas tran vdout0_9ck1450 FIND v(dout0_9) AT=730.025n

.meas tran vdout0_10ck1450 FIND v(dout0_10) AT=730.025n

.meas tran vdout0_11ck1450 FIND v(dout0_11) AT=730.025n

.meas tran vdout0_12ck1450 FIND v(dout0_12) AT=730.025n

.meas tran vdout0_13ck1450 FIND v(dout0_13) AT=730.025n

.meas tran vdout0_14ck1450 FIND v(dout0_14) AT=730.025n

.meas tran vdout0_15ck1450 FIND v(dout0_15) AT=730.025n

.meas tran vdout0_16ck1450 FIND v(dout0_16) AT=730.025n

.meas tran vdout0_17ck1450 FIND v(dout0_17) AT=730.025n

.meas tran vdout0_18ck1450 FIND v(dout0_18) AT=730.025n

.meas tran vdout0_19ck1450 FIND v(dout0_19) AT=730.025n

.meas tran vdout0_20ck1450 FIND v(dout0_20) AT=730.025n

.meas tran vdout0_21ck1450 FIND v(dout0_21) AT=730.025n

.meas tran vdout0_22ck1450 FIND v(dout0_22) AT=730.025n

.meas tran vdout0_23ck1450 FIND v(dout0_23) AT=730.025n

.meas tran vdout0_24ck1450 FIND v(dout0_24) AT=730.025n

.meas tran vdout0_25ck1450 FIND v(dout0_25) AT=730.025n

.meas tran vdout0_26ck1450 FIND v(dout0_26) AT=730.025n

.meas tran vdout0_27ck1450 FIND v(dout0_27) AT=730.025n

.meas tran vdout0_28ck1450 FIND v(dout0_28) AT=730.025n

.meas tran vdout0_29ck1450 FIND v(dout0_29) AT=730.025n

.meas tran vdout0_30ck1450 FIND v(dout0_30) AT=730.025n

.meas tran vdout0_31ck1450 FIND v(dout0_31) AT=730.025n

.meas tran vdout0_32ck1450 FIND v(dout0_32) AT=730.025n

.meas tran vdout0_33ck1450 FIND v(dout0_33) AT=730.025n

.meas tran vdout0_34ck1450 FIND v(dout0_34) AT=730.025n

.meas tran vdout0_35ck1450 FIND v(dout0_35) AT=730.025n

.meas tran vdout0_36ck1450 FIND v(dout0_36) AT=730.025n

.meas tran vdout0_37ck1450 FIND v(dout0_37) AT=730.025n

.meas tran vdout0_38ck1450 FIND v(dout0_38) AT=730.025n

.meas tran vdout0_39ck1450 FIND v(dout0_39) AT=730.025n

.meas tran vdout0_40ck1450 FIND v(dout0_40) AT=730.025n

.meas tran vdout0_41ck1450 FIND v(dout0_41) AT=730.025n

.meas tran vdout0_42ck1450 FIND v(dout0_42) AT=730.025n

.meas tran vdout0_43ck1450 FIND v(dout0_43) AT=730.025n

.meas tran vdout0_44ck1450 FIND v(dout0_44) AT=730.025n

.meas tran vdout0_45ck1450 FIND v(dout0_45) AT=730.025n

.meas tran vdout0_46ck1450 FIND v(dout0_46) AT=730.025n

.meas tran vdout0_47ck1450 FIND v(dout0_47) AT=730.025n

.meas tran vdout0_48ck1450 FIND v(dout0_48) AT=730.025n

.meas tran vdout0_49ck1450 FIND v(dout0_49) AT=730.025n

.meas tran vdout0_50ck1450 FIND v(dout0_50) AT=730.025n

.meas tran vdout0_51ck1450 FIND v(dout0_51) AT=730.025n

.meas tran vdout0_52ck1450 FIND v(dout0_52) AT=730.025n

.meas tran vdout0_53ck1450 FIND v(dout0_53) AT=730.025n

.meas tran vdout0_54ck1450 FIND v(dout0_54) AT=730.025n

.meas tran vdout0_55ck1450 FIND v(dout0_55) AT=730.025n

.meas tran vdout0_56ck1450 FIND v(dout0_56) AT=730.025n

.meas tran vdout0_57ck1450 FIND v(dout0_57) AT=730.025n

.meas tran vdout0_58ck1450 FIND v(dout0_58) AT=730.025n

.meas tran vdout0_59ck1450 FIND v(dout0_59) AT=730.025n

.meas tran vdout0_60ck1450 FIND v(dout0_60) AT=730.025n

.meas tran vdout0_61ck1450 FIND v(dout0_61) AT=730.025n

.meas tran vdout0_62ck1450 FIND v(dout0_62) AT=730.025n

.meas tran vdout0_63ck1450 FIND v(dout0_63) AT=730.025n

.meas tran vdout1_0ck1450 FIND v(dout1_0) AT=730.025n

.meas tran vdout1_1ck1450 FIND v(dout1_1) AT=730.025n

.meas tran vdout1_2ck1450 FIND v(dout1_2) AT=730.025n

.meas tran vdout1_3ck1450 FIND v(dout1_3) AT=730.025n

.meas tran vdout1_4ck1450 FIND v(dout1_4) AT=730.025n

.meas tran vdout1_5ck1450 FIND v(dout1_5) AT=730.025n

.meas tran vdout1_6ck1450 FIND v(dout1_6) AT=730.025n

.meas tran vdout1_7ck1450 FIND v(dout1_7) AT=730.025n

.meas tran vdout1_8ck1450 FIND v(dout1_8) AT=730.025n

.meas tran vdout1_9ck1450 FIND v(dout1_9) AT=730.025n

.meas tran vdout1_10ck1450 FIND v(dout1_10) AT=730.025n

.meas tran vdout1_11ck1450 FIND v(dout1_11) AT=730.025n

.meas tran vdout1_12ck1450 FIND v(dout1_12) AT=730.025n

.meas tran vdout1_13ck1450 FIND v(dout1_13) AT=730.025n

.meas tran vdout1_14ck1450 FIND v(dout1_14) AT=730.025n

.meas tran vdout1_15ck1450 FIND v(dout1_15) AT=730.025n

.meas tran vdout1_16ck1450 FIND v(dout1_16) AT=730.025n

.meas tran vdout1_17ck1450 FIND v(dout1_17) AT=730.025n

.meas tran vdout1_18ck1450 FIND v(dout1_18) AT=730.025n

.meas tran vdout1_19ck1450 FIND v(dout1_19) AT=730.025n

.meas tran vdout1_20ck1450 FIND v(dout1_20) AT=730.025n

.meas tran vdout1_21ck1450 FIND v(dout1_21) AT=730.025n

.meas tran vdout1_22ck1450 FIND v(dout1_22) AT=730.025n

.meas tran vdout1_23ck1450 FIND v(dout1_23) AT=730.025n

.meas tran vdout1_24ck1450 FIND v(dout1_24) AT=730.025n

.meas tran vdout1_25ck1450 FIND v(dout1_25) AT=730.025n

.meas tran vdout1_26ck1450 FIND v(dout1_26) AT=730.025n

.meas tran vdout1_27ck1450 FIND v(dout1_27) AT=730.025n

.meas tran vdout1_28ck1450 FIND v(dout1_28) AT=730.025n

.meas tran vdout1_29ck1450 FIND v(dout1_29) AT=730.025n

.meas tran vdout1_30ck1450 FIND v(dout1_30) AT=730.025n

.meas tran vdout1_31ck1450 FIND v(dout1_31) AT=730.025n

.meas tran vdout1_32ck1450 FIND v(dout1_32) AT=730.025n

.meas tran vdout1_33ck1450 FIND v(dout1_33) AT=730.025n

.meas tran vdout1_34ck1450 FIND v(dout1_34) AT=730.025n

.meas tran vdout1_35ck1450 FIND v(dout1_35) AT=730.025n

.meas tran vdout1_36ck1450 FIND v(dout1_36) AT=730.025n

.meas tran vdout1_37ck1450 FIND v(dout1_37) AT=730.025n

.meas tran vdout1_38ck1450 FIND v(dout1_38) AT=730.025n

.meas tran vdout1_39ck1450 FIND v(dout1_39) AT=730.025n

.meas tran vdout1_40ck1450 FIND v(dout1_40) AT=730.025n

.meas tran vdout1_41ck1450 FIND v(dout1_41) AT=730.025n

.meas tran vdout1_42ck1450 FIND v(dout1_42) AT=730.025n

.meas tran vdout1_43ck1450 FIND v(dout1_43) AT=730.025n

.meas tran vdout1_44ck1450 FIND v(dout1_44) AT=730.025n

.meas tran vdout1_45ck1450 FIND v(dout1_45) AT=730.025n

.meas tran vdout1_46ck1450 FIND v(dout1_46) AT=730.025n

.meas tran vdout1_47ck1450 FIND v(dout1_47) AT=730.025n

.meas tran vdout1_48ck1450 FIND v(dout1_48) AT=730.025n

.meas tran vdout1_49ck1450 FIND v(dout1_49) AT=730.025n

.meas tran vdout1_50ck1450 FIND v(dout1_50) AT=730.025n

.meas tran vdout1_51ck1450 FIND v(dout1_51) AT=730.025n

.meas tran vdout1_52ck1450 FIND v(dout1_52) AT=730.025n

.meas tran vdout1_53ck1450 FIND v(dout1_53) AT=730.025n

.meas tran vdout1_54ck1450 FIND v(dout1_54) AT=730.025n

.meas tran vdout1_55ck1450 FIND v(dout1_55) AT=730.025n

.meas tran vdout1_56ck1450 FIND v(dout1_56) AT=730.025n

.meas tran vdout1_57ck1450 FIND v(dout1_57) AT=730.025n

.meas tran vdout1_58ck1450 FIND v(dout1_58) AT=730.025n

.meas tran vdout1_59ck1450 FIND v(dout1_59) AT=730.025n

.meas tran vdout1_60ck1450 FIND v(dout1_60) AT=730.025n

.meas tran vdout1_61ck1450 FIND v(dout1_61) AT=730.025n

.meas tran vdout1_62ck1450 FIND v(dout1_62) AT=730.025n

.meas tran vdout1_63ck1450 FIND v(dout1_63) AT=730.025n

.meas tran vdout0_0ck1460 FIND v(dout0_0) AT=735.025n

.meas tran vdout0_1ck1460 FIND v(dout0_1) AT=735.025n

.meas tran vdout0_2ck1460 FIND v(dout0_2) AT=735.025n

.meas tran vdout0_3ck1460 FIND v(dout0_3) AT=735.025n

.meas tran vdout0_4ck1460 FIND v(dout0_4) AT=735.025n

.meas tran vdout0_5ck1460 FIND v(dout0_5) AT=735.025n

.meas tran vdout0_6ck1460 FIND v(dout0_6) AT=735.025n

.meas tran vdout0_7ck1460 FIND v(dout0_7) AT=735.025n

.meas tran vdout0_8ck1460 FIND v(dout0_8) AT=735.025n

.meas tran vdout0_9ck1460 FIND v(dout0_9) AT=735.025n

.meas tran vdout0_10ck1460 FIND v(dout0_10) AT=735.025n

.meas tran vdout0_11ck1460 FIND v(dout0_11) AT=735.025n

.meas tran vdout0_12ck1460 FIND v(dout0_12) AT=735.025n

.meas tran vdout0_13ck1460 FIND v(dout0_13) AT=735.025n

.meas tran vdout0_14ck1460 FIND v(dout0_14) AT=735.025n

.meas tran vdout0_15ck1460 FIND v(dout0_15) AT=735.025n

.meas tran vdout0_16ck1460 FIND v(dout0_16) AT=735.025n

.meas tran vdout0_17ck1460 FIND v(dout0_17) AT=735.025n

.meas tran vdout0_18ck1460 FIND v(dout0_18) AT=735.025n

.meas tran vdout0_19ck1460 FIND v(dout0_19) AT=735.025n

.meas tran vdout0_20ck1460 FIND v(dout0_20) AT=735.025n

.meas tran vdout0_21ck1460 FIND v(dout0_21) AT=735.025n

.meas tran vdout0_22ck1460 FIND v(dout0_22) AT=735.025n

.meas tran vdout0_23ck1460 FIND v(dout0_23) AT=735.025n

.meas tran vdout0_24ck1460 FIND v(dout0_24) AT=735.025n

.meas tran vdout0_25ck1460 FIND v(dout0_25) AT=735.025n

.meas tran vdout0_26ck1460 FIND v(dout0_26) AT=735.025n

.meas tran vdout0_27ck1460 FIND v(dout0_27) AT=735.025n

.meas tran vdout0_28ck1460 FIND v(dout0_28) AT=735.025n

.meas tran vdout0_29ck1460 FIND v(dout0_29) AT=735.025n

.meas tran vdout0_30ck1460 FIND v(dout0_30) AT=735.025n

.meas tran vdout0_31ck1460 FIND v(dout0_31) AT=735.025n

.meas tran vdout0_32ck1460 FIND v(dout0_32) AT=735.025n

.meas tran vdout0_33ck1460 FIND v(dout0_33) AT=735.025n

.meas tran vdout0_34ck1460 FIND v(dout0_34) AT=735.025n

.meas tran vdout0_35ck1460 FIND v(dout0_35) AT=735.025n

.meas tran vdout0_36ck1460 FIND v(dout0_36) AT=735.025n

.meas tran vdout0_37ck1460 FIND v(dout0_37) AT=735.025n

.meas tran vdout0_38ck1460 FIND v(dout0_38) AT=735.025n

.meas tran vdout0_39ck1460 FIND v(dout0_39) AT=735.025n

.meas tran vdout0_40ck1460 FIND v(dout0_40) AT=735.025n

.meas tran vdout0_41ck1460 FIND v(dout0_41) AT=735.025n

.meas tran vdout0_42ck1460 FIND v(dout0_42) AT=735.025n

.meas tran vdout0_43ck1460 FIND v(dout0_43) AT=735.025n

.meas tran vdout0_44ck1460 FIND v(dout0_44) AT=735.025n

.meas tran vdout0_45ck1460 FIND v(dout0_45) AT=735.025n

.meas tran vdout0_46ck1460 FIND v(dout0_46) AT=735.025n

.meas tran vdout0_47ck1460 FIND v(dout0_47) AT=735.025n

.meas tran vdout0_48ck1460 FIND v(dout0_48) AT=735.025n

.meas tran vdout0_49ck1460 FIND v(dout0_49) AT=735.025n

.meas tran vdout0_50ck1460 FIND v(dout0_50) AT=735.025n

.meas tran vdout0_51ck1460 FIND v(dout0_51) AT=735.025n

.meas tran vdout0_52ck1460 FIND v(dout0_52) AT=735.025n

.meas tran vdout0_53ck1460 FIND v(dout0_53) AT=735.025n

.meas tran vdout0_54ck1460 FIND v(dout0_54) AT=735.025n

.meas tran vdout0_55ck1460 FIND v(dout0_55) AT=735.025n

.meas tran vdout0_56ck1460 FIND v(dout0_56) AT=735.025n

.meas tran vdout0_57ck1460 FIND v(dout0_57) AT=735.025n

.meas tran vdout0_58ck1460 FIND v(dout0_58) AT=735.025n

.meas tran vdout0_59ck1460 FIND v(dout0_59) AT=735.025n

.meas tran vdout0_60ck1460 FIND v(dout0_60) AT=735.025n

.meas tran vdout0_61ck1460 FIND v(dout0_61) AT=735.025n

.meas tran vdout0_62ck1460 FIND v(dout0_62) AT=735.025n

.meas tran vdout0_63ck1460 FIND v(dout0_63) AT=735.025n

.meas tran vdout0_0ck1470 FIND v(dout0_0) AT=740.025n

.meas tran vdout0_1ck1470 FIND v(dout0_1) AT=740.025n

.meas tran vdout0_2ck1470 FIND v(dout0_2) AT=740.025n

.meas tran vdout0_3ck1470 FIND v(dout0_3) AT=740.025n

.meas tran vdout0_4ck1470 FIND v(dout0_4) AT=740.025n

.meas tran vdout0_5ck1470 FIND v(dout0_5) AT=740.025n

.meas tran vdout0_6ck1470 FIND v(dout0_6) AT=740.025n

.meas tran vdout0_7ck1470 FIND v(dout0_7) AT=740.025n

.meas tran vdout0_8ck1470 FIND v(dout0_8) AT=740.025n

.meas tran vdout0_9ck1470 FIND v(dout0_9) AT=740.025n

.meas tran vdout0_10ck1470 FIND v(dout0_10) AT=740.025n

.meas tran vdout0_11ck1470 FIND v(dout0_11) AT=740.025n

.meas tran vdout0_12ck1470 FIND v(dout0_12) AT=740.025n

.meas tran vdout0_13ck1470 FIND v(dout0_13) AT=740.025n

.meas tran vdout0_14ck1470 FIND v(dout0_14) AT=740.025n

.meas tran vdout0_15ck1470 FIND v(dout0_15) AT=740.025n

.meas tran vdout0_16ck1470 FIND v(dout0_16) AT=740.025n

.meas tran vdout0_17ck1470 FIND v(dout0_17) AT=740.025n

.meas tran vdout0_18ck1470 FIND v(dout0_18) AT=740.025n

.meas tran vdout0_19ck1470 FIND v(dout0_19) AT=740.025n

.meas tran vdout0_20ck1470 FIND v(dout0_20) AT=740.025n

.meas tran vdout0_21ck1470 FIND v(dout0_21) AT=740.025n

.meas tran vdout0_22ck1470 FIND v(dout0_22) AT=740.025n

.meas tran vdout0_23ck1470 FIND v(dout0_23) AT=740.025n

.meas tran vdout0_24ck1470 FIND v(dout0_24) AT=740.025n

.meas tran vdout0_25ck1470 FIND v(dout0_25) AT=740.025n

.meas tran vdout0_26ck1470 FIND v(dout0_26) AT=740.025n

.meas tran vdout0_27ck1470 FIND v(dout0_27) AT=740.025n

.meas tran vdout0_28ck1470 FIND v(dout0_28) AT=740.025n

.meas tran vdout0_29ck1470 FIND v(dout0_29) AT=740.025n

.meas tran vdout0_30ck1470 FIND v(dout0_30) AT=740.025n

.meas tran vdout0_31ck1470 FIND v(dout0_31) AT=740.025n

.meas tran vdout0_32ck1470 FIND v(dout0_32) AT=740.025n

.meas tran vdout0_33ck1470 FIND v(dout0_33) AT=740.025n

.meas tran vdout0_34ck1470 FIND v(dout0_34) AT=740.025n

.meas tran vdout0_35ck1470 FIND v(dout0_35) AT=740.025n

.meas tran vdout0_36ck1470 FIND v(dout0_36) AT=740.025n

.meas tran vdout0_37ck1470 FIND v(dout0_37) AT=740.025n

.meas tran vdout0_38ck1470 FIND v(dout0_38) AT=740.025n

.meas tran vdout0_39ck1470 FIND v(dout0_39) AT=740.025n

.meas tran vdout0_40ck1470 FIND v(dout0_40) AT=740.025n

.meas tran vdout0_41ck1470 FIND v(dout0_41) AT=740.025n

.meas tran vdout0_42ck1470 FIND v(dout0_42) AT=740.025n

.meas tran vdout0_43ck1470 FIND v(dout0_43) AT=740.025n

.meas tran vdout0_44ck1470 FIND v(dout0_44) AT=740.025n

.meas tran vdout0_45ck1470 FIND v(dout0_45) AT=740.025n

.meas tran vdout0_46ck1470 FIND v(dout0_46) AT=740.025n

.meas tran vdout0_47ck1470 FIND v(dout0_47) AT=740.025n

.meas tran vdout0_48ck1470 FIND v(dout0_48) AT=740.025n

.meas tran vdout0_49ck1470 FIND v(dout0_49) AT=740.025n

.meas tran vdout0_50ck1470 FIND v(dout0_50) AT=740.025n

.meas tran vdout0_51ck1470 FIND v(dout0_51) AT=740.025n

.meas tran vdout0_52ck1470 FIND v(dout0_52) AT=740.025n

.meas tran vdout0_53ck1470 FIND v(dout0_53) AT=740.025n

.meas tran vdout0_54ck1470 FIND v(dout0_54) AT=740.025n

.meas tran vdout0_55ck1470 FIND v(dout0_55) AT=740.025n

.meas tran vdout0_56ck1470 FIND v(dout0_56) AT=740.025n

.meas tran vdout0_57ck1470 FIND v(dout0_57) AT=740.025n

.meas tran vdout0_58ck1470 FIND v(dout0_58) AT=740.025n

.meas tran vdout0_59ck1470 FIND v(dout0_59) AT=740.025n

.meas tran vdout0_60ck1470 FIND v(dout0_60) AT=740.025n

.meas tran vdout0_61ck1470 FIND v(dout0_61) AT=740.025n

.meas tran vdout0_62ck1470 FIND v(dout0_62) AT=740.025n

.meas tran vdout0_63ck1470 FIND v(dout0_63) AT=740.025n

.meas tran vdout0_0ck1490 FIND v(dout0_0) AT=750.025n

.meas tran vdout0_1ck1490 FIND v(dout0_1) AT=750.025n

.meas tran vdout0_2ck1490 FIND v(dout0_2) AT=750.025n

.meas tran vdout0_3ck1490 FIND v(dout0_3) AT=750.025n

.meas tran vdout0_4ck1490 FIND v(dout0_4) AT=750.025n

.meas tran vdout0_5ck1490 FIND v(dout0_5) AT=750.025n

.meas tran vdout0_6ck1490 FIND v(dout0_6) AT=750.025n

.meas tran vdout0_7ck1490 FIND v(dout0_7) AT=750.025n

.meas tran vdout0_8ck1490 FIND v(dout0_8) AT=750.025n

.meas tran vdout0_9ck1490 FIND v(dout0_9) AT=750.025n

.meas tran vdout0_10ck1490 FIND v(dout0_10) AT=750.025n

.meas tran vdout0_11ck1490 FIND v(dout0_11) AT=750.025n

.meas tran vdout0_12ck1490 FIND v(dout0_12) AT=750.025n

.meas tran vdout0_13ck1490 FIND v(dout0_13) AT=750.025n

.meas tran vdout0_14ck1490 FIND v(dout0_14) AT=750.025n

.meas tran vdout0_15ck1490 FIND v(dout0_15) AT=750.025n

.meas tran vdout0_16ck1490 FIND v(dout0_16) AT=750.025n

.meas tran vdout0_17ck1490 FIND v(dout0_17) AT=750.025n

.meas tran vdout0_18ck1490 FIND v(dout0_18) AT=750.025n

.meas tran vdout0_19ck1490 FIND v(dout0_19) AT=750.025n

.meas tran vdout0_20ck1490 FIND v(dout0_20) AT=750.025n

.meas tran vdout0_21ck1490 FIND v(dout0_21) AT=750.025n

.meas tran vdout0_22ck1490 FIND v(dout0_22) AT=750.025n

.meas tran vdout0_23ck1490 FIND v(dout0_23) AT=750.025n

.meas tran vdout0_24ck1490 FIND v(dout0_24) AT=750.025n

.meas tran vdout0_25ck1490 FIND v(dout0_25) AT=750.025n

.meas tran vdout0_26ck1490 FIND v(dout0_26) AT=750.025n

.meas tran vdout0_27ck1490 FIND v(dout0_27) AT=750.025n

.meas tran vdout0_28ck1490 FIND v(dout0_28) AT=750.025n

.meas tran vdout0_29ck1490 FIND v(dout0_29) AT=750.025n

.meas tran vdout0_30ck1490 FIND v(dout0_30) AT=750.025n

.meas tran vdout0_31ck1490 FIND v(dout0_31) AT=750.025n

.meas tran vdout0_32ck1490 FIND v(dout0_32) AT=750.025n

.meas tran vdout0_33ck1490 FIND v(dout0_33) AT=750.025n

.meas tran vdout0_34ck1490 FIND v(dout0_34) AT=750.025n

.meas tran vdout0_35ck1490 FIND v(dout0_35) AT=750.025n

.meas tran vdout0_36ck1490 FIND v(dout0_36) AT=750.025n

.meas tran vdout0_37ck1490 FIND v(dout0_37) AT=750.025n

.meas tran vdout0_38ck1490 FIND v(dout0_38) AT=750.025n

.meas tran vdout0_39ck1490 FIND v(dout0_39) AT=750.025n

.meas tran vdout0_40ck1490 FIND v(dout0_40) AT=750.025n

.meas tran vdout0_41ck1490 FIND v(dout0_41) AT=750.025n

.meas tran vdout0_42ck1490 FIND v(dout0_42) AT=750.025n

.meas tran vdout0_43ck1490 FIND v(dout0_43) AT=750.025n

.meas tran vdout0_44ck1490 FIND v(dout0_44) AT=750.025n

.meas tran vdout0_45ck1490 FIND v(dout0_45) AT=750.025n

.meas tran vdout0_46ck1490 FIND v(dout0_46) AT=750.025n

.meas tran vdout0_47ck1490 FIND v(dout0_47) AT=750.025n

.meas tran vdout0_48ck1490 FIND v(dout0_48) AT=750.025n

.meas tran vdout0_49ck1490 FIND v(dout0_49) AT=750.025n

.meas tran vdout0_50ck1490 FIND v(dout0_50) AT=750.025n

.meas tran vdout0_51ck1490 FIND v(dout0_51) AT=750.025n

.meas tran vdout0_52ck1490 FIND v(dout0_52) AT=750.025n

.meas tran vdout0_53ck1490 FIND v(dout0_53) AT=750.025n

.meas tran vdout0_54ck1490 FIND v(dout0_54) AT=750.025n

.meas tran vdout0_55ck1490 FIND v(dout0_55) AT=750.025n

.meas tran vdout0_56ck1490 FIND v(dout0_56) AT=750.025n

.meas tran vdout0_57ck1490 FIND v(dout0_57) AT=750.025n

.meas tran vdout0_58ck1490 FIND v(dout0_58) AT=750.025n

.meas tran vdout0_59ck1490 FIND v(dout0_59) AT=750.025n

.meas tran vdout0_60ck1490 FIND v(dout0_60) AT=750.025n

.meas tran vdout0_61ck1490 FIND v(dout0_61) AT=750.025n

.meas tran vdout0_62ck1490 FIND v(dout0_62) AT=750.025n

.meas tran vdout0_63ck1490 FIND v(dout0_63) AT=750.025n

.meas tran vdout1_0ck1490 FIND v(dout1_0) AT=750.025n

.meas tran vdout1_1ck1490 FIND v(dout1_1) AT=750.025n

.meas tran vdout1_2ck1490 FIND v(dout1_2) AT=750.025n

.meas tran vdout1_3ck1490 FIND v(dout1_3) AT=750.025n

.meas tran vdout1_4ck1490 FIND v(dout1_4) AT=750.025n

.meas tran vdout1_5ck1490 FIND v(dout1_5) AT=750.025n

.meas tran vdout1_6ck1490 FIND v(dout1_6) AT=750.025n

.meas tran vdout1_7ck1490 FIND v(dout1_7) AT=750.025n

.meas tran vdout1_8ck1490 FIND v(dout1_8) AT=750.025n

.meas tran vdout1_9ck1490 FIND v(dout1_9) AT=750.025n

.meas tran vdout1_10ck1490 FIND v(dout1_10) AT=750.025n

.meas tran vdout1_11ck1490 FIND v(dout1_11) AT=750.025n

.meas tran vdout1_12ck1490 FIND v(dout1_12) AT=750.025n

.meas tran vdout1_13ck1490 FIND v(dout1_13) AT=750.025n

.meas tran vdout1_14ck1490 FIND v(dout1_14) AT=750.025n

.meas tran vdout1_15ck1490 FIND v(dout1_15) AT=750.025n

.meas tran vdout1_16ck1490 FIND v(dout1_16) AT=750.025n

.meas tran vdout1_17ck1490 FIND v(dout1_17) AT=750.025n

.meas tran vdout1_18ck1490 FIND v(dout1_18) AT=750.025n

.meas tran vdout1_19ck1490 FIND v(dout1_19) AT=750.025n

.meas tran vdout1_20ck1490 FIND v(dout1_20) AT=750.025n

.meas tran vdout1_21ck1490 FIND v(dout1_21) AT=750.025n

.meas tran vdout1_22ck1490 FIND v(dout1_22) AT=750.025n

.meas tran vdout1_23ck1490 FIND v(dout1_23) AT=750.025n

.meas tran vdout1_24ck1490 FIND v(dout1_24) AT=750.025n

.meas tran vdout1_25ck1490 FIND v(dout1_25) AT=750.025n

.meas tran vdout1_26ck1490 FIND v(dout1_26) AT=750.025n

.meas tran vdout1_27ck1490 FIND v(dout1_27) AT=750.025n

.meas tran vdout1_28ck1490 FIND v(dout1_28) AT=750.025n

.meas tran vdout1_29ck1490 FIND v(dout1_29) AT=750.025n

.meas tran vdout1_30ck1490 FIND v(dout1_30) AT=750.025n

.meas tran vdout1_31ck1490 FIND v(dout1_31) AT=750.025n

.meas tran vdout1_32ck1490 FIND v(dout1_32) AT=750.025n

.meas tran vdout1_33ck1490 FIND v(dout1_33) AT=750.025n

.meas tran vdout1_34ck1490 FIND v(dout1_34) AT=750.025n

.meas tran vdout1_35ck1490 FIND v(dout1_35) AT=750.025n

.meas tran vdout1_36ck1490 FIND v(dout1_36) AT=750.025n

.meas tran vdout1_37ck1490 FIND v(dout1_37) AT=750.025n

.meas tran vdout1_38ck1490 FIND v(dout1_38) AT=750.025n

.meas tran vdout1_39ck1490 FIND v(dout1_39) AT=750.025n

.meas tran vdout1_40ck1490 FIND v(dout1_40) AT=750.025n

.meas tran vdout1_41ck1490 FIND v(dout1_41) AT=750.025n

.meas tran vdout1_42ck1490 FIND v(dout1_42) AT=750.025n

.meas tran vdout1_43ck1490 FIND v(dout1_43) AT=750.025n

.meas tran vdout1_44ck1490 FIND v(dout1_44) AT=750.025n

.meas tran vdout1_45ck1490 FIND v(dout1_45) AT=750.025n

.meas tran vdout1_46ck1490 FIND v(dout1_46) AT=750.025n

.meas tran vdout1_47ck1490 FIND v(dout1_47) AT=750.025n

.meas tran vdout1_48ck1490 FIND v(dout1_48) AT=750.025n

.meas tran vdout1_49ck1490 FIND v(dout1_49) AT=750.025n

.meas tran vdout1_50ck1490 FIND v(dout1_50) AT=750.025n

.meas tran vdout1_51ck1490 FIND v(dout1_51) AT=750.025n

.meas tran vdout1_52ck1490 FIND v(dout1_52) AT=750.025n

.meas tran vdout1_53ck1490 FIND v(dout1_53) AT=750.025n

.meas tran vdout1_54ck1490 FIND v(dout1_54) AT=750.025n

.meas tran vdout1_55ck1490 FIND v(dout1_55) AT=750.025n

.meas tran vdout1_56ck1490 FIND v(dout1_56) AT=750.025n

.meas tran vdout1_57ck1490 FIND v(dout1_57) AT=750.025n

.meas tran vdout1_58ck1490 FIND v(dout1_58) AT=750.025n

.meas tran vdout1_59ck1490 FIND v(dout1_59) AT=750.025n

.meas tran vdout1_60ck1490 FIND v(dout1_60) AT=750.025n

.meas tran vdout1_61ck1490 FIND v(dout1_61) AT=750.025n

.meas tran vdout1_62ck1490 FIND v(dout1_62) AT=750.025n

.meas tran vdout1_63ck1490 FIND v(dout1_63) AT=750.025n

.meas tran vdout0_0ck1500 FIND v(dout0_0) AT=755.025n

.meas tran vdout0_1ck1500 FIND v(dout0_1) AT=755.025n

.meas tran vdout0_2ck1500 FIND v(dout0_2) AT=755.025n

.meas tran vdout0_3ck1500 FIND v(dout0_3) AT=755.025n

.meas tran vdout0_4ck1500 FIND v(dout0_4) AT=755.025n

.meas tran vdout0_5ck1500 FIND v(dout0_5) AT=755.025n

.meas tran vdout0_6ck1500 FIND v(dout0_6) AT=755.025n

.meas tran vdout0_7ck1500 FIND v(dout0_7) AT=755.025n

.meas tran vdout0_8ck1500 FIND v(dout0_8) AT=755.025n

.meas tran vdout0_9ck1500 FIND v(dout0_9) AT=755.025n

.meas tran vdout0_10ck1500 FIND v(dout0_10) AT=755.025n

.meas tran vdout0_11ck1500 FIND v(dout0_11) AT=755.025n

.meas tran vdout0_12ck1500 FIND v(dout0_12) AT=755.025n

.meas tran vdout0_13ck1500 FIND v(dout0_13) AT=755.025n

.meas tran vdout0_14ck1500 FIND v(dout0_14) AT=755.025n

.meas tran vdout0_15ck1500 FIND v(dout0_15) AT=755.025n

.meas tran vdout0_16ck1500 FIND v(dout0_16) AT=755.025n

.meas tran vdout0_17ck1500 FIND v(dout0_17) AT=755.025n

.meas tran vdout0_18ck1500 FIND v(dout0_18) AT=755.025n

.meas tran vdout0_19ck1500 FIND v(dout0_19) AT=755.025n

.meas tran vdout0_20ck1500 FIND v(dout0_20) AT=755.025n

.meas tran vdout0_21ck1500 FIND v(dout0_21) AT=755.025n

.meas tran vdout0_22ck1500 FIND v(dout0_22) AT=755.025n

.meas tran vdout0_23ck1500 FIND v(dout0_23) AT=755.025n

.meas tran vdout0_24ck1500 FIND v(dout0_24) AT=755.025n

.meas tran vdout0_25ck1500 FIND v(dout0_25) AT=755.025n

.meas tran vdout0_26ck1500 FIND v(dout0_26) AT=755.025n

.meas tran vdout0_27ck1500 FIND v(dout0_27) AT=755.025n

.meas tran vdout0_28ck1500 FIND v(dout0_28) AT=755.025n

.meas tran vdout0_29ck1500 FIND v(dout0_29) AT=755.025n

.meas tran vdout0_30ck1500 FIND v(dout0_30) AT=755.025n

.meas tran vdout0_31ck1500 FIND v(dout0_31) AT=755.025n

.meas tran vdout0_32ck1500 FIND v(dout0_32) AT=755.025n

.meas tran vdout0_33ck1500 FIND v(dout0_33) AT=755.025n

.meas tran vdout0_34ck1500 FIND v(dout0_34) AT=755.025n

.meas tran vdout0_35ck1500 FIND v(dout0_35) AT=755.025n

.meas tran vdout0_36ck1500 FIND v(dout0_36) AT=755.025n

.meas tran vdout0_37ck1500 FIND v(dout0_37) AT=755.025n

.meas tran vdout0_38ck1500 FIND v(dout0_38) AT=755.025n

.meas tran vdout0_39ck1500 FIND v(dout0_39) AT=755.025n

.meas tran vdout0_40ck1500 FIND v(dout0_40) AT=755.025n

.meas tran vdout0_41ck1500 FIND v(dout0_41) AT=755.025n

.meas tran vdout0_42ck1500 FIND v(dout0_42) AT=755.025n

.meas tran vdout0_43ck1500 FIND v(dout0_43) AT=755.025n

.meas tran vdout0_44ck1500 FIND v(dout0_44) AT=755.025n

.meas tran vdout0_45ck1500 FIND v(dout0_45) AT=755.025n

.meas tran vdout0_46ck1500 FIND v(dout0_46) AT=755.025n

.meas tran vdout0_47ck1500 FIND v(dout0_47) AT=755.025n

.meas tran vdout0_48ck1500 FIND v(dout0_48) AT=755.025n

.meas tran vdout0_49ck1500 FIND v(dout0_49) AT=755.025n

.meas tran vdout0_50ck1500 FIND v(dout0_50) AT=755.025n

.meas tran vdout0_51ck1500 FIND v(dout0_51) AT=755.025n

.meas tran vdout0_52ck1500 FIND v(dout0_52) AT=755.025n

.meas tran vdout0_53ck1500 FIND v(dout0_53) AT=755.025n

.meas tran vdout0_54ck1500 FIND v(dout0_54) AT=755.025n

.meas tran vdout0_55ck1500 FIND v(dout0_55) AT=755.025n

.meas tran vdout0_56ck1500 FIND v(dout0_56) AT=755.025n

.meas tran vdout0_57ck1500 FIND v(dout0_57) AT=755.025n

.meas tran vdout0_58ck1500 FIND v(dout0_58) AT=755.025n

.meas tran vdout0_59ck1500 FIND v(dout0_59) AT=755.025n

.meas tran vdout0_60ck1500 FIND v(dout0_60) AT=755.025n

.meas tran vdout0_61ck1500 FIND v(dout0_61) AT=755.025n

.meas tran vdout0_62ck1500 FIND v(dout0_62) AT=755.025n

.meas tran vdout0_63ck1500 FIND v(dout0_63) AT=755.025n

.meas tran vdout1_0ck1500 FIND v(dout1_0) AT=755.025n

.meas tran vdout1_1ck1500 FIND v(dout1_1) AT=755.025n

.meas tran vdout1_2ck1500 FIND v(dout1_2) AT=755.025n

.meas tran vdout1_3ck1500 FIND v(dout1_3) AT=755.025n

.meas tran vdout1_4ck1500 FIND v(dout1_4) AT=755.025n

.meas tran vdout1_5ck1500 FIND v(dout1_5) AT=755.025n

.meas tran vdout1_6ck1500 FIND v(dout1_6) AT=755.025n

.meas tran vdout1_7ck1500 FIND v(dout1_7) AT=755.025n

.meas tran vdout1_8ck1500 FIND v(dout1_8) AT=755.025n

.meas tran vdout1_9ck1500 FIND v(dout1_9) AT=755.025n

.meas tran vdout1_10ck1500 FIND v(dout1_10) AT=755.025n

.meas tran vdout1_11ck1500 FIND v(dout1_11) AT=755.025n

.meas tran vdout1_12ck1500 FIND v(dout1_12) AT=755.025n

.meas tran vdout1_13ck1500 FIND v(dout1_13) AT=755.025n

.meas tran vdout1_14ck1500 FIND v(dout1_14) AT=755.025n

.meas tran vdout1_15ck1500 FIND v(dout1_15) AT=755.025n

.meas tran vdout1_16ck1500 FIND v(dout1_16) AT=755.025n

.meas tran vdout1_17ck1500 FIND v(dout1_17) AT=755.025n

.meas tran vdout1_18ck1500 FIND v(dout1_18) AT=755.025n

.meas tran vdout1_19ck1500 FIND v(dout1_19) AT=755.025n

.meas tran vdout1_20ck1500 FIND v(dout1_20) AT=755.025n

.meas tran vdout1_21ck1500 FIND v(dout1_21) AT=755.025n

.meas tran vdout1_22ck1500 FIND v(dout1_22) AT=755.025n

.meas tran vdout1_23ck1500 FIND v(dout1_23) AT=755.025n

.meas tran vdout1_24ck1500 FIND v(dout1_24) AT=755.025n

.meas tran vdout1_25ck1500 FIND v(dout1_25) AT=755.025n

.meas tran vdout1_26ck1500 FIND v(dout1_26) AT=755.025n

.meas tran vdout1_27ck1500 FIND v(dout1_27) AT=755.025n

.meas tran vdout1_28ck1500 FIND v(dout1_28) AT=755.025n

.meas tran vdout1_29ck1500 FIND v(dout1_29) AT=755.025n

.meas tran vdout1_30ck1500 FIND v(dout1_30) AT=755.025n

.meas tran vdout1_31ck1500 FIND v(dout1_31) AT=755.025n

.meas tran vdout1_32ck1500 FIND v(dout1_32) AT=755.025n

.meas tran vdout1_33ck1500 FIND v(dout1_33) AT=755.025n

.meas tran vdout1_34ck1500 FIND v(dout1_34) AT=755.025n

.meas tran vdout1_35ck1500 FIND v(dout1_35) AT=755.025n

.meas tran vdout1_36ck1500 FIND v(dout1_36) AT=755.025n

.meas tran vdout1_37ck1500 FIND v(dout1_37) AT=755.025n

.meas tran vdout1_38ck1500 FIND v(dout1_38) AT=755.025n

.meas tran vdout1_39ck1500 FIND v(dout1_39) AT=755.025n

.meas tran vdout1_40ck1500 FIND v(dout1_40) AT=755.025n

.meas tran vdout1_41ck1500 FIND v(dout1_41) AT=755.025n

.meas tran vdout1_42ck1500 FIND v(dout1_42) AT=755.025n

.meas tran vdout1_43ck1500 FIND v(dout1_43) AT=755.025n

.meas tran vdout1_44ck1500 FIND v(dout1_44) AT=755.025n

.meas tran vdout1_45ck1500 FIND v(dout1_45) AT=755.025n

.meas tran vdout1_46ck1500 FIND v(dout1_46) AT=755.025n

.meas tran vdout1_47ck1500 FIND v(dout1_47) AT=755.025n

.meas tran vdout1_48ck1500 FIND v(dout1_48) AT=755.025n

.meas tran vdout1_49ck1500 FIND v(dout1_49) AT=755.025n

.meas tran vdout1_50ck1500 FIND v(dout1_50) AT=755.025n

.meas tran vdout1_51ck1500 FIND v(dout1_51) AT=755.025n

.meas tran vdout1_52ck1500 FIND v(dout1_52) AT=755.025n

.meas tran vdout1_53ck1500 FIND v(dout1_53) AT=755.025n

.meas tran vdout1_54ck1500 FIND v(dout1_54) AT=755.025n

.meas tran vdout1_55ck1500 FIND v(dout1_55) AT=755.025n

.meas tran vdout1_56ck1500 FIND v(dout1_56) AT=755.025n

.meas tran vdout1_57ck1500 FIND v(dout1_57) AT=755.025n

.meas tran vdout1_58ck1500 FIND v(dout1_58) AT=755.025n

.meas tran vdout1_59ck1500 FIND v(dout1_59) AT=755.025n

.meas tran vdout1_60ck1500 FIND v(dout1_60) AT=755.025n

.meas tran vdout1_61ck1500 FIND v(dout1_61) AT=755.025n

.meas tran vdout1_62ck1500 FIND v(dout1_62) AT=755.025n

.meas tran vdout1_63ck1500 FIND v(dout1_63) AT=755.025n

.meas tran vdout1_0ck1510 FIND v(dout1_0) AT=760.025n

.meas tran vdout1_1ck1510 FIND v(dout1_1) AT=760.025n

.meas tran vdout1_2ck1510 FIND v(dout1_2) AT=760.025n

.meas tran vdout1_3ck1510 FIND v(dout1_3) AT=760.025n

.meas tran vdout1_4ck1510 FIND v(dout1_4) AT=760.025n

.meas tran vdout1_5ck1510 FIND v(dout1_5) AT=760.025n

.meas tran vdout1_6ck1510 FIND v(dout1_6) AT=760.025n

.meas tran vdout1_7ck1510 FIND v(dout1_7) AT=760.025n

.meas tran vdout1_8ck1510 FIND v(dout1_8) AT=760.025n

.meas tran vdout1_9ck1510 FIND v(dout1_9) AT=760.025n

.meas tran vdout1_10ck1510 FIND v(dout1_10) AT=760.025n

.meas tran vdout1_11ck1510 FIND v(dout1_11) AT=760.025n

.meas tran vdout1_12ck1510 FIND v(dout1_12) AT=760.025n

.meas tran vdout1_13ck1510 FIND v(dout1_13) AT=760.025n

.meas tran vdout1_14ck1510 FIND v(dout1_14) AT=760.025n

.meas tran vdout1_15ck1510 FIND v(dout1_15) AT=760.025n

.meas tran vdout1_16ck1510 FIND v(dout1_16) AT=760.025n

.meas tran vdout1_17ck1510 FIND v(dout1_17) AT=760.025n

.meas tran vdout1_18ck1510 FIND v(dout1_18) AT=760.025n

.meas tran vdout1_19ck1510 FIND v(dout1_19) AT=760.025n

.meas tran vdout1_20ck1510 FIND v(dout1_20) AT=760.025n

.meas tran vdout1_21ck1510 FIND v(dout1_21) AT=760.025n

.meas tran vdout1_22ck1510 FIND v(dout1_22) AT=760.025n

.meas tran vdout1_23ck1510 FIND v(dout1_23) AT=760.025n

.meas tran vdout1_24ck1510 FIND v(dout1_24) AT=760.025n

.meas tran vdout1_25ck1510 FIND v(dout1_25) AT=760.025n

.meas tran vdout1_26ck1510 FIND v(dout1_26) AT=760.025n

.meas tran vdout1_27ck1510 FIND v(dout1_27) AT=760.025n

.meas tran vdout1_28ck1510 FIND v(dout1_28) AT=760.025n

.meas tran vdout1_29ck1510 FIND v(dout1_29) AT=760.025n

.meas tran vdout1_30ck1510 FIND v(dout1_30) AT=760.025n

.meas tran vdout1_31ck1510 FIND v(dout1_31) AT=760.025n

.meas tran vdout1_32ck1510 FIND v(dout1_32) AT=760.025n

.meas tran vdout1_33ck1510 FIND v(dout1_33) AT=760.025n

.meas tran vdout1_34ck1510 FIND v(dout1_34) AT=760.025n

.meas tran vdout1_35ck1510 FIND v(dout1_35) AT=760.025n

.meas tran vdout1_36ck1510 FIND v(dout1_36) AT=760.025n

.meas tran vdout1_37ck1510 FIND v(dout1_37) AT=760.025n

.meas tran vdout1_38ck1510 FIND v(dout1_38) AT=760.025n

.meas tran vdout1_39ck1510 FIND v(dout1_39) AT=760.025n

.meas tran vdout1_40ck1510 FIND v(dout1_40) AT=760.025n

.meas tran vdout1_41ck1510 FIND v(dout1_41) AT=760.025n

.meas tran vdout1_42ck1510 FIND v(dout1_42) AT=760.025n

.meas tran vdout1_43ck1510 FIND v(dout1_43) AT=760.025n

.meas tran vdout1_44ck1510 FIND v(dout1_44) AT=760.025n

.meas tran vdout1_45ck1510 FIND v(dout1_45) AT=760.025n

.meas tran vdout1_46ck1510 FIND v(dout1_46) AT=760.025n

.meas tran vdout1_47ck1510 FIND v(dout1_47) AT=760.025n

.meas tran vdout1_48ck1510 FIND v(dout1_48) AT=760.025n

.meas tran vdout1_49ck1510 FIND v(dout1_49) AT=760.025n

.meas tran vdout1_50ck1510 FIND v(dout1_50) AT=760.025n

.meas tran vdout1_51ck1510 FIND v(dout1_51) AT=760.025n

.meas tran vdout1_52ck1510 FIND v(dout1_52) AT=760.025n

.meas tran vdout1_53ck1510 FIND v(dout1_53) AT=760.025n

.meas tran vdout1_54ck1510 FIND v(dout1_54) AT=760.025n

.meas tran vdout1_55ck1510 FIND v(dout1_55) AT=760.025n

.meas tran vdout1_56ck1510 FIND v(dout1_56) AT=760.025n

.meas tran vdout1_57ck1510 FIND v(dout1_57) AT=760.025n

.meas tran vdout1_58ck1510 FIND v(dout1_58) AT=760.025n

.meas tran vdout1_59ck1510 FIND v(dout1_59) AT=760.025n

.meas tran vdout1_60ck1510 FIND v(dout1_60) AT=760.025n

.meas tran vdout1_61ck1510 FIND v(dout1_61) AT=760.025n

.meas tran vdout1_62ck1510 FIND v(dout1_62) AT=760.025n

.meas tran vdout1_63ck1510 FIND v(dout1_63) AT=760.025n

.meas tran vdout0_0ck1520 FIND v(dout0_0) AT=765.025n

.meas tran vdout0_1ck1520 FIND v(dout0_1) AT=765.025n

.meas tran vdout0_2ck1520 FIND v(dout0_2) AT=765.025n

.meas tran vdout0_3ck1520 FIND v(dout0_3) AT=765.025n

.meas tran vdout0_4ck1520 FIND v(dout0_4) AT=765.025n

.meas tran vdout0_5ck1520 FIND v(dout0_5) AT=765.025n

.meas tran vdout0_6ck1520 FIND v(dout0_6) AT=765.025n

.meas tran vdout0_7ck1520 FIND v(dout0_7) AT=765.025n

.meas tran vdout0_8ck1520 FIND v(dout0_8) AT=765.025n

.meas tran vdout0_9ck1520 FIND v(dout0_9) AT=765.025n

.meas tran vdout0_10ck1520 FIND v(dout0_10) AT=765.025n

.meas tran vdout0_11ck1520 FIND v(dout0_11) AT=765.025n

.meas tran vdout0_12ck1520 FIND v(dout0_12) AT=765.025n

.meas tran vdout0_13ck1520 FIND v(dout0_13) AT=765.025n

.meas tran vdout0_14ck1520 FIND v(dout0_14) AT=765.025n

.meas tran vdout0_15ck1520 FIND v(dout0_15) AT=765.025n

.meas tran vdout0_16ck1520 FIND v(dout0_16) AT=765.025n

.meas tran vdout0_17ck1520 FIND v(dout0_17) AT=765.025n

.meas tran vdout0_18ck1520 FIND v(dout0_18) AT=765.025n

.meas tran vdout0_19ck1520 FIND v(dout0_19) AT=765.025n

.meas tran vdout0_20ck1520 FIND v(dout0_20) AT=765.025n

.meas tran vdout0_21ck1520 FIND v(dout0_21) AT=765.025n

.meas tran vdout0_22ck1520 FIND v(dout0_22) AT=765.025n

.meas tran vdout0_23ck1520 FIND v(dout0_23) AT=765.025n

.meas tran vdout0_24ck1520 FIND v(dout0_24) AT=765.025n

.meas tran vdout0_25ck1520 FIND v(dout0_25) AT=765.025n

.meas tran vdout0_26ck1520 FIND v(dout0_26) AT=765.025n

.meas tran vdout0_27ck1520 FIND v(dout0_27) AT=765.025n

.meas tran vdout0_28ck1520 FIND v(dout0_28) AT=765.025n

.meas tran vdout0_29ck1520 FIND v(dout0_29) AT=765.025n

.meas tran vdout0_30ck1520 FIND v(dout0_30) AT=765.025n

.meas tran vdout0_31ck1520 FIND v(dout0_31) AT=765.025n

.meas tran vdout0_32ck1520 FIND v(dout0_32) AT=765.025n

.meas tran vdout0_33ck1520 FIND v(dout0_33) AT=765.025n

.meas tran vdout0_34ck1520 FIND v(dout0_34) AT=765.025n

.meas tran vdout0_35ck1520 FIND v(dout0_35) AT=765.025n

.meas tran vdout0_36ck1520 FIND v(dout0_36) AT=765.025n

.meas tran vdout0_37ck1520 FIND v(dout0_37) AT=765.025n

.meas tran vdout0_38ck1520 FIND v(dout0_38) AT=765.025n

.meas tran vdout0_39ck1520 FIND v(dout0_39) AT=765.025n

.meas tran vdout0_40ck1520 FIND v(dout0_40) AT=765.025n

.meas tran vdout0_41ck1520 FIND v(dout0_41) AT=765.025n

.meas tran vdout0_42ck1520 FIND v(dout0_42) AT=765.025n

.meas tran vdout0_43ck1520 FIND v(dout0_43) AT=765.025n

.meas tran vdout0_44ck1520 FIND v(dout0_44) AT=765.025n

.meas tran vdout0_45ck1520 FIND v(dout0_45) AT=765.025n

.meas tran vdout0_46ck1520 FIND v(dout0_46) AT=765.025n

.meas tran vdout0_47ck1520 FIND v(dout0_47) AT=765.025n

.meas tran vdout0_48ck1520 FIND v(dout0_48) AT=765.025n

.meas tran vdout0_49ck1520 FIND v(dout0_49) AT=765.025n

.meas tran vdout0_50ck1520 FIND v(dout0_50) AT=765.025n

.meas tran vdout0_51ck1520 FIND v(dout0_51) AT=765.025n

.meas tran vdout0_52ck1520 FIND v(dout0_52) AT=765.025n

.meas tran vdout0_53ck1520 FIND v(dout0_53) AT=765.025n

.meas tran vdout0_54ck1520 FIND v(dout0_54) AT=765.025n

.meas tran vdout0_55ck1520 FIND v(dout0_55) AT=765.025n

.meas tran vdout0_56ck1520 FIND v(dout0_56) AT=765.025n

.meas tran vdout0_57ck1520 FIND v(dout0_57) AT=765.025n

.meas tran vdout0_58ck1520 FIND v(dout0_58) AT=765.025n

.meas tran vdout0_59ck1520 FIND v(dout0_59) AT=765.025n

.meas tran vdout0_60ck1520 FIND v(dout0_60) AT=765.025n

.meas tran vdout0_61ck1520 FIND v(dout0_61) AT=765.025n

.meas tran vdout0_62ck1520 FIND v(dout0_62) AT=765.025n

.meas tran vdout0_63ck1520 FIND v(dout0_63) AT=765.025n

.meas tran vdout0_0ck1530 FIND v(dout0_0) AT=770.025n

.meas tran vdout0_1ck1530 FIND v(dout0_1) AT=770.025n

.meas tran vdout0_2ck1530 FIND v(dout0_2) AT=770.025n

.meas tran vdout0_3ck1530 FIND v(dout0_3) AT=770.025n

.meas tran vdout0_4ck1530 FIND v(dout0_4) AT=770.025n

.meas tran vdout0_5ck1530 FIND v(dout0_5) AT=770.025n

.meas tran vdout0_6ck1530 FIND v(dout0_6) AT=770.025n

.meas tran vdout0_7ck1530 FIND v(dout0_7) AT=770.025n

.meas tran vdout0_8ck1530 FIND v(dout0_8) AT=770.025n

.meas tran vdout0_9ck1530 FIND v(dout0_9) AT=770.025n

.meas tran vdout0_10ck1530 FIND v(dout0_10) AT=770.025n

.meas tran vdout0_11ck1530 FIND v(dout0_11) AT=770.025n

.meas tran vdout0_12ck1530 FIND v(dout0_12) AT=770.025n

.meas tran vdout0_13ck1530 FIND v(dout0_13) AT=770.025n

.meas tran vdout0_14ck1530 FIND v(dout0_14) AT=770.025n

.meas tran vdout0_15ck1530 FIND v(dout0_15) AT=770.025n

.meas tran vdout0_16ck1530 FIND v(dout0_16) AT=770.025n

.meas tran vdout0_17ck1530 FIND v(dout0_17) AT=770.025n

.meas tran vdout0_18ck1530 FIND v(dout0_18) AT=770.025n

.meas tran vdout0_19ck1530 FIND v(dout0_19) AT=770.025n

.meas tran vdout0_20ck1530 FIND v(dout0_20) AT=770.025n

.meas tran vdout0_21ck1530 FIND v(dout0_21) AT=770.025n

.meas tran vdout0_22ck1530 FIND v(dout0_22) AT=770.025n

.meas tran vdout0_23ck1530 FIND v(dout0_23) AT=770.025n

.meas tran vdout0_24ck1530 FIND v(dout0_24) AT=770.025n

.meas tran vdout0_25ck1530 FIND v(dout0_25) AT=770.025n

.meas tran vdout0_26ck1530 FIND v(dout0_26) AT=770.025n

.meas tran vdout0_27ck1530 FIND v(dout0_27) AT=770.025n

.meas tran vdout0_28ck1530 FIND v(dout0_28) AT=770.025n

.meas tran vdout0_29ck1530 FIND v(dout0_29) AT=770.025n

.meas tran vdout0_30ck1530 FIND v(dout0_30) AT=770.025n

.meas tran vdout0_31ck1530 FIND v(dout0_31) AT=770.025n

.meas tran vdout0_32ck1530 FIND v(dout0_32) AT=770.025n

.meas tran vdout0_33ck1530 FIND v(dout0_33) AT=770.025n

.meas tran vdout0_34ck1530 FIND v(dout0_34) AT=770.025n

.meas tran vdout0_35ck1530 FIND v(dout0_35) AT=770.025n

.meas tran vdout0_36ck1530 FIND v(dout0_36) AT=770.025n

.meas tran vdout0_37ck1530 FIND v(dout0_37) AT=770.025n

.meas tran vdout0_38ck1530 FIND v(dout0_38) AT=770.025n

.meas tran vdout0_39ck1530 FIND v(dout0_39) AT=770.025n

.meas tran vdout0_40ck1530 FIND v(dout0_40) AT=770.025n

.meas tran vdout0_41ck1530 FIND v(dout0_41) AT=770.025n

.meas tran vdout0_42ck1530 FIND v(dout0_42) AT=770.025n

.meas tran vdout0_43ck1530 FIND v(dout0_43) AT=770.025n

.meas tran vdout0_44ck1530 FIND v(dout0_44) AT=770.025n

.meas tran vdout0_45ck1530 FIND v(dout0_45) AT=770.025n

.meas tran vdout0_46ck1530 FIND v(dout0_46) AT=770.025n

.meas tran vdout0_47ck1530 FIND v(dout0_47) AT=770.025n

.meas tran vdout0_48ck1530 FIND v(dout0_48) AT=770.025n

.meas tran vdout0_49ck1530 FIND v(dout0_49) AT=770.025n

.meas tran vdout0_50ck1530 FIND v(dout0_50) AT=770.025n

.meas tran vdout0_51ck1530 FIND v(dout0_51) AT=770.025n

.meas tran vdout0_52ck1530 FIND v(dout0_52) AT=770.025n

.meas tran vdout0_53ck1530 FIND v(dout0_53) AT=770.025n

.meas tran vdout0_54ck1530 FIND v(dout0_54) AT=770.025n

.meas tran vdout0_55ck1530 FIND v(dout0_55) AT=770.025n

.meas tran vdout0_56ck1530 FIND v(dout0_56) AT=770.025n

.meas tran vdout0_57ck1530 FIND v(dout0_57) AT=770.025n

.meas tran vdout0_58ck1530 FIND v(dout0_58) AT=770.025n

.meas tran vdout0_59ck1530 FIND v(dout0_59) AT=770.025n

.meas tran vdout0_60ck1530 FIND v(dout0_60) AT=770.025n

.meas tran vdout0_61ck1530 FIND v(dout0_61) AT=770.025n

.meas tran vdout0_62ck1530 FIND v(dout0_62) AT=770.025n

.meas tran vdout0_63ck1530 FIND v(dout0_63) AT=770.025n

.meas tran vdout0_0ck1550 FIND v(dout0_0) AT=780.025n

.meas tran vdout0_1ck1550 FIND v(dout0_1) AT=780.025n

.meas tran vdout0_2ck1550 FIND v(dout0_2) AT=780.025n

.meas tran vdout0_3ck1550 FIND v(dout0_3) AT=780.025n

.meas tran vdout0_4ck1550 FIND v(dout0_4) AT=780.025n

.meas tran vdout0_5ck1550 FIND v(dout0_5) AT=780.025n

.meas tran vdout0_6ck1550 FIND v(dout0_6) AT=780.025n

.meas tran vdout0_7ck1550 FIND v(dout0_7) AT=780.025n

.meas tran vdout0_8ck1550 FIND v(dout0_8) AT=780.025n

.meas tran vdout0_9ck1550 FIND v(dout0_9) AT=780.025n

.meas tran vdout0_10ck1550 FIND v(dout0_10) AT=780.025n

.meas tran vdout0_11ck1550 FIND v(dout0_11) AT=780.025n

.meas tran vdout0_12ck1550 FIND v(dout0_12) AT=780.025n

.meas tran vdout0_13ck1550 FIND v(dout0_13) AT=780.025n

.meas tran vdout0_14ck1550 FIND v(dout0_14) AT=780.025n

.meas tran vdout0_15ck1550 FIND v(dout0_15) AT=780.025n

.meas tran vdout0_16ck1550 FIND v(dout0_16) AT=780.025n

.meas tran vdout0_17ck1550 FIND v(dout0_17) AT=780.025n

.meas tran vdout0_18ck1550 FIND v(dout0_18) AT=780.025n

.meas tran vdout0_19ck1550 FIND v(dout0_19) AT=780.025n

.meas tran vdout0_20ck1550 FIND v(dout0_20) AT=780.025n

.meas tran vdout0_21ck1550 FIND v(dout0_21) AT=780.025n

.meas tran vdout0_22ck1550 FIND v(dout0_22) AT=780.025n

.meas tran vdout0_23ck1550 FIND v(dout0_23) AT=780.025n

.meas tran vdout0_24ck1550 FIND v(dout0_24) AT=780.025n

.meas tran vdout0_25ck1550 FIND v(dout0_25) AT=780.025n

.meas tran vdout0_26ck1550 FIND v(dout0_26) AT=780.025n

.meas tran vdout0_27ck1550 FIND v(dout0_27) AT=780.025n

.meas tran vdout0_28ck1550 FIND v(dout0_28) AT=780.025n

.meas tran vdout0_29ck1550 FIND v(dout0_29) AT=780.025n

.meas tran vdout0_30ck1550 FIND v(dout0_30) AT=780.025n

.meas tran vdout0_31ck1550 FIND v(dout0_31) AT=780.025n

.meas tran vdout0_32ck1550 FIND v(dout0_32) AT=780.025n

.meas tran vdout0_33ck1550 FIND v(dout0_33) AT=780.025n

.meas tran vdout0_34ck1550 FIND v(dout0_34) AT=780.025n

.meas tran vdout0_35ck1550 FIND v(dout0_35) AT=780.025n

.meas tran vdout0_36ck1550 FIND v(dout0_36) AT=780.025n

.meas tran vdout0_37ck1550 FIND v(dout0_37) AT=780.025n

.meas tran vdout0_38ck1550 FIND v(dout0_38) AT=780.025n

.meas tran vdout0_39ck1550 FIND v(dout0_39) AT=780.025n

.meas tran vdout0_40ck1550 FIND v(dout0_40) AT=780.025n

.meas tran vdout0_41ck1550 FIND v(dout0_41) AT=780.025n

.meas tran vdout0_42ck1550 FIND v(dout0_42) AT=780.025n

.meas tran vdout0_43ck1550 FIND v(dout0_43) AT=780.025n

.meas tran vdout0_44ck1550 FIND v(dout0_44) AT=780.025n

.meas tran vdout0_45ck1550 FIND v(dout0_45) AT=780.025n

.meas tran vdout0_46ck1550 FIND v(dout0_46) AT=780.025n

.meas tran vdout0_47ck1550 FIND v(dout0_47) AT=780.025n

.meas tran vdout0_48ck1550 FIND v(dout0_48) AT=780.025n

.meas tran vdout0_49ck1550 FIND v(dout0_49) AT=780.025n

.meas tran vdout0_50ck1550 FIND v(dout0_50) AT=780.025n

.meas tran vdout0_51ck1550 FIND v(dout0_51) AT=780.025n

.meas tran vdout0_52ck1550 FIND v(dout0_52) AT=780.025n

.meas tran vdout0_53ck1550 FIND v(dout0_53) AT=780.025n

.meas tran vdout0_54ck1550 FIND v(dout0_54) AT=780.025n

.meas tran vdout0_55ck1550 FIND v(dout0_55) AT=780.025n

.meas tran vdout0_56ck1550 FIND v(dout0_56) AT=780.025n

.meas tran vdout0_57ck1550 FIND v(dout0_57) AT=780.025n

.meas tran vdout0_58ck1550 FIND v(dout0_58) AT=780.025n

.meas tran vdout0_59ck1550 FIND v(dout0_59) AT=780.025n

.meas tran vdout0_60ck1550 FIND v(dout0_60) AT=780.025n

.meas tran vdout0_61ck1550 FIND v(dout0_61) AT=780.025n

.meas tran vdout0_62ck1550 FIND v(dout0_62) AT=780.025n

.meas tran vdout0_63ck1550 FIND v(dout0_63) AT=780.025n

.meas tran vdout1_0ck1550 FIND v(dout1_0) AT=780.025n

.meas tran vdout1_1ck1550 FIND v(dout1_1) AT=780.025n

.meas tran vdout1_2ck1550 FIND v(dout1_2) AT=780.025n

.meas tran vdout1_3ck1550 FIND v(dout1_3) AT=780.025n

.meas tran vdout1_4ck1550 FIND v(dout1_4) AT=780.025n

.meas tran vdout1_5ck1550 FIND v(dout1_5) AT=780.025n

.meas tran vdout1_6ck1550 FIND v(dout1_6) AT=780.025n

.meas tran vdout1_7ck1550 FIND v(dout1_7) AT=780.025n

.meas tran vdout1_8ck1550 FIND v(dout1_8) AT=780.025n

.meas tran vdout1_9ck1550 FIND v(dout1_9) AT=780.025n

.meas tran vdout1_10ck1550 FIND v(dout1_10) AT=780.025n

.meas tran vdout1_11ck1550 FIND v(dout1_11) AT=780.025n

.meas tran vdout1_12ck1550 FIND v(dout1_12) AT=780.025n

.meas tran vdout1_13ck1550 FIND v(dout1_13) AT=780.025n

.meas tran vdout1_14ck1550 FIND v(dout1_14) AT=780.025n

.meas tran vdout1_15ck1550 FIND v(dout1_15) AT=780.025n

.meas tran vdout1_16ck1550 FIND v(dout1_16) AT=780.025n

.meas tran vdout1_17ck1550 FIND v(dout1_17) AT=780.025n

.meas tran vdout1_18ck1550 FIND v(dout1_18) AT=780.025n

.meas tran vdout1_19ck1550 FIND v(dout1_19) AT=780.025n

.meas tran vdout1_20ck1550 FIND v(dout1_20) AT=780.025n

.meas tran vdout1_21ck1550 FIND v(dout1_21) AT=780.025n

.meas tran vdout1_22ck1550 FIND v(dout1_22) AT=780.025n

.meas tran vdout1_23ck1550 FIND v(dout1_23) AT=780.025n

.meas tran vdout1_24ck1550 FIND v(dout1_24) AT=780.025n

.meas tran vdout1_25ck1550 FIND v(dout1_25) AT=780.025n

.meas tran vdout1_26ck1550 FIND v(dout1_26) AT=780.025n

.meas tran vdout1_27ck1550 FIND v(dout1_27) AT=780.025n

.meas tran vdout1_28ck1550 FIND v(dout1_28) AT=780.025n

.meas tran vdout1_29ck1550 FIND v(dout1_29) AT=780.025n

.meas tran vdout1_30ck1550 FIND v(dout1_30) AT=780.025n

.meas tran vdout1_31ck1550 FIND v(dout1_31) AT=780.025n

.meas tran vdout1_32ck1550 FIND v(dout1_32) AT=780.025n

.meas tran vdout1_33ck1550 FIND v(dout1_33) AT=780.025n

.meas tran vdout1_34ck1550 FIND v(dout1_34) AT=780.025n

.meas tran vdout1_35ck1550 FIND v(dout1_35) AT=780.025n

.meas tran vdout1_36ck1550 FIND v(dout1_36) AT=780.025n

.meas tran vdout1_37ck1550 FIND v(dout1_37) AT=780.025n

.meas tran vdout1_38ck1550 FIND v(dout1_38) AT=780.025n

.meas tran vdout1_39ck1550 FIND v(dout1_39) AT=780.025n

.meas tran vdout1_40ck1550 FIND v(dout1_40) AT=780.025n

.meas tran vdout1_41ck1550 FIND v(dout1_41) AT=780.025n

.meas tran vdout1_42ck1550 FIND v(dout1_42) AT=780.025n

.meas tran vdout1_43ck1550 FIND v(dout1_43) AT=780.025n

.meas tran vdout1_44ck1550 FIND v(dout1_44) AT=780.025n

.meas tran vdout1_45ck1550 FIND v(dout1_45) AT=780.025n

.meas tran vdout1_46ck1550 FIND v(dout1_46) AT=780.025n

.meas tran vdout1_47ck1550 FIND v(dout1_47) AT=780.025n

.meas tran vdout1_48ck1550 FIND v(dout1_48) AT=780.025n

.meas tran vdout1_49ck1550 FIND v(dout1_49) AT=780.025n

.meas tran vdout1_50ck1550 FIND v(dout1_50) AT=780.025n

.meas tran vdout1_51ck1550 FIND v(dout1_51) AT=780.025n

.meas tran vdout1_52ck1550 FIND v(dout1_52) AT=780.025n

.meas tran vdout1_53ck1550 FIND v(dout1_53) AT=780.025n

.meas tran vdout1_54ck1550 FIND v(dout1_54) AT=780.025n

.meas tran vdout1_55ck1550 FIND v(dout1_55) AT=780.025n

.meas tran vdout1_56ck1550 FIND v(dout1_56) AT=780.025n

.meas tran vdout1_57ck1550 FIND v(dout1_57) AT=780.025n

.meas tran vdout1_58ck1550 FIND v(dout1_58) AT=780.025n

.meas tran vdout1_59ck1550 FIND v(dout1_59) AT=780.025n

.meas tran vdout1_60ck1550 FIND v(dout1_60) AT=780.025n

.meas tran vdout1_61ck1550 FIND v(dout1_61) AT=780.025n

.meas tran vdout1_62ck1550 FIND v(dout1_62) AT=780.025n

.meas tran vdout1_63ck1550 FIND v(dout1_63) AT=780.025n

.meas tran vdout0_0ck1570 FIND v(dout0_0) AT=790.025n

.meas tran vdout0_1ck1570 FIND v(dout0_1) AT=790.025n

.meas tran vdout0_2ck1570 FIND v(dout0_2) AT=790.025n

.meas tran vdout0_3ck1570 FIND v(dout0_3) AT=790.025n

.meas tran vdout0_4ck1570 FIND v(dout0_4) AT=790.025n

.meas tran vdout0_5ck1570 FIND v(dout0_5) AT=790.025n

.meas tran vdout0_6ck1570 FIND v(dout0_6) AT=790.025n

.meas tran vdout0_7ck1570 FIND v(dout0_7) AT=790.025n

.meas tran vdout0_8ck1570 FIND v(dout0_8) AT=790.025n

.meas tran vdout0_9ck1570 FIND v(dout0_9) AT=790.025n

.meas tran vdout0_10ck1570 FIND v(dout0_10) AT=790.025n

.meas tran vdout0_11ck1570 FIND v(dout0_11) AT=790.025n

.meas tran vdout0_12ck1570 FIND v(dout0_12) AT=790.025n

.meas tran vdout0_13ck1570 FIND v(dout0_13) AT=790.025n

.meas tran vdout0_14ck1570 FIND v(dout0_14) AT=790.025n

.meas tran vdout0_15ck1570 FIND v(dout0_15) AT=790.025n

.meas tran vdout0_16ck1570 FIND v(dout0_16) AT=790.025n

.meas tran vdout0_17ck1570 FIND v(dout0_17) AT=790.025n

.meas tran vdout0_18ck1570 FIND v(dout0_18) AT=790.025n

.meas tran vdout0_19ck1570 FIND v(dout0_19) AT=790.025n

.meas tran vdout0_20ck1570 FIND v(dout0_20) AT=790.025n

.meas tran vdout0_21ck1570 FIND v(dout0_21) AT=790.025n

.meas tran vdout0_22ck1570 FIND v(dout0_22) AT=790.025n

.meas tran vdout0_23ck1570 FIND v(dout0_23) AT=790.025n

.meas tran vdout0_24ck1570 FIND v(dout0_24) AT=790.025n

.meas tran vdout0_25ck1570 FIND v(dout0_25) AT=790.025n

.meas tran vdout0_26ck1570 FIND v(dout0_26) AT=790.025n

.meas tran vdout0_27ck1570 FIND v(dout0_27) AT=790.025n

.meas tran vdout0_28ck1570 FIND v(dout0_28) AT=790.025n

.meas tran vdout0_29ck1570 FIND v(dout0_29) AT=790.025n

.meas tran vdout0_30ck1570 FIND v(dout0_30) AT=790.025n

.meas tran vdout0_31ck1570 FIND v(dout0_31) AT=790.025n

.meas tran vdout0_32ck1570 FIND v(dout0_32) AT=790.025n

.meas tran vdout0_33ck1570 FIND v(dout0_33) AT=790.025n

.meas tran vdout0_34ck1570 FIND v(dout0_34) AT=790.025n

.meas tran vdout0_35ck1570 FIND v(dout0_35) AT=790.025n

.meas tran vdout0_36ck1570 FIND v(dout0_36) AT=790.025n

.meas tran vdout0_37ck1570 FIND v(dout0_37) AT=790.025n

.meas tran vdout0_38ck1570 FIND v(dout0_38) AT=790.025n

.meas tran vdout0_39ck1570 FIND v(dout0_39) AT=790.025n

.meas tran vdout0_40ck1570 FIND v(dout0_40) AT=790.025n

.meas tran vdout0_41ck1570 FIND v(dout0_41) AT=790.025n

.meas tran vdout0_42ck1570 FIND v(dout0_42) AT=790.025n

.meas tran vdout0_43ck1570 FIND v(dout0_43) AT=790.025n

.meas tran vdout0_44ck1570 FIND v(dout0_44) AT=790.025n

.meas tran vdout0_45ck1570 FIND v(dout0_45) AT=790.025n

.meas tran vdout0_46ck1570 FIND v(dout0_46) AT=790.025n

.meas tran vdout0_47ck1570 FIND v(dout0_47) AT=790.025n

.meas tran vdout0_48ck1570 FIND v(dout0_48) AT=790.025n

.meas tran vdout0_49ck1570 FIND v(dout0_49) AT=790.025n

.meas tran vdout0_50ck1570 FIND v(dout0_50) AT=790.025n

.meas tran vdout0_51ck1570 FIND v(dout0_51) AT=790.025n

.meas tran vdout0_52ck1570 FIND v(dout0_52) AT=790.025n

.meas tran vdout0_53ck1570 FIND v(dout0_53) AT=790.025n

.meas tran vdout0_54ck1570 FIND v(dout0_54) AT=790.025n

.meas tran vdout0_55ck1570 FIND v(dout0_55) AT=790.025n

.meas tran vdout0_56ck1570 FIND v(dout0_56) AT=790.025n

.meas tran vdout0_57ck1570 FIND v(dout0_57) AT=790.025n

.meas tran vdout0_58ck1570 FIND v(dout0_58) AT=790.025n

.meas tran vdout0_59ck1570 FIND v(dout0_59) AT=790.025n

.meas tran vdout0_60ck1570 FIND v(dout0_60) AT=790.025n

.meas tran vdout0_61ck1570 FIND v(dout0_61) AT=790.025n

.meas tran vdout0_62ck1570 FIND v(dout0_62) AT=790.025n

.meas tran vdout0_63ck1570 FIND v(dout0_63) AT=790.025n

.meas tran vdout0_0ck1580 FIND v(dout0_0) AT=795.025n

.meas tran vdout0_1ck1580 FIND v(dout0_1) AT=795.025n

.meas tran vdout0_2ck1580 FIND v(dout0_2) AT=795.025n

.meas tran vdout0_3ck1580 FIND v(dout0_3) AT=795.025n

.meas tran vdout0_4ck1580 FIND v(dout0_4) AT=795.025n

.meas tran vdout0_5ck1580 FIND v(dout0_5) AT=795.025n

.meas tran vdout0_6ck1580 FIND v(dout0_6) AT=795.025n

.meas tran vdout0_7ck1580 FIND v(dout0_7) AT=795.025n

.meas tran vdout0_8ck1580 FIND v(dout0_8) AT=795.025n

.meas tran vdout0_9ck1580 FIND v(dout0_9) AT=795.025n

.meas tran vdout0_10ck1580 FIND v(dout0_10) AT=795.025n

.meas tran vdout0_11ck1580 FIND v(dout0_11) AT=795.025n

.meas tran vdout0_12ck1580 FIND v(dout0_12) AT=795.025n

.meas tran vdout0_13ck1580 FIND v(dout0_13) AT=795.025n

.meas tran vdout0_14ck1580 FIND v(dout0_14) AT=795.025n

.meas tran vdout0_15ck1580 FIND v(dout0_15) AT=795.025n

.meas tran vdout0_16ck1580 FIND v(dout0_16) AT=795.025n

.meas tran vdout0_17ck1580 FIND v(dout0_17) AT=795.025n

.meas tran vdout0_18ck1580 FIND v(dout0_18) AT=795.025n

.meas tran vdout0_19ck1580 FIND v(dout0_19) AT=795.025n

.meas tran vdout0_20ck1580 FIND v(dout0_20) AT=795.025n

.meas tran vdout0_21ck1580 FIND v(dout0_21) AT=795.025n

.meas tran vdout0_22ck1580 FIND v(dout0_22) AT=795.025n

.meas tran vdout0_23ck1580 FIND v(dout0_23) AT=795.025n

.meas tran vdout0_24ck1580 FIND v(dout0_24) AT=795.025n

.meas tran vdout0_25ck1580 FIND v(dout0_25) AT=795.025n

.meas tran vdout0_26ck1580 FIND v(dout0_26) AT=795.025n

.meas tran vdout0_27ck1580 FIND v(dout0_27) AT=795.025n

.meas tran vdout0_28ck1580 FIND v(dout0_28) AT=795.025n

.meas tran vdout0_29ck1580 FIND v(dout0_29) AT=795.025n

.meas tran vdout0_30ck1580 FIND v(dout0_30) AT=795.025n

.meas tran vdout0_31ck1580 FIND v(dout0_31) AT=795.025n

.meas tran vdout0_32ck1580 FIND v(dout0_32) AT=795.025n

.meas tran vdout0_33ck1580 FIND v(dout0_33) AT=795.025n

.meas tran vdout0_34ck1580 FIND v(dout0_34) AT=795.025n

.meas tran vdout0_35ck1580 FIND v(dout0_35) AT=795.025n

.meas tran vdout0_36ck1580 FIND v(dout0_36) AT=795.025n

.meas tran vdout0_37ck1580 FIND v(dout0_37) AT=795.025n

.meas tran vdout0_38ck1580 FIND v(dout0_38) AT=795.025n

.meas tran vdout0_39ck1580 FIND v(dout0_39) AT=795.025n

.meas tran vdout0_40ck1580 FIND v(dout0_40) AT=795.025n

.meas tran vdout0_41ck1580 FIND v(dout0_41) AT=795.025n

.meas tran vdout0_42ck1580 FIND v(dout0_42) AT=795.025n

.meas tran vdout0_43ck1580 FIND v(dout0_43) AT=795.025n

.meas tran vdout0_44ck1580 FIND v(dout0_44) AT=795.025n

.meas tran vdout0_45ck1580 FIND v(dout0_45) AT=795.025n

.meas tran vdout0_46ck1580 FIND v(dout0_46) AT=795.025n

.meas tran vdout0_47ck1580 FIND v(dout0_47) AT=795.025n

.meas tran vdout0_48ck1580 FIND v(dout0_48) AT=795.025n

.meas tran vdout0_49ck1580 FIND v(dout0_49) AT=795.025n

.meas tran vdout0_50ck1580 FIND v(dout0_50) AT=795.025n

.meas tran vdout0_51ck1580 FIND v(dout0_51) AT=795.025n

.meas tran vdout0_52ck1580 FIND v(dout0_52) AT=795.025n

.meas tran vdout0_53ck1580 FIND v(dout0_53) AT=795.025n

.meas tran vdout0_54ck1580 FIND v(dout0_54) AT=795.025n

.meas tran vdout0_55ck1580 FIND v(dout0_55) AT=795.025n

.meas tran vdout0_56ck1580 FIND v(dout0_56) AT=795.025n

.meas tran vdout0_57ck1580 FIND v(dout0_57) AT=795.025n

.meas tran vdout0_58ck1580 FIND v(dout0_58) AT=795.025n

.meas tran vdout0_59ck1580 FIND v(dout0_59) AT=795.025n

.meas tran vdout0_60ck1580 FIND v(dout0_60) AT=795.025n

.meas tran vdout0_61ck1580 FIND v(dout0_61) AT=795.025n

.meas tran vdout0_62ck1580 FIND v(dout0_62) AT=795.025n

.meas tran vdout0_63ck1580 FIND v(dout0_63) AT=795.025n

.meas tran vdout0_0ck1590 FIND v(dout0_0) AT=800.025n

.meas tran vdout0_1ck1590 FIND v(dout0_1) AT=800.025n

.meas tran vdout0_2ck1590 FIND v(dout0_2) AT=800.025n

.meas tran vdout0_3ck1590 FIND v(dout0_3) AT=800.025n

.meas tran vdout0_4ck1590 FIND v(dout0_4) AT=800.025n

.meas tran vdout0_5ck1590 FIND v(dout0_5) AT=800.025n

.meas tran vdout0_6ck1590 FIND v(dout0_6) AT=800.025n

.meas tran vdout0_7ck1590 FIND v(dout0_7) AT=800.025n

.meas tran vdout0_8ck1590 FIND v(dout0_8) AT=800.025n

.meas tran vdout0_9ck1590 FIND v(dout0_9) AT=800.025n

.meas tran vdout0_10ck1590 FIND v(dout0_10) AT=800.025n

.meas tran vdout0_11ck1590 FIND v(dout0_11) AT=800.025n

.meas tran vdout0_12ck1590 FIND v(dout0_12) AT=800.025n

.meas tran vdout0_13ck1590 FIND v(dout0_13) AT=800.025n

.meas tran vdout0_14ck1590 FIND v(dout0_14) AT=800.025n

.meas tran vdout0_15ck1590 FIND v(dout0_15) AT=800.025n

.meas tran vdout0_16ck1590 FIND v(dout0_16) AT=800.025n

.meas tran vdout0_17ck1590 FIND v(dout0_17) AT=800.025n

.meas tran vdout0_18ck1590 FIND v(dout0_18) AT=800.025n

.meas tran vdout0_19ck1590 FIND v(dout0_19) AT=800.025n

.meas tran vdout0_20ck1590 FIND v(dout0_20) AT=800.025n

.meas tran vdout0_21ck1590 FIND v(dout0_21) AT=800.025n

.meas tran vdout0_22ck1590 FIND v(dout0_22) AT=800.025n

.meas tran vdout0_23ck1590 FIND v(dout0_23) AT=800.025n

.meas tran vdout0_24ck1590 FIND v(dout0_24) AT=800.025n

.meas tran vdout0_25ck1590 FIND v(dout0_25) AT=800.025n

.meas tran vdout0_26ck1590 FIND v(dout0_26) AT=800.025n

.meas tran vdout0_27ck1590 FIND v(dout0_27) AT=800.025n

.meas tran vdout0_28ck1590 FIND v(dout0_28) AT=800.025n

.meas tran vdout0_29ck1590 FIND v(dout0_29) AT=800.025n

.meas tran vdout0_30ck1590 FIND v(dout0_30) AT=800.025n

.meas tran vdout0_31ck1590 FIND v(dout0_31) AT=800.025n

.meas tran vdout0_32ck1590 FIND v(dout0_32) AT=800.025n

.meas tran vdout0_33ck1590 FIND v(dout0_33) AT=800.025n

.meas tran vdout0_34ck1590 FIND v(dout0_34) AT=800.025n

.meas tran vdout0_35ck1590 FIND v(dout0_35) AT=800.025n

.meas tran vdout0_36ck1590 FIND v(dout0_36) AT=800.025n

.meas tran vdout0_37ck1590 FIND v(dout0_37) AT=800.025n

.meas tran vdout0_38ck1590 FIND v(dout0_38) AT=800.025n

.meas tran vdout0_39ck1590 FIND v(dout0_39) AT=800.025n

.meas tran vdout0_40ck1590 FIND v(dout0_40) AT=800.025n

.meas tran vdout0_41ck1590 FIND v(dout0_41) AT=800.025n

.meas tran vdout0_42ck1590 FIND v(dout0_42) AT=800.025n

.meas tran vdout0_43ck1590 FIND v(dout0_43) AT=800.025n

.meas tran vdout0_44ck1590 FIND v(dout0_44) AT=800.025n

.meas tran vdout0_45ck1590 FIND v(dout0_45) AT=800.025n

.meas tran vdout0_46ck1590 FIND v(dout0_46) AT=800.025n

.meas tran vdout0_47ck1590 FIND v(dout0_47) AT=800.025n

.meas tran vdout0_48ck1590 FIND v(dout0_48) AT=800.025n

.meas tran vdout0_49ck1590 FIND v(dout0_49) AT=800.025n

.meas tran vdout0_50ck1590 FIND v(dout0_50) AT=800.025n

.meas tran vdout0_51ck1590 FIND v(dout0_51) AT=800.025n

.meas tran vdout0_52ck1590 FIND v(dout0_52) AT=800.025n

.meas tran vdout0_53ck1590 FIND v(dout0_53) AT=800.025n

.meas tran vdout0_54ck1590 FIND v(dout0_54) AT=800.025n

.meas tran vdout0_55ck1590 FIND v(dout0_55) AT=800.025n

.meas tran vdout0_56ck1590 FIND v(dout0_56) AT=800.025n

.meas tran vdout0_57ck1590 FIND v(dout0_57) AT=800.025n

.meas tran vdout0_58ck1590 FIND v(dout0_58) AT=800.025n

.meas tran vdout0_59ck1590 FIND v(dout0_59) AT=800.025n

.meas tran vdout0_60ck1590 FIND v(dout0_60) AT=800.025n

.meas tran vdout0_61ck1590 FIND v(dout0_61) AT=800.025n

.meas tran vdout0_62ck1590 FIND v(dout0_62) AT=800.025n

.meas tran vdout0_63ck1590 FIND v(dout0_63) AT=800.025n

.meas tran vdout1_0ck1600 FIND v(dout1_0) AT=805.025n

.meas tran vdout1_1ck1600 FIND v(dout1_1) AT=805.025n

.meas tran vdout1_2ck1600 FIND v(dout1_2) AT=805.025n

.meas tran vdout1_3ck1600 FIND v(dout1_3) AT=805.025n

.meas tran vdout1_4ck1600 FIND v(dout1_4) AT=805.025n

.meas tran vdout1_5ck1600 FIND v(dout1_5) AT=805.025n

.meas tran vdout1_6ck1600 FIND v(dout1_6) AT=805.025n

.meas tran vdout1_7ck1600 FIND v(dout1_7) AT=805.025n

.meas tran vdout1_8ck1600 FIND v(dout1_8) AT=805.025n

.meas tran vdout1_9ck1600 FIND v(dout1_9) AT=805.025n

.meas tran vdout1_10ck1600 FIND v(dout1_10) AT=805.025n

.meas tran vdout1_11ck1600 FIND v(dout1_11) AT=805.025n

.meas tran vdout1_12ck1600 FIND v(dout1_12) AT=805.025n

.meas tran vdout1_13ck1600 FIND v(dout1_13) AT=805.025n

.meas tran vdout1_14ck1600 FIND v(dout1_14) AT=805.025n

.meas tran vdout1_15ck1600 FIND v(dout1_15) AT=805.025n

.meas tran vdout1_16ck1600 FIND v(dout1_16) AT=805.025n

.meas tran vdout1_17ck1600 FIND v(dout1_17) AT=805.025n

.meas tran vdout1_18ck1600 FIND v(dout1_18) AT=805.025n

.meas tran vdout1_19ck1600 FIND v(dout1_19) AT=805.025n

.meas tran vdout1_20ck1600 FIND v(dout1_20) AT=805.025n

.meas tran vdout1_21ck1600 FIND v(dout1_21) AT=805.025n

.meas tran vdout1_22ck1600 FIND v(dout1_22) AT=805.025n

.meas tran vdout1_23ck1600 FIND v(dout1_23) AT=805.025n

.meas tran vdout1_24ck1600 FIND v(dout1_24) AT=805.025n

.meas tran vdout1_25ck1600 FIND v(dout1_25) AT=805.025n

.meas tran vdout1_26ck1600 FIND v(dout1_26) AT=805.025n

.meas tran vdout1_27ck1600 FIND v(dout1_27) AT=805.025n

.meas tran vdout1_28ck1600 FIND v(dout1_28) AT=805.025n

.meas tran vdout1_29ck1600 FIND v(dout1_29) AT=805.025n

.meas tran vdout1_30ck1600 FIND v(dout1_30) AT=805.025n

.meas tran vdout1_31ck1600 FIND v(dout1_31) AT=805.025n

.meas tran vdout1_32ck1600 FIND v(dout1_32) AT=805.025n

.meas tran vdout1_33ck1600 FIND v(dout1_33) AT=805.025n

.meas tran vdout1_34ck1600 FIND v(dout1_34) AT=805.025n

.meas tran vdout1_35ck1600 FIND v(dout1_35) AT=805.025n

.meas tran vdout1_36ck1600 FIND v(dout1_36) AT=805.025n

.meas tran vdout1_37ck1600 FIND v(dout1_37) AT=805.025n

.meas tran vdout1_38ck1600 FIND v(dout1_38) AT=805.025n

.meas tran vdout1_39ck1600 FIND v(dout1_39) AT=805.025n

.meas tran vdout1_40ck1600 FIND v(dout1_40) AT=805.025n

.meas tran vdout1_41ck1600 FIND v(dout1_41) AT=805.025n

.meas tran vdout1_42ck1600 FIND v(dout1_42) AT=805.025n

.meas tran vdout1_43ck1600 FIND v(dout1_43) AT=805.025n

.meas tran vdout1_44ck1600 FIND v(dout1_44) AT=805.025n

.meas tran vdout1_45ck1600 FIND v(dout1_45) AT=805.025n

.meas tran vdout1_46ck1600 FIND v(dout1_46) AT=805.025n

.meas tran vdout1_47ck1600 FIND v(dout1_47) AT=805.025n

.meas tran vdout1_48ck1600 FIND v(dout1_48) AT=805.025n

.meas tran vdout1_49ck1600 FIND v(dout1_49) AT=805.025n

.meas tran vdout1_50ck1600 FIND v(dout1_50) AT=805.025n

.meas tran vdout1_51ck1600 FIND v(dout1_51) AT=805.025n

.meas tran vdout1_52ck1600 FIND v(dout1_52) AT=805.025n

.meas tran vdout1_53ck1600 FIND v(dout1_53) AT=805.025n

.meas tran vdout1_54ck1600 FIND v(dout1_54) AT=805.025n

.meas tran vdout1_55ck1600 FIND v(dout1_55) AT=805.025n

.meas tran vdout1_56ck1600 FIND v(dout1_56) AT=805.025n

.meas tran vdout1_57ck1600 FIND v(dout1_57) AT=805.025n

.meas tran vdout1_58ck1600 FIND v(dout1_58) AT=805.025n

.meas tran vdout1_59ck1600 FIND v(dout1_59) AT=805.025n

.meas tran vdout1_60ck1600 FIND v(dout1_60) AT=805.025n

.meas tran vdout1_61ck1600 FIND v(dout1_61) AT=805.025n

.meas tran vdout1_62ck1600 FIND v(dout1_62) AT=805.025n

.meas tran vdout1_63ck1600 FIND v(dout1_63) AT=805.025n

.meas tran vdout1_0ck1610 FIND v(dout1_0) AT=810.025n

.meas tran vdout1_1ck1610 FIND v(dout1_1) AT=810.025n

.meas tran vdout1_2ck1610 FIND v(dout1_2) AT=810.025n

.meas tran vdout1_3ck1610 FIND v(dout1_3) AT=810.025n

.meas tran vdout1_4ck1610 FIND v(dout1_4) AT=810.025n

.meas tran vdout1_5ck1610 FIND v(dout1_5) AT=810.025n

.meas tran vdout1_6ck1610 FIND v(dout1_6) AT=810.025n

.meas tran vdout1_7ck1610 FIND v(dout1_7) AT=810.025n

.meas tran vdout1_8ck1610 FIND v(dout1_8) AT=810.025n

.meas tran vdout1_9ck1610 FIND v(dout1_9) AT=810.025n

.meas tran vdout1_10ck1610 FIND v(dout1_10) AT=810.025n

.meas tran vdout1_11ck1610 FIND v(dout1_11) AT=810.025n

.meas tran vdout1_12ck1610 FIND v(dout1_12) AT=810.025n

.meas tran vdout1_13ck1610 FIND v(dout1_13) AT=810.025n

.meas tran vdout1_14ck1610 FIND v(dout1_14) AT=810.025n

.meas tran vdout1_15ck1610 FIND v(dout1_15) AT=810.025n

.meas tran vdout1_16ck1610 FIND v(dout1_16) AT=810.025n

.meas tran vdout1_17ck1610 FIND v(dout1_17) AT=810.025n

.meas tran vdout1_18ck1610 FIND v(dout1_18) AT=810.025n

.meas tran vdout1_19ck1610 FIND v(dout1_19) AT=810.025n

.meas tran vdout1_20ck1610 FIND v(dout1_20) AT=810.025n

.meas tran vdout1_21ck1610 FIND v(dout1_21) AT=810.025n

.meas tran vdout1_22ck1610 FIND v(dout1_22) AT=810.025n

.meas tran vdout1_23ck1610 FIND v(dout1_23) AT=810.025n

.meas tran vdout1_24ck1610 FIND v(dout1_24) AT=810.025n

.meas tran vdout1_25ck1610 FIND v(dout1_25) AT=810.025n

.meas tran vdout1_26ck1610 FIND v(dout1_26) AT=810.025n

.meas tran vdout1_27ck1610 FIND v(dout1_27) AT=810.025n

.meas tran vdout1_28ck1610 FIND v(dout1_28) AT=810.025n

.meas tran vdout1_29ck1610 FIND v(dout1_29) AT=810.025n

.meas tran vdout1_30ck1610 FIND v(dout1_30) AT=810.025n

.meas tran vdout1_31ck1610 FIND v(dout1_31) AT=810.025n

.meas tran vdout1_32ck1610 FIND v(dout1_32) AT=810.025n

.meas tran vdout1_33ck1610 FIND v(dout1_33) AT=810.025n

.meas tran vdout1_34ck1610 FIND v(dout1_34) AT=810.025n

.meas tran vdout1_35ck1610 FIND v(dout1_35) AT=810.025n

.meas tran vdout1_36ck1610 FIND v(dout1_36) AT=810.025n

.meas tran vdout1_37ck1610 FIND v(dout1_37) AT=810.025n

.meas tran vdout1_38ck1610 FIND v(dout1_38) AT=810.025n

.meas tran vdout1_39ck1610 FIND v(dout1_39) AT=810.025n

.meas tran vdout1_40ck1610 FIND v(dout1_40) AT=810.025n

.meas tran vdout1_41ck1610 FIND v(dout1_41) AT=810.025n

.meas tran vdout1_42ck1610 FIND v(dout1_42) AT=810.025n

.meas tran vdout1_43ck1610 FIND v(dout1_43) AT=810.025n

.meas tran vdout1_44ck1610 FIND v(dout1_44) AT=810.025n

.meas tran vdout1_45ck1610 FIND v(dout1_45) AT=810.025n

.meas tran vdout1_46ck1610 FIND v(dout1_46) AT=810.025n

.meas tran vdout1_47ck1610 FIND v(dout1_47) AT=810.025n

.meas tran vdout1_48ck1610 FIND v(dout1_48) AT=810.025n

.meas tran vdout1_49ck1610 FIND v(dout1_49) AT=810.025n

.meas tran vdout1_50ck1610 FIND v(dout1_50) AT=810.025n

.meas tran vdout1_51ck1610 FIND v(dout1_51) AT=810.025n

.meas tran vdout1_52ck1610 FIND v(dout1_52) AT=810.025n

.meas tran vdout1_53ck1610 FIND v(dout1_53) AT=810.025n

.meas tran vdout1_54ck1610 FIND v(dout1_54) AT=810.025n

.meas tran vdout1_55ck1610 FIND v(dout1_55) AT=810.025n

.meas tran vdout1_56ck1610 FIND v(dout1_56) AT=810.025n

.meas tran vdout1_57ck1610 FIND v(dout1_57) AT=810.025n

.meas tran vdout1_58ck1610 FIND v(dout1_58) AT=810.025n

.meas tran vdout1_59ck1610 FIND v(dout1_59) AT=810.025n

.meas tran vdout1_60ck1610 FIND v(dout1_60) AT=810.025n

.meas tran vdout1_61ck1610 FIND v(dout1_61) AT=810.025n

.meas tran vdout1_62ck1610 FIND v(dout1_62) AT=810.025n

.meas tran vdout1_63ck1610 FIND v(dout1_63) AT=810.025n

.meas tran vdout0_0ck1630 FIND v(dout0_0) AT=820.025n

.meas tran vdout0_1ck1630 FIND v(dout0_1) AT=820.025n

.meas tran vdout0_2ck1630 FIND v(dout0_2) AT=820.025n

.meas tran vdout0_3ck1630 FIND v(dout0_3) AT=820.025n

.meas tran vdout0_4ck1630 FIND v(dout0_4) AT=820.025n

.meas tran vdout0_5ck1630 FIND v(dout0_5) AT=820.025n

.meas tran vdout0_6ck1630 FIND v(dout0_6) AT=820.025n

.meas tran vdout0_7ck1630 FIND v(dout0_7) AT=820.025n

.meas tran vdout0_8ck1630 FIND v(dout0_8) AT=820.025n

.meas tran vdout0_9ck1630 FIND v(dout0_9) AT=820.025n

.meas tran vdout0_10ck1630 FIND v(dout0_10) AT=820.025n

.meas tran vdout0_11ck1630 FIND v(dout0_11) AT=820.025n

.meas tran vdout0_12ck1630 FIND v(dout0_12) AT=820.025n

.meas tran vdout0_13ck1630 FIND v(dout0_13) AT=820.025n

.meas tran vdout0_14ck1630 FIND v(dout0_14) AT=820.025n

.meas tran vdout0_15ck1630 FIND v(dout0_15) AT=820.025n

.meas tran vdout0_16ck1630 FIND v(dout0_16) AT=820.025n

.meas tran vdout0_17ck1630 FIND v(dout0_17) AT=820.025n

.meas tran vdout0_18ck1630 FIND v(dout0_18) AT=820.025n

.meas tran vdout0_19ck1630 FIND v(dout0_19) AT=820.025n

.meas tran vdout0_20ck1630 FIND v(dout0_20) AT=820.025n

.meas tran vdout0_21ck1630 FIND v(dout0_21) AT=820.025n

.meas tran vdout0_22ck1630 FIND v(dout0_22) AT=820.025n

.meas tran vdout0_23ck1630 FIND v(dout0_23) AT=820.025n

.meas tran vdout0_24ck1630 FIND v(dout0_24) AT=820.025n

.meas tran vdout0_25ck1630 FIND v(dout0_25) AT=820.025n

.meas tran vdout0_26ck1630 FIND v(dout0_26) AT=820.025n

.meas tran vdout0_27ck1630 FIND v(dout0_27) AT=820.025n

.meas tran vdout0_28ck1630 FIND v(dout0_28) AT=820.025n

.meas tran vdout0_29ck1630 FIND v(dout0_29) AT=820.025n

.meas tran vdout0_30ck1630 FIND v(dout0_30) AT=820.025n

.meas tran vdout0_31ck1630 FIND v(dout0_31) AT=820.025n

.meas tran vdout0_32ck1630 FIND v(dout0_32) AT=820.025n

.meas tran vdout0_33ck1630 FIND v(dout0_33) AT=820.025n

.meas tran vdout0_34ck1630 FIND v(dout0_34) AT=820.025n

.meas tran vdout0_35ck1630 FIND v(dout0_35) AT=820.025n

.meas tran vdout0_36ck1630 FIND v(dout0_36) AT=820.025n

.meas tran vdout0_37ck1630 FIND v(dout0_37) AT=820.025n

.meas tran vdout0_38ck1630 FIND v(dout0_38) AT=820.025n

.meas tran vdout0_39ck1630 FIND v(dout0_39) AT=820.025n

.meas tran vdout0_40ck1630 FIND v(dout0_40) AT=820.025n

.meas tran vdout0_41ck1630 FIND v(dout0_41) AT=820.025n

.meas tran vdout0_42ck1630 FIND v(dout0_42) AT=820.025n

.meas tran vdout0_43ck1630 FIND v(dout0_43) AT=820.025n

.meas tran vdout0_44ck1630 FIND v(dout0_44) AT=820.025n

.meas tran vdout0_45ck1630 FIND v(dout0_45) AT=820.025n

.meas tran vdout0_46ck1630 FIND v(dout0_46) AT=820.025n

.meas tran vdout0_47ck1630 FIND v(dout0_47) AT=820.025n

.meas tran vdout0_48ck1630 FIND v(dout0_48) AT=820.025n

.meas tran vdout0_49ck1630 FIND v(dout0_49) AT=820.025n

.meas tran vdout0_50ck1630 FIND v(dout0_50) AT=820.025n

.meas tran vdout0_51ck1630 FIND v(dout0_51) AT=820.025n

.meas tran vdout0_52ck1630 FIND v(dout0_52) AT=820.025n

.meas tran vdout0_53ck1630 FIND v(dout0_53) AT=820.025n

.meas tran vdout0_54ck1630 FIND v(dout0_54) AT=820.025n

.meas tran vdout0_55ck1630 FIND v(dout0_55) AT=820.025n

.meas tran vdout0_56ck1630 FIND v(dout0_56) AT=820.025n

.meas tran vdout0_57ck1630 FIND v(dout0_57) AT=820.025n

.meas tran vdout0_58ck1630 FIND v(dout0_58) AT=820.025n

.meas tran vdout0_59ck1630 FIND v(dout0_59) AT=820.025n

.meas tran vdout0_60ck1630 FIND v(dout0_60) AT=820.025n

.meas tran vdout0_61ck1630 FIND v(dout0_61) AT=820.025n

.meas tran vdout0_62ck1630 FIND v(dout0_62) AT=820.025n

.meas tran vdout0_63ck1630 FIND v(dout0_63) AT=820.025n

.meas tran vdout0_0ck1640 FIND v(dout0_0) AT=825.025n

.meas tran vdout0_1ck1640 FIND v(dout0_1) AT=825.025n

.meas tran vdout0_2ck1640 FIND v(dout0_2) AT=825.025n

.meas tran vdout0_3ck1640 FIND v(dout0_3) AT=825.025n

.meas tran vdout0_4ck1640 FIND v(dout0_4) AT=825.025n

.meas tran vdout0_5ck1640 FIND v(dout0_5) AT=825.025n

.meas tran vdout0_6ck1640 FIND v(dout0_6) AT=825.025n

.meas tran vdout0_7ck1640 FIND v(dout0_7) AT=825.025n

.meas tran vdout0_8ck1640 FIND v(dout0_8) AT=825.025n

.meas tran vdout0_9ck1640 FIND v(dout0_9) AT=825.025n

.meas tran vdout0_10ck1640 FIND v(dout0_10) AT=825.025n

.meas tran vdout0_11ck1640 FIND v(dout0_11) AT=825.025n

.meas tran vdout0_12ck1640 FIND v(dout0_12) AT=825.025n

.meas tran vdout0_13ck1640 FIND v(dout0_13) AT=825.025n

.meas tran vdout0_14ck1640 FIND v(dout0_14) AT=825.025n

.meas tran vdout0_15ck1640 FIND v(dout0_15) AT=825.025n

.meas tran vdout0_16ck1640 FIND v(dout0_16) AT=825.025n

.meas tran vdout0_17ck1640 FIND v(dout0_17) AT=825.025n

.meas tran vdout0_18ck1640 FIND v(dout0_18) AT=825.025n

.meas tran vdout0_19ck1640 FIND v(dout0_19) AT=825.025n

.meas tran vdout0_20ck1640 FIND v(dout0_20) AT=825.025n

.meas tran vdout0_21ck1640 FIND v(dout0_21) AT=825.025n

.meas tran vdout0_22ck1640 FIND v(dout0_22) AT=825.025n

.meas tran vdout0_23ck1640 FIND v(dout0_23) AT=825.025n

.meas tran vdout0_24ck1640 FIND v(dout0_24) AT=825.025n

.meas tran vdout0_25ck1640 FIND v(dout0_25) AT=825.025n

.meas tran vdout0_26ck1640 FIND v(dout0_26) AT=825.025n

.meas tran vdout0_27ck1640 FIND v(dout0_27) AT=825.025n

.meas tran vdout0_28ck1640 FIND v(dout0_28) AT=825.025n

.meas tran vdout0_29ck1640 FIND v(dout0_29) AT=825.025n

.meas tran vdout0_30ck1640 FIND v(dout0_30) AT=825.025n

.meas tran vdout0_31ck1640 FIND v(dout0_31) AT=825.025n

.meas tran vdout0_32ck1640 FIND v(dout0_32) AT=825.025n

.meas tran vdout0_33ck1640 FIND v(dout0_33) AT=825.025n

.meas tran vdout0_34ck1640 FIND v(dout0_34) AT=825.025n

.meas tran vdout0_35ck1640 FIND v(dout0_35) AT=825.025n

.meas tran vdout0_36ck1640 FIND v(dout0_36) AT=825.025n

.meas tran vdout0_37ck1640 FIND v(dout0_37) AT=825.025n

.meas tran vdout0_38ck1640 FIND v(dout0_38) AT=825.025n

.meas tran vdout0_39ck1640 FIND v(dout0_39) AT=825.025n

.meas tran vdout0_40ck1640 FIND v(dout0_40) AT=825.025n

.meas tran vdout0_41ck1640 FIND v(dout0_41) AT=825.025n

.meas tran vdout0_42ck1640 FIND v(dout0_42) AT=825.025n

.meas tran vdout0_43ck1640 FIND v(dout0_43) AT=825.025n

.meas tran vdout0_44ck1640 FIND v(dout0_44) AT=825.025n

.meas tran vdout0_45ck1640 FIND v(dout0_45) AT=825.025n

.meas tran vdout0_46ck1640 FIND v(dout0_46) AT=825.025n

.meas tran vdout0_47ck1640 FIND v(dout0_47) AT=825.025n

.meas tran vdout0_48ck1640 FIND v(dout0_48) AT=825.025n

.meas tran vdout0_49ck1640 FIND v(dout0_49) AT=825.025n

.meas tran vdout0_50ck1640 FIND v(dout0_50) AT=825.025n

.meas tran vdout0_51ck1640 FIND v(dout0_51) AT=825.025n

.meas tran vdout0_52ck1640 FIND v(dout0_52) AT=825.025n

.meas tran vdout0_53ck1640 FIND v(dout0_53) AT=825.025n

.meas tran vdout0_54ck1640 FIND v(dout0_54) AT=825.025n

.meas tran vdout0_55ck1640 FIND v(dout0_55) AT=825.025n

.meas tran vdout0_56ck1640 FIND v(dout0_56) AT=825.025n

.meas tran vdout0_57ck1640 FIND v(dout0_57) AT=825.025n

.meas tran vdout0_58ck1640 FIND v(dout0_58) AT=825.025n

.meas tran vdout0_59ck1640 FIND v(dout0_59) AT=825.025n

.meas tran vdout0_60ck1640 FIND v(dout0_60) AT=825.025n

.meas tran vdout0_61ck1640 FIND v(dout0_61) AT=825.025n

.meas tran vdout0_62ck1640 FIND v(dout0_62) AT=825.025n

.meas tran vdout0_63ck1640 FIND v(dout0_63) AT=825.025n

.meas tran vdout1_0ck1640 FIND v(dout1_0) AT=825.025n

.meas tran vdout1_1ck1640 FIND v(dout1_1) AT=825.025n

.meas tran vdout1_2ck1640 FIND v(dout1_2) AT=825.025n

.meas tran vdout1_3ck1640 FIND v(dout1_3) AT=825.025n

.meas tran vdout1_4ck1640 FIND v(dout1_4) AT=825.025n

.meas tran vdout1_5ck1640 FIND v(dout1_5) AT=825.025n

.meas tran vdout1_6ck1640 FIND v(dout1_6) AT=825.025n

.meas tran vdout1_7ck1640 FIND v(dout1_7) AT=825.025n

.meas tran vdout1_8ck1640 FIND v(dout1_8) AT=825.025n

.meas tran vdout1_9ck1640 FIND v(dout1_9) AT=825.025n

.meas tran vdout1_10ck1640 FIND v(dout1_10) AT=825.025n

.meas tran vdout1_11ck1640 FIND v(dout1_11) AT=825.025n

.meas tran vdout1_12ck1640 FIND v(dout1_12) AT=825.025n

.meas tran vdout1_13ck1640 FIND v(dout1_13) AT=825.025n

.meas tran vdout1_14ck1640 FIND v(dout1_14) AT=825.025n

.meas tran vdout1_15ck1640 FIND v(dout1_15) AT=825.025n

.meas tran vdout1_16ck1640 FIND v(dout1_16) AT=825.025n

.meas tran vdout1_17ck1640 FIND v(dout1_17) AT=825.025n

.meas tran vdout1_18ck1640 FIND v(dout1_18) AT=825.025n

.meas tran vdout1_19ck1640 FIND v(dout1_19) AT=825.025n

.meas tran vdout1_20ck1640 FIND v(dout1_20) AT=825.025n

.meas tran vdout1_21ck1640 FIND v(dout1_21) AT=825.025n

.meas tran vdout1_22ck1640 FIND v(dout1_22) AT=825.025n

.meas tran vdout1_23ck1640 FIND v(dout1_23) AT=825.025n

.meas tran vdout1_24ck1640 FIND v(dout1_24) AT=825.025n

.meas tran vdout1_25ck1640 FIND v(dout1_25) AT=825.025n

.meas tran vdout1_26ck1640 FIND v(dout1_26) AT=825.025n

.meas tran vdout1_27ck1640 FIND v(dout1_27) AT=825.025n

.meas tran vdout1_28ck1640 FIND v(dout1_28) AT=825.025n

.meas tran vdout1_29ck1640 FIND v(dout1_29) AT=825.025n

.meas tran vdout1_30ck1640 FIND v(dout1_30) AT=825.025n

.meas tran vdout1_31ck1640 FIND v(dout1_31) AT=825.025n

.meas tran vdout1_32ck1640 FIND v(dout1_32) AT=825.025n

.meas tran vdout1_33ck1640 FIND v(dout1_33) AT=825.025n

.meas tran vdout1_34ck1640 FIND v(dout1_34) AT=825.025n

.meas tran vdout1_35ck1640 FIND v(dout1_35) AT=825.025n

.meas tran vdout1_36ck1640 FIND v(dout1_36) AT=825.025n

.meas tran vdout1_37ck1640 FIND v(dout1_37) AT=825.025n

.meas tran vdout1_38ck1640 FIND v(dout1_38) AT=825.025n

.meas tran vdout1_39ck1640 FIND v(dout1_39) AT=825.025n

.meas tran vdout1_40ck1640 FIND v(dout1_40) AT=825.025n

.meas tran vdout1_41ck1640 FIND v(dout1_41) AT=825.025n

.meas tran vdout1_42ck1640 FIND v(dout1_42) AT=825.025n

.meas tran vdout1_43ck1640 FIND v(dout1_43) AT=825.025n

.meas tran vdout1_44ck1640 FIND v(dout1_44) AT=825.025n

.meas tran vdout1_45ck1640 FIND v(dout1_45) AT=825.025n

.meas tran vdout1_46ck1640 FIND v(dout1_46) AT=825.025n

.meas tran vdout1_47ck1640 FIND v(dout1_47) AT=825.025n

.meas tran vdout1_48ck1640 FIND v(dout1_48) AT=825.025n

.meas tran vdout1_49ck1640 FIND v(dout1_49) AT=825.025n

.meas tran vdout1_50ck1640 FIND v(dout1_50) AT=825.025n

.meas tran vdout1_51ck1640 FIND v(dout1_51) AT=825.025n

.meas tran vdout1_52ck1640 FIND v(dout1_52) AT=825.025n

.meas tran vdout1_53ck1640 FIND v(dout1_53) AT=825.025n

.meas tran vdout1_54ck1640 FIND v(dout1_54) AT=825.025n

.meas tran vdout1_55ck1640 FIND v(dout1_55) AT=825.025n

.meas tran vdout1_56ck1640 FIND v(dout1_56) AT=825.025n

.meas tran vdout1_57ck1640 FIND v(dout1_57) AT=825.025n

.meas tran vdout1_58ck1640 FIND v(dout1_58) AT=825.025n

.meas tran vdout1_59ck1640 FIND v(dout1_59) AT=825.025n

.meas tran vdout1_60ck1640 FIND v(dout1_60) AT=825.025n

.meas tran vdout1_61ck1640 FIND v(dout1_61) AT=825.025n

.meas tran vdout1_62ck1640 FIND v(dout1_62) AT=825.025n

.meas tran vdout1_63ck1640 FIND v(dout1_63) AT=825.025n

.meas tran vdout0_0ck1650 FIND v(dout0_0) AT=830.025n

.meas tran vdout0_1ck1650 FIND v(dout0_1) AT=830.025n

.meas tran vdout0_2ck1650 FIND v(dout0_2) AT=830.025n

.meas tran vdout0_3ck1650 FIND v(dout0_3) AT=830.025n

.meas tran vdout0_4ck1650 FIND v(dout0_4) AT=830.025n

.meas tran vdout0_5ck1650 FIND v(dout0_5) AT=830.025n

.meas tran vdout0_6ck1650 FIND v(dout0_6) AT=830.025n

.meas tran vdout0_7ck1650 FIND v(dout0_7) AT=830.025n

.meas tran vdout0_8ck1650 FIND v(dout0_8) AT=830.025n

.meas tran vdout0_9ck1650 FIND v(dout0_9) AT=830.025n

.meas tran vdout0_10ck1650 FIND v(dout0_10) AT=830.025n

.meas tran vdout0_11ck1650 FIND v(dout0_11) AT=830.025n

.meas tran vdout0_12ck1650 FIND v(dout0_12) AT=830.025n

.meas tran vdout0_13ck1650 FIND v(dout0_13) AT=830.025n

.meas tran vdout0_14ck1650 FIND v(dout0_14) AT=830.025n

.meas tran vdout0_15ck1650 FIND v(dout0_15) AT=830.025n

.meas tran vdout0_16ck1650 FIND v(dout0_16) AT=830.025n

.meas tran vdout0_17ck1650 FIND v(dout0_17) AT=830.025n

.meas tran vdout0_18ck1650 FIND v(dout0_18) AT=830.025n

.meas tran vdout0_19ck1650 FIND v(dout0_19) AT=830.025n

.meas tran vdout0_20ck1650 FIND v(dout0_20) AT=830.025n

.meas tran vdout0_21ck1650 FIND v(dout0_21) AT=830.025n

.meas tran vdout0_22ck1650 FIND v(dout0_22) AT=830.025n

.meas tran vdout0_23ck1650 FIND v(dout0_23) AT=830.025n

.meas tran vdout0_24ck1650 FIND v(dout0_24) AT=830.025n

.meas tran vdout0_25ck1650 FIND v(dout0_25) AT=830.025n

.meas tran vdout0_26ck1650 FIND v(dout0_26) AT=830.025n

.meas tran vdout0_27ck1650 FIND v(dout0_27) AT=830.025n

.meas tran vdout0_28ck1650 FIND v(dout0_28) AT=830.025n

.meas tran vdout0_29ck1650 FIND v(dout0_29) AT=830.025n

.meas tran vdout0_30ck1650 FIND v(dout0_30) AT=830.025n

.meas tran vdout0_31ck1650 FIND v(dout0_31) AT=830.025n

.meas tran vdout0_32ck1650 FIND v(dout0_32) AT=830.025n

.meas tran vdout0_33ck1650 FIND v(dout0_33) AT=830.025n

.meas tran vdout0_34ck1650 FIND v(dout0_34) AT=830.025n

.meas tran vdout0_35ck1650 FIND v(dout0_35) AT=830.025n

.meas tran vdout0_36ck1650 FIND v(dout0_36) AT=830.025n

.meas tran vdout0_37ck1650 FIND v(dout0_37) AT=830.025n

.meas tran vdout0_38ck1650 FIND v(dout0_38) AT=830.025n

.meas tran vdout0_39ck1650 FIND v(dout0_39) AT=830.025n

.meas tran vdout0_40ck1650 FIND v(dout0_40) AT=830.025n

.meas tran vdout0_41ck1650 FIND v(dout0_41) AT=830.025n

.meas tran vdout0_42ck1650 FIND v(dout0_42) AT=830.025n

.meas tran vdout0_43ck1650 FIND v(dout0_43) AT=830.025n

.meas tran vdout0_44ck1650 FIND v(dout0_44) AT=830.025n

.meas tran vdout0_45ck1650 FIND v(dout0_45) AT=830.025n

.meas tran vdout0_46ck1650 FIND v(dout0_46) AT=830.025n

.meas tran vdout0_47ck1650 FIND v(dout0_47) AT=830.025n

.meas tran vdout0_48ck1650 FIND v(dout0_48) AT=830.025n

.meas tran vdout0_49ck1650 FIND v(dout0_49) AT=830.025n

.meas tran vdout0_50ck1650 FIND v(dout0_50) AT=830.025n

.meas tran vdout0_51ck1650 FIND v(dout0_51) AT=830.025n

.meas tran vdout0_52ck1650 FIND v(dout0_52) AT=830.025n

.meas tran vdout0_53ck1650 FIND v(dout0_53) AT=830.025n

.meas tran vdout0_54ck1650 FIND v(dout0_54) AT=830.025n

.meas tran vdout0_55ck1650 FIND v(dout0_55) AT=830.025n

.meas tran vdout0_56ck1650 FIND v(dout0_56) AT=830.025n

.meas tran vdout0_57ck1650 FIND v(dout0_57) AT=830.025n

.meas tran vdout0_58ck1650 FIND v(dout0_58) AT=830.025n

.meas tran vdout0_59ck1650 FIND v(dout0_59) AT=830.025n

.meas tran vdout0_60ck1650 FIND v(dout0_60) AT=830.025n

.meas tran vdout0_61ck1650 FIND v(dout0_61) AT=830.025n

.meas tran vdout0_62ck1650 FIND v(dout0_62) AT=830.025n

.meas tran vdout0_63ck1650 FIND v(dout0_63) AT=830.025n

.meas tran vdout0_0ck1660 FIND v(dout0_0) AT=835.025n

.meas tran vdout0_1ck1660 FIND v(dout0_1) AT=835.025n

.meas tran vdout0_2ck1660 FIND v(dout0_2) AT=835.025n

.meas tran vdout0_3ck1660 FIND v(dout0_3) AT=835.025n

.meas tran vdout0_4ck1660 FIND v(dout0_4) AT=835.025n

.meas tran vdout0_5ck1660 FIND v(dout0_5) AT=835.025n

.meas tran vdout0_6ck1660 FIND v(dout0_6) AT=835.025n

.meas tran vdout0_7ck1660 FIND v(dout0_7) AT=835.025n

.meas tran vdout0_8ck1660 FIND v(dout0_8) AT=835.025n

.meas tran vdout0_9ck1660 FIND v(dout0_9) AT=835.025n

.meas tran vdout0_10ck1660 FIND v(dout0_10) AT=835.025n

.meas tran vdout0_11ck1660 FIND v(dout0_11) AT=835.025n

.meas tran vdout0_12ck1660 FIND v(dout0_12) AT=835.025n

.meas tran vdout0_13ck1660 FIND v(dout0_13) AT=835.025n

.meas tran vdout0_14ck1660 FIND v(dout0_14) AT=835.025n

.meas tran vdout0_15ck1660 FIND v(dout0_15) AT=835.025n

.meas tran vdout0_16ck1660 FIND v(dout0_16) AT=835.025n

.meas tran vdout0_17ck1660 FIND v(dout0_17) AT=835.025n

.meas tran vdout0_18ck1660 FIND v(dout0_18) AT=835.025n

.meas tran vdout0_19ck1660 FIND v(dout0_19) AT=835.025n

.meas tran vdout0_20ck1660 FIND v(dout0_20) AT=835.025n

.meas tran vdout0_21ck1660 FIND v(dout0_21) AT=835.025n

.meas tran vdout0_22ck1660 FIND v(dout0_22) AT=835.025n

.meas tran vdout0_23ck1660 FIND v(dout0_23) AT=835.025n

.meas tran vdout0_24ck1660 FIND v(dout0_24) AT=835.025n

.meas tran vdout0_25ck1660 FIND v(dout0_25) AT=835.025n

.meas tran vdout0_26ck1660 FIND v(dout0_26) AT=835.025n

.meas tran vdout0_27ck1660 FIND v(dout0_27) AT=835.025n

.meas tran vdout0_28ck1660 FIND v(dout0_28) AT=835.025n

.meas tran vdout0_29ck1660 FIND v(dout0_29) AT=835.025n

.meas tran vdout0_30ck1660 FIND v(dout0_30) AT=835.025n

.meas tran vdout0_31ck1660 FIND v(dout0_31) AT=835.025n

.meas tran vdout0_32ck1660 FIND v(dout0_32) AT=835.025n

.meas tran vdout0_33ck1660 FIND v(dout0_33) AT=835.025n

.meas tran vdout0_34ck1660 FIND v(dout0_34) AT=835.025n

.meas tran vdout0_35ck1660 FIND v(dout0_35) AT=835.025n

.meas tran vdout0_36ck1660 FIND v(dout0_36) AT=835.025n

.meas tran vdout0_37ck1660 FIND v(dout0_37) AT=835.025n

.meas tran vdout0_38ck1660 FIND v(dout0_38) AT=835.025n

.meas tran vdout0_39ck1660 FIND v(dout0_39) AT=835.025n

.meas tran vdout0_40ck1660 FIND v(dout0_40) AT=835.025n

.meas tran vdout0_41ck1660 FIND v(dout0_41) AT=835.025n

.meas tran vdout0_42ck1660 FIND v(dout0_42) AT=835.025n

.meas tran vdout0_43ck1660 FIND v(dout0_43) AT=835.025n

.meas tran vdout0_44ck1660 FIND v(dout0_44) AT=835.025n

.meas tran vdout0_45ck1660 FIND v(dout0_45) AT=835.025n

.meas tran vdout0_46ck1660 FIND v(dout0_46) AT=835.025n

.meas tran vdout0_47ck1660 FIND v(dout0_47) AT=835.025n

.meas tran vdout0_48ck1660 FIND v(dout0_48) AT=835.025n

.meas tran vdout0_49ck1660 FIND v(dout0_49) AT=835.025n

.meas tran vdout0_50ck1660 FIND v(dout0_50) AT=835.025n

.meas tran vdout0_51ck1660 FIND v(dout0_51) AT=835.025n

.meas tran vdout0_52ck1660 FIND v(dout0_52) AT=835.025n

.meas tran vdout0_53ck1660 FIND v(dout0_53) AT=835.025n

.meas tran vdout0_54ck1660 FIND v(dout0_54) AT=835.025n

.meas tran vdout0_55ck1660 FIND v(dout0_55) AT=835.025n

.meas tran vdout0_56ck1660 FIND v(dout0_56) AT=835.025n

.meas tran vdout0_57ck1660 FIND v(dout0_57) AT=835.025n

.meas tran vdout0_58ck1660 FIND v(dout0_58) AT=835.025n

.meas tran vdout0_59ck1660 FIND v(dout0_59) AT=835.025n

.meas tran vdout0_60ck1660 FIND v(dout0_60) AT=835.025n

.meas tran vdout0_61ck1660 FIND v(dout0_61) AT=835.025n

.meas tran vdout0_62ck1660 FIND v(dout0_62) AT=835.025n

.meas tran vdout0_63ck1660 FIND v(dout0_63) AT=835.025n

.meas tran vdout0_0ck1670 FIND v(dout0_0) AT=840.025n

.meas tran vdout0_1ck1670 FIND v(dout0_1) AT=840.025n

.meas tran vdout0_2ck1670 FIND v(dout0_2) AT=840.025n

.meas tran vdout0_3ck1670 FIND v(dout0_3) AT=840.025n

.meas tran vdout0_4ck1670 FIND v(dout0_4) AT=840.025n

.meas tran vdout0_5ck1670 FIND v(dout0_5) AT=840.025n

.meas tran vdout0_6ck1670 FIND v(dout0_6) AT=840.025n

.meas tran vdout0_7ck1670 FIND v(dout0_7) AT=840.025n

.meas tran vdout0_8ck1670 FIND v(dout0_8) AT=840.025n

.meas tran vdout0_9ck1670 FIND v(dout0_9) AT=840.025n

.meas tran vdout0_10ck1670 FIND v(dout0_10) AT=840.025n

.meas tran vdout0_11ck1670 FIND v(dout0_11) AT=840.025n

.meas tran vdout0_12ck1670 FIND v(dout0_12) AT=840.025n

.meas tran vdout0_13ck1670 FIND v(dout0_13) AT=840.025n

.meas tran vdout0_14ck1670 FIND v(dout0_14) AT=840.025n

.meas tran vdout0_15ck1670 FIND v(dout0_15) AT=840.025n

.meas tran vdout0_16ck1670 FIND v(dout0_16) AT=840.025n

.meas tran vdout0_17ck1670 FIND v(dout0_17) AT=840.025n

.meas tran vdout0_18ck1670 FIND v(dout0_18) AT=840.025n

.meas tran vdout0_19ck1670 FIND v(dout0_19) AT=840.025n

.meas tran vdout0_20ck1670 FIND v(dout0_20) AT=840.025n

.meas tran vdout0_21ck1670 FIND v(dout0_21) AT=840.025n

.meas tran vdout0_22ck1670 FIND v(dout0_22) AT=840.025n

.meas tran vdout0_23ck1670 FIND v(dout0_23) AT=840.025n

.meas tran vdout0_24ck1670 FIND v(dout0_24) AT=840.025n

.meas tran vdout0_25ck1670 FIND v(dout0_25) AT=840.025n

.meas tran vdout0_26ck1670 FIND v(dout0_26) AT=840.025n

.meas tran vdout0_27ck1670 FIND v(dout0_27) AT=840.025n

.meas tran vdout0_28ck1670 FIND v(dout0_28) AT=840.025n

.meas tran vdout0_29ck1670 FIND v(dout0_29) AT=840.025n

.meas tran vdout0_30ck1670 FIND v(dout0_30) AT=840.025n

.meas tran vdout0_31ck1670 FIND v(dout0_31) AT=840.025n

.meas tran vdout0_32ck1670 FIND v(dout0_32) AT=840.025n

.meas tran vdout0_33ck1670 FIND v(dout0_33) AT=840.025n

.meas tran vdout0_34ck1670 FIND v(dout0_34) AT=840.025n

.meas tran vdout0_35ck1670 FIND v(dout0_35) AT=840.025n

.meas tran vdout0_36ck1670 FIND v(dout0_36) AT=840.025n

.meas tran vdout0_37ck1670 FIND v(dout0_37) AT=840.025n

.meas tran vdout0_38ck1670 FIND v(dout0_38) AT=840.025n

.meas tran vdout0_39ck1670 FIND v(dout0_39) AT=840.025n

.meas tran vdout0_40ck1670 FIND v(dout0_40) AT=840.025n

.meas tran vdout0_41ck1670 FIND v(dout0_41) AT=840.025n

.meas tran vdout0_42ck1670 FIND v(dout0_42) AT=840.025n

.meas tran vdout0_43ck1670 FIND v(dout0_43) AT=840.025n

.meas tran vdout0_44ck1670 FIND v(dout0_44) AT=840.025n

.meas tran vdout0_45ck1670 FIND v(dout0_45) AT=840.025n

.meas tran vdout0_46ck1670 FIND v(dout0_46) AT=840.025n

.meas tran vdout0_47ck1670 FIND v(dout0_47) AT=840.025n

.meas tran vdout0_48ck1670 FIND v(dout0_48) AT=840.025n

.meas tran vdout0_49ck1670 FIND v(dout0_49) AT=840.025n

.meas tran vdout0_50ck1670 FIND v(dout0_50) AT=840.025n

.meas tran vdout0_51ck1670 FIND v(dout0_51) AT=840.025n

.meas tran vdout0_52ck1670 FIND v(dout0_52) AT=840.025n

.meas tran vdout0_53ck1670 FIND v(dout0_53) AT=840.025n

.meas tran vdout0_54ck1670 FIND v(dout0_54) AT=840.025n

.meas tran vdout0_55ck1670 FIND v(dout0_55) AT=840.025n

.meas tran vdout0_56ck1670 FIND v(dout0_56) AT=840.025n

.meas tran vdout0_57ck1670 FIND v(dout0_57) AT=840.025n

.meas tran vdout0_58ck1670 FIND v(dout0_58) AT=840.025n

.meas tran vdout0_59ck1670 FIND v(dout0_59) AT=840.025n

.meas tran vdout0_60ck1670 FIND v(dout0_60) AT=840.025n

.meas tran vdout0_61ck1670 FIND v(dout0_61) AT=840.025n

.meas tran vdout0_62ck1670 FIND v(dout0_62) AT=840.025n

.meas tran vdout0_63ck1670 FIND v(dout0_63) AT=840.025n

.meas tran vdout1_0ck1670 FIND v(dout1_0) AT=840.025n

.meas tran vdout1_1ck1670 FIND v(dout1_1) AT=840.025n

.meas tran vdout1_2ck1670 FIND v(dout1_2) AT=840.025n

.meas tran vdout1_3ck1670 FIND v(dout1_3) AT=840.025n

.meas tran vdout1_4ck1670 FIND v(dout1_4) AT=840.025n

.meas tran vdout1_5ck1670 FIND v(dout1_5) AT=840.025n

.meas tran vdout1_6ck1670 FIND v(dout1_6) AT=840.025n

.meas tran vdout1_7ck1670 FIND v(dout1_7) AT=840.025n

.meas tran vdout1_8ck1670 FIND v(dout1_8) AT=840.025n

.meas tran vdout1_9ck1670 FIND v(dout1_9) AT=840.025n

.meas tran vdout1_10ck1670 FIND v(dout1_10) AT=840.025n

.meas tran vdout1_11ck1670 FIND v(dout1_11) AT=840.025n

.meas tran vdout1_12ck1670 FIND v(dout1_12) AT=840.025n

.meas tran vdout1_13ck1670 FIND v(dout1_13) AT=840.025n

.meas tran vdout1_14ck1670 FIND v(dout1_14) AT=840.025n

.meas tran vdout1_15ck1670 FIND v(dout1_15) AT=840.025n

.meas tran vdout1_16ck1670 FIND v(dout1_16) AT=840.025n

.meas tran vdout1_17ck1670 FIND v(dout1_17) AT=840.025n

.meas tran vdout1_18ck1670 FIND v(dout1_18) AT=840.025n

.meas tran vdout1_19ck1670 FIND v(dout1_19) AT=840.025n

.meas tran vdout1_20ck1670 FIND v(dout1_20) AT=840.025n

.meas tran vdout1_21ck1670 FIND v(dout1_21) AT=840.025n

.meas tran vdout1_22ck1670 FIND v(dout1_22) AT=840.025n

.meas tran vdout1_23ck1670 FIND v(dout1_23) AT=840.025n

.meas tran vdout1_24ck1670 FIND v(dout1_24) AT=840.025n

.meas tran vdout1_25ck1670 FIND v(dout1_25) AT=840.025n

.meas tran vdout1_26ck1670 FIND v(dout1_26) AT=840.025n

.meas tran vdout1_27ck1670 FIND v(dout1_27) AT=840.025n

.meas tran vdout1_28ck1670 FIND v(dout1_28) AT=840.025n

.meas tran vdout1_29ck1670 FIND v(dout1_29) AT=840.025n

.meas tran vdout1_30ck1670 FIND v(dout1_30) AT=840.025n

.meas tran vdout1_31ck1670 FIND v(dout1_31) AT=840.025n

.meas tran vdout1_32ck1670 FIND v(dout1_32) AT=840.025n

.meas tran vdout1_33ck1670 FIND v(dout1_33) AT=840.025n

.meas tran vdout1_34ck1670 FIND v(dout1_34) AT=840.025n

.meas tran vdout1_35ck1670 FIND v(dout1_35) AT=840.025n

.meas tran vdout1_36ck1670 FIND v(dout1_36) AT=840.025n

.meas tran vdout1_37ck1670 FIND v(dout1_37) AT=840.025n

.meas tran vdout1_38ck1670 FIND v(dout1_38) AT=840.025n

.meas tran vdout1_39ck1670 FIND v(dout1_39) AT=840.025n

.meas tran vdout1_40ck1670 FIND v(dout1_40) AT=840.025n

.meas tran vdout1_41ck1670 FIND v(dout1_41) AT=840.025n

.meas tran vdout1_42ck1670 FIND v(dout1_42) AT=840.025n

.meas tran vdout1_43ck1670 FIND v(dout1_43) AT=840.025n

.meas tran vdout1_44ck1670 FIND v(dout1_44) AT=840.025n

.meas tran vdout1_45ck1670 FIND v(dout1_45) AT=840.025n

.meas tran vdout1_46ck1670 FIND v(dout1_46) AT=840.025n

.meas tran vdout1_47ck1670 FIND v(dout1_47) AT=840.025n

.meas tran vdout1_48ck1670 FIND v(dout1_48) AT=840.025n

.meas tran vdout1_49ck1670 FIND v(dout1_49) AT=840.025n

.meas tran vdout1_50ck1670 FIND v(dout1_50) AT=840.025n

.meas tran vdout1_51ck1670 FIND v(dout1_51) AT=840.025n

.meas tran vdout1_52ck1670 FIND v(dout1_52) AT=840.025n

.meas tran vdout1_53ck1670 FIND v(dout1_53) AT=840.025n

.meas tran vdout1_54ck1670 FIND v(dout1_54) AT=840.025n

.meas tran vdout1_55ck1670 FIND v(dout1_55) AT=840.025n

.meas tran vdout1_56ck1670 FIND v(dout1_56) AT=840.025n

.meas tran vdout1_57ck1670 FIND v(dout1_57) AT=840.025n

.meas tran vdout1_58ck1670 FIND v(dout1_58) AT=840.025n

.meas tran vdout1_59ck1670 FIND v(dout1_59) AT=840.025n

.meas tran vdout1_60ck1670 FIND v(dout1_60) AT=840.025n

.meas tran vdout1_61ck1670 FIND v(dout1_61) AT=840.025n

.meas tran vdout1_62ck1670 FIND v(dout1_62) AT=840.025n

.meas tran vdout1_63ck1670 FIND v(dout1_63) AT=840.025n

.meas tran vdout1_0ck1680 FIND v(dout1_0) AT=845.025n

.meas tran vdout1_1ck1680 FIND v(dout1_1) AT=845.025n

.meas tran vdout1_2ck1680 FIND v(dout1_2) AT=845.025n

.meas tran vdout1_3ck1680 FIND v(dout1_3) AT=845.025n

.meas tran vdout1_4ck1680 FIND v(dout1_4) AT=845.025n

.meas tran vdout1_5ck1680 FIND v(dout1_5) AT=845.025n

.meas tran vdout1_6ck1680 FIND v(dout1_6) AT=845.025n

.meas tran vdout1_7ck1680 FIND v(dout1_7) AT=845.025n

.meas tran vdout1_8ck1680 FIND v(dout1_8) AT=845.025n

.meas tran vdout1_9ck1680 FIND v(dout1_9) AT=845.025n

.meas tran vdout1_10ck1680 FIND v(dout1_10) AT=845.025n

.meas tran vdout1_11ck1680 FIND v(dout1_11) AT=845.025n

.meas tran vdout1_12ck1680 FIND v(dout1_12) AT=845.025n

.meas tran vdout1_13ck1680 FIND v(dout1_13) AT=845.025n

.meas tran vdout1_14ck1680 FIND v(dout1_14) AT=845.025n

.meas tran vdout1_15ck1680 FIND v(dout1_15) AT=845.025n

.meas tran vdout1_16ck1680 FIND v(dout1_16) AT=845.025n

.meas tran vdout1_17ck1680 FIND v(dout1_17) AT=845.025n

.meas tran vdout1_18ck1680 FIND v(dout1_18) AT=845.025n

.meas tran vdout1_19ck1680 FIND v(dout1_19) AT=845.025n

.meas tran vdout1_20ck1680 FIND v(dout1_20) AT=845.025n

.meas tran vdout1_21ck1680 FIND v(dout1_21) AT=845.025n

.meas tran vdout1_22ck1680 FIND v(dout1_22) AT=845.025n

.meas tran vdout1_23ck1680 FIND v(dout1_23) AT=845.025n

.meas tran vdout1_24ck1680 FIND v(dout1_24) AT=845.025n

.meas tran vdout1_25ck1680 FIND v(dout1_25) AT=845.025n

.meas tran vdout1_26ck1680 FIND v(dout1_26) AT=845.025n

.meas tran vdout1_27ck1680 FIND v(dout1_27) AT=845.025n

.meas tran vdout1_28ck1680 FIND v(dout1_28) AT=845.025n

.meas tran vdout1_29ck1680 FIND v(dout1_29) AT=845.025n

.meas tran vdout1_30ck1680 FIND v(dout1_30) AT=845.025n

.meas tran vdout1_31ck1680 FIND v(dout1_31) AT=845.025n

.meas tran vdout1_32ck1680 FIND v(dout1_32) AT=845.025n

.meas tran vdout1_33ck1680 FIND v(dout1_33) AT=845.025n

.meas tran vdout1_34ck1680 FIND v(dout1_34) AT=845.025n

.meas tran vdout1_35ck1680 FIND v(dout1_35) AT=845.025n

.meas tran vdout1_36ck1680 FIND v(dout1_36) AT=845.025n

.meas tran vdout1_37ck1680 FIND v(dout1_37) AT=845.025n

.meas tran vdout1_38ck1680 FIND v(dout1_38) AT=845.025n

.meas tran vdout1_39ck1680 FIND v(dout1_39) AT=845.025n

.meas tran vdout1_40ck1680 FIND v(dout1_40) AT=845.025n

.meas tran vdout1_41ck1680 FIND v(dout1_41) AT=845.025n

.meas tran vdout1_42ck1680 FIND v(dout1_42) AT=845.025n

.meas tran vdout1_43ck1680 FIND v(dout1_43) AT=845.025n

.meas tran vdout1_44ck1680 FIND v(dout1_44) AT=845.025n

.meas tran vdout1_45ck1680 FIND v(dout1_45) AT=845.025n

.meas tran vdout1_46ck1680 FIND v(dout1_46) AT=845.025n

.meas tran vdout1_47ck1680 FIND v(dout1_47) AT=845.025n

.meas tran vdout1_48ck1680 FIND v(dout1_48) AT=845.025n

.meas tran vdout1_49ck1680 FIND v(dout1_49) AT=845.025n

.meas tran vdout1_50ck1680 FIND v(dout1_50) AT=845.025n

.meas tran vdout1_51ck1680 FIND v(dout1_51) AT=845.025n

.meas tran vdout1_52ck1680 FIND v(dout1_52) AT=845.025n

.meas tran vdout1_53ck1680 FIND v(dout1_53) AT=845.025n

.meas tran vdout1_54ck1680 FIND v(dout1_54) AT=845.025n

.meas tran vdout1_55ck1680 FIND v(dout1_55) AT=845.025n

.meas tran vdout1_56ck1680 FIND v(dout1_56) AT=845.025n

.meas tran vdout1_57ck1680 FIND v(dout1_57) AT=845.025n

.meas tran vdout1_58ck1680 FIND v(dout1_58) AT=845.025n

.meas tran vdout1_59ck1680 FIND v(dout1_59) AT=845.025n

.meas tran vdout1_60ck1680 FIND v(dout1_60) AT=845.025n

.meas tran vdout1_61ck1680 FIND v(dout1_61) AT=845.025n

.meas tran vdout1_62ck1680 FIND v(dout1_62) AT=845.025n

.meas tran vdout1_63ck1680 FIND v(dout1_63) AT=845.025n

.meas tran vdout1_0ck1690 FIND v(dout1_0) AT=850.025n

.meas tran vdout1_1ck1690 FIND v(dout1_1) AT=850.025n

.meas tran vdout1_2ck1690 FIND v(dout1_2) AT=850.025n

.meas tran vdout1_3ck1690 FIND v(dout1_3) AT=850.025n

.meas tran vdout1_4ck1690 FIND v(dout1_4) AT=850.025n

.meas tran vdout1_5ck1690 FIND v(dout1_5) AT=850.025n

.meas tran vdout1_6ck1690 FIND v(dout1_6) AT=850.025n

.meas tran vdout1_7ck1690 FIND v(dout1_7) AT=850.025n

.meas tran vdout1_8ck1690 FIND v(dout1_8) AT=850.025n

.meas tran vdout1_9ck1690 FIND v(dout1_9) AT=850.025n

.meas tran vdout1_10ck1690 FIND v(dout1_10) AT=850.025n

.meas tran vdout1_11ck1690 FIND v(dout1_11) AT=850.025n

.meas tran vdout1_12ck1690 FIND v(dout1_12) AT=850.025n

.meas tran vdout1_13ck1690 FIND v(dout1_13) AT=850.025n

.meas tran vdout1_14ck1690 FIND v(dout1_14) AT=850.025n

.meas tran vdout1_15ck1690 FIND v(dout1_15) AT=850.025n

.meas tran vdout1_16ck1690 FIND v(dout1_16) AT=850.025n

.meas tran vdout1_17ck1690 FIND v(dout1_17) AT=850.025n

.meas tran vdout1_18ck1690 FIND v(dout1_18) AT=850.025n

.meas tran vdout1_19ck1690 FIND v(dout1_19) AT=850.025n

.meas tran vdout1_20ck1690 FIND v(dout1_20) AT=850.025n

.meas tran vdout1_21ck1690 FIND v(dout1_21) AT=850.025n

.meas tran vdout1_22ck1690 FIND v(dout1_22) AT=850.025n

.meas tran vdout1_23ck1690 FIND v(dout1_23) AT=850.025n

.meas tran vdout1_24ck1690 FIND v(dout1_24) AT=850.025n

.meas tran vdout1_25ck1690 FIND v(dout1_25) AT=850.025n

.meas tran vdout1_26ck1690 FIND v(dout1_26) AT=850.025n

.meas tran vdout1_27ck1690 FIND v(dout1_27) AT=850.025n

.meas tran vdout1_28ck1690 FIND v(dout1_28) AT=850.025n

.meas tran vdout1_29ck1690 FIND v(dout1_29) AT=850.025n

.meas tran vdout1_30ck1690 FIND v(dout1_30) AT=850.025n

.meas tran vdout1_31ck1690 FIND v(dout1_31) AT=850.025n

.meas tran vdout1_32ck1690 FIND v(dout1_32) AT=850.025n

.meas tran vdout1_33ck1690 FIND v(dout1_33) AT=850.025n

.meas tran vdout1_34ck1690 FIND v(dout1_34) AT=850.025n

.meas tran vdout1_35ck1690 FIND v(dout1_35) AT=850.025n

.meas tran vdout1_36ck1690 FIND v(dout1_36) AT=850.025n

.meas tran vdout1_37ck1690 FIND v(dout1_37) AT=850.025n

.meas tran vdout1_38ck1690 FIND v(dout1_38) AT=850.025n

.meas tran vdout1_39ck1690 FIND v(dout1_39) AT=850.025n

.meas tran vdout1_40ck1690 FIND v(dout1_40) AT=850.025n

.meas tran vdout1_41ck1690 FIND v(dout1_41) AT=850.025n

.meas tran vdout1_42ck1690 FIND v(dout1_42) AT=850.025n

.meas tran vdout1_43ck1690 FIND v(dout1_43) AT=850.025n

.meas tran vdout1_44ck1690 FIND v(dout1_44) AT=850.025n

.meas tran vdout1_45ck1690 FIND v(dout1_45) AT=850.025n

.meas tran vdout1_46ck1690 FIND v(dout1_46) AT=850.025n

.meas tran vdout1_47ck1690 FIND v(dout1_47) AT=850.025n

.meas tran vdout1_48ck1690 FIND v(dout1_48) AT=850.025n

.meas tran vdout1_49ck1690 FIND v(dout1_49) AT=850.025n

.meas tran vdout1_50ck1690 FIND v(dout1_50) AT=850.025n

.meas tran vdout1_51ck1690 FIND v(dout1_51) AT=850.025n

.meas tran vdout1_52ck1690 FIND v(dout1_52) AT=850.025n

.meas tran vdout1_53ck1690 FIND v(dout1_53) AT=850.025n

.meas tran vdout1_54ck1690 FIND v(dout1_54) AT=850.025n

.meas tran vdout1_55ck1690 FIND v(dout1_55) AT=850.025n

.meas tran vdout1_56ck1690 FIND v(dout1_56) AT=850.025n

.meas tran vdout1_57ck1690 FIND v(dout1_57) AT=850.025n

.meas tran vdout1_58ck1690 FIND v(dout1_58) AT=850.025n

.meas tran vdout1_59ck1690 FIND v(dout1_59) AT=850.025n

.meas tran vdout1_60ck1690 FIND v(dout1_60) AT=850.025n

.meas tran vdout1_61ck1690 FIND v(dout1_61) AT=850.025n

.meas tran vdout1_62ck1690 FIND v(dout1_62) AT=850.025n

.meas tran vdout1_63ck1690 FIND v(dout1_63) AT=850.025n

.meas tran vdout1_0ck1700 FIND v(dout1_0) AT=855.025n

.meas tran vdout1_1ck1700 FIND v(dout1_1) AT=855.025n

.meas tran vdout1_2ck1700 FIND v(dout1_2) AT=855.025n

.meas tran vdout1_3ck1700 FIND v(dout1_3) AT=855.025n

.meas tran vdout1_4ck1700 FIND v(dout1_4) AT=855.025n

.meas tran vdout1_5ck1700 FIND v(dout1_5) AT=855.025n

.meas tran vdout1_6ck1700 FIND v(dout1_6) AT=855.025n

.meas tran vdout1_7ck1700 FIND v(dout1_7) AT=855.025n

.meas tran vdout1_8ck1700 FIND v(dout1_8) AT=855.025n

.meas tran vdout1_9ck1700 FIND v(dout1_9) AT=855.025n

.meas tran vdout1_10ck1700 FIND v(dout1_10) AT=855.025n

.meas tran vdout1_11ck1700 FIND v(dout1_11) AT=855.025n

.meas tran vdout1_12ck1700 FIND v(dout1_12) AT=855.025n

.meas tran vdout1_13ck1700 FIND v(dout1_13) AT=855.025n

.meas tran vdout1_14ck1700 FIND v(dout1_14) AT=855.025n

.meas tran vdout1_15ck1700 FIND v(dout1_15) AT=855.025n

.meas tran vdout1_16ck1700 FIND v(dout1_16) AT=855.025n

.meas tran vdout1_17ck1700 FIND v(dout1_17) AT=855.025n

.meas tran vdout1_18ck1700 FIND v(dout1_18) AT=855.025n

.meas tran vdout1_19ck1700 FIND v(dout1_19) AT=855.025n

.meas tran vdout1_20ck1700 FIND v(dout1_20) AT=855.025n

.meas tran vdout1_21ck1700 FIND v(dout1_21) AT=855.025n

.meas tran vdout1_22ck1700 FIND v(dout1_22) AT=855.025n

.meas tran vdout1_23ck1700 FIND v(dout1_23) AT=855.025n

.meas tran vdout1_24ck1700 FIND v(dout1_24) AT=855.025n

.meas tran vdout1_25ck1700 FIND v(dout1_25) AT=855.025n

.meas tran vdout1_26ck1700 FIND v(dout1_26) AT=855.025n

.meas tran vdout1_27ck1700 FIND v(dout1_27) AT=855.025n

.meas tran vdout1_28ck1700 FIND v(dout1_28) AT=855.025n

.meas tran vdout1_29ck1700 FIND v(dout1_29) AT=855.025n

.meas tran vdout1_30ck1700 FIND v(dout1_30) AT=855.025n

.meas tran vdout1_31ck1700 FIND v(dout1_31) AT=855.025n

.meas tran vdout1_32ck1700 FIND v(dout1_32) AT=855.025n

.meas tran vdout1_33ck1700 FIND v(dout1_33) AT=855.025n

.meas tran vdout1_34ck1700 FIND v(dout1_34) AT=855.025n

.meas tran vdout1_35ck1700 FIND v(dout1_35) AT=855.025n

.meas tran vdout1_36ck1700 FIND v(dout1_36) AT=855.025n

.meas tran vdout1_37ck1700 FIND v(dout1_37) AT=855.025n

.meas tran vdout1_38ck1700 FIND v(dout1_38) AT=855.025n

.meas tran vdout1_39ck1700 FIND v(dout1_39) AT=855.025n

.meas tran vdout1_40ck1700 FIND v(dout1_40) AT=855.025n

.meas tran vdout1_41ck1700 FIND v(dout1_41) AT=855.025n

.meas tran vdout1_42ck1700 FIND v(dout1_42) AT=855.025n

.meas tran vdout1_43ck1700 FIND v(dout1_43) AT=855.025n

.meas tran vdout1_44ck1700 FIND v(dout1_44) AT=855.025n

.meas tran vdout1_45ck1700 FIND v(dout1_45) AT=855.025n

.meas tran vdout1_46ck1700 FIND v(dout1_46) AT=855.025n

.meas tran vdout1_47ck1700 FIND v(dout1_47) AT=855.025n

.meas tran vdout1_48ck1700 FIND v(dout1_48) AT=855.025n

.meas tran vdout1_49ck1700 FIND v(dout1_49) AT=855.025n

.meas tran vdout1_50ck1700 FIND v(dout1_50) AT=855.025n

.meas tran vdout1_51ck1700 FIND v(dout1_51) AT=855.025n

.meas tran vdout1_52ck1700 FIND v(dout1_52) AT=855.025n

.meas tran vdout1_53ck1700 FIND v(dout1_53) AT=855.025n

.meas tran vdout1_54ck1700 FIND v(dout1_54) AT=855.025n

.meas tran vdout1_55ck1700 FIND v(dout1_55) AT=855.025n

.meas tran vdout1_56ck1700 FIND v(dout1_56) AT=855.025n

.meas tran vdout1_57ck1700 FIND v(dout1_57) AT=855.025n

.meas tran vdout1_58ck1700 FIND v(dout1_58) AT=855.025n

.meas tran vdout1_59ck1700 FIND v(dout1_59) AT=855.025n

.meas tran vdout1_60ck1700 FIND v(dout1_60) AT=855.025n

.meas tran vdout1_61ck1700 FIND v(dout1_61) AT=855.025n

.meas tran vdout1_62ck1700 FIND v(dout1_62) AT=855.025n

.meas tran vdout1_63ck1700 FIND v(dout1_63) AT=855.025n

.meas tran vdout1_0ck1710 FIND v(dout1_0) AT=860.025n

.meas tran vdout1_1ck1710 FIND v(dout1_1) AT=860.025n

.meas tran vdout1_2ck1710 FIND v(dout1_2) AT=860.025n

.meas tran vdout1_3ck1710 FIND v(dout1_3) AT=860.025n

.meas tran vdout1_4ck1710 FIND v(dout1_4) AT=860.025n

.meas tran vdout1_5ck1710 FIND v(dout1_5) AT=860.025n

.meas tran vdout1_6ck1710 FIND v(dout1_6) AT=860.025n

.meas tran vdout1_7ck1710 FIND v(dout1_7) AT=860.025n

.meas tran vdout1_8ck1710 FIND v(dout1_8) AT=860.025n

.meas tran vdout1_9ck1710 FIND v(dout1_9) AT=860.025n

.meas tran vdout1_10ck1710 FIND v(dout1_10) AT=860.025n

.meas tran vdout1_11ck1710 FIND v(dout1_11) AT=860.025n

.meas tran vdout1_12ck1710 FIND v(dout1_12) AT=860.025n

.meas tran vdout1_13ck1710 FIND v(dout1_13) AT=860.025n

.meas tran vdout1_14ck1710 FIND v(dout1_14) AT=860.025n

.meas tran vdout1_15ck1710 FIND v(dout1_15) AT=860.025n

.meas tran vdout1_16ck1710 FIND v(dout1_16) AT=860.025n

.meas tran vdout1_17ck1710 FIND v(dout1_17) AT=860.025n

.meas tran vdout1_18ck1710 FIND v(dout1_18) AT=860.025n

.meas tran vdout1_19ck1710 FIND v(dout1_19) AT=860.025n

.meas tran vdout1_20ck1710 FIND v(dout1_20) AT=860.025n

.meas tran vdout1_21ck1710 FIND v(dout1_21) AT=860.025n

.meas tran vdout1_22ck1710 FIND v(dout1_22) AT=860.025n

.meas tran vdout1_23ck1710 FIND v(dout1_23) AT=860.025n

.meas tran vdout1_24ck1710 FIND v(dout1_24) AT=860.025n

.meas tran vdout1_25ck1710 FIND v(dout1_25) AT=860.025n

.meas tran vdout1_26ck1710 FIND v(dout1_26) AT=860.025n

.meas tran vdout1_27ck1710 FIND v(dout1_27) AT=860.025n

.meas tran vdout1_28ck1710 FIND v(dout1_28) AT=860.025n

.meas tran vdout1_29ck1710 FIND v(dout1_29) AT=860.025n

.meas tran vdout1_30ck1710 FIND v(dout1_30) AT=860.025n

.meas tran vdout1_31ck1710 FIND v(dout1_31) AT=860.025n

.meas tran vdout1_32ck1710 FIND v(dout1_32) AT=860.025n

.meas tran vdout1_33ck1710 FIND v(dout1_33) AT=860.025n

.meas tran vdout1_34ck1710 FIND v(dout1_34) AT=860.025n

.meas tran vdout1_35ck1710 FIND v(dout1_35) AT=860.025n

.meas tran vdout1_36ck1710 FIND v(dout1_36) AT=860.025n

.meas tran vdout1_37ck1710 FIND v(dout1_37) AT=860.025n

.meas tran vdout1_38ck1710 FIND v(dout1_38) AT=860.025n

.meas tran vdout1_39ck1710 FIND v(dout1_39) AT=860.025n

.meas tran vdout1_40ck1710 FIND v(dout1_40) AT=860.025n

.meas tran vdout1_41ck1710 FIND v(dout1_41) AT=860.025n

.meas tran vdout1_42ck1710 FIND v(dout1_42) AT=860.025n

.meas tran vdout1_43ck1710 FIND v(dout1_43) AT=860.025n

.meas tran vdout1_44ck1710 FIND v(dout1_44) AT=860.025n

.meas tran vdout1_45ck1710 FIND v(dout1_45) AT=860.025n

.meas tran vdout1_46ck1710 FIND v(dout1_46) AT=860.025n

.meas tran vdout1_47ck1710 FIND v(dout1_47) AT=860.025n

.meas tran vdout1_48ck1710 FIND v(dout1_48) AT=860.025n

.meas tran vdout1_49ck1710 FIND v(dout1_49) AT=860.025n

.meas tran vdout1_50ck1710 FIND v(dout1_50) AT=860.025n

.meas tran vdout1_51ck1710 FIND v(dout1_51) AT=860.025n

.meas tran vdout1_52ck1710 FIND v(dout1_52) AT=860.025n

.meas tran vdout1_53ck1710 FIND v(dout1_53) AT=860.025n

.meas tran vdout1_54ck1710 FIND v(dout1_54) AT=860.025n

.meas tran vdout1_55ck1710 FIND v(dout1_55) AT=860.025n

.meas tran vdout1_56ck1710 FIND v(dout1_56) AT=860.025n

.meas tran vdout1_57ck1710 FIND v(dout1_57) AT=860.025n

.meas tran vdout1_58ck1710 FIND v(dout1_58) AT=860.025n

.meas tran vdout1_59ck1710 FIND v(dout1_59) AT=860.025n

.meas tran vdout1_60ck1710 FIND v(dout1_60) AT=860.025n

.meas tran vdout1_61ck1710 FIND v(dout1_61) AT=860.025n

.meas tran vdout1_62ck1710 FIND v(dout1_62) AT=860.025n

.meas tran vdout1_63ck1710 FIND v(dout1_63) AT=860.025n

.meas tran vdout0_0ck1720 FIND v(dout0_0) AT=865.025n

.meas tran vdout0_1ck1720 FIND v(dout0_1) AT=865.025n

.meas tran vdout0_2ck1720 FIND v(dout0_2) AT=865.025n

.meas tran vdout0_3ck1720 FIND v(dout0_3) AT=865.025n

.meas tran vdout0_4ck1720 FIND v(dout0_4) AT=865.025n

.meas tran vdout0_5ck1720 FIND v(dout0_5) AT=865.025n

.meas tran vdout0_6ck1720 FIND v(dout0_6) AT=865.025n

.meas tran vdout0_7ck1720 FIND v(dout0_7) AT=865.025n

.meas tran vdout0_8ck1720 FIND v(dout0_8) AT=865.025n

.meas tran vdout0_9ck1720 FIND v(dout0_9) AT=865.025n

.meas tran vdout0_10ck1720 FIND v(dout0_10) AT=865.025n

.meas tran vdout0_11ck1720 FIND v(dout0_11) AT=865.025n

.meas tran vdout0_12ck1720 FIND v(dout0_12) AT=865.025n

.meas tran vdout0_13ck1720 FIND v(dout0_13) AT=865.025n

.meas tran vdout0_14ck1720 FIND v(dout0_14) AT=865.025n

.meas tran vdout0_15ck1720 FIND v(dout0_15) AT=865.025n

.meas tran vdout0_16ck1720 FIND v(dout0_16) AT=865.025n

.meas tran vdout0_17ck1720 FIND v(dout0_17) AT=865.025n

.meas tran vdout0_18ck1720 FIND v(dout0_18) AT=865.025n

.meas tran vdout0_19ck1720 FIND v(dout0_19) AT=865.025n

.meas tran vdout0_20ck1720 FIND v(dout0_20) AT=865.025n

.meas tran vdout0_21ck1720 FIND v(dout0_21) AT=865.025n

.meas tran vdout0_22ck1720 FIND v(dout0_22) AT=865.025n

.meas tran vdout0_23ck1720 FIND v(dout0_23) AT=865.025n

.meas tran vdout0_24ck1720 FIND v(dout0_24) AT=865.025n

.meas tran vdout0_25ck1720 FIND v(dout0_25) AT=865.025n

.meas tran vdout0_26ck1720 FIND v(dout0_26) AT=865.025n

.meas tran vdout0_27ck1720 FIND v(dout0_27) AT=865.025n

.meas tran vdout0_28ck1720 FIND v(dout0_28) AT=865.025n

.meas tran vdout0_29ck1720 FIND v(dout0_29) AT=865.025n

.meas tran vdout0_30ck1720 FIND v(dout0_30) AT=865.025n

.meas tran vdout0_31ck1720 FIND v(dout0_31) AT=865.025n

.meas tran vdout0_32ck1720 FIND v(dout0_32) AT=865.025n

.meas tran vdout0_33ck1720 FIND v(dout0_33) AT=865.025n

.meas tran vdout0_34ck1720 FIND v(dout0_34) AT=865.025n

.meas tran vdout0_35ck1720 FIND v(dout0_35) AT=865.025n

.meas tran vdout0_36ck1720 FIND v(dout0_36) AT=865.025n

.meas tran vdout0_37ck1720 FIND v(dout0_37) AT=865.025n

.meas tran vdout0_38ck1720 FIND v(dout0_38) AT=865.025n

.meas tran vdout0_39ck1720 FIND v(dout0_39) AT=865.025n

.meas tran vdout0_40ck1720 FIND v(dout0_40) AT=865.025n

.meas tran vdout0_41ck1720 FIND v(dout0_41) AT=865.025n

.meas tran vdout0_42ck1720 FIND v(dout0_42) AT=865.025n

.meas tran vdout0_43ck1720 FIND v(dout0_43) AT=865.025n

.meas tran vdout0_44ck1720 FIND v(dout0_44) AT=865.025n

.meas tran vdout0_45ck1720 FIND v(dout0_45) AT=865.025n

.meas tran vdout0_46ck1720 FIND v(dout0_46) AT=865.025n

.meas tran vdout0_47ck1720 FIND v(dout0_47) AT=865.025n

.meas tran vdout0_48ck1720 FIND v(dout0_48) AT=865.025n

.meas tran vdout0_49ck1720 FIND v(dout0_49) AT=865.025n

.meas tran vdout0_50ck1720 FIND v(dout0_50) AT=865.025n

.meas tran vdout0_51ck1720 FIND v(dout0_51) AT=865.025n

.meas tran vdout0_52ck1720 FIND v(dout0_52) AT=865.025n

.meas tran vdout0_53ck1720 FIND v(dout0_53) AT=865.025n

.meas tran vdout0_54ck1720 FIND v(dout0_54) AT=865.025n

.meas tran vdout0_55ck1720 FIND v(dout0_55) AT=865.025n

.meas tran vdout0_56ck1720 FIND v(dout0_56) AT=865.025n

.meas tran vdout0_57ck1720 FIND v(dout0_57) AT=865.025n

.meas tran vdout0_58ck1720 FIND v(dout0_58) AT=865.025n

.meas tran vdout0_59ck1720 FIND v(dout0_59) AT=865.025n

.meas tran vdout0_60ck1720 FIND v(dout0_60) AT=865.025n

.meas tran vdout0_61ck1720 FIND v(dout0_61) AT=865.025n

.meas tran vdout0_62ck1720 FIND v(dout0_62) AT=865.025n

.meas tran vdout0_63ck1720 FIND v(dout0_63) AT=865.025n

.meas tran vdout1_0ck1740 FIND v(dout1_0) AT=875.025n

.meas tran vdout1_1ck1740 FIND v(dout1_1) AT=875.025n

.meas tran vdout1_2ck1740 FIND v(dout1_2) AT=875.025n

.meas tran vdout1_3ck1740 FIND v(dout1_3) AT=875.025n

.meas tran vdout1_4ck1740 FIND v(dout1_4) AT=875.025n

.meas tran vdout1_5ck1740 FIND v(dout1_5) AT=875.025n

.meas tran vdout1_6ck1740 FIND v(dout1_6) AT=875.025n

.meas tran vdout1_7ck1740 FIND v(dout1_7) AT=875.025n

.meas tran vdout1_8ck1740 FIND v(dout1_8) AT=875.025n

.meas tran vdout1_9ck1740 FIND v(dout1_9) AT=875.025n

.meas tran vdout1_10ck1740 FIND v(dout1_10) AT=875.025n

.meas tran vdout1_11ck1740 FIND v(dout1_11) AT=875.025n

.meas tran vdout1_12ck1740 FIND v(dout1_12) AT=875.025n

.meas tran vdout1_13ck1740 FIND v(dout1_13) AT=875.025n

.meas tran vdout1_14ck1740 FIND v(dout1_14) AT=875.025n

.meas tran vdout1_15ck1740 FIND v(dout1_15) AT=875.025n

.meas tran vdout1_16ck1740 FIND v(dout1_16) AT=875.025n

.meas tran vdout1_17ck1740 FIND v(dout1_17) AT=875.025n

.meas tran vdout1_18ck1740 FIND v(dout1_18) AT=875.025n

.meas tran vdout1_19ck1740 FIND v(dout1_19) AT=875.025n

.meas tran vdout1_20ck1740 FIND v(dout1_20) AT=875.025n

.meas tran vdout1_21ck1740 FIND v(dout1_21) AT=875.025n

.meas tran vdout1_22ck1740 FIND v(dout1_22) AT=875.025n

.meas tran vdout1_23ck1740 FIND v(dout1_23) AT=875.025n

.meas tran vdout1_24ck1740 FIND v(dout1_24) AT=875.025n

.meas tran vdout1_25ck1740 FIND v(dout1_25) AT=875.025n

.meas tran vdout1_26ck1740 FIND v(dout1_26) AT=875.025n

.meas tran vdout1_27ck1740 FIND v(dout1_27) AT=875.025n

.meas tran vdout1_28ck1740 FIND v(dout1_28) AT=875.025n

.meas tran vdout1_29ck1740 FIND v(dout1_29) AT=875.025n

.meas tran vdout1_30ck1740 FIND v(dout1_30) AT=875.025n

.meas tran vdout1_31ck1740 FIND v(dout1_31) AT=875.025n

.meas tran vdout1_32ck1740 FIND v(dout1_32) AT=875.025n

.meas tran vdout1_33ck1740 FIND v(dout1_33) AT=875.025n

.meas tran vdout1_34ck1740 FIND v(dout1_34) AT=875.025n

.meas tran vdout1_35ck1740 FIND v(dout1_35) AT=875.025n

.meas tran vdout1_36ck1740 FIND v(dout1_36) AT=875.025n

.meas tran vdout1_37ck1740 FIND v(dout1_37) AT=875.025n

.meas tran vdout1_38ck1740 FIND v(dout1_38) AT=875.025n

.meas tran vdout1_39ck1740 FIND v(dout1_39) AT=875.025n

.meas tran vdout1_40ck1740 FIND v(dout1_40) AT=875.025n

.meas tran vdout1_41ck1740 FIND v(dout1_41) AT=875.025n

.meas tran vdout1_42ck1740 FIND v(dout1_42) AT=875.025n

.meas tran vdout1_43ck1740 FIND v(dout1_43) AT=875.025n

.meas tran vdout1_44ck1740 FIND v(dout1_44) AT=875.025n

.meas tran vdout1_45ck1740 FIND v(dout1_45) AT=875.025n

.meas tran vdout1_46ck1740 FIND v(dout1_46) AT=875.025n

.meas tran vdout1_47ck1740 FIND v(dout1_47) AT=875.025n

.meas tran vdout1_48ck1740 FIND v(dout1_48) AT=875.025n

.meas tran vdout1_49ck1740 FIND v(dout1_49) AT=875.025n

.meas tran vdout1_50ck1740 FIND v(dout1_50) AT=875.025n

.meas tran vdout1_51ck1740 FIND v(dout1_51) AT=875.025n

.meas tran vdout1_52ck1740 FIND v(dout1_52) AT=875.025n

.meas tran vdout1_53ck1740 FIND v(dout1_53) AT=875.025n

.meas tran vdout1_54ck1740 FIND v(dout1_54) AT=875.025n

.meas tran vdout1_55ck1740 FIND v(dout1_55) AT=875.025n

.meas tran vdout1_56ck1740 FIND v(dout1_56) AT=875.025n

.meas tran vdout1_57ck1740 FIND v(dout1_57) AT=875.025n

.meas tran vdout1_58ck1740 FIND v(dout1_58) AT=875.025n

.meas tran vdout1_59ck1740 FIND v(dout1_59) AT=875.025n

.meas tran vdout1_60ck1740 FIND v(dout1_60) AT=875.025n

.meas tran vdout1_61ck1740 FIND v(dout1_61) AT=875.025n

.meas tran vdout1_62ck1740 FIND v(dout1_62) AT=875.025n

.meas tran vdout1_63ck1740 FIND v(dout1_63) AT=875.025n

.meas tran vdout0_0ck1750 FIND v(dout0_0) AT=880.025n

.meas tran vdout0_1ck1750 FIND v(dout0_1) AT=880.025n

.meas tran vdout0_2ck1750 FIND v(dout0_2) AT=880.025n

.meas tran vdout0_3ck1750 FIND v(dout0_3) AT=880.025n

.meas tran vdout0_4ck1750 FIND v(dout0_4) AT=880.025n

.meas tran vdout0_5ck1750 FIND v(dout0_5) AT=880.025n

.meas tran vdout0_6ck1750 FIND v(dout0_6) AT=880.025n

.meas tran vdout0_7ck1750 FIND v(dout0_7) AT=880.025n

.meas tran vdout0_8ck1750 FIND v(dout0_8) AT=880.025n

.meas tran vdout0_9ck1750 FIND v(dout0_9) AT=880.025n

.meas tran vdout0_10ck1750 FIND v(dout0_10) AT=880.025n

.meas tran vdout0_11ck1750 FIND v(dout0_11) AT=880.025n

.meas tran vdout0_12ck1750 FIND v(dout0_12) AT=880.025n

.meas tran vdout0_13ck1750 FIND v(dout0_13) AT=880.025n

.meas tran vdout0_14ck1750 FIND v(dout0_14) AT=880.025n

.meas tran vdout0_15ck1750 FIND v(dout0_15) AT=880.025n

.meas tran vdout0_16ck1750 FIND v(dout0_16) AT=880.025n

.meas tran vdout0_17ck1750 FIND v(dout0_17) AT=880.025n

.meas tran vdout0_18ck1750 FIND v(dout0_18) AT=880.025n

.meas tran vdout0_19ck1750 FIND v(dout0_19) AT=880.025n

.meas tran vdout0_20ck1750 FIND v(dout0_20) AT=880.025n

.meas tran vdout0_21ck1750 FIND v(dout0_21) AT=880.025n

.meas tran vdout0_22ck1750 FIND v(dout0_22) AT=880.025n

.meas tran vdout0_23ck1750 FIND v(dout0_23) AT=880.025n

.meas tran vdout0_24ck1750 FIND v(dout0_24) AT=880.025n

.meas tran vdout0_25ck1750 FIND v(dout0_25) AT=880.025n

.meas tran vdout0_26ck1750 FIND v(dout0_26) AT=880.025n

.meas tran vdout0_27ck1750 FIND v(dout0_27) AT=880.025n

.meas tran vdout0_28ck1750 FIND v(dout0_28) AT=880.025n

.meas tran vdout0_29ck1750 FIND v(dout0_29) AT=880.025n

.meas tran vdout0_30ck1750 FIND v(dout0_30) AT=880.025n

.meas tran vdout0_31ck1750 FIND v(dout0_31) AT=880.025n

.meas tran vdout0_32ck1750 FIND v(dout0_32) AT=880.025n

.meas tran vdout0_33ck1750 FIND v(dout0_33) AT=880.025n

.meas tran vdout0_34ck1750 FIND v(dout0_34) AT=880.025n

.meas tran vdout0_35ck1750 FIND v(dout0_35) AT=880.025n

.meas tran vdout0_36ck1750 FIND v(dout0_36) AT=880.025n

.meas tran vdout0_37ck1750 FIND v(dout0_37) AT=880.025n

.meas tran vdout0_38ck1750 FIND v(dout0_38) AT=880.025n

.meas tran vdout0_39ck1750 FIND v(dout0_39) AT=880.025n

.meas tran vdout0_40ck1750 FIND v(dout0_40) AT=880.025n

.meas tran vdout0_41ck1750 FIND v(dout0_41) AT=880.025n

.meas tran vdout0_42ck1750 FIND v(dout0_42) AT=880.025n

.meas tran vdout0_43ck1750 FIND v(dout0_43) AT=880.025n

.meas tran vdout0_44ck1750 FIND v(dout0_44) AT=880.025n

.meas tran vdout0_45ck1750 FIND v(dout0_45) AT=880.025n

.meas tran vdout0_46ck1750 FIND v(dout0_46) AT=880.025n

.meas tran vdout0_47ck1750 FIND v(dout0_47) AT=880.025n

.meas tran vdout0_48ck1750 FIND v(dout0_48) AT=880.025n

.meas tran vdout0_49ck1750 FIND v(dout0_49) AT=880.025n

.meas tran vdout0_50ck1750 FIND v(dout0_50) AT=880.025n

.meas tran vdout0_51ck1750 FIND v(dout0_51) AT=880.025n

.meas tran vdout0_52ck1750 FIND v(dout0_52) AT=880.025n

.meas tran vdout0_53ck1750 FIND v(dout0_53) AT=880.025n

.meas tran vdout0_54ck1750 FIND v(dout0_54) AT=880.025n

.meas tran vdout0_55ck1750 FIND v(dout0_55) AT=880.025n

.meas tran vdout0_56ck1750 FIND v(dout0_56) AT=880.025n

.meas tran vdout0_57ck1750 FIND v(dout0_57) AT=880.025n

.meas tran vdout0_58ck1750 FIND v(dout0_58) AT=880.025n

.meas tran vdout0_59ck1750 FIND v(dout0_59) AT=880.025n

.meas tran vdout0_60ck1750 FIND v(dout0_60) AT=880.025n

.meas tran vdout0_61ck1750 FIND v(dout0_61) AT=880.025n

.meas tran vdout0_62ck1750 FIND v(dout0_62) AT=880.025n

.meas tran vdout0_63ck1750 FIND v(dout0_63) AT=880.025n

.meas tran vdout1_0ck1750 FIND v(dout1_0) AT=880.025n

.meas tran vdout1_1ck1750 FIND v(dout1_1) AT=880.025n

.meas tran vdout1_2ck1750 FIND v(dout1_2) AT=880.025n

.meas tran vdout1_3ck1750 FIND v(dout1_3) AT=880.025n

.meas tran vdout1_4ck1750 FIND v(dout1_4) AT=880.025n

.meas tran vdout1_5ck1750 FIND v(dout1_5) AT=880.025n

.meas tran vdout1_6ck1750 FIND v(dout1_6) AT=880.025n

.meas tran vdout1_7ck1750 FIND v(dout1_7) AT=880.025n

.meas tran vdout1_8ck1750 FIND v(dout1_8) AT=880.025n

.meas tran vdout1_9ck1750 FIND v(dout1_9) AT=880.025n

.meas tran vdout1_10ck1750 FIND v(dout1_10) AT=880.025n

.meas tran vdout1_11ck1750 FIND v(dout1_11) AT=880.025n

.meas tran vdout1_12ck1750 FIND v(dout1_12) AT=880.025n

.meas tran vdout1_13ck1750 FIND v(dout1_13) AT=880.025n

.meas tran vdout1_14ck1750 FIND v(dout1_14) AT=880.025n

.meas tran vdout1_15ck1750 FIND v(dout1_15) AT=880.025n

.meas tran vdout1_16ck1750 FIND v(dout1_16) AT=880.025n

.meas tran vdout1_17ck1750 FIND v(dout1_17) AT=880.025n

.meas tran vdout1_18ck1750 FIND v(dout1_18) AT=880.025n

.meas tran vdout1_19ck1750 FIND v(dout1_19) AT=880.025n

.meas tran vdout1_20ck1750 FIND v(dout1_20) AT=880.025n

.meas tran vdout1_21ck1750 FIND v(dout1_21) AT=880.025n

.meas tran vdout1_22ck1750 FIND v(dout1_22) AT=880.025n

.meas tran vdout1_23ck1750 FIND v(dout1_23) AT=880.025n

.meas tran vdout1_24ck1750 FIND v(dout1_24) AT=880.025n

.meas tran vdout1_25ck1750 FIND v(dout1_25) AT=880.025n

.meas tran vdout1_26ck1750 FIND v(dout1_26) AT=880.025n

.meas tran vdout1_27ck1750 FIND v(dout1_27) AT=880.025n

.meas tran vdout1_28ck1750 FIND v(dout1_28) AT=880.025n

.meas tran vdout1_29ck1750 FIND v(dout1_29) AT=880.025n

.meas tran vdout1_30ck1750 FIND v(dout1_30) AT=880.025n

.meas tran vdout1_31ck1750 FIND v(dout1_31) AT=880.025n

.meas tran vdout1_32ck1750 FIND v(dout1_32) AT=880.025n

.meas tran vdout1_33ck1750 FIND v(dout1_33) AT=880.025n

.meas tran vdout1_34ck1750 FIND v(dout1_34) AT=880.025n

.meas tran vdout1_35ck1750 FIND v(dout1_35) AT=880.025n

.meas tran vdout1_36ck1750 FIND v(dout1_36) AT=880.025n

.meas tran vdout1_37ck1750 FIND v(dout1_37) AT=880.025n

.meas tran vdout1_38ck1750 FIND v(dout1_38) AT=880.025n

.meas tran vdout1_39ck1750 FIND v(dout1_39) AT=880.025n

.meas tran vdout1_40ck1750 FIND v(dout1_40) AT=880.025n

.meas tran vdout1_41ck1750 FIND v(dout1_41) AT=880.025n

.meas tran vdout1_42ck1750 FIND v(dout1_42) AT=880.025n

.meas tran vdout1_43ck1750 FIND v(dout1_43) AT=880.025n

.meas tran vdout1_44ck1750 FIND v(dout1_44) AT=880.025n

.meas tran vdout1_45ck1750 FIND v(dout1_45) AT=880.025n

.meas tran vdout1_46ck1750 FIND v(dout1_46) AT=880.025n

.meas tran vdout1_47ck1750 FIND v(dout1_47) AT=880.025n

.meas tran vdout1_48ck1750 FIND v(dout1_48) AT=880.025n

.meas tran vdout1_49ck1750 FIND v(dout1_49) AT=880.025n

.meas tran vdout1_50ck1750 FIND v(dout1_50) AT=880.025n

.meas tran vdout1_51ck1750 FIND v(dout1_51) AT=880.025n

.meas tran vdout1_52ck1750 FIND v(dout1_52) AT=880.025n

.meas tran vdout1_53ck1750 FIND v(dout1_53) AT=880.025n

.meas tran vdout1_54ck1750 FIND v(dout1_54) AT=880.025n

.meas tran vdout1_55ck1750 FIND v(dout1_55) AT=880.025n

.meas tran vdout1_56ck1750 FIND v(dout1_56) AT=880.025n

.meas tran vdout1_57ck1750 FIND v(dout1_57) AT=880.025n

.meas tran vdout1_58ck1750 FIND v(dout1_58) AT=880.025n

.meas tran vdout1_59ck1750 FIND v(dout1_59) AT=880.025n

.meas tran vdout1_60ck1750 FIND v(dout1_60) AT=880.025n

.meas tran vdout1_61ck1750 FIND v(dout1_61) AT=880.025n

.meas tran vdout1_62ck1750 FIND v(dout1_62) AT=880.025n

.meas tran vdout1_63ck1750 FIND v(dout1_63) AT=880.025n

.meas tran vdout0_0ck1760 FIND v(dout0_0) AT=885.025n

.meas tran vdout0_1ck1760 FIND v(dout0_1) AT=885.025n

.meas tran vdout0_2ck1760 FIND v(dout0_2) AT=885.025n

.meas tran vdout0_3ck1760 FIND v(dout0_3) AT=885.025n

.meas tran vdout0_4ck1760 FIND v(dout0_4) AT=885.025n

.meas tran vdout0_5ck1760 FIND v(dout0_5) AT=885.025n

.meas tran vdout0_6ck1760 FIND v(dout0_6) AT=885.025n

.meas tran vdout0_7ck1760 FIND v(dout0_7) AT=885.025n

.meas tran vdout0_8ck1760 FIND v(dout0_8) AT=885.025n

.meas tran vdout0_9ck1760 FIND v(dout0_9) AT=885.025n

.meas tran vdout0_10ck1760 FIND v(dout0_10) AT=885.025n

.meas tran vdout0_11ck1760 FIND v(dout0_11) AT=885.025n

.meas tran vdout0_12ck1760 FIND v(dout0_12) AT=885.025n

.meas tran vdout0_13ck1760 FIND v(dout0_13) AT=885.025n

.meas tran vdout0_14ck1760 FIND v(dout0_14) AT=885.025n

.meas tran vdout0_15ck1760 FIND v(dout0_15) AT=885.025n

.meas tran vdout0_16ck1760 FIND v(dout0_16) AT=885.025n

.meas tran vdout0_17ck1760 FIND v(dout0_17) AT=885.025n

.meas tran vdout0_18ck1760 FIND v(dout0_18) AT=885.025n

.meas tran vdout0_19ck1760 FIND v(dout0_19) AT=885.025n

.meas tran vdout0_20ck1760 FIND v(dout0_20) AT=885.025n

.meas tran vdout0_21ck1760 FIND v(dout0_21) AT=885.025n

.meas tran vdout0_22ck1760 FIND v(dout0_22) AT=885.025n

.meas tran vdout0_23ck1760 FIND v(dout0_23) AT=885.025n

.meas tran vdout0_24ck1760 FIND v(dout0_24) AT=885.025n

.meas tran vdout0_25ck1760 FIND v(dout0_25) AT=885.025n

.meas tran vdout0_26ck1760 FIND v(dout0_26) AT=885.025n

.meas tran vdout0_27ck1760 FIND v(dout0_27) AT=885.025n

.meas tran vdout0_28ck1760 FIND v(dout0_28) AT=885.025n

.meas tran vdout0_29ck1760 FIND v(dout0_29) AT=885.025n

.meas tran vdout0_30ck1760 FIND v(dout0_30) AT=885.025n

.meas tran vdout0_31ck1760 FIND v(dout0_31) AT=885.025n

.meas tran vdout0_32ck1760 FIND v(dout0_32) AT=885.025n

.meas tran vdout0_33ck1760 FIND v(dout0_33) AT=885.025n

.meas tran vdout0_34ck1760 FIND v(dout0_34) AT=885.025n

.meas tran vdout0_35ck1760 FIND v(dout0_35) AT=885.025n

.meas tran vdout0_36ck1760 FIND v(dout0_36) AT=885.025n

.meas tran vdout0_37ck1760 FIND v(dout0_37) AT=885.025n

.meas tran vdout0_38ck1760 FIND v(dout0_38) AT=885.025n

.meas tran vdout0_39ck1760 FIND v(dout0_39) AT=885.025n

.meas tran vdout0_40ck1760 FIND v(dout0_40) AT=885.025n

.meas tran vdout0_41ck1760 FIND v(dout0_41) AT=885.025n

.meas tran vdout0_42ck1760 FIND v(dout0_42) AT=885.025n

.meas tran vdout0_43ck1760 FIND v(dout0_43) AT=885.025n

.meas tran vdout0_44ck1760 FIND v(dout0_44) AT=885.025n

.meas tran vdout0_45ck1760 FIND v(dout0_45) AT=885.025n

.meas tran vdout0_46ck1760 FIND v(dout0_46) AT=885.025n

.meas tran vdout0_47ck1760 FIND v(dout0_47) AT=885.025n

.meas tran vdout0_48ck1760 FIND v(dout0_48) AT=885.025n

.meas tran vdout0_49ck1760 FIND v(dout0_49) AT=885.025n

.meas tran vdout0_50ck1760 FIND v(dout0_50) AT=885.025n

.meas tran vdout0_51ck1760 FIND v(dout0_51) AT=885.025n

.meas tran vdout0_52ck1760 FIND v(dout0_52) AT=885.025n

.meas tran vdout0_53ck1760 FIND v(dout0_53) AT=885.025n

.meas tran vdout0_54ck1760 FIND v(dout0_54) AT=885.025n

.meas tran vdout0_55ck1760 FIND v(dout0_55) AT=885.025n

.meas tran vdout0_56ck1760 FIND v(dout0_56) AT=885.025n

.meas tran vdout0_57ck1760 FIND v(dout0_57) AT=885.025n

.meas tran vdout0_58ck1760 FIND v(dout0_58) AT=885.025n

.meas tran vdout0_59ck1760 FIND v(dout0_59) AT=885.025n

.meas tran vdout0_60ck1760 FIND v(dout0_60) AT=885.025n

.meas tran vdout0_61ck1760 FIND v(dout0_61) AT=885.025n

.meas tran vdout0_62ck1760 FIND v(dout0_62) AT=885.025n

.meas tran vdout0_63ck1760 FIND v(dout0_63) AT=885.025n

.meas tran vdout0_0ck1770 FIND v(dout0_0) AT=890.025n

.meas tran vdout0_1ck1770 FIND v(dout0_1) AT=890.025n

.meas tran vdout0_2ck1770 FIND v(dout0_2) AT=890.025n

.meas tran vdout0_3ck1770 FIND v(dout0_3) AT=890.025n

.meas tran vdout0_4ck1770 FIND v(dout0_4) AT=890.025n

.meas tran vdout0_5ck1770 FIND v(dout0_5) AT=890.025n

.meas tran vdout0_6ck1770 FIND v(dout0_6) AT=890.025n

.meas tran vdout0_7ck1770 FIND v(dout0_7) AT=890.025n

.meas tran vdout0_8ck1770 FIND v(dout0_8) AT=890.025n

.meas tran vdout0_9ck1770 FIND v(dout0_9) AT=890.025n

.meas tran vdout0_10ck1770 FIND v(dout0_10) AT=890.025n

.meas tran vdout0_11ck1770 FIND v(dout0_11) AT=890.025n

.meas tran vdout0_12ck1770 FIND v(dout0_12) AT=890.025n

.meas tran vdout0_13ck1770 FIND v(dout0_13) AT=890.025n

.meas tran vdout0_14ck1770 FIND v(dout0_14) AT=890.025n

.meas tran vdout0_15ck1770 FIND v(dout0_15) AT=890.025n

.meas tran vdout0_16ck1770 FIND v(dout0_16) AT=890.025n

.meas tran vdout0_17ck1770 FIND v(dout0_17) AT=890.025n

.meas tran vdout0_18ck1770 FIND v(dout0_18) AT=890.025n

.meas tran vdout0_19ck1770 FIND v(dout0_19) AT=890.025n

.meas tran vdout0_20ck1770 FIND v(dout0_20) AT=890.025n

.meas tran vdout0_21ck1770 FIND v(dout0_21) AT=890.025n

.meas tran vdout0_22ck1770 FIND v(dout0_22) AT=890.025n

.meas tran vdout0_23ck1770 FIND v(dout0_23) AT=890.025n

.meas tran vdout0_24ck1770 FIND v(dout0_24) AT=890.025n

.meas tran vdout0_25ck1770 FIND v(dout0_25) AT=890.025n

.meas tran vdout0_26ck1770 FIND v(dout0_26) AT=890.025n

.meas tran vdout0_27ck1770 FIND v(dout0_27) AT=890.025n

.meas tran vdout0_28ck1770 FIND v(dout0_28) AT=890.025n

.meas tran vdout0_29ck1770 FIND v(dout0_29) AT=890.025n

.meas tran vdout0_30ck1770 FIND v(dout0_30) AT=890.025n

.meas tran vdout0_31ck1770 FIND v(dout0_31) AT=890.025n

.meas tran vdout0_32ck1770 FIND v(dout0_32) AT=890.025n

.meas tran vdout0_33ck1770 FIND v(dout0_33) AT=890.025n

.meas tran vdout0_34ck1770 FIND v(dout0_34) AT=890.025n

.meas tran vdout0_35ck1770 FIND v(dout0_35) AT=890.025n

.meas tran vdout0_36ck1770 FIND v(dout0_36) AT=890.025n

.meas tran vdout0_37ck1770 FIND v(dout0_37) AT=890.025n

.meas tran vdout0_38ck1770 FIND v(dout0_38) AT=890.025n

.meas tran vdout0_39ck1770 FIND v(dout0_39) AT=890.025n

.meas tran vdout0_40ck1770 FIND v(dout0_40) AT=890.025n

.meas tran vdout0_41ck1770 FIND v(dout0_41) AT=890.025n

.meas tran vdout0_42ck1770 FIND v(dout0_42) AT=890.025n

.meas tran vdout0_43ck1770 FIND v(dout0_43) AT=890.025n

.meas tran vdout0_44ck1770 FIND v(dout0_44) AT=890.025n

.meas tran vdout0_45ck1770 FIND v(dout0_45) AT=890.025n

.meas tran vdout0_46ck1770 FIND v(dout0_46) AT=890.025n

.meas tran vdout0_47ck1770 FIND v(dout0_47) AT=890.025n

.meas tran vdout0_48ck1770 FIND v(dout0_48) AT=890.025n

.meas tran vdout0_49ck1770 FIND v(dout0_49) AT=890.025n

.meas tran vdout0_50ck1770 FIND v(dout0_50) AT=890.025n

.meas tran vdout0_51ck1770 FIND v(dout0_51) AT=890.025n

.meas tran vdout0_52ck1770 FIND v(dout0_52) AT=890.025n

.meas tran vdout0_53ck1770 FIND v(dout0_53) AT=890.025n

.meas tran vdout0_54ck1770 FIND v(dout0_54) AT=890.025n

.meas tran vdout0_55ck1770 FIND v(dout0_55) AT=890.025n

.meas tran vdout0_56ck1770 FIND v(dout0_56) AT=890.025n

.meas tran vdout0_57ck1770 FIND v(dout0_57) AT=890.025n

.meas tran vdout0_58ck1770 FIND v(dout0_58) AT=890.025n

.meas tran vdout0_59ck1770 FIND v(dout0_59) AT=890.025n

.meas tran vdout0_60ck1770 FIND v(dout0_60) AT=890.025n

.meas tran vdout0_61ck1770 FIND v(dout0_61) AT=890.025n

.meas tran vdout0_62ck1770 FIND v(dout0_62) AT=890.025n

.meas tran vdout0_63ck1770 FIND v(dout0_63) AT=890.025n

.meas tran vdout0_0ck1780 FIND v(dout0_0) AT=895.025n

.meas tran vdout0_1ck1780 FIND v(dout0_1) AT=895.025n

.meas tran vdout0_2ck1780 FIND v(dout0_2) AT=895.025n

.meas tran vdout0_3ck1780 FIND v(dout0_3) AT=895.025n

.meas tran vdout0_4ck1780 FIND v(dout0_4) AT=895.025n

.meas tran vdout0_5ck1780 FIND v(dout0_5) AT=895.025n

.meas tran vdout0_6ck1780 FIND v(dout0_6) AT=895.025n

.meas tran vdout0_7ck1780 FIND v(dout0_7) AT=895.025n

.meas tran vdout0_8ck1780 FIND v(dout0_8) AT=895.025n

.meas tran vdout0_9ck1780 FIND v(dout0_9) AT=895.025n

.meas tran vdout0_10ck1780 FIND v(dout0_10) AT=895.025n

.meas tran vdout0_11ck1780 FIND v(dout0_11) AT=895.025n

.meas tran vdout0_12ck1780 FIND v(dout0_12) AT=895.025n

.meas tran vdout0_13ck1780 FIND v(dout0_13) AT=895.025n

.meas tran vdout0_14ck1780 FIND v(dout0_14) AT=895.025n

.meas tran vdout0_15ck1780 FIND v(dout0_15) AT=895.025n

.meas tran vdout0_16ck1780 FIND v(dout0_16) AT=895.025n

.meas tran vdout0_17ck1780 FIND v(dout0_17) AT=895.025n

.meas tran vdout0_18ck1780 FIND v(dout0_18) AT=895.025n

.meas tran vdout0_19ck1780 FIND v(dout0_19) AT=895.025n

.meas tran vdout0_20ck1780 FIND v(dout0_20) AT=895.025n

.meas tran vdout0_21ck1780 FIND v(dout0_21) AT=895.025n

.meas tran vdout0_22ck1780 FIND v(dout0_22) AT=895.025n

.meas tran vdout0_23ck1780 FIND v(dout0_23) AT=895.025n

.meas tran vdout0_24ck1780 FIND v(dout0_24) AT=895.025n

.meas tran vdout0_25ck1780 FIND v(dout0_25) AT=895.025n

.meas tran vdout0_26ck1780 FIND v(dout0_26) AT=895.025n

.meas tran vdout0_27ck1780 FIND v(dout0_27) AT=895.025n

.meas tran vdout0_28ck1780 FIND v(dout0_28) AT=895.025n

.meas tran vdout0_29ck1780 FIND v(dout0_29) AT=895.025n

.meas tran vdout0_30ck1780 FIND v(dout0_30) AT=895.025n

.meas tran vdout0_31ck1780 FIND v(dout0_31) AT=895.025n

.meas tran vdout0_32ck1780 FIND v(dout0_32) AT=895.025n

.meas tran vdout0_33ck1780 FIND v(dout0_33) AT=895.025n

.meas tran vdout0_34ck1780 FIND v(dout0_34) AT=895.025n

.meas tran vdout0_35ck1780 FIND v(dout0_35) AT=895.025n

.meas tran vdout0_36ck1780 FIND v(dout0_36) AT=895.025n

.meas tran vdout0_37ck1780 FIND v(dout0_37) AT=895.025n

.meas tran vdout0_38ck1780 FIND v(dout0_38) AT=895.025n

.meas tran vdout0_39ck1780 FIND v(dout0_39) AT=895.025n

.meas tran vdout0_40ck1780 FIND v(dout0_40) AT=895.025n

.meas tran vdout0_41ck1780 FIND v(dout0_41) AT=895.025n

.meas tran vdout0_42ck1780 FIND v(dout0_42) AT=895.025n

.meas tran vdout0_43ck1780 FIND v(dout0_43) AT=895.025n

.meas tran vdout0_44ck1780 FIND v(dout0_44) AT=895.025n

.meas tran vdout0_45ck1780 FIND v(dout0_45) AT=895.025n

.meas tran vdout0_46ck1780 FIND v(dout0_46) AT=895.025n

.meas tran vdout0_47ck1780 FIND v(dout0_47) AT=895.025n

.meas tran vdout0_48ck1780 FIND v(dout0_48) AT=895.025n

.meas tran vdout0_49ck1780 FIND v(dout0_49) AT=895.025n

.meas tran vdout0_50ck1780 FIND v(dout0_50) AT=895.025n

.meas tran vdout0_51ck1780 FIND v(dout0_51) AT=895.025n

.meas tran vdout0_52ck1780 FIND v(dout0_52) AT=895.025n

.meas tran vdout0_53ck1780 FIND v(dout0_53) AT=895.025n

.meas tran vdout0_54ck1780 FIND v(dout0_54) AT=895.025n

.meas tran vdout0_55ck1780 FIND v(dout0_55) AT=895.025n

.meas tran vdout0_56ck1780 FIND v(dout0_56) AT=895.025n

.meas tran vdout0_57ck1780 FIND v(dout0_57) AT=895.025n

.meas tran vdout0_58ck1780 FIND v(dout0_58) AT=895.025n

.meas tran vdout0_59ck1780 FIND v(dout0_59) AT=895.025n

.meas tran vdout0_60ck1780 FIND v(dout0_60) AT=895.025n

.meas tran vdout0_61ck1780 FIND v(dout0_61) AT=895.025n

.meas tran vdout0_62ck1780 FIND v(dout0_62) AT=895.025n

.meas tran vdout0_63ck1780 FIND v(dout0_63) AT=895.025n

.meas tran vdout1_0ck1780 FIND v(dout1_0) AT=895.025n

.meas tran vdout1_1ck1780 FIND v(dout1_1) AT=895.025n

.meas tran vdout1_2ck1780 FIND v(dout1_2) AT=895.025n

.meas tran vdout1_3ck1780 FIND v(dout1_3) AT=895.025n

.meas tran vdout1_4ck1780 FIND v(dout1_4) AT=895.025n

.meas tran vdout1_5ck1780 FIND v(dout1_5) AT=895.025n

.meas tran vdout1_6ck1780 FIND v(dout1_6) AT=895.025n

.meas tran vdout1_7ck1780 FIND v(dout1_7) AT=895.025n

.meas tran vdout1_8ck1780 FIND v(dout1_8) AT=895.025n

.meas tran vdout1_9ck1780 FIND v(dout1_9) AT=895.025n

.meas tran vdout1_10ck1780 FIND v(dout1_10) AT=895.025n

.meas tran vdout1_11ck1780 FIND v(dout1_11) AT=895.025n

.meas tran vdout1_12ck1780 FIND v(dout1_12) AT=895.025n

.meas tran vdout1_13ck1780 FIND v(dout1_13) AT=895.025n

.meas tran vdout1_14ck1780 FIND v(dout1_14) AT=895.025n

.meas tran vdout1_15ck1780 FIND v(dout1_15) AT=895.025n

.meas tran vdout1_16ck1780 FIND v(dout1_16) AT=895.025n

.meas tran vdout1_17ck1780 FIND v(dout1_17) AT=895.025n

.meas tran vdout1_18ck1780 FIND v(dout1_18) AT=895.025n

.meas tran vdout1_19ck1780 FIND v(dout1_19) AT=895.025n

.meas tran vdout1_20ck1780 FIND v(dout1_20) AT=895.025n

.meas tran vdout1_21ck1780 FIND v(dout1_21) AT=895.025n

.meas tran vdout1_22ck1780 FIND v(dout1_22) AT=895.025n

.meas tran vdout1_23ck1780 FIND v(dout1_23) AT=895.025n

.meas tran vdout1_24ck1780 FIND v(dout1_24) AT=895.025n

.meas tran vdout1_25ck1780 FIND v(dout1_25) AT=895.025n

.meas tran vdout1_26ck1780 FIND v(dout1_26) AT=895.025n

.meas tran vdout1_27ck1780 FIND v(dout1_27) AT=895.025n

.meas tran vdout1_28ck1780 FIND v(dout1_28) AT=895.025n

.meas tran vdout1_29ck1780 FIND v(dout1_29) AT=895.025n

.meas tran vdout1_30ck1780 FIND v(dout1_30) AT=895.025n

.meas tran vdout1_31ck1780 FIND v(dout1_31) AT=895.025n

.meas tran vdout1_32ck1780 FIND v(dout1_32) AT=895.025n

.meas tran vdout1_33ck1780 FIND v(dout1_33) AT=895.025n

.meas tran vdout1_34ck1780 FIND v(dout1_34) AT=895.025n

.meas tran vdout1_35ck1780 FIND v(dout1_35) AT=895.025n

.meas tran vdout1_36ck1780 FIND v(dout1_36) AT=895.025n

.meas tran vdout1_37ck1780 FIND v(dout1_37) AT=895.025n

.meas tran vdout1_38ck1780 FIND v(dout1_38) AT=895.025n

.meas tran vdout1_39ck1780 FIND v(dout1_39) AT=895.025n

.meas tran vdout1_40ck1780 FIND v(dout1_40) AT=895.025n

.meas tran vdout1_41ck1780 FIND v(dout1_41) AT=895.025n

.meas tran vdout1_42ck1780 FIND v(dout1_42) AT=895.025n

.meas tran vdout1_43ck1780 FIND v(dout1_43) AT=895.025n

.meas tran vdout1_44ck1780 FIND v(dout1_44) AT=895.025n

.meas tran vdout1_45ck1780 FIND v(dout1_45) AT=895.025n

.meas tran vdout1_46ck1780 FIND v(dout1_46) AT=895.025n

.meas tran vdout1_47ck1780 FIND v(dout1_47) AT=895.025n

.meas tran vdout1_48ck1780 FIND v(dout1_48) AT=895.025n

.meas tran vdout1_49ck1780 FIND v(dout1_49) AT=895.025n

.meas tran vdout1_50ck1780 FIND v(dout1_50) AT=895.025n

.meas tran vdout1_51ck1780 FIND v(dout1_51) AT=895.025n

.meas tran vdout1_52ck1780 FIND v(dout1_52) AT=895.025n

.meas tran vdout1_53ck1780 FIND v(dout1_53) AT=895.025n

.meas tran vdout1_54ck1780 FIND v(dout1_54) AT=895.025n

.meas tran vdout1_55ck1780 FIND v(dout1_55) AT=895.025n

.meas tran vdout1_56ck1780 FIND v(dout1_56) AT=895.025n

.meas tran vdout1_57ck1780 FIND v(dout1_57) AT=895.025n

.meas tran vdout1_58ck1780 FIND v(dout1_58) AT=895.025n

.meas tran vdout1_59ck1780 FIND v(dout1_59) AT=895.025n

.meas tran vdout1_60ck1780 FIND v(dout1_60) AT=895.025n

.meas tran vdout1_61ck1780 FIND v(dout1_61) AT=895.025n

.meas tran vdout1_62ck1780 FIND v(dout1_62) AT=895.025n

.meas tran vdout1_63ck1780 FIND v(dout1_63) AT=895.025n

.meas tran vdout0_0ck1790 FIND v(dout0_0) AT=900.025n

.meas tran vdout0_1ck1790 FIND v(dout0_1) AT=900.025n

.meas tran vdout0_2ck1790 FIND v(dout0_2) AT=900.025n

.meas tran vdout0_3ck1790 FIND v(dout0_3) AT=900.025n

.meas tran vdout0_4ck1790 FIND v(dout0_4) AT=900.025n

.meas tran vdout0_5ck1790 FIND v(dout0_5) AT=900.025n

.meas tran vdout0_6ck1790 FIND v(dout0_6) AT=900.025n

.meas tran vdout0_7ck1790 FIND v(dout0_7) AT=900.025n

.meas tran vdout0_8ck1790 FIND v(dout0_8) AT=900.025n

.meas tran vdout0_9ck1790 FIND v(dout0_9) AT=900.025n

.meas tran vdout0_10ck1790 FIND v(dout0_10) AT=900.025n

.meas tran vdout0_11ck1790 FIND v(dout0_11) AT=900.025n

.meas tran vdout0_12ck1790 FIND v(dout0_12) AT=900.025n

.meas tran vdout0_13ck1790 FIND v(dout0_13) AT=900.025n

.meas tran vdout0_14ck1790 FIND v(dout0_14) AT=900.025n

.meas tran vdout0_15ck1790 FIND v(dout0_15) AT=900.025n

.meas tran vdout0_16ck1790 FIND v(dout0_16) AT=900.025n

.meas tran vdout0_17ck1790 FIND v(dout0_17) AT=900.025n

.meas tran vdout0_18ck1790 FIND v(dout0_18) AT=900.025n

.meas tran vdout0_19ck1790 FIND v(dout0_19) AT=900.025n

.meas tran vdout0_20ck1790 FIND v(dout0_20) AT=900.025n

.meas tran vdout0_21ck1790 FIND v(dout0_21) AT=900.025n

.meas tran vdout0_22ck1790 FIND v(dout0_22) AT=900.025n

.meas tran vdout0_23ck1790 FIND v(dout0_23) AT=900.025n

.meas tran vdout0_24ck1790 FIND v(dout0_24) AT=900.025n

.meas tran vdout0_25ck1790 FIND v(dout0_25) AT=900.025n

.meas tran vdout0_26ck1790 FIND v(dout0_26) AT=900.025n

.meas tran vdout0_27ck1790 FIND v(dout0_27) AT=900.025n

.meas tran vdout0_28ck1790 FIND v(dout0_28) AT=900.025n

.meas tran vdout0_29ck1790 FIND v(dout0_29) AT=900.025n

.meas tran vdout0_30ck1790 FIND v(dout0_30) AT=900.025n

.meas tran vdout0_31ck1790 FIND v(dout0_31) AT=900.025n

.meas tran vdout0_32ck1790 FIND v(dout0_32) AT=900.025n

.meas tran vdout0_33ck1790 FIND v(dout0_33) AT=900.025n

.meas tran vdout0_34ck1790 FIND v(dout0_34) AT=900.025n

.meas tran vdout0_35ck1790 FIND v(dout0_35) AT=900.025n

.meas tran vdout0_36ck1790 FIND v(dout0_36) AT=900.025n

.meas tran vdout0_37ck1790 FIND v(dout0_37) AT=900.025n

.meas tran vdout0_38ck1790 FIND v(dout0_38) AT=900.025n

.meas tran vdout0_39ck1790 FIND v(dout0_39) AT=900.025n

.meas tran vdout0_40ck1790 FIND v(dout0_40) AT=900.025n

.meas tran vdout0_41ck1790 FIND v(dout0_41) AT=900.025n

.meas tran vdout0_42ck1790 FIND v(dout0_42) AT=900.025n

.meas tran vdout0_43ck1790 FIND v(dout0_43) AT=900.025n

.meas tran vdout0_44ck1790 FIND v(dout0_44) AT=900.025n

.meas tran vdout0_45ck1790 FIND v(dout0_45) AT=900.025n

.meas tran vdout0_46ck1790 FIND v(dout0_46) AT=900.025n

.meas tran vdout0_47ck1790 FIND v(dout0_47) AT=900.025n

.meas tran vdout0_48ck1790 FIND v(dout0_48) AT=900.025n

.meas tran vdout0_49ck1790 FIND v(dout0_49) AT=900.025n

.meas tran vdout0_50ck1790 FIND v(dout0_50) AT=900.025n

.meas tran vdout0_51ck1790 FIND v(dout0_51) AT=900.025n

.meas tran vdout0_52ck1790 FIND v(dout0_52) AT=900.025n

.meas tran vdout0_53ck1790 FIND v(dout0_53) AT=900.025n

.meas tran vdout0_54ck1790 FIND v(dout0_54) AT=900.025n

.meas tran vdout0_55ck1790 FIND v(dout0_55) AT=900.025n

.meas tran vdout0_56ck1790 FIND v(dout0_56) AT=900.025n

.meas tran vdout0_57ck1790 FIND v(dout0_57) AT=900.025n

.meas tran vdout0_58ck1790 FIND v(dout0_58) AT=900.025n

.meas tran vdout0_59ck1790 FIND v(dout0_59) AT=900.025n

.meas tran vdout0_60ck1790 FIND v(dout0_60) AT=900.025n

.meas tran vdout0_61ck1790 FIND v(dout0_61) AT=900.025n

.meas tran vdout0_62ck1790 FIND v(dout0_62) AT=900.025n

.meas tran vdout0_63ck1790 FIND v(dout0_63) AT=900.025n

.meas tran vdout1_0ck1790 FIND v(dout1_0) AT=900.025n

.meas tran vdout1_1ck1790 FIND v(dout1_1) AT=900.025n

.meas tran vdout1_2ck1790 FIND v(dout1_2) AT=900.025n

.meas tran vdout1_3ck1790 FIND v(dout1_3) AT=900.025n

.meas tran vdout1_4ck1790 FIND v(dout1_4) AT=900.025n

.meas tran vdout1_5ck1790 FIND v(dout1_5) AT=900.025n

.meas tran vdout1_6ck1790 FIND v(dout1_6) AT=900.025n

.meas tran vdout1_7ck1790 FIND v(dout1_7) AT=900.025n

.meas tran vdout1_8ck1790 FIND v(dout1_8) AT=900.025n

.meas tran vdout1_9ck1790 FIND v(dout1_9) AT=900.025n

.meas tran vdout1_10ck1790 FIND v(dout1_10) AT=900.025n

.meas tran vdout1_11ck1790 FIND v(dout1_11) AT=900.025n

.meas tran vdout1_12ck1790 FIND v(dout1_12) AT=900.025n

.meas tran vdout1_13ck1790 FIND v(dout1_13) AT=900.025n

.meas tran vdout1_14ck1790 FIND v(dout1_14) AT=900.025n

.meas tran vdout1_15ck1790 FIND v(dout1_15) AT=900.025n

.meas tran vdout1_16ck1790 FIND v(dout1_16) AT=900.025n

.meas tran vdout1_17ck1790 FIND v(dout1_17) AT=900.025n

.meas tran vdout1_18ck1790 FIND v(dout1_18) AT=900.025n

.meas tran vdout1_19ck1790 FIND v(dout1_19) AT=900.025n

.meas tran vdout1_20ck1790 FIND v(dout1_20) AT=900.025n

.meas tran vdout1_21ck1790 FIND v(dout1_21) AT=900.025n

.meas tran vdout1_22ck1790 FIND v(dout1_22) AT=900.025n

.meas tran vdout1_23ck1790 FIND v(dout1_23) AT=900.025n

.meas tran vdout1_24ck1790 FIND v(dout1_24) AT=900.025n

.meas tran vdout1_25ck1790 FIND v(dout1_25) AT=900.025n

.meas tran vdout1_26ck1790 FIND v(dout1_26) AT=900.025n

.meas tran vdout1_27ck1790 FIND v(dout1_27) AT=900.025n

.meas tran vdout1_28ck1790 FIND v(dout1_28) AT=900.025n

.meas tran vdout1_29ck1790 FIND v(dout1_29) AT=900.025n

.meas tran vdout1_30ck1790 FIND v(dout1_30) AT=900.025n

.meas tran vdout1_31ck1790 FIND v(dout1_31) AT=900.025n

.meas tran vdout1_32ck1790 FIND v(dout1_32) AT=900.025n

.meas tran vdout1_33ck1790 FIND v(dout1_33) AT=900.025n

.meas tran vdout1_34ck1790 FIND v(dout1_34) AT=900.025n

.meas tran vdout1_35ck1790 FIND v(dout1_35) AT=900.025n

.meas tran vdout1_36ck1790 FIND v(dout1_36) AT=900.025n

.meas tran vdout1_37ck1790 FIND v(dout1_37) AT=900.025n

.meas tran vdout1_38ck1790 FIND v(dout1_38) AT=900.025n

.meas tran vdout1_39ck1790 FIND v(dout1_39) AT=900.025n

.meas tran vdout1_40ck1790 FIND v(dout1_40) AT=900.025n

.meas tran vdout1_41ck1790 FIND v(dout1_41) AT=900.025n

.meas tran vdout1_42ck1790 FIND v(dout1_42) AT=900.025n

.meas tran vdout1_43ck1790 FIND v(dout1_43) AT=900.025n

.meas tran vdout1_44ck1790 FIND v(dout1_44) AT=900.025n

.meas tran vdout1_45ck1790 FIND v(dout1_45) AT=900.025n

.meas tran vdout1_46ck1790 FIND v(dout1_46) AT=900.025n

.meas tran vdout1_47ck1790 FIND v(dout1_47) AT=900.025n

.meas tran vdout1_48ck1790 FIND v(dout1_48) AT=900.025n

.meas tran vdout1_49ck1790 FIND v(dout1_49) AT=900.025n

.meas tran vdout1_50ck1790 FIND v(dout1_50) AT=900.025n

.meas tran vdout1_51ck1790 FIND v(dout1_51) AT=900.025n

.meas tran vdout1_52ck1790 FIND v(dout1_52) AT=900.025n

.meas tran vdout1_53ck1790 FIND v(dout1_53) AT=900.025n

.meas tran vdout1_54ck1790 FIND v(dout1_54) AT=900.025n

.meas tran vdout1_55ck1790 FIND v(dout1_55) AT=900.025n

.meas tran vdout1_56ck1790 FIND v(dout1_56) AT=900.025n

.meas tran vdout1_57ck1790 FIND v(dout1_57) AT=900.025n

.meas tran vdout1_58ck1790 FIND v(dout1_58) AT=900.025n

.meas tran vdout1_59ck1790 FIND v(dout1_59) AT=900.025n

.meas tran vdout1_60ck1790 FIND v(dout1_60) AT=900.025n

.meas tran vdout1_61ck1790 FIND v(dout1_61) AT=900.025n

.meas tran vdout1_62ck1790 FIND v(dout1_62) AT=900.025n

.meas tran vdout1_63ck1790 FIND v(dout1_63) AT=900.025n

.meas tran vdout0_0ck1800 FIND v(dout0_0) AT=905.025n

.meas tran vdout0_1ck1800 FIND v(dout0_1) AT=905.025n

.meas tran vdout0_2ck1800 FIND v(dout0_2) AT=905.025n

.meas tran vdout0_3ck1800 FIND v(dout0_3) AT=905.025n

.meas tran vdout0_4ck1800 FIND v(dout0_4) AT=905.025n

.meas tran vdout0_5ck1800 FIND v(dout0_5) AT=905.025n

.meas tran vdout0_6ck1800 FIND v(dout0_6) AT=905.025n

.meas tran vdout0_7ck1800 FIND v(dout0_7) AT=905.025n

.meas tran vdout0_8ck1800 FIND v(dout0_8) AT=905.025n

.meas tran vdout0_9ck1800 FIND v(dout0_9) AT=905.025n

.meas tran vdout0_10ck1800 FIND v(dout0_10) AT=905.025n

.meas tran vdout0_11ck1800 FIND v(dout0_11) AT=905.025n

.meas tran vdout0_12ck1800 FIND v(dout0_12) AT=905.025n

.meas tran vdout0_13ck1800 FIND v(dout0_13) AT=905.025n

.meas tran vdout0_14ck1800 FIND v(dout0_14) AT=905.025n

.meas tran vdout0_15ck1800 FIND v(dout0_15) AT=905.025n

.meas tran vdout0_16ck1800 FIND v(dout0_16) AT=905.025n

.meas tran vdout0_17ck1800 FIND v(dout0_17) AT=905.025n

.meas tran vdout0_18ck1800 FIND v(dout0_18) AT=905.025n

.meas tran vdout0_19ck1800 FIND v(dout0_19) AT=905.025n

.meas tran vdout0_20ck1800 FIND v(dout0_20) AT=905.025n

.meas tran vdout0_21ck1800 FIND v(dout0_21) AT=905.025n

.meas tran vdout0_22ck1800 FIND v(dout0_22) AT=905.025n

.meas tran vdout0_23ck1800 FIND v(dout0_23) AT=905.025n

.meas tran vdout0_24ck1800 FIND v(dout0_24) AT=905.025n

.meas tran vdout0_25ck1800 FIND v(dout0_25) AT=905.025n

.meas tran vdout0_26ck1800 FIND v(dout0_26) AT=905.025n

.meas tran vdout0_27ck1800 FIND v(dout0_27) AT=905.025n

.meas tran vdout0_28ck1800 FIND v(dout0_28) AT=905.025n

.meas tran vdout0_29ck1800 FIND v(dout0_29) AT=905.025n

.meas tran vdout0_30ck1800 FIND v(dout0_30) AT=905.025n

.meas tran vdout0_31ck1800 FIND v(dout0_31) AT=905.025n

.meas tran vdout0_32ck1800 FIND v(dout0_32) AT=905.025n

.meas tran vdout0_33ck1800 FIND v(dout0_33) AT=905.025n

.meas tran vdout0_34ck1800 FIND v(dout0_34) AT=905.025n

.meas tran vdout0_35ck1800 FIND v(dout0_35) AT=905.025n

.meas tran vdout0_36ck1800 FIND v(dout0_36) AT=905.025n

.meas tran vdout0_37ck1800 FIND v(dout0_37) AT=905.025n

.meas tran vdout0_38ck1800 FIND v(dout0_38) AT=905.025n

.meas tran vdout0_39ck1800 FIND v(dout0_39) AT=905.025n

.meas tran vdout0_40ck1800 FIND v(dout0_40) AT=905.025n

.meas tran vdout0_41ck1800 FIND v(dout0_41) AT=905.025n

.meas tran vdout0_42ck1800 FIND v(dout0_42) AT=905.025n

.meas tran vdout0_43ck1800 FIND v(dout0_43) AT=905.025n

.meas tran vdout0_44ck1800 FIND v(dout0_44) AT=905.025n

.meas tran vdout0_45ck1800 FIND v(dout0_45) AT=905.025n

.meas tran vdout0_46ck1800 FIND v(dout0_46) AT=905.025n

.meas tran vdout0_47ck1800 FIND v(dout0_47) AT=905.025n

.meas tran vdout0_48ck1800 FIND v(dout0_48) AT=905.025n

.meas tran vdout0_49ck1800 FIND v(dout0_49) AT=905.025n

.meas tran vdout0_50ck1800 FIND v(dout0_50) AT=905.025n

.meas tran vdout0_51ck1800 FIND v(dout0_51) AT=905.025n

.meas tran vdout0_52ck1800 FIND v(dout0_52) AT=905.025n

.meas tran vdout0_53ck1800 FIND v(dout0_53) AT=905.025n

.meas tran vdout0_54ck1800 FIND v(dout0_54) AT=905.025n

.meas tran vdout0_55ck1800 FIND v(dout0_55) AT=905.025n

.meas tran vdout0_56ck1800 FIND v(dout0_56) AT=905.025n

.meas tran vdout0_57ck1800 FIND v(dout0_57) AT=905.025n

.meas tran vdout0_58ck1800 FIND v(dout0_58) AT=905.025n

.meas tran vdout0_59ck1800 FIND v(dout0_59) AT=905.025n

.meas tran vdout0_60ck1800 FIND v(dout0_60) AT=905.025n

.meas tran vdout0_61ck1800 FIND v(dout0_61) AT=905.025n

.meas tran vdout0_62ck1800 FIND v(dout0_62) AT=905.025n

.meas tran vdout0_63ck1800 FIND v(dout0_63) AT=905.025n

.meas tran vdout0_0ck1810 FIND v(dout0_0) AT=910.025n

.meas tran vdout0_1ck1810 FIND v(dout0_1) AT=910.025n

.meas tran vdout0_2ck1810 FIND v(dout0_2) AT=910.025n

.meas tran vdout0_3ck1810 FIND v(dout0_3) AT=910.025n

.meas tran vdout0_4ck1810 FIND v(dout0_4) AT=910.025n

.meas tran vdout0_5ck1810 FIND v(dout0_5) AT=910.025n

.meas tran vdout0_6ck1810 FIND v(dout0_6) AT=910.025n

.meas tran vdout0_7ck1810 FIND v(dout0_7) AT=910.025n

.meas tran vdout0_8ck1810 FIND v(dout0_8) AT=910.025n

.meas tran vdout0_9ck1810 FIND v(dout0_9) AT=910.025n

.meas tran vdout0_10ck1810 FIND v(dout0_10) AT=910.025n

.meas tran vdout0_11ck1810 FIND v(dout0_11) AT=910.025n

.meas tran vdout0_12ck1810 FIND v(dout0_12) AT=910.025n

.meas tran vdout0_13ck1810 FIND v(dout0_13) AT=910.025n

.meas tran vdout0_14ck1810 FIND v(dout0_14) AT=910.025n

.meas tran vdout0_15ck1810 FIND v(dout0_15) AT=910.025n

.meas tran vdout0_16ck1810 FIND v(dout0_16) AT=910.025n

.meas tran vdout0_17ck1810 FIND v(dout0_17) AT=910.025n

.meas tran vdout0_18ck1810 FIND v(dout0_18) AT=910.025n

.meas tran vdout0_19ck1810 FIND v(dout0_19) AT=910.025n

.meas tran vdout0_20ck1810 FIND v(dout0_20) AT=910.025n

.meas tran vdout0_21ck1810 FIND v(dout0_21) AT=910.025n

.meas tran vdout0_22ck1810 FIND v(dout0_22) AT=910.025n

.meas tran vdout0_23ck1810 FIND v(dout0_23) AT=910.025n

.meas tran vdout0_24ck1810 FIND v(dout0_24) AT=910.025n

.meas tran vdout0_25ck1810 FIND v(dout0_25) AT=910.025n

.meas tran vdout0_26ck1810 FIND v(dout0_26) AT=910.025n

.meas tran vdout0_27ck1810 FIND v(dout0_27) AT=910.025n

.meas tran vdout0_28ck1810 FIND v(dout0_28) AT=910.025n

.meas tran vdout0_29ck1810 FIND v(dout0_29) AT=910.025n

.meas tran vdout0_30ck1810 FIND v(dout0_30) AT=910.025n

.meas tran vdout0_31ck1810 FIND v(dout0_31) AT=910.025n

.meas tran vdout0_32ck1810 FIND v(dout0_32) AT=910.025n

.meas tran vdout0_33ck1810 FIND v(dout0_33) AT=910.025n

.meas tran vdout0_34ck1810 FIND v(dout0_34) AT=910.025n

.meas tran vdout0_35ck1810 FIND v(dout0_35) AT=910.025n

.meas tran vdout0_36ck1810 FIND v(dout0_36) AT=910.025n

.meas tran vdout0_37ck1810 FIND v(dout0_37) AT=910.025n

.meas tran vdout0_38ck1810 FIND v(dout0_38) AT=910.025n

.meas tran vdout0_39ck1810 FIND v(dout0_39) AT=910.025n

.meas tran vdout0_40ck1810 FIND v(dout0_40) AT=910.025n

.meas tran vdout0_41ck1810 FIND v(dout0_41) AT=910.025n

.meas tran vdout0_42ck1810 FIND v(dout0_42) AT=910.025n

.meas tran vdout0_43ck1810 FIND v(dout0_43) AT=910.025n

.meas tran vdout0_44ck1810 FIND v(dout0_44) AT=910.025n

.meas tran vdout0_45ck1810 FIND v(dout0_45) AT=910.025n

.meas tran vdout0_46ck1810 FIND v(dout0_46) AT=910.025n

.meas tran vdout0_47ck1810 FIND v(dout0_47) AT=910.025n

.meas tran vdout0_48ck1810 FIND v(dout0_48) AT=910.025n

.meas tran vdout0_49ck1810 FIND v(dout0_49) AT=910.025n

.meas tran vdout0_50ck1810 FIND v(dout0_50) AT=910.025n

.meas tran vdout0_51ck1810 FIND v(dout0_51) AT=910.025n

.meas tran vdout0_52ck1810 FIND v(dout0_52) AT=910.025n

.meas tran vdout0_53ck1810 FIND v(dout0_53) AT=910.025n

.meas tran vdout0_54ck1810 FIND v(dout0_54) AT=910.025n

.meas tran vdout0_55ck1810 FIND v(dout0_55) AT=910.025n

.meas tran vdout0_56ck1810 FIND v(dout0_56) AT=910.025n

.meas tran vdout0_57ck1810 FIND v(dout0_57) AT=910.025n

.meas tran vdout0_58ck1810 FIND v(dout0_58) AT=910.025n

.meas tran vdout0_59ck1810 FIND v(dout0_59) AT=910.025n

.meas tran vdout0_60ck1810 FIND v(dout0_60) AT=910.025n

.meas tran vdout0_61ck1810 FIND v(dout0_61) AT=910.025n

.meas tran vdout0_62ck1810 FIND v(dout0_62) AT=910.025n

.meas tran vdout0_63ck1810 FIND v(dout0_63) AT=910.025n

.meas tran vdout1_0ck1830 FIND v(dout1_0) AT=920.025n

.meas tran vdout1_1ck1830 FIND v(dout1_1) AT=920.025n

.meas tran vdout1_2ck1830 FIND v(dout1_2) AT=920.025n

.meas tran vdout1_3ck1830 FIND v(dout1_3) AT=920.025n

.meas tran vdout1_4ck1830 FIND v(dout1_4) AT=920.025n

.meas tran vdout1_5ck1830 FIND v(dout1_5) AT=920.025n

.meas tran vdout1_6ck1830 FIND v(dout1_6) AT=920.025n

.meas tran vdout1_7ck1830 FIND v(dout1_7) AT=920.025n

.meas tran vdout1_8ck1830 FIND v(dout1_8) AT=920.025n

.meas tran vdout1_9ck1830 FIND v(dout1_9) AT=920.025n

.meas tran vdout1_10ck1830 FIND v(dout1_10) AT=920.025n

.meas tran vdout1_11ck1830 FIND v(dout1_11) AT=920.025n

.meas tran vdout1_12ck1830 FIND v(dout1_12) AT=920.025n

.meas tran vdout1_13ck1830 FIND v(dout1_13) AT=920.025n

.meas tran vdout1_14ck1830 FIND v(dout1_14) AT=920.025n

.meas tran vdout1_15ck1830 FIND v(dout1_15) AT=920.025n

.meas tran vdout1_16ck1830 FIND v(dout1_16) AT=920.025n

.meas tran vdout1_17ck1830 FIND v(dout1_17) AT=920.025n

.meas tran vdout1_18ck1830 FIND v(dout1_18) AT=920.025n

.meas tran vdout1_19ck1830 FIND v(dout1_19) AT=920.025n

.meas tran vdout1_20ck1830 FIND v(dout1_20) AT=920.025n

.meas tran vdout1_21ck1830 FIND v(dout1_21) AT=920.025n

.meas tran vdout1_22ck1830 FIND v(dout1_22) AT=920.025n

.meas tran vdout1_23ck1830 FIND v(dout1_23) AT=920.025n

.meas tran vdout1_24ck1830 FIND v(dout1_24) AT=920.025n

.meas tran vdout1_25ck1830 FIND v(dout1_25) AT=920.025n

.meas tran vdout1_26ck1830 FIND v(dout1_26) AT=920.025n

.meas tran vdout1_27ck1830 FIND v(dout1_27) AT=920.025n

.meas tran vdout1_28ck1830 FIND v(dout1_28) AT=920.025n

.meas tran vdout1_29ck1830 FIND v(dout1_29) AT=920.025n

.meas tran vdout1_30ck1830 FIND v(dout1_30) AT=920.025n

.meas tran vdout1_31ck1830 FIND v(dout1_31) AT=920.025n

.meas tran vdout1_32ck1830 FIND v(dout1_32) AT=920.025n

.meas tran vdout1_33ck1830 FIND v(dout1_33) AT=920.025n

.meas tran vdout1_34ck1830 FIND v(dout1_34) AT=920.025n

.meas tran vdout1_35ck1830 FIND v(dout1_35) AT=920.025n

.meas tran vdout1_36ck1830 FIND v(dout1_36) AT=920.025n

.meas tran vdout1_37ck1830 FIND v(dout1_37) AT=920.025n

.meas tran vdout1_38ck1830 FIND v(dout1_38) AT=920.025n

.meas tran vdout1_39ck1830 FIND v(dout1_39) AT=920.025n

.meas tran vdout1_40ck1830 FIND v(dout1_40) AT=920.025n

.meas tran vdout1_41ck1830 FIND v(dout1_41) AT=920.025n

.meas tran vdout1_42ck1830 FIND v(dout1_42) AT=920.025n

.meas tran vdout1_43ck1830 FIND v(dout1_43) AT=920.025n

.meas tran vdout1_44ck1830 FIND v(dout1_44) AT=920.025n

.meas tran vdout1_45ck1830 FIND v(dout1_45) AT=920.025n

.meas tran vdout1_46ck1830 FIND v(dout1_46) AT=920.025n

.meas tran vdout1_47ck1830 FIND v(dout1_47) AT=920.025n

.meas tran vdout1_48ck1830 FIND v(dout1_48) AT=920.025n

.meas tran vdout1_49ck1830 FIND v(dout1_49) AT=920.025n

.meas tran vdout1_50ck1830 FIND v(dout1_50) AT=920.025n

.meas tran vdout1_51ck1830 FIND v(dout1_51) AT=920.025n

.meas tran vdout1_52ck1830 FIND v(dout1_52) AT=920.025n

.meas tran vdout1_53ck1830 FIND v(dout1_53) AT=920.025n

.meas tran vdout1_54ck1830 FIND v(dout1_54) AT=920.025n

.meas tran vdout1_55ck1830 FIND v(dout1_55) AT=920.025n

.meas tran vdout1_56ck1830 FIND v(dout1_56) AT=920.025n

.meas tran vdout1_57ck1830 FIND v(dout1_57) AT=920.025n

.meas tran vdout1_58ck1830 FIND v(dout1_58) AT=920.025n

.meas tran vdout1_59ck1830 FIND v(dout1_59) AT=920.025n

.meas tran vdout1_60ck1830 FIND v(dout1_60) AT=920.025n

.meas tran vdout1_61ck1830 FIND v(dout1_61) AT=920.025n

.meas tran vdout1_62ck1830 FIND v(dout1_62) AT=920.025n

.meas tran vdout1_63ck1830 FIND v(dout1_63) AT=920.025n

.meas tran vdout1_0ck1840 FIND v(dout1_0) AT=925.025n

.meas tran vdout1_1ck1840 FIND v(dout1_1) AT=925.025n

.meas tran vdout1_2ck1840 FIND v(dout1_2) AT=925.025n

.meas tran vdout1_3ck1840 FIND v(dout1_3) AT=925.025n

.meas tran vdout1_4ck1840 FIND v(dout1_4) AT=925.025n

.meas tran vdout1_5ck1840 FIND v(dout1_5) AT=925.025n

.meas tran vdout1_6ck1840 FIND v(dout1_6) AT=925.025n

.meas tran vdout1_7ck1840 FIND v(dout1_7) AT=925.025n

.meas tran vdout1_8ck1840 FIND v(dout1_8) AT=925.025n

.meas tran vdout1_9ck1840 FIND v(dout1_9) AT=925.025n

.meas tran vdout1_10ck1840 FIND v(dout1_10) AT=925.025n

.meas tran vdout1_11ck1840 FIND v(dout1_11) AT=925.025n

.meas tran vdout1_12ck1840 FIND v(dout1_12) AT=925.025n

.meas tran vdout1_13ck1840 FIND v(dout1_13) AT=925.025n

.meas tran vdout1_14ck1840 FIND v(dout1_14) AT=925.025n

.meas tran vdout1_15ck1840 FIND v(dout1_15) AT=925.025n

.meas tran vdout1_16ck1840 FIND v(dout1_16) AT=925.025n

.meas tran vdout1_17ck1840 FIND v(dout1_17) AT=925.025n

.meas tran vdout1_18ck1840 FIND v(dout1_18) AT=925.025n

.meas tran vdout1_19ck1840 FIND v(dout1_19) AT=925.025n

.meas tran vdout1_20ck1840 FIND v(dout1_20) AT=925.025n

.meas tran vdout1_21ck1840 FIND v(dout1_21) AT=925.025n

.meas tran vdout1_22ck1840 FIND v(dout1_22) AT=925.025n

.meas tran vdout1_23ck1840 FIND v(dout1_23) AT=925.025n

.meas tran vdout1_24ck1840 FIND v(dout1_24) AT=925.025n

.meas tran vdout1_25ck1840 FIND v(dout1_25) AT=925.025n

.meas tran vdout1_26ck1840 FIND v(dout1_26) AT=925.025n

.meas tran vdout1_27ck1840 FIND v(dout1_27) AT=925.025n

.meas tran vdout1_28ck1840 FIND v(dout1_28) AT=925.025n

.meas tran vdout1_29ck1840 FIND v(dout1_29) AT=925.025n

.meas tran vdout1_30ck1840 FIND v(dout1_30) AT=925.025n

.meas tran vdout1_31ck1840 FIND v(dout1_31) AT=925.025n

.meas tran vdout1_32ck1840 FIND v(dout1_32) AT=925.025n

.meas tran vdout1_33ck1840 FIND v(dout1_33) AT=925.025n

.meas tran vdout1_34ck1840 FIND v(dout1_34) AT=925.025n

.meas tran vdout1_35ck1840 FIND v(dout1_35) AT=925.025n

.meas tran vdout1_36ck1840 FIND v(dout1_36) AT=925.025n

.meas tran vdout1_37ck1840 FIND v(dout1_37) AT=925.025n

.meas tran vdout1_38ck1840 FIND v(dout1_38) AT=925.025n

.meas tran vdout1_39ck1840 FIND v(dout1_39) AT=925.025n

.meas tran vdout1_40ck1840 FIND v(dout1_40) AT=925.025n

.meas tran vdout1_41ck1840 FIND v(dout1_41) AT=925.025n

.meas tran vdout1_42ck1840 FIND v(dout1_42) AT=925.025n

.meas tran vdout1_43ck1840 FIND v(dout1_43) AT=925.025n

.meas tran vdout1_44ck1840 FIND v(dout1_44) AT=925.025n

.meas tran vdout1_45ck1840 FIND v(dout1_45) AT=925.025n

.meas tran vdout1_46ck1840 FIND v(dout1_46) AT=925.025n

.meas tran vdout1_47ck1840 FIND v(dout1_47) AT=925.025n

.meas tran vdout1_48ck1840 FIND v(dout1_48) AT=925.025n

.meas tran vdout1_49ck1840 FIND v(dout1_49) AT=925.025n

.meas tran vdout1_50ck1840 FIND v(dout1_50) AT=925.025n

.meas tran vdout1_51ck1840 FIND v(dout1_51) AT=925.025n

.meas tran vdout1_52ck1840 FIND v(dout1_52) AT=925.025n

.meas tran vdout1_53ck1840 FIND v(dout1_53) AT=925.025n

.meas tran vdout1_54ck1840 FIND v(dout1_54) AT=925.025n

.meas tran vdout1_55ck1840 FIND v(dout1_55) AT=925.025n

.meas tran vdout1_56ck1840 FIND v(dout1_56) AT=925.025n

.meas tran vdout1_57ck1840 FIND v(dout1_57) AT=925.025n

.meas tran vdout1_58ck1840 FIND v(dout1_58) AT=925.025n

.meas tran vdout1_59ck1840 FIND v(dout1_59) AT=925.025n

.meas tran vdout1_60ck1840 FIND v(dout1_60) AT=925.025n

.meas tran vdout1_61ck1840 FIND v(dout1_61) AT=925.025n

.meas tran vdout1_62ck1840 FIND v(dout1_62) AT=925.025n

.meas tran vdout1_63ck1840 FIND v(dout1_63) AT=925.025n

.meas tran vdout0_0ck1850 FIND v(dout0_0) AT=930.025n

.meas tran vdout0_1ck1850 FIND v(dout0_1) AT=930.025n

.meas tran vdout0_2ck1850 FIND v(dout0_2) AT=930.025n

.meas tran vdout0_3ck1850 FIND v(dout0_3) AT=930.025n

.meas tran vdout0_4ck1850 FIND v(dout0_4) AT=930.025n

.meas tran vdout0_5ck1850 FIND v(dout0_5) AT=930.025n

.meas tran vdout0_6ck1850 FIND v(dout0_6) AT=930.025n

.meas tran vdout0_7ck1850 FIND v(dout0_7) AT=930.025n

.meas tran vdout0_8ck1850 FIND v(dout0_8) AT=930.025n

.meas tran vdout0_9ck1850 FIND v(dout0_9) AT=930.025n

.meas tran vdout0_10ck1850 FIND v(dout0_10) AT=930.025n

.meas tran vdout0_11ck1850 FIND v(dout0_11) AT=930.025n

.meas tran vdout0_12ck1850 FIND v(dout0_12) AT=930.025n

.meas tran vdout0_13ck1850 FIND v(dout0_13) AT=930.025n

.meas tran vdout0_14ck1850 FIND v(dout0_14) AT=930.025n

.meas tran vdout0_15ck1850 FIND v(dout0_15) AT=930.025n

.meas tran vdout0_16ck1850 FIND v(dout0_16) AT=930.025n

.meas tran vdout0_17ck1850 FIND v(dout0_17) AT=930.025n

.meas tran vdout0_18ck1850 FIND v(dout0_18) AT=930.025n

.meas tran vdout0_19ck1850 FIND v(dout0_19) AT=930.025n

.meas tran vdout0_20ck1850 FIND v(dout0_20) AT=930.025n

.meas tran vdout0_21ck1850 FIND v(dout0_21) AT=930.025n

.meas tran vdout0_22ck1850 FIND v(dout0_22) AT=930.025n

.meas tran vdout0_23ck1850 FIND v(dout0_23) AT=930.025n

.meas tran vdout0_24ck1850 FIND v(dout0_24) AT=930.025n

.meas tran vdout0_25ck1850 FIND v(dout0_25) AT=930.025n

.meas tran vdout0_26ck1850 FIND v(dout0_26) AT=930.025n

.meas tran vdout0_27ck1850 FIND v(dout0_27) AT=930.025n

.meas tran vdout0_28ck1850 FIND v(dout0_28) AT=930.025n

.meas tran vdout0_29ck1850 FIND v(dout0_29) AT=930.025n

.meas tran vdout0_30ck1850 FIND v(dout0_30) AT=930.025n

.meas tran vdout0_31ck1850 FIND v(dout0_31) AT=930.025n

.meas tran vdout0_32ck1850 FIND v(dout0_32) AT=930.025n

.meas tran vdout0_33ck1850 FIND v(dout0_33) AT=930.025n

.meas tran vdout0_34ck1850 FIND v(dout0_34) AT=930.025n

.meas tran vdout0_35ck1850 FIND v(dout0_35) AT=930.025n

.meas tran vdout0_36ck1850 FIND v(dout0_36) AT=930.025n

.meas tran vdout0_37ck1850 FIND v(dout0_37) AT=930.025n

.meas tran vdout0_38ck1850 FIND v(dout0_38) AT=930.025n

.meas tran vdout0_39ck1850 FIND v(dout0_39) AT=930.025n

.meas tran vdout0_40ck1850 FIND v(dout0_40) AT=930.025n

.meas tran vdout0_41ck1850 FIND v(dout0_41) AT=930.025n

.meas tran vdout0_42ck1850 FIND v(dout0_42) AT=930.025n

.meas tran vdout0_43ck1850 FIND v(dout0_43) AT=930.025n

.meas tran vdout0_44ck1850 FIND v(dout0_44) AT=930.025n

.meas tran vdout0_45ck1850 FIND v(dout0_45) AT=930.025n

.meas tran vdout0_46ck1850 FIND v(dout0_46) AT=930.025n

.meas tran vdout0_47ck1850 FIND v(dout0_47) AT=930.025n

.meas tran vdout0_48ck1850 FIND v(dout0_48) AT=930.025n

.meas tran vdout0_49ck1850 FIND v(dout0_49) AT=930.025n

.meas tran vdout0_50ck1850 FIND v(dout0_50) AT=930.025n

.meas tran vdout0_51ck1850 FIND v(dout0_51) AT=930.025n

.meas tran vdout0_52ck1850 FIND v(dout0_52) AT=930.025n

.meas tran vdout0_53ck1850 FIND v(dout0_53) AT=930.025n

.meas tran vdout0_54ck1850 FIND v(dout0_54) AT=930.025n

.meas tran vdout0_55ck1850 FIND v(dout0_55) AT=930.025n

.meas tran vdout0_56ck1850 FIND v(dout0_56) AT=930.025n

.meas tran vdout0_57ck1850 FIND v(dout0_57) AT=930.025n

.meas tran vdout0_58ck1850 FIND v(dout0_58) AT=930.025n

.meas tran vdout0_59ck1850 FIND v(dout0_59) AT=930.025n

.meas tran vdout0_60ck1850 FIND v(dout0_60) AT=930.025n

.meas tran vdout0_61ck1850 FIND v(dout0_61) AT=930.025n

.meas tran vdout0_62ck1850 FIND v(dout0_62) AT=930.025n

.meas tran vdout0_63ck1850 FIND v(dout0_63) AT=930.025n

.meas tran vdout0_0ck1880 FIND v(dout0_0) AT=945.025n

.meas tran vdout0_1ck1880 FIND v(dout0_1) AT=945.025n

.meas tran vdout0_2ck1880 FIND v(dout0_2) AT=945.025n

.meas tran vdout0_3ck1880 FIND v(dout0_3) AT=945.025n

.meas tran vdout0_4ck1880 FIND v(dout0_4) AT=945.025n

.meas tran vdout0_5ck1880 FIND v(dout0_5) AT=945.025n

.meas tran vdout0_6ck1880 FIND v(dout0_6) AT=945.025n

.meas tran vdout0_7ck1880 FIND v(dout0_7) AT=945.025n

.meas tran vdout0_8ck1880 FIND v(dout0_8) AT=945.025n

.meas tran vdout0_9ck1880 FIND v(dout0_9) AT=945.025n

.meas tran vdout0_10ck1880 FIND v(dout0_10) AT=945.025n

.meas tran vdout0_11ck1880 FIND v(dout0_11) AT=945.025n

.meas tran vdout0_12ck1880 FIND v(dout0_12) AT=945.025n

.meas tran vdout0_13ck1880 FIND v(dout0_13) AT=945.025n

.meas tran vdout0_14ck1880 FIND v(dout0_14) AT=945.025n

.meas tran vdout0_15ck1880 FIND v(dout0_15) AT=945.025n

.meas tran vdout0_16ck1880 FIND v(dout0_16) AT=945.025n

.meas tran vdout0_17ck1880 FIND v(dout0_17) AT=945.025n

.meas tran vdout0_18ck1880 FIND v(dout0_18) AT=945.025n

.meas tran vdout0_19ck1880 FIND v(dout0_19) AT=945.025n

.meas tran vdout0_20ck1880 FIND v(dout0_20) AT=945.025n

.meas tran vdout0_21ck1880 FIND v(dout0_21) AT=945.025n

.meas tran vdout0_22ck1880 FIND v(dout0_22) AT=945.025n

.meas tran vdout0_23ck1880 FIND v(dout0_23) AT=945.025n

.meas tran vdout0_24ck1880 FIND v(dout0_24) AT=945.025n

.meas tran vdout0_25ck1880 FIND v(dout0_25) AT=945.025n

.meas tran vdout0_26ck1880 FIND v(dout0_26) AT=945.025n

.meas tran vdout0_27ck1880 FIND v(dout0_27) AT=945.025n

.meas tran vdout0_28ck1880 FIND v(dout0_28) AT=945.025n

.meas tran vdout0_29ck1880 FIND v(dout0_29) AT=945.025n

.meas tran vdout0_30ck1880 FIND v(dout0_30) AT=945.025n

.meas tran vdout0_31ck1880 FIND v(dout0_31) AT=945.025n

.meas tran vdout0_32ck1880 FIND v(dout0_32) AT=945.025n

.meas tran vdout0_33ck1880 FIND v(dout0_33) AT=945.025n

.meas tran vdout0_34ck1880 FIND v(dout0_34) AT=945.025n

.meas tran vdout0_35ck1880 FIND v(dout0_35) AT=945.025n

.meas tran vdout0_36ck1880 FIND v(dout0_36) AT=945.025n

.meas tran vdout0_37ck1880 FIND v(dout0_37) AT=945.025n

.meas tran vdout0_38ck1880 FIND v(dout0_38) AT=945.025n

.meas tran vdout0_39ck1880 FIND v(dout0_39) AT=945.025n

.meas tran vdout0_40ck1880 FIND v(dout0_40) AT=945.025n

.meas tran vdout0_41ck1880 FIND v(dout0_41) AT=945.025n

.meas tran vdout0_42ck1880 FIND v(dout0_42) AT=945.025n

.meas tran vdout0_43ck1880 FIND v(dout0_43) AT=945.025n

.meas tran vdout0_44ck1880 FIND v(dout0_44) AT=945.025n

.meas tran vdout0_45ck1880 FIND v(dout0_45) AT=945.025n

.meas tran vdout0_46ck1880 FIND v(dout0_46) AT=945.025n

.meas tran vdout0_47ck1880 FIND v(dout0_47) AT=945.025n

.meas tran vdout0_48ck1880 FIND v(dout0_48) AT=945.025n

.meas tran vdout0_49ck1880 FIND v(dout0_49) AT=945.025n

.meas tran vdout0_50ck1880 FIND v(dout0_50) AT=945.025n

.meas tran vdout0_51ck1880 FIND v(dout0_51) AT=945.025n

.meas tran vdout0_52ck1880 FIND v(dout0_52) AT=945.025n

.meas tran vdout0_53ck1880 FIND v(dout0_53) AT=945.025n

.meas tran vdout0_54ck1880 FIND v(dout0_54) AT=945.025n

.meas tran vdout0_55ck1880 FIND v(dout0_55) AT=945.025n

.meas tran vdout0_56ck1880 FIND v(dout0_56) AT=945.025n

.meas tran vdout0_57ck1880 FIND v(dout0_57) AT=945.025n

.meas tran vdout0_58ck1880 FIND v(dout0_58) AT=945.025n

.meas tran vdout0_59ck1880 FIND v(dout0_59) AT=945.025n

.meas tran vdout0_60ck1880 FIND v(dout0_60) AT=945.025n

.meas tran vdout0_61ck1880 FIND v(dout0_61) AT=945.025n

.meas tran vdout0_62ck1880 FIND v(dout0_62) AT=945.025n

.meas tran vdout0_63ck1880 FIND v(dout0_63) AT=945.025n

.meas tran vdout1_0ck1880 FIND v(dout1_0) AT=945.025n

.meas tran vdout1_1ck1880 FIND v(dout1_1) AT=945.025n

.meas tran vdout1_2ck1880 FIND v(dout1_2) AT=945.025n

.meas tran vdout1_3ck1880 FIND v(dout1_3) AT=945.025n

.meas tran vdout1_4ck1880 FIND v(dout1_4) AT=945.025n

.meas tran vdout1_5ck1880 FIND v(dout1_5) AT=945.025n

.meas tran vdout1_6ck1880 FIND v(dout1_6) AT=945.025n

.meas tran vdout1_7ck1880 FIND v(dout1_7) AT=945.025n

.meas tran vdout1_8ck1880 FIND v(dout1_8) AT=945.025n

.meas tran vdout1_9ck1880 FIND v(dout1_9) AT=945.025n

.meas tran vdout1_10ck1880 FIND v(dout1_10) AT=945.025n

.meas tran vdout1_11ck1880 FIND v(dout1_11) AT=945.025n

.meas tran vdout1_12ck1880 FIND v(dout1_12) AT=945.025n

.meas tran vdout1_13ck1880 FIND v(dout1_13) AT=945.025n

.meas tran vdout1_14ck1880 FIND v(dout1_14) AT=945.025n

.meas tran vdout1_15ck1880 FIND v(dout1_15) AT=945.025n

.meas tran vdout1_16ck1880 FIND v(dout1_16) AT=945.025n

.meas tran vdout1_17ck1880 FIND v(dout1_17) AT=945.025n

.meas tran vdout1_18ck1880 FIND v(dout1_18) AT=945.025n

.meas tran vdout1_19ck1880 FIND v(dout1_19) AT=945.025n

.meas tran vdout1_20ck1880 FIND v(dout1_20) AT=945.025n

.meas tran vdout1_21ck1880 FIND v(dout1_21) AT=945.025n

.meas tran vdout1_22ck1880 FIND v(dout1_22) AT=945.025n

.meas tran vdout1_23ck1880 FIND v(dout1_23) AT=945.025n

.meas tran vdout1_24ck1880 FIND v(dout1_24) AT=945.025n

.meas tran vdout1_25ck1880 FIND v(dout1_25) AT=945.025n

.meas tran vdout1_26ck1880 FIND v(dout1_26) AT=945.025n

.meas tran vdout1_27ck1880 FIND v(dout1_27) AT=945.025n

.meas tran vdout1_28ck1880 FIND v(dout1_28) AT=945.025n

.meas tran vdout1_29ck1880 FIND v(dout1_29) AT=945.025n

.meas tran vdout1_30ck1880 FIND v(dout1_30) AT=945.025n

.meas tran vdout1_31ck1880 FIND v(dout1_31) AT=945.025n

.meas tran vdout1_32ck1880 FIND v(dout1_32) AT=945.025n

.meas tran vdout1_33ck1880 FIND v(dout1_33) AT=945.025n

.meas tran vdout1_34ck1880 FIND v(dout1_34) AT=945.025n

.meas tran vdout1_35ck1880 FIND v(dout1_35) AT=945.025n

.meas tran vdout1_36ck1880 FIND v(dout1_36) AT=945.025n

.meas tran vdout1_37ck1880 FIND v(dout1_37) AT=945.025n

.meas tran vdout1_38ck1880 FIND v(dout1_38) AT=945.025n

.meas tran vdout1_39ck1880 FIND v(dout1_39) AT=945.025n

.meas tran vdout1_40ck1880 FIND v(dout1_40) AT=945.025n

.meas tran vdout1_41ck1880 FIND v(dout1_41) AT=945.025n

.meas tran vdout1_42ck1880 FIND v(dout1_42) AT=945.025n

.meas tran vdout1_43ck1880 FIND v(dout1_43) AT=945.025n

.meas tran vdout1_44ck1880 FIND v(dout1_44) AT=945.025n

.meas tran vdout1_45ck1880 FIND v(dout1_45) AT=945.025n

.meas tran vdout1_46ck1880 FIND v(dout1_46) AT=945.025n

.meas tran vdout1_47ck1880 FIND v(dout1_47) AT=945.025n

.meas tran vdout1_48ck1880 FIND v(dout1_48) AT=945.025n

.meas tran vdout1_49ck1880 FIND v(dout1_49) AT=945.025n

.meas tran vdout1_50ck1880 FIND v(dout1_50) AT=945.025n

.meas tran vdout1_51ck1880 FIND v(dout1_51) AT=945.025n

.meas tran vdout1_52ck1880 FIND v(dout1_52) AT=945.025n

.meas tran vdout1_53ck1880 FIND v(dout1_53) AT=945.025n

.meas tran vdout1_54ck1880 FIND v(dout1_54) AT=945.025n

.meas tran vdout1_55ck1880 FIND v(dout1_55) AT=945.025n

.meas tran vdout1_56ck1880 FIND v(dout1_56) AT=945.025n

.meas tran vdout1_57ck1880 FIND v(dout1_57) AT=945.025n

.meas tran vdout1_58ck1880 FIND v(dout1_58) AT=945.025n

.meas tran vdout1_59ck1880 FIND v(dout1_59) AT=945.025n

.meas tran vdout1_60ck1880 FIND v(dout1_60) AT=945.025n

.meas tran vdout1_61ck1880 FIND v(dout1_61) AT=945.025n

.meas tran vdout1_62ck1880 FIND v(dout1_62) AT=945.025n

.meas tran vdout1_63ck1880 FIND v(dout1_63) AT=945.025n

.meas tran vdout0_0ck1890 FIND v(dout0_0) AT=950.025n

.meas tran vdout0_1ck1890 FIND v(dout0_1) AT=950.025n

.meas tran vdout0_2ck1890 FIND v(dout0_2) AT=950.025n

.meas tran vdout0_3ck1890 FIND v(dout0_3) AT=950.025n

.meas tran vdout0_4ck1890 FIND v(dout0_4) AT=950.025n

.meas tran vdout0_5ck1890 FIND v(dout0_5) AT=950.025n

.meas tran vdout0_6ck1890 FIND v(dout0_6) AT=950.025n

.meas tran vdout0_7ck1890 FIND v(dout0_7) AT=950.025n

.meas tran vdout0_8ck1890 FIND v(dout0_8) AT=950.025n

.meas tran vdout0_9ck1890 FIND v(dout0_9) AT=950.025n

.meas tran vdout0_10ck1890 FIND v(dout0_10) AT=950.025n

.meas tran vdout0_11ck1890 FIND v(dout0_11) AT=950.025n

.meas tran vdout0_12ck1890 FIND v(dout0_12) AT=950.025n

.meas tran vdout0_13ck1890 FIND v(dout0_13) AT=950.025n

.meas tran vdout0_14ck1890 FIND v(dout0_14) AT=950.025n

.meas tran vdout0_15ck1890 FIND v(dout0_15) AT=950.025n

.meas tran vdout0_16ck1890 FIND v(dout0_16) AT=950.025n

.meas tran vdout0_17ck1890 FIND v(dout0_17) AT=950.025n

.meas tran vdout0_18ck1890 FIND v(dout0_18) AT=950.025n

.meas tran vdout0_19ck1890 FIND v(dout0_19) AT=950.025n

.meas tran vdout0_20ck1890 FIND v(dout0_20) AT=950.025n

.meas tran vdout0_21ck1890 FIND v(dout0_21) AT=950.025n

.meas tran vdout0_22ck1890 FIND v(dout0_22) AT=950.025n

.meas tran vdout0_23ck1890 FIND v(dout0_23) AT=950.025n

.meas tran vdout0_24ck1890 FIND v(dout0_24) AT=950.025n

.meas tran vdout0_25ck1890 FIND v(dout0_25) AT=950.025n

.meas tran vdout0_26ck1890 FIND v(dout0_26) AT=950.025n

.meas tran vdout0_27ck1890 FIND v(dout0_27) AT=950.025n

.meas tran vdout0_28ck1890 FIND v(dout0_28) AT=950.025n

.meas tran vdout0_29ck1890 FIND v(dout0_29) AT=950.025n

.meas tran vdout0_30ck1890 FIND v(dout0_30) AT=950.025n

.meas tran vdout0_31ck1890 FIND v(dout0_31) AT=950.025n

.meas tran vdout0_32ck1890 FIND v(dout0_32) AT=950.025n

.meas tran vdout0_33ck1890 FIND v(dout0_33) AT=950.025n

.meas tran vdout0_34ck1890 FIND v(dout0_34) AT=950.025n

.meas tran vdout0_35ck1890 FIND v(dout0_35) AT=950.025n

.meas tran vdout0_36ck1890 FIND v(dout0_36) AT=950.025n

.meas tran vdout0_37ck1890 FIND v(dout0_37) AT=950.025n

.meas tran vdout0_38ck1890 FIND v(dout0_38) AT=950.025n

.meas tran vdout0_39ck1890 FIND v(dout0_39) AT=950.025n

.meas tran vdout0_40ck1890 FIND v(dout0_40) AT=950.025n

.meas tran vdout0_41ck1890 FIND v(dout0_41) AT=950.025n

.meas tran vdout0_42ck1890 FIND v(dout0_42) AT=950.025n

.meas tran vdout0_43ck1890 FIND v(dout0_43) AT=950.025n

.meas tran vdout0_44ck1890 FIND v(dout0_44) AT=950.025n

.meas tran vdout0_45ck1890 FIND v(dout0_45) AT=950.025n

.meas tran vdout0_46ck1890 FIND v(dout0_46) AT=950.025n

.meas tran vdout0_47ck1890 FIND v(dout0_47) AT=950.025n

.meas tran vdout0_48ck1890 FIND v(dout0_48) AT=950.025n

.meas tran vdout0_49ck1890 FIND v(dout0_49) AT=950.025n

.meas tran vdout0_50ck1890 FIND v(dout0_50) AT=950.025n

.meas tran vdout0_51ck1890 FIND v(dout0_51) AT=950.025n

.meas tran vdout0_52ck1890 FIND v(dout0_52) AT=950.025n

.meas tran vdout0_53ck1890 FIND v(dout0_53) AT=950.025n

.meas tran vdout0_54ck1890 FIND v(dout0_54) AT=950.025n

.meas tran vdout0_55ck1890 FIND v(dout0_55) AT=950.025n

.meas tran vdout0_56ck1890 FIND v(dout0_56) AT=950.025n

.meas tran vdout0_57ck1890 FIND v(dout0_57) AT=950.025n

.meas tran vdout0_58ck1890 FIND v(dout0_58) AT=950.025n

.meas tran vdout0_59ck1890 FIND v(dout0_59) AT=950.025n

.meas tran vdout0_60ck1890 FIND v(dout0_60) AT=950.025n

.meas tran vdout0_61ck1890 FIND v(dout0_61) AT=950.025n

.meas tran vdout0_62ck1890 FIND v(dout0_62) AT=950.025n

.meas tran vdout0_63ck1890 FIND v(dout0_63) AT=950.025n

.meas tran vdout1_0ck1900 FIND v(dout1_0) AT=955.025n

.meas tran vdout1_1ck1900 FIND v(dout1_1) AT=955.025n

.meas tran vdout1_2ck1900 FIND v(dout1_2) AT=955.025n

.meas tran vdout1_3ck1900 FIND v(dout1_3) AT=955.025n

.meas tran vdout1_4ck1900 FIND v(dout1_4) AT=955.025n

.meas tran vdout1_5ck1900 FIND v(dout1_5) AT=955.025n

.meas tran vdout1_6ck1900 FIND v(dout1_6) AT=955.025n

.meas tran vdout1_7ck1900 FIND v(dout1_7) AT=955.025n

.meas tran vdout1_8ck1900 FIND v(dout1_8) AT=955.025n

.meas tran vdout1_9ck1900 FIND v(dout1_9) AT=955.025n

.meas tran vdout1_10ck1900 FIND v(dout1_10) AT=955.025n

.meas tran vdout1_11ck1900 FIND v(dout1_11) AT=955.025n

.meas tran vdout1_12ck1900 FIND v(dout1_12) AT=955.025n

.meas tran vdout1_13ck1900 FIND v(dout1_13) AT=955.025n

.meas tran vdout1_14ck1900 FIND v(dout1_14) AT=955.025n

.meas tran vdout1_15ck1900 FIND v(dout1_15) AT=955.025n

.meas tran vdout1_16ck1900 FIND v(dout1_16) AT=955.025n

.meas tran vdout1_17ck1900 FIND v(dout1_17) AT=955.025n

.meas tran vdout1_18ck1900 FIND v(dout1_18) AT=955.025n

.meas tran vdout1_19ck1900 FIND v(dout1_19) AT=955.025n

.meas tran vdout1_20ck1900 FIND v(dout1_20) AT=955.025n

.meas tran vdout1_21ck1900 FIND v(dout1_21) AT=955.025n

.meas tran vdout1_22ck1900 FIND v(dout1_22) AT=955.025n

.meas tran vdout1_23ck1900 FIND v(dout1_23) AT=955.025n

.meas tran vdout1_24ck1900 FIND v(dout1_24) AT=955.025n

.meas tran vdout1_25ck1900 FIND v(dout1_25) AT=955.025n

.meas tran vdout1_26ck1900 FIND v(dout1_26) AT=955.025n

.meas tran vdout1_27ck1900 FIND v(dout1_27) AT=955.025n

.meas tran vdout1_28ck1900 FIND v(dout1_28) AT=955.025n

.meas tran vdout1_29ck1900 FIND v(dout1_29) AT=955.025n

.meas tran vdout1_30ck1900 FIND v(dout1_30) AT=955.025n

.meas tran vdout1_31ck1900 FIND v(dout1_31) AT=955.025n

.meas tran vdout1_32ck1900 FIND v(dout1_32) AT=955.025n

.meas tran vdout1_33ck1900 FIND v(dout1_33) AT=955.025n

.meas tran vdout1_34ck1900 FIND v(dout1_34) AT=955.025n

.meas tran vdout1_35ck1900 FIND v(dout1_35) AT=955.025n

.meas tran vdout1_36ck1900 FIND v(dout1_36) AT=955.025n

.meas tran vdout1_37ck1900 FIND v(dout1_37) AT=955.025n

.meas tran vdout1_38ck1900 FIND v(dout1_38) AT=955.025n

.meas tran vdout1_39ck1900 FIND v(dout1_39) AT=955.025n

.meas tran vdout1_40ck1900 FIND v(dout1_40) AT=955.025n

.meas tran vdout1_41ck1900 FIND v(dout1_41) AT=955.025n

.meas tran vdout1_42ck1900 FIND v(dout1_42) AT=955.025n

.meas tran vdout1_43ck1900 FIND v(dout1_43) AT=955.025n

.meas tran vdout1_44ck1900 FIND v(dout1_44) AT=955.025n

.meas tran vdout1_45ck1900 FIND v(dout1_45) AT=955.025n

.meas tran vdout1_46ck1900 FIND v(dout1_46) AT=955.025n

.meas tran vdout1_47ck1900 FIND v(dout1_47) AT=955.025n

.meas tran vdout1_48ck1900 FIND v(dout1_48) AT=955.025n

.meas tran vdout1_49ck1900 FIND v(dout1_49) AT=955.025n

.meas tran vdout1_50ck1900 FIND v(dout1_50) AT=955.025n

.meas tran vdout1_51ck1900 FIND v(dout1_51) AT=955.025n

.meas tran vdout1_52ck1900 FIND v(dout1_52) AT=955.025n

.meas tran vdout1_53ck1900 FIND v(dout1_53) AT=955.025n

.meas tran vdout1_54ck1900 FIND v(dout1_54) AT=955.025n

.meas tran vdout1_55ck1900 FIND v(dout1_55) AT=955.025n

.meas tran vdout1_56ck1900 FIND v(dout1_56) AT=955.025n

.meas tran vdout1_57ck1900 FIND v(dout1_57) AT=955.025n

.meas tran vdout1_58ck1900 FIND v(dout1_58) AT=955.025n

.meas tran vdout1_59ck1900 FIND v(dout1_59) AT=955.025n

.meas tran vdout1_60ck1900 FIND v(dout1_60) AT=955.025n

.meas tran vdout1_61ck1900 FIND v(dout1_61) AT=955.025n

.meas tran vdout1_62ck1900 FIND v(dout1_62) AT=955.025n

.meas tran vdout1_63ck1900 FIND v(dout1_63) AT=955.025n

.meas tran vdout0_0ck1910 FIND v(dout0_0) AT=960.025n

.meas tran vdout0_1ck1910 FIND v(dout0_1) AT=960.025n

.meas tran vdout0_2ck1910 FIND v(dout0_2) AT=960.025n

.meas tran vdout0_3ck1910 FIND v(dout0_3) AT=960.025n

.meas tran vdout0_4ck1910 FIND v(dout0_4) AT=960.025n

.meas tran vdout0_5ck1910 FIND v(dout0_5) AT=960.025n

.meas tran vdout0_6ck1910 FIND v(dout0_6) AT=960.025n

.meas tran vdout0_7ck1910 FIND v(dout0_7) AT=960.025n

.meas tran vdout0_8ck1910 FIND v(dout0_8) AT=960.025n

.meas tran vdout0_9ck1910 FIND v(dout0_9) AT=960.025n

.meas tran vdout0_10ck1910 FIND v(dout0_10) AT=960.025n

.meas tran vdout0_11ck1910 FIND v(dout0_11) AT=960.025n

.meas tran vdout0_12ck1910 FIND v(dout0_12) AT=960.025n

.meas tran vdout0_13ck1910 FIND v(dout0_13) AT=960.025n

.meas tran vdout0_14ck1910 FIND v(dout0_14) AT=960.025n

.meas tran vdout0_15ck1910 FIND v(dout0_15) AT=960.025n

.meas tran vdout0_16ck1910 FIND v(dout0_16) AT=960.025n

.meas tran vdout0_17ck1910 FIND v(dout0_17) AT=960.025n

.meas tran vdout0_18ck1910 FIND v(dout0_18) AT=960.025n

.meas tran vdout0_19ck1910 FIND v(dout0_19) AT=960.025n

.meas tran vdout0_20ck1910 FIND v(dout0_20) AT=960.025n

.meas tran vdout0_21ck1910 FIND v(dout0_21) AT=960.025n

.meas tran vdout0_22ck1910 FIND v(dout0_22) AT=960.025n

.meas tran vdout0_23ck1910 FIND v(dout0_23) AT=960.025n

.meas tran vdout0_24ck1910 FIND v(dout0_24) AT=960.025n

.meas tran vdout0_25ck1910 FIND v(dout0_25) AT=960.025n

.meas tran vdout0_26ck1910 FIND v(dout0_26) AT=960.025n

.meas tran vdout0_27ck1910 FIND v(dout0_27) AT=960.025n

.meas tran vdout0_28ck1910 FIND v(dout0_28) AT=960.025n

.meas tran vdout0_29ck1910 FIND v(dout0_29) AT=960.025n

.meas tran vdout0_30ck1910 FIND v(dout0_30) AT=960.025n

.meas tran vdout0_31ck1910 FIND v(dout0_31) AT=960.025n

.meas tran vdout0_32ck1910 FIND v(dout0_32) AT=960.025n

.meas tran vdout0_33ck1910 FIND v(dout0_33) AT=960.025n

.meas tran vdout0_34ck1910 FIND v(dout0_34) AT=960.025n

.meas tran vdout0_35ck1910 FIND v(dout0_35) AT=960.025n

.meas tran vdout0_36ck1910 FIND v(dout0_36) AT=960.025n

.meas tran vdout0_37ck1910 FIND v(dout0_37) AT=960.025n

.meas tran vdout0_38ck1910 FIND v(dout0_38) AT=960.025n

.meas tran vdout0_39ck1910 FIND v(dout0_39) AT=960.025n

.meas tran vdout0_40ck1910 FIND v(dout0_40) AT=960.025n

.meas tran vdout0_41ck1910 FIND v(dout0_41) AT=960.025n

.meas tran vdout0_42ck1910 FIND v(dout0_42) AT=960.025n

.meas tran vdout0_43ck1910 FIND v(dout0_43) AT=960.025n

.meas tran vdout0_44ck1910 FIND v(dout0_44) AT=960.025n

.meas tran vdout0_45ck1910 FIND v(dout0_45) AT=960.025n

.meas tran vdout0_46ck1910 FIND v(dout0_46) AT=960.025n

.meas tran vdout0_47ck1910 FIND v(dout0_47) AT=960.025n

.meas tran vdout0_48ck1910 FIND v(dout0_48) AT=960.025n

.meas tran vdout0_49ck1910 FIND v(dout0_49) AT=960.025n

.meas tran vdout0_50ck1910 FIND v(dout0_50) AT=960.025n

.meas tran vdout0_51ck1910 FIND v(dout0_51) AT=960.025n

.meas tran vdout0_52ck1910 FIND v(dout0_52) AT=960.025n

.meas tran vdout0_53ck1910 FIND v(dout0_53) AT=960.025n

.meas tran vdout0_54ck1910 FIND v(dout0_54) AT=960.025n

.meas tran vdout0_55ck1910 FIND v(dout0_55) AT=960.025n

.meas tran vdout0_56ck1910 FIND v(dout0_56) AT=960.025n

.meas tran vdout0_57ck1910 FIND v(dout0_57) AT=960.025n

.meas tran vdout0_58ck1910 FIND v(dout0_58) AT=960.025n

.meas tran vdout0_59ck1910 FIND v(dout0_59) AT=960.025n

.meas tran vdout0_60ck1910 FIND v(dout0_60) AT=960.025n

.meas tran vdout0_61ck1910 FIND v(dout0_61) AT=960.025n

.meas tran vdout0_62ck1910 FIND v(dout0_62) AT=960.025n

.meas tran vdout0_63ck1910 FIND v(dout0_63) AT=960.025n

.meas tran vdout1_0ck1920 FIND v(dout1_0) AT=965.025n

.meas tran vdout1_1ck1920 FIND v(dout1_1) AT=965.025n

.meas tran vdout1_2ck1920 FIND v(dout1_2) AT=965.025n

.meas tran vdout1_3ck1920 FIND v(dout1_3) AT=965.025n

.meas tran vdout1_4ck1920 FIND v(dout1_4) AT=965.025n

.meas tran vdout1_5ck1920 FIND v(dout1_5) AT=965.025n

.meas tran vdout1_6ck1920 FIND v(dout1_6) AT=965.025n

.meas tran vdout1_7ck1920 FIND v(dout1_7) AT=965.025n

.meas tran vdout1_8ck1920 FIND v(dout1_8) AT=965.025n

.meas tran vdout1_9ck1920 FIND v(dout1_9) AT=965.025n

.meas tran vdout1_10ck1920 FIND v(dout1_10) AT=965.025n

.meas tran vdout1_11ck1920 FIND v(dout1_11) AT=965.025n

.meas tran vdout1_12ck1920 FIND v(dout1_12) AT=965.025n

.meas tran vdout1_13ck1920 FIND v(dout1_13) AT=965.025n

.meas tran vdout1_14ck1920 FIND v(dout1_14) AT=965.025n

.meas tran vdout1_15ck1920 FIND v(dout1_15) AT=965.025n

.meas tran vdout1_16ck1920 FIND v(dout1_16) AT=965.025n

.meas tran vdout1_17ck1920 FIND v(dout1_17) AT=965.025n

.meas tran vdout1_18ck1920 FIND v(dout1_18) AT=965.025n

.meas tran vdout1_19ck1920 FIND v(dout1_19) AT=965.025n

.meas tran vdout1_20ck1920 FIND v(dout1_20) AT=965.025n

.meas tran vdout1_21ck1920 FIND v(dout1_21) AT=965.025n

.meas tran vdout1_22ck1920 FIND v(dout1_22) AT=965.025n

.meas tran vdout1_23ck1920 FIND v(dout1_23) AT=965.025n

.meas tran vdout1_24ck1920 FIND v(dout1_24) AT=965.025n

.meas tran vdout1_25ck1920 FIND v(dout1_25) AT=965.025n

.meas tran vdout1_26ck1920 FIND v(dout1_26) AT=965.025n

.meas tran vdout1_27ck1920 FIND v(dout1_27) AT=965.025n

.meas tran vdout1_28ck1920 FIND v(dout1_28) AT=965.025n

.meas tran vdout1_29ck1920 FIND v(dout1_29) AT=965.025n

.meas tran vdout1_30ck1920 FIND v(dout1_30) AT=965.025n

.meas tran vdout1_31ck1920 FIND v(dout1_31) AT=965.025n

.meas tran vdout1_32ck1920 FIND v(dout1_32) AT=965.025n

.meas tran vdout1_33ck1920 FIND v(dout1_33) AT=965.025n

.meas tran vdout1_34ck1920 FIND v(dout1_34) AT=965.025n

.meas tran vdout1_35ck1920 FIND v(dout1_35) AT=965.025n

.meas tran vdout1_36ck1920 FIND v(dout1_36) AT=965.025n

.meas tran vdout1_37ck1920 FIND v(dout1_37) AT=965.025n

.meas tran vdout1_38ck1920 FIND v(dout1_38) AT=965.025n

.meas tran vdout1_39ck1920 FIND v(dout1_39) AT=965.025n

.meas tran vdout1_40ck1920 FIND v(dout1_40) AT=965.025n

.meas tran vdout1_41ck1920 FIND v(dout1_41) AT=965.025n

.meas tran vdout1_42ck1920 FIND v(dout1_42) AT=965.025n

.meas tran vdout1_43ck1920 FIND v(dout1_43) AT=965.025n

.meas tran vdout1_44ck1920 FIND v(dout1_44) AT=965.025n

.meas tran vdout1_45ck1920 FIND v(dout1_45) AT=965.025n

.meas tran vdout1_46ck1920 FIND v(dout1_46) AT=965.025n

.meas tran vdout1_47ck1920 FIND v(dout1_47) AT=965.025n

.meas tran vdout1_48ck1920 FIND v(dout1_48) AT=965.025n

.meas tran vdout1_49ck1920 FIND v(dout1_49) AT=965.025n

.meas tran vdout1_50ck1920 FIND v(dout1_50) AT=965.025n

.meas tran vdout1_51ck1920 FIND v(dout1_51) AT=965.025n

.meas tran vdout1_52ck1920 FIND v(dout1_52) AT=965.025n

.meas tran vdout1_53ck1920 FIND v(dout1_53) AT=965.025n

.meas tran vdout1_54ck1920 FIND v(dout1_54) AT=965.025n

.meas tran vdout1_55ck1920 FIND v(dout1_55) AT=965.025n

.meas tran vdout1_56ck1920 FIND v(dout1_56) AT=965.025n

.meas tran vdout1_57ck1920 FIND v(dout1_57) AT=965.025n

.meas tran vdout1_58ck1920 FIND v(dout1_58) AT=965.025n

.meas tran vdout1_59ck1920 FIND v(dout1_59) AT=965.025n

.meas tran vdout1_60ck1920 FIND v(dout1_60) AT=965.025n

.meas tran vdout1_61ck1920 FIND v(dout1_61) AT=965.025n

.meas tran vdout1_62ck1920 FIND v(dout1_62) AT=965.025n

.meas tran vdout1_63ck1920 FIND v(dout1_63) AT=965.025n

.meas tran vdout1_0ck1930 FIND v(dout1_0) AT=970.025n

.meas tran vdout1_1ck1930 FIND v(dout1_1) AT=970.025n

.meas tran vdout1_2ck1930 FIND v(dout1_2) AT=970.025n

.meas tran vdout1_3ck1930 FIND v(dout1_3) AT=970.025n

.meas tran vdout1_4ck1930 FIND v(dout1_4) AT=970.025n

.meas tran vdout1_5ck1930 FIND v(dout1_5) AT=970.025n

.meas tran vdout1_6ck1930 FIND v(dout1_6) AT=970.025n

.meas tran vdout1_7ck1930 FIND v(dout1_7) AT=970.025n

.meas tran vdout1_8ck1930 FIND v(dout1_8) AT=970.025n

.meas tran vdout1_9ck1930 FIND v(dout1_9) AT=970.025n

.meas tran vdout1_10ck1930 FIND v(dout1_10) AT=970.025n

.meas tran vdout1_11ck1930 FIND v(dout1_11) AT=970.025n

.meas tran vdout1_12ck1930 FIND v(dout1_12) AT=970.025n

.meas tran vdout1_13ck1930 FIND v(dout1_13) AT=970.025n

.meas tran vdout1_14ck1930 FIND v(dout1_14) AT=970.025n

.meas tran vdout1_15ck1930 FIND v(dout1_15) AT=970.025n

.meas tran vdout1_16ck1930 FIND v(dout1_16) AT=970.025n

.meas tran vdout1_17ck1930 FIND v(dout1_17) AT=970.025n

.meas tran vdout1_18ck1930 FIND v(dout1_18) AT=970.025n

.meas tran vdout1_19ck1930 FIND v(dout1_19) AT=970.025n

.meas tran vdout1_20ck1930 FIND v(dout1_20) AT=970.025n

.meas tran vdout1_21ck1930 FIND v(dout1_21) AT=970.025n

.meas tran vdout1_22ck1930 FIND v(dout1_22) AT=970.025n

.meas tran vdout1_23ck1930 FIND v(dout1_23) AT=970.025n

.meas tran vdout1_24ck1930 FIND v(dout1_24) AT=970.025n

.meas tran vdout1_25ck1930 FIND v(dout1_25) AT=970.025n

.meas tran vdout1_26ck1930 FIND v(dout1_26) AT=970.025n

.meas tran vdout1_27ck1930 FIND v(dout1_27) AT=970.025n

.meas tran vdout1_28ck1930 FIND v(dout1_28) AT=970.025n

.meas tran vdout1_29ck1930 FIND v(dout1_29) AT=970.025n

.meas tran vdout1_30ck1930 FIND v(dout1_30) AT=970.025n

.meas tran vdout1_31ck1930 FIND v(dout1_31) AT=970.025n

.meas tran vdout1_32ck1930 FIND v(dout1_32) AT=970.025n

.meas tran vdout1_33ck1930 FIND v(dout1_33) AT=970.025n

.meas tran vdout1_34ck1930 FIND v(dout1_34) AT=970.025n

.meas tran vdout1_35ck1930 FIND v(dout1_35) AT=970.025n

.meas tran vdout1_36ck1930 FIND v(dout1_36) AT=970.025n

.meas tran vdout1_37ck1930 FIND v(dout1_37) AT=970.025n

.meas tran vdout1_38ck1930 FIND v(dout1_38) AT=970.025n

.meas tran vdout1_39ck1930 FIND v(dout1_39) AT=970.025n

.meas tran vdout1_40ck1930 FIND v(dout1_40) AT=970.025n

.meas tran vdout1_41ck1930 FIND v(dout1_41) AT=970.025n

.meas tran vdout1_42ck1930 FIND v(dout1_42) AT=970.025n

.meas tran vdout1_43ck1930 FIND v(dout1_43) AT=970.025n

.meas tran vdout1_44ck1930 FIND v(dout1_44) AT=970.025n

.meas tran vdout1_45ck1930 FIND v(dout1_45) AT=970.025n

.meas tran vdout1_46ck1930 FIND v(dout1_46) AT=970.025n

.meas tran vdout1_47ck1930 FIND v(dout1_47) AT=970.025n

.meas tran vdout1_48ck1930 FIND v(dout1_48) AT=970.025n

.meas tran vdout1_49ck1930 FIND v(dout1_49) AT=970.025n

.meas tran vdout1_50ck1930 FIND v(dout1_50) AT=970.025n

.meas tran vdout1_51ck1930 FIND v(dout1_51) AT=970.025n

.meas tran vdout1_52ck1930 FIND v(dout1_52) AT=970.025n

.meas tran vdout1_53ck1930 FIND v(dout1_53) AT=970.025n

.meas tran vdout1_54ck1930 FIND v(dout1_54) AT=970.025n

.meas tran vdout1_55ck1930 FIND v(dout1_55) AT=970.025n

.meas tran vdout1_56ck1930 FIND v(dout1_56) AT=970.025n

.meas tran vdout1_57ck1930 FIND v(dout1_57) AT=970.025n

.meas tran vdout1_58ck1930 FIND v(dout1_58) AT=970.025n

.meas tran vdout1_59ck1930 FIND v(dout1_59) AT=970.025n

.meas tran vdout1_60ck1930 FIND v(dout1_60) AT=970.025n

.meas tran vdout1_61ck1930 FIND v(dout1_61) AT=970.025n

.meas tran vdout1_62ck1930 FIND v(dout1_62) AT=970.025n

.meas tran vdout1_63ck1930 FIND v(dout1_63) AT=970.025n

.meas tran vdout0_0ck1940 FIND v(dout0_0) AT=975.025n

.meas tran vdout0_1ck1940 FIND v(dout0_1) AT=975.025n

.meas tran vdout0_2ck1940 FIND v(dout0_2) AT=975.025n

.meas tran vdout0_3ck1940 FIND v(dout0_3) AT=975.025n

.meas tran vdout0_4ck1940 FIND v(dout0_4) AT=975.025n

.meas tran vdout0_5ck1940 FIND v(dout0_5) AT=975.025n

.meas tran vdout0_6ck1940 FIND v(dout0_6) AT=975.025n

.meas tran vdout0_7ck1940 FIND v(dout0_7) AT=975.025n

.meas tran vdout0_8ck1940 FIND v(dout0_8) AT=975.025n

.meas tran vdout0_9ck1940 FIND v(dout0_9) AT=975.025n

.meas tran vdout0_10ck1940 FIND v(dout0_10) AT=975.025n

.meas tran vdout0_11ck1940 FIND v(dout0_11) AT=975.025n

.meas tran vdout0_12ck1940 FIND v(dout0_12) AT=975.025n

.meas tran vdout0_13ck1940 FIND v(dout0_13) AT=975.025n

.meas tran vdout0_14ck1940 FIND v(dout0_14) AT=975.025n

.meas tran vdout0_15ck1940 FIND v(dout0_15) AT=975.025n

.meas tran vdout0_16ck1940 FIND v(dout0_16) AT=975.025n

.meas tran vdout0_17ck1940 FIND v(dout0_17) AT=975.025n

.meas tran vdout0_18ck1940 FIND v(dout0_18) AT=975.025n

.meas tran vdout0_19ck1940 FIND v(dout0_19) AT=975.025n

.meas tran vdout0_20ck1940 FIND v(dout0_20) AT=975.025n

.meas tran vdout0_21ck1940 FIND v(dout0_21) AT=975.025n

.meas tran vdout0_22ck1940 FIND v(dout0_22) AT=975.025n

.meas tran vdout0_23ck1940 FIND v(dout0_23) AT=975.025n

.meas tran vdout0_24ck1940 FIND v(dout0_24) AT=975.025n

.meas tran vdout0_25ck1940 FIND v(dout0_25) AT=975.025n

.meas tran vdout0_26ck1940 FIND v(dout0_26) AT=975.025n

.meas tran vdout0_27ck1940 FIND v(dout0_27) AT=975.025n

.meas tran vdout0_28ck1940 FIND v(dout0_28) AT=975.025n

.meas tran vdout0_29ck1940 FIND v(dout0_29) AT=975.025n

.meas tran vdout0_30ck1940 FIND v(dout0_30) AT=975.025n

.meas tran vdout0_31ck1940 FIND v(dout0_31) AT=975.025n

.meas tran vdout0_32ck1940 FIND v(dout0_32) AT=975.025n

.meas tran vdout0_33ck1940 FIND v(dout0_33) AT=975.025n

.meas tran vdout0_34ck1940 FIND v(dout0_34) AT=975.025n

.meas tran vdout0_35ck1940 FIND v(dout0_35) AT=975.025n

.meas tran vdout0_36ck1940 FIND v(dout0_36) AT=975.025n

.meas tran vdout0_37ck1940 FIND v(dout0_37) AT=975.025n

.meas tran vdout0_38ck1940 FIND v(dout0_38) AT=975.025n

.meas tran vdout0_39ck1940 FIND v(dout0_39) AT=975.025n

.meas tran vdout0_40ck1940 FIND v(dout0_40) AT=975.025n

.meas tran vdout0_41ck1940 FIND v(dout0_41) AT=975.025n

.meas tran vdout0_42ck1940 FIND v(dout0_42) AT=975.025n

.meas tran vdout0_43ck1940 FIND v(dout0_43) AT=975.025n

.meas tran vdout0_44ck1940 FIND v(dout0_44) AT=975.025n

.meas tran vdout0_45ck1940 FIND v(dout0_45) AT=975.025n

.meas tran vdout0_46ck1940 FIND v(dout0_46) AT=975.025n

.meas tran vdout0_47ck1940 FIND v(dout0_47) AT=975.025n

.meas tran vdout0_48ck1940 FIND v(dout0_48) AT=975.025n

.meas tran vdout0_49ck1940 FIND v(dout0_49) AT=975.025n

.meas tran vdout0_50ck1940 FIND v(dout0_50) AT=975.025n

.meas tran vdout0_51ck1940 FIND v(dout0_51) AT=975.025n

.meas tran vdout0_52ck1940 FIND v(dout0_52) AT=975.025n

.meas tran vdout0_53ck1940 FIND v(dout0_53) AT=975.025n

.meas tran vdout0_54ck1940 FIND v(dout0_54) AT=975.025n

.meas tran vdout0_55ck1940 FIND v(dout0_55) AT=975.025n

.meas tran vdout0_56ck1940 FIND v(dout0_56) AT=975.025n

.meas tran vdout0_57ck1940 FIND v(dout0_57) AT=975.025n

.meas tran vdout0_58ck1940 FIND v(dout0_58) AT=975.025n

.meas tran vdout0_59ck1940 FIND v(dout0_59) AT=975.025n

.meas tran vdout0_60ck1940 FIND v(dout0_60) AT=975.025n

.meas tran vdout0_61ck1940 FIND v(dout0_61) AT=975.025n

.meas tran vdout0_62ck1940 FIND v(dout0_62) AT=975.025n

.meas tran vdout0_63ck1940 FIND v(dout0_63) AT=975.025n

.meas tran vdout1_0ck1940 FIND v(dout1_0) AT=975.025n

.meas tran vdout1_1ck1940 FIND v(dout1_1) AT=975.025n

.meas tran vdout1_2ck1940 FIND v(dout1_2) AT=975.025n

.meas tran vdout1_3ck1940 FIND v(dout1_3) AT=975.025n

.meas tran vdout1_4ck1940 FIND v(dout1_4) AT=975.025n

.meas tran vdout1_5ck1940 FIND v(dout1_5) AT=975.025n

.meas tran vdout1_6ck1940 FIND v(dout1_6) AT=975.025n

.meas tran vdout1_7ck1940 FIND v(dout1_7) AT=975.025n

.meas tran vdout1_8ck1940 FIND v(dout1_8) AT=975.025n

.meas tran vdout1_9ck1940 FIND v(dout1_9) AT=975.025n

.meas tran vdout1_10ck1940 FIND v(dout1_10) AT=975.025n

.meas tran vdout1_11ck1940 FIND v(dout1_11) AT=975.025n

.meas tran vdout1_12ck1940 FIND v(dout1_12) AT=975.025n

.meas tran vdout1_13ck1940 FIND v(dout1_13) AT=975.025n

.meas tran vdout1_14ck1940 FIND v(dout1_14) AT=975.025n

.meas tran vdout1_15ck1940 FIND v(dout1_15) AT=975.025n

.meas tran vdout1_16ck1940 FIND v(dout1_16) AT=975.025n

.meas tran vdout1_17ck1940 FIND v(dout1_17) AT=975.025n

.meas tran vdout1_18ck1940 FIND v(dout1_18) AT=975.025n

.meas tran vdout1_19ck1940 FIND v(dout1_19) AT=975.025n

.meas tran vdout1_20ck1940 FIND v(dout1_20) AT=975.025n

.meas tran vdout1_21ck1940 FIND v(dout1_21) AT=975.025n

.meas tran vdout1_22ck1940 FIND v(dout1_22) AT=975.025n

.meas tran vdout1_23ck1940 FIND v(dout1_23) AT=975.025n

.meas tran vdout1_24ck1940 FIND v(dout1_24) AT=975.025n

.meas tran vdout1_25ck1940 FIND v(dout1_25) AT=975.025n

.meas tran vdout1_26ck1940 FIND v(dout1_26) AT=975.025n

.meas tran vdout1_27ck1940 FIND v(dout1_27) AT=975.025n

.meas tran vdout1_28ck1940 FIND v(dout1_28) AT=975.025n

.meas tran vdout1_29ck1940 FIND v(dout1_29) AT=975.025n

.meas tran vdout1_30ck1940 FIND v(dout1_30) AT=975.025n

.meas tran vdout1_31ck1940 FIND v(dout1_31) AT=975.025n

.meas tran vdout1_32ck1940 FIND v(dout1_32) AT=975.025n

.meas tran vdout1_33ck1940 FIND v(dout1_33) AT=975.025n

.meas tran vdout1_34ck1940 FIND v(dout1_34) AT=975.025n

.meas tran vdout1_35ck1940 FIND v(dout1_35) AT=975.025n

.meas tran vdout1_36ck1940 FIND v(dout1_36) AT=975.025n

.meas tran vdout1_37ck1940 FIND v(dout1_37) AT=975.025n

.meas tran vdout1_38ck1940 FIND v(dout1_38) AT=975.025n

.meas tran vdout1_39ck1940 FIND v(dout1_39) AT=975.025n

.meas tran vdout1_40ck1940 FIND v(dout1_40) AT=975.025n

.meas tran vdout1_41ck1940 FIND v(dout1_41) AT=975.025n

.meas tran vdout1_42ck1940 FIND v(dout1_42) AT=975.025n

.meas tran vdout1_43ck1940 FIND v(dout1_43) AT=975.025n

.meas tran vdout1_44ck1940 FIND v(dout1_44) AT=975.025n

.meas tran vdout1_45ck1940 FIND v(dout1_45) AT=975.025n

.meas tran vdout1_46ck1940 FIND v(dout1_46) AT=975.025n

.meas tran vdout1_47ck1940 FIND v(dout1_47) AT=975.025n

.meas tran vdout1_48ck1940 FIND v(dout1_48) AT=975.025n

.meas tran vdout1_49ck1940 FIND v(dout1_49) AT=975.025n

.meas tran vdout1_50ck1940 FIND v(dout1_50) AT=975.025n

.meas tran vdout1_51ck1940 FIND v(dout1_51) AT=975.025n

.meas tran vdout1_52ck1940 FIND v(dout1_52) AT=975.025n

.meas tran vdout1_53ck1940 FIND v(dout1_53) AT=975.025n

.meas tran vdout1_54ck1940 FIND v(dout1_54) AT=975.025n

.meas tran vdout1_55ck1940 FIND v(dout1_55) AT=975.025n

.meas tran vdout1_56ck1940 FIND v(dout1_56) AT=975.025n

.meas tran vdout1_57ck1940 FIND v(dout1_57) AT=975.025n

.meas tran vdout1_58ck1940 FIND v(dout1_58) AT=975.025n

.meas tran vdout1_59ck1940 FIND v(dout1_59) AT=975.025n

.meas tran vdout1_60ck1940 FIND v(dout1_60) AT=975.025n

.meas tran vdout1_61ck1940 FIND v(dout1_61) AT=975.025n

.meas tran vdout1_62ck1940 FIND v(dout1_62) AT=975.025n

.meas tran vdout1_63ck1940 FIND v(dout1_63) AT=975.025n

.meas tran vdout0_0ck1950 FIND v(dout0_0) AT=980.025n

.meas tran vdout0_1ck1950 FIND v(dout0_1) AT=980.025n

.meas tran vdout0_2ck1950 FIND v(dout0_2) AT=980.025n

.meas tran vdout0_3ck1950 FIND v(dout0_3) AT=980.025n

.meas tran vdout0_4ck1950 FIND v(dout0_4) AT=980.025n

.meas tran vdout0_5ck1950 FIND v(dout0_5) AT=980.025n

.meas tran vdout0_6ck1950 FIND v(dout0_6) AT=980.025n

.meas tran vdout0_7ck1950 FIND v(dout0_7) AT=980.025n

.meas tran vdout0_8ck1950 FIND v(dout0_8) AT=980.025n

.meas tran vdout0_9ck1950 FIND v(dout0_9) AT=980.025n

.meas tran vdout0_10ck1950 FIND v(dout0_10) AT=980.025n

.meas tran vdout0_11ck1950 FIND v(dout0_11) AT=980.025n

.meas tran vdout0_12ck1950 FIND v(dout0_12) AT=980.025n

.meas tran vdout0_13ck1950 FIND v(dout0_13) AT=980.025n

.meas tran vdout0_14ck1950 FIND v(dout0_14) AT=980.025n

.meas tran vdout0_15ck1950 FIND v(dout0_15) AT=980.025n

.meas tran vdout0_16ck1950 FIND v(dout0_16) AT=980.025n

.meas tran vdout0_17ck1950 FIND v(dout0_17) AT=980.025n

.meas tran vdout0_18ck1950 FIND v(dout0_18) AT=980.025n

.meas tran vdout0_19ck1950 FIND v(dout0_19) AT=980.025n

.meas tran vdout0_20ck1950 FIND v(dout0_20) AT=980.025n

.meas tran vdout0_21ck1950 FIND v(dout0_21) AT=980.025n

.meas tran vdout0_22ck1950 FIND v(dout0_22) AT=980.025n

.meas tran vdout0_23ck1950 FIND v(dout0_23) AT=980.025n

.meas tran vdout0_24ck1950 FIND v(dout0_24) AT=980.025n

.meas tran vdout0_25ck1950 FIND v(dout0_25) AT=980.025n

.meas tran vdout0_26ck1950 FIND v(dout0_26) AT=980.025n

.meas tran vdout0_27ck1950 FIND v(dout0_27) AT=980.025n

.meas tran vdout0_28ck1950 FIND v(dout0_28) AT=980.025n

.meas tran vdout0_29ck1950 FIND v(dout0_29) AT=980.025n

.meas tran vdout0_30ck1950 FIND v(dout0_30) AT=980.025n

.meas tran vdout0_31ck1950 FIND v(dout0_31) AT=980.025n

.meas tran vdout0_32ck1950 FIND v(dout0_32) AT=980.025n

.meas tran vdout0_33ck1950 FIND v(dout0_33) AT=980.025n

.meas tran vdout0_34ck1950 FIND v(dout0_34) AT=980.025n

.meas tran vdout0_35ck1950 FIND v(dout0_35) AT=980.025n

.meas tran vdout0_36ck1950 FIND v(dout0_36) AT=980.025n

.meas tran vdout0_37ck1950 FIND v(dout0_37) AT=980.025n

.meas tran vdout0_38ck1950 FIND v(dout0_38) AT=980.025n

.meas tran vdout0_39ck1950 FIND v(dout0_39) AT=980.025n

.meas tran vdout0_40ck1950 FIND v(dout0_40) AT=980.025n

.meas tran vdout0_41ck1950 FIND v(dout0_41) AT=980.025n

.meas tran vdout0_42ck1950 FIND v(dout0_42) AT=980.025n

.meas tran vdout0_43ck1950 FIND v(dout0_43) AT=980.025n

.meas tran vdout0_44ck1950 FIND v(dout0_44) AT=980.025n

.meas tran vdout0_45ck1950 FIND v(dout0_45) AT=980.025n

.meas tran vdout0_46ck1950 FIND v(dout0_46) AT=980.025n

.meas tran vdout0_47ck1950 FIND v(dout0_47) AT=980.025n

.meas tran vdout0_48ck1950 FIND v(dout0_48) AT=980.025n

.meas tran vdout0_49ck1950 FIND v(dout0_49) AT=980.025n

.meas tran vdout0_50ck1950 FIND v(dout0_50) AT=980.025n

.meas tran vdout0_51ck1950 FIND v(dout0_51) AT=980.025n

.meas tran vdout0_52ck1950 FIND v(dout0_52) AT=980.025n

.meas tran vdout0_53ck1950 FIND v(dout0_53) AT=980.025n

.meas tran vdout0_54ck1950 FIND v(dout0_54) AT=980.025n

.meas tran vdout0_55ck1950 FIND v(dout0_55) AT=980.025n

.meas tran vdout0_56ck1950 FIND v(dout0_56) AT=980.025n

.meas tran vdout0_57ck1950 FIND v(dout0_57) AT=980.025n

.meas tran vdout0_58ck1950 FIND v(dout0_58) AT=980.025n

.meas tran vdout0_59ck1950 FIND v(dout0_59) AT=980.025n

.meas tran vdout0_60ck1950 FIND v(dout0_60) AT=980.025n

.meas tran vdout0_61ck1950 FIND v(dout0_61) AT=980.025n

.meas tran vdout0_62ck1950 FIND v(dout0_62) AT=980.025n

.meas tran vdout0_63ck1950 FIND v(dout0_63) AT=980.025n

.meas tran vdout0_0ck1960 FIND v(dout0_0) AT=985.025n

.meas tran vdout0_1ck1960 FIND v(dout0_1) AT=985.025n

.meas tran vdout0_2ck1960 FIND v(dout0_2) AT=985.025n

.meas tran vdout0_3ck1960 FIND v(dout0_3) AT=985.025n

.meas tran vdout0_4ck1960 FIND v(dout0_4) AT=985.025n

.meas tran vdout0_5ck1960 FIND v(dout0_5) AT=985.025n

.meas tran vdout0_6ck1960 FIND v(dout0_6) AT=985.025n

.meas tran vdout0_7ck1960 FIND v(dout0_7) AT=985.025n

.meas tran vdout0_8ck1960 FIND v(dout0_8) AT=985.025n

.meas tran vdout0_9ck1960 FIND v(dout0_9) AT=985.025n

.meas tran vdout0_10ck1960 FIND v(dout0_10) AT=985.025n

.meas tran vdout0_11ck1960 FIND v(dout0_11) AT=985.025n

.meas tran vdout0_12ck1960 FIND v(dout0_12) AT=985.025n

.meas tran vdout0_13ck1960 FIND v(dout0_13) AT=985.025n

.meas tran vdout0_14ck1960 FIND v(dout0_14) AT=985.025n

.meas tran vdout0_15ck1960 FIND v(dout0_15) AT=985.025n

.meas tran vdout0_16ck1960 FIND v(dout0_16) AT=985.025n

.meas tran vdout0_17ck1960 FIND v(dout0_17) AT=985.025n

.meas tran vdout0_18ck1960 FIND v(dout0_18) AT=985.025n

.meas tran vdout0_19ck1960 FIND v(dout0_19) AT=985.025n

.meas tran vdout0_20ck1960 FIND v(dout0_20) AT=985.025n

.meas tran vdout0_21ck1960 FIND v(dout0_21) AT=985.025n

.meas tran vdout0_22ck1960 FIND v(dout0_22) AT=985.025n

.meas tran vdout0_23ck1960 FIND v(dout0_23) AT=985.025n

.meas tran vdout0_24ck1960 FIND v(dout0_24) AT=985.025n

.meas tran vdout0_25ck1960 FIND v(dout0_25) AT=985.025n

.meas tran vdout0_26ck1960 FIND v(dout0_26) AT=985.025n

.meas tran vdout0_27ck1960 FIND v(dout0_27) AT=985.025n

.meas tran vdout0_28ck1960 FIND v(dout0_28) AT=985.025n

.meas tran vdout0_29ck1960 FIND v(dout0_29) AT=985.025n

.meas tran vdout0_30ck1960 FIND v(dout0_30) AT=985.025n

.meas tran vdout0_31ck1960 FIND v(dout0_31) AT=985.025n

.meas tran vdout0_32ck1960 FIND v(dout0_32) AT=985.025n

.meas tran vdout0_33ck1960 FIND v(dout0_33) AT=985.025n

.meas tran vdout0_34ck1960 FIND v(dout0_34) AT=985.025n

.meas tran vdout0_35ck1960 FIND v(dout0_35) AT=985.025n

.meas tran vdout0_36ck1960 FIND v(dout0_36) AT=985.025n

.meas tran vdout0_37ck1960 FIND v(dout0_37) AT=985.025n

.meas tran vdout0_38ck1960 FIND v(dout0_38) AT=985.025n

.meas tran vdout0_39ck1960 FIND v(dout0_39) AT=985.025n

.meas tran vdout0_40ck1960 FIND v(dout0_40) AT=985.025n

.meas tran vdout0_41ck1960 FIND v(dout0_41) AT=985.025n

.meas tran vdout0_42ck1960 FIND v(dout0_42) AT=985.025n

.meas tran vdout0_43ck1960 FIND v(dout0_43) AT=985.025n

.meas tran vdout0_44ck1960 FIND v(dout0_44) AT=985.025n

.meas tran vdout0_45ck1960 FIND v(dout0_45) AT=985.025n

.meas tran vdout0_46ck1960 FIND v(dout0_46) AT=985.025n

.meas tran vdout0_47ck1960 FIND v(dout0_47) AT=985.025n

.meas tran vdout0_48ck1960 FIND v(dout0_48) AT=985.025n

.meas tran vdout0_49ck1960 FIND v(dout0_49) AT=985.025n

.meas tran vdout0_50ck1960 FIND v(dout0_50) AT=985.025n

.meas tran vdout0_51ck1960 FIND v(dout0_51) AT=985.025n

.meas tran vdout0_52ck1960 FIND v(dout0_52) AT=985.025n

.meas tran vdout0_53ck1960 FIND v(dout0_53) AT=985.025n

.meas tran vdout0_54ck1960 FIND v(dout0_54) AT=985.025n

.meas tran vdout0_55ck1960 FIND v(dout0_55) AT=985.025n

.meas tran vdout0_56ck1960 FIND v(dout0_56) AT=985.025n

.meas tran vdout0_57ck1960 FIND v(dout0_57) AT=985.025n

.meas tran vdout0_58ck1960 FIND v(dout0_58) AT=985.025n

.meas tran vdout0_59ck1960 FIND v(dout0_59) AT=985.025n

.meas tran vdout0_60ck1960 FIND v(dout0_60) AT=985.025n

.meas tran vdout0_61ck1960 FIND v(dout0_61) AT=985.025n

.meas tran vdout0_62ck1960 FIND v(dout0_62) AT=985.025n

.meas tran vdout0_63ck1960 FIND v(dout0_63) AT=985.025n

.meas tran vdout0_0ck1970 FIND v(dout0_0) AT=990.025n

.meas tran vdout0_1ck1970 FIND v(dout0_1) AT=990.025n

.meas tran vdout0_2ck1970 FIND v(dout0_2) AT=990.025n

.meas tran vdout0_3ck1970 FIND v(dout0_3) AT=990.025n

.meas tran vdout0_4ck1970 FIND v(dout0_4) AT=990.025n

.meas tran vdout0_5ck1970 FIND v(dout0_5) AT=990.025n

.meas tran vdout0_6ck1970 FIND v(dout0_6) AT=990.025n

.meas tran vdout0_7ck1970 FIND v(dout0_7) AT=990.025n

.meas tran vdout0_8ck1970 FIND v(dout0_8) AT=990.025n

.meas tran vdout0_9ck1970 FIND v(dout0_9) AT=990.025n

.meas tran vdout0_10ck1970 FIND v(dout0_10) AT=990.025n

.meas tran vdout0_11ck1970 FIND v(dout0_11) AT=990.025n

.meas tran vdout0_12ck1970 FIND v(dout0_12) AT=990.025n

.meas tran vdout0_13ck1970 FIND v(dout0_13) AT=990.025n

.meas tran vdout0_14ck1970 FIND v(dout0_14) AT=990.025n

.meas tran vdout0_15ck1970 FIND v(dout0_15) AT=990.025n

.meas tran vdout0_16ck1970 FIND v(dout0_16) AT=990.025n

.meas tran vdout0_17ck1970 FIND v(dout0_17) AT=990.025n

.meas tran vdout0_18ck1970 FIND v(dout0_18) AT=990.025n

.meas tran vdout0_19ck1970 FIND v(dout0_19) AT=990.025n

.meas tran vdout0_20ck1970 FIND v(dout0_20) AT=990.025n

.meas tran vdout0_21ck1970 FIND v(dout0_21) AT=990.025n

.meas tran vdout0_22ck1970 FIND v(dout0_22) AT=990.025n

.meas tran vdout0_23ck1970 FIND v(dout0_23) AT=990.025n

.meas tran vdout0_24ck1970 FIND v(dout0_24) AT=990.025n

.meas tran vdout0_25ck1970 FIND v(dout0_25) AT=990.025n

.meas tran vdout0_26ck1970 FIND v(dout0_26) AT=990.025n

.meas tran vdout0_27ck1970 FIND v(dout0_27) AT=990.025n

.meas tran vdout0_28ck1970 FIND v(dout0_28) AT=990.025n

.meas tran vdout0_29ck1970 FIND v(dout0_29) AT=990.025n

.meas tran vdout0_30ck1970 FIND v(dout0_30) AT=990.025n

.meas tran vdout0_31ck1970 FIND v(dout0_31) AT=990.025n

.meas tran vdout0_32ck1970 FIND v(dout0_32) AT=990.025n

.meas tran vdout0_33ck1970 FIND v(dout0_33) AT=990.025n

.meas tran vdout0_34ck1970 FIND v(dout0_34) AT=990.025n

.meas tran vdout0_35ck1970 FIND v(dout0_35) AT=990.025n

.meas tran vdout0_36ck1970 FIND v(dout0_36) AT=990.025n

.meas tran vdout0_37ck1970 FIND v(dout0_37) AT=990.025n

.meas tran vdout0_38ck1970 FIND v(dout0_38) AT=990.025n

.meas tran vdout0_39ck1970 FIND v(dout0_39) AT=990.025n

.meas tran vdout0_40ck1970 FIND v(dout0_40) AT=990.025n

.meas tran vdout0_41ck1970 FIND v(dout0_41) AT=990.025n

.meas tran vdout0_42ck1970 FIND v(dout0_42) AT=990.025n

.meas tran vdout0_43ck1970 FIND v(dout0_43) AT=990.025n

.meas tran vdout0_44ck1970 FIND v(dout0_44) AT=990.025n

.meas tran vdout0_45ck1970 FIND v(dout0_45) AT=990.025n

.meas tran vdout0_46ck1970 FIND v(dout0_46) AT=990.025n

.meas tran vdout0_47ck1970 FIND v(dout0_47) AT=990.025n

.meas tran vdout0_48ck1970 FIND v(dout0_48) AT=990.025n

.meas tran vdout0_49ck1970 FIND v(dout0_49) AT=990.025n

.meas tran vdout0_50ck1970 FIND v(dout0_50) AT=990.025n

.meas tran vdout0_51ck1970 FIND v(dout0_51) AT=990.025n

.meas tran vdout0_52ck1970 FIND v(dout0_52) AT=990.025n

.meas tran vdout0_53ck1970 FIND v(dout0_53) AT=990.025n

.meas tran vdout0_54ck1970 FIND v(dout0_54) AT=990.025n

.meas tran vdout0_55ck1970 FIND v(dout0_55) AT=990.025n

.meas tran vdout0_56ck1970 FIND v(dout0_56) AT=990.025n

.meas tran vdout0_57ck1970 FIND v(dout0_57) AT=990.025n

.meas tran vdout0_58ck1970 FIND v(dout0_58) AT=990.025n

.meas tran vdout0_59ck1970 FIND v(dout0_59) AT=990.025n

.meas tran vdout0_60ck1970 FIND v(dout0_60) AT=990.025n

.meas tran vdout0_61ck1970 FIND v(dout0_61) AT=990.025n

.meas tran vdout0_62ck1970 FIND v(dout0_62) AT=990.025n

.meas tran vdout0_63ck1970 FIND v(dout0_63) AT=990.025n

.meas tran vdout1_0ck1970 FIND v(dout1_0) AT=990.025n

.meas tran vdout1_1ck1970 FIND v(dout1_1) AT=990.025n

.meas tran vdout1_2ck1970 FIND v(dout1_2) AT=990.025n

.meas tran vdout1_3ck1970 FIND v(dout1_3) AT=990.025n

.meas tran vdout1_4ck1970 FIND v(dout1_4) AT=990.025n

.meas tran vdout1_5ck1970 FIND v(dout1_5) AT=990.025n

.meas tran vdout1_6ck1970 FIND v(dout1_6) AT=990.025n

.meas tran vdout1_7ck1970 FIND v(dout1_7) AT=990.025n

.meas tran vdout1_8ck1970 FIND v(dout1_8) AT=990.025n

.meas tran vdout1_9ck1970 FIND v(dout1_9) AT=990.025n

.meas tran vdout1_10ck1970 FIND v(dout1_10) AT=990.025n

.meas tran vdout1_11ck1970 FIND v(dout1_11) AT=990.025n

.meas tran vdout1_12ck1970 FIND v(dout1_12) AT=990.025n

.meas tran vdout1_13ck1970 FIND v(dout1_13) AT=990.025n

.meas tran vdout1_14ck1970 FIND v(dout1_14) AT=990.025n

.meas tran vdout1_15ck1970 FIND v(dout1_15) AT=990.025n

.meas tran vdout1_16ck1970 FIND v(dout1_16) AT=990.025n

.meas tran vdout1_17ck1970 FIND v(dout1_17) AT=990.025n

.meas tran vdout1_18ck1970 FIND v(dout1_18) AT=990.025n

.meas tran vdout1_19ck1970 FIND v(dout1_19) AT=990.025n

.meas tran vdout1_20ck1970 FIND v(dout1_20) AT=990.025n

.meas tran vdout1_21ck1970 FIND v(dout1_21) AT=990.025n

.meas tran vdout1_22ck1970 FIND v(dout1_22) AT=990.025n

.meas tran vdout1_23ck1970 FIND v(dout1_23) AT=990.025n

.meas tran vdout1_24ck1970 FIND v(dout1_24) AT=990.025n

.meas tran vdout1_25ck1970 FIND v(dout1_25) AT=990.025n

.meas tran vdout1_26ck1970 FIND v(dout1_26) AT=990.025n

.meas tran vdout1_27ck1970 FIND v(dout1_27) AT=990.025n

.meas tran vdout1_28ck1970 FIND v(dout1_28) AT=990.025n

.meas tran vdout1_29ck1970 FIND v(dout1_29) AT=990.025n

.meas tran vdout1_30ck1970 FIND v(dout1_30) AT=990.025n

.meas tran vdout1_31ck1970 FIND v(dout1_31) AT=990.025n

.meas tran vdout1_32ck1970 FIND v(dout1_32) AT=990.025n

.meas tran vdout1_33ck1970 FIND v(dout1_33) AT=990.025n

.meas tran vdout1_34ck1970 FIND v(dout1_34) AT=990.025n

.meas tran vdout1_35ck1970 FIND v(dout1_35) AT=990.025n

.meas tran vdout1_36ck1970 FIND v(dout1_36) AT=990.025n

.meas tran vdout1_37ck1970 FIND v(dout1_37) AT=990.025n

.meas tran vdout1_38ck1970 FIND v(dout1_38) AT=990.025n

.meas tran vdout1_39ck1970 FIND v(dout1_39) AT=990.025n

.meas tran vdout1_40ck1970 FIND v(dout1_40) AT=990.025n

.meas tran vdout1_41ck1970 FIND v(dout1_41) AT=990.025n

.meas tran vdout1_42ck1970 FIND v(dout1_42) AT=990.025n

.meas tran vdout1_43ck1970 FIND v(dout1_43) AT=990.025n

.meas tran vdout1_44ck1970 FIND v(dout1_44) AT=990.025n

.meas tran vdout1_45ck1970 FIND v(dout1_45) AT=990.025n

.meas tran vdout1_46ck1970 FIND v(dout1_46) AT=990.025n

.meas tran vdout1_47ck1970 FIND v(dout1_47) AT=990.025n

.meas tran vdout1_48ck1970 FIND v(dout1_48) AT=990.025n

.meas tran vdout1_49ck1970 FIND v(dout1_49) AT=990.025n

.meas tran vdout1_50ck1970 FIND v(dout1_50) AT=990.025n

.meas tran vdout1_51ck1970 FIND v(dout1_51) AT=990.025n

.meas tran vdout1_52ck1970 FIND v(dout1_52) AT=990.025n

.meas tran vdout1_53ck1970 FIND v(dout1_53) AT=990.025n

.meas tran vdout1_54ck1970 FIND v(dout1_54) AT=990.025n

.meas tran vdout1_55ck1970 FIND v(dout1_55) AT=990.025n

.meas tran vdout1_56ck1970 FIND v(dout1_56) AT=990.025n

.meas tran vdout1_57ck1970 FIND v(dout1_57) AT=990.025n

.meas tran vdout1_58ck1970 FIND v(dout1_58) AT=990.025n

.meas tran vdout1_59ck1970 FIND v(dout1_59) AT=990.025n

.meas tran vdout1_60ck1970 FIND v(dout1_60) AT=990.025n

.meas tran vdout1_61ck1970 FIND v(dout1_61) AT=990.025n

.meas tran vdout1_62ck1970 FIND v(dout1_62) AT=990.025n

.meas tran vdout1_63ck1970 FIND v(dout1_63) AT=990.025n

.meas tran vdout1_0ck1980 FIND v(dout1_0) AT=995.025n

.meas tran vdout1_1ck1980 FIND v(dout1_1) AT=995.025n

.meas tran vdout1_2ck1980 FIND v(dout1_2) AT=995.025n

.meas tran vdout1_3ck1980 FIND v(dout1_3) AT=995.025n

.meas tran vdout1_4ck1980 FIND v(dout1_4) AT=995.025n

.meas tran vdout1_5ck1980 FIND v(dout1_5) AT=995.025n

.meas tran vdout1_6ck1980 FIND v(dout1_6) AT=995.025n

.meas tran vdout1_7ck1980 FIND v(dout1_7) AT=995.025n

.meas tran vdout1_8ck1980 FIND v(dout1_8) AT=995.025n

.meas tran vdout1_9ck1980 FIND v(dout1_9) AT=995.025n

.meas tran vdout1_10ck1980 FIND v(dout1_10) AT=995.025n

.meas tran vdout1_11ck1980 FIND v(dout1_11) AT=995.025n

.meas tran vdout1_12ck1980 FIND v(dout1_12) AT=995.025n

.meas tran vdout1_13ck1980 FIND v(dout1_13) AT=995.025n

.meas tran vdout1_14ck1980 FIND v(dout1_14) AT=995.025n

.meas tran vdout1_15ck1980 FIND v(dout1_15) AT=995.025n

.meas tran vdout1_16ck1980 FIND v(dout1_16) AT=995.025n

.meas tran vdout1_17ck1980 FIND v(dout1_17) AT=995.025n

.meas tran vdout1_18ck1980 FIND v(dout1_18) AT=995.025n

.meas tran vdout1_19ck1980 FIND v(dout1_19) AT=995.025n

.meas tran vdout1_20ck1980 FIND v(dout1_20) AT=995.025n

.meas tran vdout1_21ck1980 FIND v(dout1_21) AT=995.025n

.meas tran vdout1_22ck1980 FIND v(dout1_22) AT=995.025n

.meas tran vdout1_23ck1980 FIND v(dout1_23) AT=995.025n

.meas tran vdout1_24ck1980 FIND v(dout1_24) AT=995.025n

.meas tran vdout1_25ck1980 FIND v(dout1_25) AT=995.025n

.meas tran vdout1_26ck1980 FIND v(dout1_26) AT=995.025n

.meas tran vdout1_27ck1980 FIND v(dout1_27) AT=995.025n

.meas tran vdout1_28ck1980 FIND v(dout1_28) AT=995.025n

.meas tran vdout1_29ck1980 FIND v(dout1_29) AT=995.025n

.meas tran vdout1_30ck1980 FIND v(dout1_30) AT=995.025n

.meas tran vdout1_31ck1980 FIND v(dout1_31) AT=995.025n

.meas tran vdout1_32ck1980 FIND v(dout1_32) AT=995.025n

.meas tran vdout1_33ck1980 FIND v(dout1_33) AT=995.025n

.meas tran vdout1_34ck1980 FIND v(dout1_34) AT=995.025n

.meas tran vdout1_35ck1980 FIND v(dout1_35) AT=995.025n

.meas tran vdout1_36ck1980 FIND v(dout1_36) AT=995.025n

.meas tran vdout1_37ck1980 FIND v(dout1_37) AT=995.025n

.meas tran vdout1_38ck1980 FIND v(dout1_38) AT=995.025n

.meas tran vdout1_39ck1980 FIND v(dout1_39) AT=995.025n

.meas tran vdout1_40ck1980 FIND v(dout1_40) AT=995.025n

.meas tran vdout1_41ck1980 FIND v(dout1_41) AT=995.025n

.meas tran vdout1_42ck1980 FIND v(dout1_42) AT=995.025n

.meas tran vdout1_43ck1980 FIND v(dout1_43) AT=995.025n

.meas tran vdout1_44ck1980 FIND v(dout1_44) AT=995.025n

.meas tran vdout1_45ck1980 FIND v(dout1_45) AT=995.025n

.meas tran vdout1_46ck1980 FIND v(dout1_46) AT=995.025n

.meas tran vdout1_47ck1980 FIND v(dout1_47) AT=995.025n

.meas tran vdout1_48ck1980 FIND v(dout1_48) AT=995.025n

.meas tran vdout1_49ck1980 FIND v(dout1_49) AT=995.025n

.meas tran vdout1_50ck1980 FIND v(dout1_50) AT=995.025n

.meas tran vdout1_51ck1980 FIND v(dout1_51) AT=995.025n

.meas tran vdout1_52ck1980 FIND v(dout1_52) AT=995.025n

.meas tran vdout1_53ck1980 FIND v(dout1_53) AT=995.025n

.meas tran vdout1_54ck1980 FIND v(dout1_54) AT=995.025n

.meas tran vdout1_55ck1980 FIND v(dout1_55) AT=995.025n

.meas tran vdout1_56ck1980 FIND v(dout1_56) AT=995.025n

.meas tran vdout1_57ck1980 FIND v(dout1_57) AT=995.025n

.meas tran vdout1_58ck1980 FIND v(dout1_58) AT=995.025n

.meas tran vdout1_59ck1980 FIND v(dout1_59) AT=995.025n

.meas tran vdout1_60ck1980 FIND v(dout1_60) AT=995.025n

.meas tran vdout1_61ck1980 FIND v(dout1_61) AT=995.025n

.meas tran vdout1_62ck1980 FIND v(dout1_62) AT=995.025n

.meas tran vdout1_63ck1980 FIND v(dout1_63) AT=995.025n

.meas tran vdout1_0ck1990 FIND v(dout1_0) AT=1000.025n

.meas tran vdout1_1ck1990 FIND v(dout1_1) AT=1000.025n

.meas tran vdout1_2ck1990 FIND v(dout1_2) AT=1000.025n

.meas tran vdout1_3ck1990 FIND v(dout1_3) AT=1000.025n

.meas tran vdout1_4ck1990 FIND v(dout1_4) AT=1000.025n

.meas tran vdout1_5ck1990 FIND v(dout1_5) AT=1000.025n

.meas tran vdout1_6ck1990 FIND v(dout1_6) AT=1000.025n

.meas tran vdout1_7ck1990 FIND v(dout1_7) AT=1000.025n

.meas tran vdout1_8ck1990 FIND v(dout1_8) AT=1000.025n

.meas tran vdout1_9ck1990 FIND v(dout1_9) AT=1000.025n

.meas tran vdout1_10ck1990 FIND v(dout1_10) AT=1000.025n

.meas tran vdout1_11ck1990 FIND v(dout1_11) AT=1000.025n

.meas tran vdout1_12ck1990 FIND v(dout1_12) AT=1000.025n

.meas tran vdout1_13ck1990 FIND v(dout1_13) AT=1000.025n

.meas tran vdout1_14ck1990 FIND v(dout1_14) AT=1000.025n

.meas tran vdout1_15ck1990 FIND v(dout1_15) AT=1000.025n

.meas tran vdout1_16ck1990 FIND v(dout1_16) AT=1000.025n

.meas tran vdout1_17ck1990 FIND v(dout1_17) AT=1000.025n

.meas tran vdout1_18ck1990 FIND v(dout1_18) AT=1000.025n

.meas tran vdout1_19ck1990 FIND v(dout1_19) AT=1000.025n

.meas tran vdout1_20ck1990 FIND v(dout1_20) AT=1000.025n

.meas tran vdout1_21ck1990 FIND v(dout1_21) AT=1000.025n

.meas tran vdout1_22ck1990 FIND v(dout1_22) AT=1000.025n

.meas tran vdout1_23ck1990 FIND v(dout1_23) AT=1000.025n

.meas tran vdout1_24ck1990 FIND v(dout1_24) AT=1000.025n

.meas tran vdout1_25ck1990 FIND v(dout1_25) AT=1000.025n

.meas tran vdout1_26ck1990 FIND v(dout1_26) AT=1000.025n

.meas tran vdout1_27ck1990 FIND v(dout1_27) AT=1000.025n

.meas tran vdout1_28ck1990 FIND v(dout1_28) AT=1000.025n

.meas tran vdout1_29ck1990 FIND v(dout1_29) AT=1000.025n

.meas tran vdout1_30ck1990 FIND v(dout1_30) AT=1000.025n

.meas tran vdout1_31ck1990 FIND v(dout1_31) AT=1000.025n

.meas tran vdout1_32ck1990 FIND v(dout1_32) AT=1000.025n

.meas tran vdout1_33ck1990 FIND v(dout1_33) AT=1000.025n

.meas tran vdout1_34ck1990 FIND v(dout1_34) AT=1000.025n

.meas tran vdout1_35ck1990 FIND v(dout1_35) AT=1000.025n

.meas tran vdout1_36ck1990 FIND v(dout1_36) AT=1000.025n

.meas tran vdout1_37ck1990 FIND v(dout1_37) AT=1000.025n

.meas tran vdout1_38ck1990 FIND v(dout1_38) AT=1000.025n

.meas tran vdout1_39ck1990 FIND v(dout1_39) AT=1000.025n

.meas tran vdout1_40ck1990 FIND v(dout1_40) AT=1000.025n

.meas tran vdout1_41ck1990 FIND v(dout1_41) AT=1000.025n

.meas tran vdout1_42ck1990 FIND v(dout1_42) AT=1000.025n

.meas tran vdout1_43ck1990 FIND v(dout1_43) AT=1000.025n

.meas tran vdout1_44ck1990 FIND v(dout1_44) AT=1000.025n

.meas tran vdout1_45ck1990 FIND v(dout1_45) AT=1000.025n

.meas tran vdout1_46ck1990 FIND v(dout1_46) AT=1000.025n

.meas tran vdout1_47ck1990 FIND v(dout1_47) AT=1000.025n

.meas tran vdout1_48ck1990 FIND v(dout1_48) AT=1000.025n

.meas tran vdout1_49ck1990 FIND v(dout1_49) AT=1000.025n

.meas tran vdout1_50ck1990 FIND v(dout1_50) AT=1000.025n

.meas tran vdout1_51ck1990 FIND v(dout1_51) AT=1000.025n

.meas tran vdout1_52ck1990 FIND v(dout1_52) AT=1000.025n

.meas tran vdout1_53ck1990 FIND v(dout1_53) AT=1000.025n

.meas tran vdout1_54ck1990 FIND v(dout1_54) AT=1000.025n

.meas tran vdout1_55ck1990 FIND v(dout1_55) AT=1000.025n

.meas tran vdout1_56ck1990 FIND v(dout1_56) AT=1000.025n

.meas tran vdout1_57ck1990 FIND v(dout1_57) AT=1000.025n

.meas tran vdout1_58ck1990 FIND v(dout1_58) AT=1000.025n

.meas tran vdout1_59ck1990 FIND v(dout1_59) AT=1000.025n

.meas tran vdout1_60ck1990 FIND v(dout1_60) AT=1000.025n

.meas tran vdout1_61ck1990 FIND v(dout1_61) AT=1000.025n

.meas tran vdout1_62ck1990 FIND v(dout1_62) AT=1000.025n

.meas tran vdout1_63ck1990 FIND v(dout1_63) AT=1000.025n

.meas tran vdout0_0ck2000 FIND v(dout0_0) AT=1005.025n

.meas tran vdout0_1ck2000 FIND v(dout0_1) AT=1005.025n

.meas tran vdout0_2ck2000 FIND v(dout0_2) AT=1005.025n

.meas tran vdout0_3ck2000 FIND v(dout0_3) AT=1005.025n

.meas tran vdout0_4ck2000 FIND v(dout0_4) AT=1005.025n

.meas tran vdout0_5ck2000 FIND v(dout0_5) AT=1005.025n

.meas tran vdout0_6ck2000 FIND v(dout0_6) AT=1005.025n

.meas tran vdout0_7ck2000 FIND v(dout0_7) AT=1005.025n

.meas tran vdout0_8ck2000 FIND v(dout0_8) AT=1005.025n

.meas tran vdout0_9ck2000 FIND v(dout0_9) AT=1005.025n

.meas tran vdout0_10ck2000 FIND v(dout0_10) AT=1005.025n

.meas tran vdout0_11ck2000 FIND v(dout0_11) AT=1005.025n

.meas tran vdout0_12ck2000 FIND v(dout0_12) AT=1005.025n

.meas tran vdout0_13ck2000 FIND v(dout0_13) AT=1005.025n

.meas tran vdout0_14ck2000 FIND v(dout0_14) AT=1005.025n

.meas tran vdout0_15ck2000 FIND v(dout0_15) AT=1005.025n

.meas tran vdout0_16ck2000 FIND v(dout0_16) AT=1005.025n

.meas tran vdout0_17ck2000 FIND v(dout0_17) AT=1005.025n

.meas tran vdout0_18ck2000 FIND v(dout0_18) AT=1005.025n

.meas tran vdout0_19ck2000 FIND v(dout0_19) AT=1005.025n

.meas tran vdout0_20ck2000 FIND v(dout0_20) AT=1005.025n

.meas tran vdout0_21ck2000 FIND v(dout0_21) AT=1005.025n

.meas tran vdout0_22ck2000 FIND v(dout0_22) AT=1005.025n

.meas tran vdout0_23ck2000 FIND v(dout0_23) AT=1005.025n

.meas tran vdout0_24ck2000 FIND v(dout0_24) AT=1005.025n

.meas tran vdout0_25ck2000 FIND v(dout0_25) AT=1005.025n

.meas tran vdout0_26ck2000 FIND v(dout0_26) AT=1005.025n

.meas tran vdout0_27ck2000 FIND v(dout0_27) AT=1005.025n

.meas tran vdout0_28ck2000 FIND v(dout0_28) AT=1005.025n

.meas tran vdout0_29ck2000 FIND v(dout0_29) AT=1005.025n

.meas tran vdout0_30ck2000 FIND v(dout0_30) AT=1005.025n

.meas tran vdout0_31ck2000 FIND v(dout0_31) AT=1005.025n

.meas tran vdout0_32ck2000 FIND v(dout0_32) AT=1005.025n

.meas tran vdout0_33ck2000 FIND v(dout0_33) AT=1005.025n

.meas tran vdout0_34ck2000 FIND v(dout0_34) AT=1005.025n

.meas tran vdout0_35ck2000 FIND v(dout0_35) AT=1005.025n

.meas tran vdout0_36ck2000 FIND v(dout0_36) AT=1005.025n

.meas tran vdout0_37ck2000 FIND v(dout0_37) AT=1005.025n

.meas tran vdout0_38ck2000 FIND v(dout0_38) AT=1005.025n

.meas tran vdout0_39ck2000 FIND v(dout0_39) AT=1005.025n

.meas tran vdout0_40ck2000 FIND v(dout0_40) AT=1005.025n

.meas tran vdout0_41ck2000 FIND v(dout0_41) AT=1005.025n

.meas tran vdout0_42ck2000 FIND v(dout0_42) AT=1005.025n

.meas tran vdout0_43ck2000 FIND v(dout0_43) AT=1005.025n

.meas tran vdout0_44ck2000 FIND v(dout0_44) AT=1005.025n

.meas tran vdout0_45ck2000 FIND v(dout0_45) AT=1005.025n

.meas tran vdout0_46ck2000 FIND v(dout0_46) AT=1005.025n

.meas tran vdout0_47ck2000 FIND v(dout0_47) AT=1005.025n

.meas tran vdout0_48ck2000 FIND v(dout0_48) AT=1005.025n

.meas tran vdout0_49ck2000 FIND v(dout0_49) AT=1005.025n

.meas tran vdout0_50ck2000 FIND v(dout0_50) AT=1005.025n

.meas tran vdout0_51ck2000 FIND v(dout0_51) AT=1005.025n

.meas tran vdout0_52ck2000 FIND v(dout0_52) AT=1005.025n

.meas tran vdout0_53ck2000 FIND v(dout0_53) AT=1005.025n

.meas tran vdout0_54ck2000 FIND v(dout0_54) AT=1005.025n

.meas tran vdout0_55ck2000 FIND v(dout0_55) AT=1005.025n

.meas tran vdout0_56ck2000 FIND v(dout0_56) AT=1005.025n

.meas tran vdout0_57ck2000 FIND v(dout0_57) AT=1005.025n

.meas tran vdout0_58ck2000 FIND v(dout0_58) AT=1005.025n

.meas tran vdout0_59ck2000 FIND v(dout0_59) AT=1005.025n

.meas tran vdout0_60ck2000 FIND v(dout0_60) AT=1005.025n

.meas tran vdout0_61ck2000 FIND v(dout0_61) AT=1005.025n

.meas tran vdout0_62ck2000 FIND v(dout0_62) AT=1005.025n

.meas tran vdout0_63ck2000 FIND v(dout0_63) AT=1005.025n

.meas tran vdout0_0ck2010 FIND v(dout0_0) AT=1010.025n

.meas tran vdout0_1ck2010 FIND v(dout0_1) AT=1010.025n

.meas tran vdout0_2ck2010 FIND v(dout0_2) AT=1010.025n

.meas tran vdout0_3ck2010 FIND v(dout0_3) AT=1010.025n

.meas tran vdout0_4ck2010 FIND v(dout0_4) AT=1010.025n

.meas tran vdout0_5ck2010 FIND v(dout0_5) AT=1010.025n

.meas tran vdout0_6ck2010 FIND v(dout0_6) AT=1010.025n

.meas tran vdout0_7ck2010 FIND v(dout0_7) AT=1010.025n

.meas tran vdout0_8ck2010 FIND v(dout0_8) AT=1010.025n

.meas tran vdout0_9ck2010 FIND v(dout0_9) AT=1010.025n

.meas tran vdout0_10ck2010 FIND v(dout0_10) AT=1010.025n

.meas tran vdout0_11ck2010 FIND v(dout0_11) AT=1010.025n

.meas tran vdout0_12ck2010 FIND v(dout0_12) AT=1010.025n

.meas tran vdout0_13ck2010 FIND v(dout0_13) AT=1010.025n

.meas tran vdout0_14ck2010 FIND v(dout0_14) AT=1010.025n

.meas tran vdout0_15ck2010 FIND v(dout0_15) AT=1010.025n

.meas tran vdout0_16ck2010 FIND v(dout0_16) AT=1010.025n

.meas tran vdout0_17ck2010 FIND v(dout0_17) AT=1010.025n

.meas tran vdout0_18ck2010 FIND v(dout0_18) AT=1010.025n

.meas tran vdout0_19ck2010 FIND v(dout0_19) AT=1010.025n

.meas tran vdout0_20ck2010 FIND v(dout0_20) AT=1010.025n

.meas tran vdout0_21ck2010 FIND v(dout0_21) AT=1010.025n

.meas tran vdout0_22ck2010 FIND v(dout0_22) AT=1010.025n

.meas tran vdout0_23ck2010 FIND v(dout0_23) AT=1010.025n

.meas tran vdout0_24ck2010 FIND v(dout0_24) AT=1010.025n

.meas tran vdout0_25ck2010 FIND v(dout0_25) AT=1010.025n

.meas tran vdout0_26ck2010 FIND v(dout0_26) AT=1010.025n

.meas tran vdout0_27ck2010 FIND v(dout0_27) AT=1010.025n

.meas tran vdout0_28ck2010 FIND v(dout0_28) AT=1010.025n

.meas tran vdout0_29ck2010 FIND v(dout0_29) AT=1010.025n

.meas tran vdout0_30ck2010 FIND v(dout0_30) AT=1010.025n

.meas tran vdout0_31ck2010 FIND v(dout0_31) AT=1010.025n

.meas tran vdout0_32ck2010 FIND v(dout0_32) AT=1010.025n

.meas tran vdout0_33ck2010 FIND v(dout0_33) AT=1010.025n

.meas tran vdout0_34ck2010 FIND v(dout0_34) AT=1010.025n

.meas tran vdout0_35ck2010 FIND v(dout0_35) AT=1010.025n

.meas tran vdout0_36ck2010 FIND v(dout0_36) AT=1010.025n

.meas tran vdout0_37ck2010 FIND v(dout0_37) AT=1010.025n

.meas tran vdout0_38ck2010 FIND v(dout0_38) AT=1010.025n

.meas tran vdout0_39ck2010 FIND v(dout0_39) AT=1010.025n

.meas tran vdout0_40ck2010 FIND v(dout0_40) AT=1010.025n

.meas tran vdout0_41ck2010 FIND v(dout0_41) AT=1010.025n

.meas tran vdout0_42ck2010 FIND v(dout0_42) AT=1010.025n

.meas tran vdout0_43ck2010 FIND v(dout0_43) AT=1010.025n

.meas tran vdout0_44ck2010 FIND v(dout0_44) AT=1010.025n

.meas tran vdout0_45ck2010 FIND v(dout0_45) AT=1010.025n

.meas tran vdout0_46ck2010 FIND v(dout0_46) AT=1010.025n

.meas tran vdout0_47ck2010 FIND v(dout0_47) AT=1010.025n

.meas tran vdout0_48ck2010 FIND v(dout0_48) AT=1010.025n

.meas tran vdout0_49ck2010 FIND v(dout0_49) AT=1010.025n

.meas tran vdout0_50ck2010 FIND v(dout0_50) AT=1010.025n

.meas tran vdout0_51ck2010 FIND v(dout0_51) AT=1010.025n

.meas tran vdout0_52ck2010 FIND v(dout0_52) AT=1010.025n

.meas tran vdout0_53ck2010 FIND v(dout0_53) AT=1010.025n

.meas tran vdout0_54ck2010 FIND v(dout0_54) AT=1010.025n

.meas tran vdout0_55ck2010 FIND v(dout0_55) AT=1010.025n

.meas tran vdout0_56ck2010 FIND v(dout0_56) AT=1010.025n

.meas tran vdout0_57ck2010 FIND v(dout0_57) AT=1010.025n

.meas tran vdout0_58ck2010 FIND v(dout0_58) AT=1010.025n

.meas tran vdout0_59ck2010 FIND v(dout0_59) AT=1010.025n

.meas tran vdout0_60ck2010 FIND v(dout0_60) AT=1010.025n

.meas tran vdout0_61ck2010 FIND v(dout0_61) AT=1010.025n

.meas tran vdout0_62ck2010 FIND v(dout0_62) AT=1010.025n

.meas tran vdout0_63ck2010 FIND v(dout0_63) AT=1010.025n

.meas tran vdout0_0ck2030 FIND v(dout0_0) AT=1020.025n

.meas tran vdout0_1ck2030 FIND v(dout0_1) AT=1020.025n

.meas tran vdout0_2ck2030 FIND v(dout0_2) AT=1020.025n

.meas tran vdout0_3ck2030 FIND v(dout0_3) AT=1020.025n

.meas tran vdout0_4ck2030 FIND v(dout0_4) AT=1020.025n

.meas tran vdout0_5ck2030 FIND v(dout0_5) AT=1020.025n

.meas tran vdout0_6ck2030 FIND v(dout0_6) AT=1020.025n

.meas tran vdout0_7ck2030 FIND v(dout0_7) AT=1020.025n

.meas tran vdout0_8ck2030 FIND v(dout0_8) AT=1020.025n

.meas tran vdout0_9ck2030 FIND v(dout0_9) AT=1020.025n

.meas tran vdout0_10ck2030 FIND v(dout0_10) AT=1020.025n

.meas tran vdout0_11ck2030 FIND v(dout0_11) AT=1020.025n

.meas tran vdout0_12ck2030 FIND v(dout0_12) AT=1020.025n

.meas tran vdout0_13ck2030 FIND v(dout0_13) AT=1020.025n

.meas tran vdout0_14ck2030 FIND v(dout0_14) AT=1020.025n

.meas tran vdout0_15ck2030 FIND v(dout0_15) AT=1020.025n

.meas tran vdout0_16ck2030 FIND v(dout0_16) AT=1020.025n

.meas tran vdout0_17ck2030 FIND v(dout0_17) AT=1020.025n

.meas tran vdout0_18ck2030 FIND v(dout0_18) AT=1020.025n

.meas tran vdout0_19ck2030 FIND v(dout0_19) AT=1020.025n

.meas tran vdout0_20ck2030 FIND v(dout0_20) AT=1020.025n

.meas tran vdout0_21ck2030 FIND v(dout0_21) AT=1020.025n

.meas tran vdout0_22ck2030 FIND v(dout0_22) AT=1020.025n

.meas tran vdout0_23ck2030 FIND v(dout0_23) AT=1020.025n

.meas tran vdout0_24ck2030 FIND v(dout0_24) AT=1020.025n

.meas tran vdout0_25ck2030 FIND v(dout0_25) AT=1020.025n

.meas tran vdout0_26ck2030 FIND v(dout0_26) AT=1020.025n

.meas tran vdout0_27ck2030 FIND v(dout0_27) AT=1020.025n

.meas tran vdout0_28ck2030 FIND v(dout0_28) AT=1020.025n

.meas tran vdout0_29ck2030 FIND v(dout0_29) AT=1020.025n

.meas tran vdout0_30ck2030 FIND v(dout0_30) AT=1020.025n

.meas tran vdout0_31ck2030 FIND v(dout0_31) AT=1020.025n

.meas tran vdout0_32ck2030 FIND v(dout0_32) AT=1020.025n

.meas tran vdout0_33ck2030 FIND v(dout0_33) AT=1020.025n

.meas tran vdout0_34ck2030 FIND v(dout0_34) AT=1020.025n

.meas tran vdout0_35ck2030 FIND v(dout0_35) AT=1020.025n

.meas tran vdout0_36ck2030 FIND v(dout0_36) AT=1020.025n

.meas tran vdout0_37ck2030 FIND v(dout0_37) AT=1020.025n

.meas tran vdout0_38ck2030 FIND v(dout0_38) AT=1020.025n

.meas tran vdout0_39ck2030 FIND v(dout0_39) AT=1020.025n

.meas tran vdout0_40ck2030 FIND v(dout0_40) AT=1020.025n

.meas tran vdout0_41ck2030 FIND v(dout0_41) AT=1020.025n

.meas tran vdout0_42ck2030 FIND v(dout0_42) AT=1020.025n

.meas tran vdout0_43ck2030 FIND v(dout0_43) AT=1020.025n

.meas tran vdout0_44ck2030 FIND v(dout0_44) AT=1020.025n

.meas tran vdout0_45ck2030 FIND v(dout0_45) AT=1020.025n

.meas tran vdout0_46ck2030 FIND v(dout0_46) AT=1020.025n

.meas tran vdout0_47ck2030 FIND v(dout0_47) AT=1020.025n

.meas tran vdout0_48ck2030 FIND v(dout0_48) AT=1020.025n

.meas tran vdout0_49ck2030 FIND v(dout0_49) AT=1020.025n

.meas tran vdout0_50ck2030 FIND v(dout0_50) AT=1020.025n

.meas tran vdout0_51ck2030 FIND v(dout0_51) AT=1020.025n

.meas tran vdout0_52ck2030 FIND v(dout0_52) AT=1020.025n

.meas tran vdout0_53ck2030 FIND v(dout0_53) AT=1020.025n

.meas tran vdout0_54ck2030 FIND v(dout0_54) AT=1020.025n

.meas tran vdout0_55ck2030 FIND v(dout0_55) AT=1020.025n

.meas tran vdout0_56ck2030 FIND v(dout0_56) AT=1020.025n

.meas tran vdout0_57ck2030 FIND v(dout0_57) AT=1020.025n

.meas tran vdout0_58ck2030 FIND v(dout0_58) AT=1020.025n

.meas tran vdout0_59ck2030 FIND v(dout0_59) AT=1020.025n

.meas tran vdout0_60ck2030 FIND v(dout0_60) AT=1020.025n

.meas tran vdout0_61ck2030 FIND v(dout0_61) AT=1020.025n

.meas tran vdout0_62ck2030 FIND v(dout0_62) AT=1020.025n

.meas tran vdout0_63ck2030 FIND v(dout0_63) AT=1020.025n

.meas tran vdout1_0ck2030 FIND v(dout1_0) AT=1020.025n

.meas tran vdout1_1ck2030 FIND v(dout1_1) AT=1020.025n

.meas tran vdout1_2ck2030 FIND v(dout1_2) AT=1020.025n

.meas tran vdout1_3ck2030 FIND v(dout1_3) AT=1020.025n

.meas tran vdout1_4ck2030 FIND v(dout1_4) AT=1020.025n

.meas tran vdout1_5ck2030 FIND v(dout1_5) AT=1020.025n

.meas tran vdout1_6ck2030 FIND v(dout1_6) AT=1020.025n

.meas tran vdout1_7ck2030 FIND v(dout1_7) AT=1020.025n

.meas tran vdout1_8ck2030 FIND v(dout1_8) AT=1020.025n

.meas tran vdout1_9ck2030 FIND v(dout1_9) AT=1020.025n

.meas tran vdout1_10ck2030 FIND v(dout1_10) AT=1020.025n

.meas tran vdout1_11ck2030 FIND v(dout1_11) AT=1020.025n

.meas tran vdout1_12ck2030 FIND v(dout1_12) AT=1020.025n

.meas tran vdout1_13ck2030 FIND v(dout1_13) AT=1020.025n

.meas tran vdout1_14ck2030 FIND v(dout1_14) AT=1020.025n

.meas tran vdout1_15ck2030 FIND v(dout1_15) AT=1020.025n

.meas tran vdout1_16ck2030 FIND v(dout1_16) AT=1020.025n

.meas tran vdout1_17ck2030 FIND v(dout1_17) AT=1020.025n

.meas tran vdout1_18ck2030 FIND v(dout1_18) AT=1020.025n

.meas tran vdout1_19ck2030 FIND v(dout1_19) AT=1020.025n

.meas tran vdout1_20ck2030 FIND v(dout1_20) AT=1020.025n

.meas tran vdout1_21ck2030 FIND v(dout1_21) AT=1020.025n

.meas tran vdout1_22ck2030 FIND v(dout1_22) AT=1020.025n

.meas tran vdout1_23ck2030 FIND v(dout1_23) AT=1020.025n

.meas tran vdout1_24ck2030 FIND v(dout1_24) AT=1020.025n

.meas tran vdout1_25ck2030 FIND v(dout1_25) AT=1020.025n

.meas tran vdout1_26ck2030 FIND v(dout1_26) AT=1020.025n

.meas tran vdout1_27ck2030 FIND v(dout1_27) AT=1020.025n

.meas tran vdout1_28ck2030 FIND v(dout1_28) AT=1020.025n

.meas tran vdout1_29ck2030 FIND v(dout1_29) AT=1020.025n

.meas tran vdout1_30ck2030 FIND v(dout1_30) AT=1020.025n

.meas tran vdout1_31ck2030 FIND v(dout1_31) AT=1020.025n

.meas tran vdout1_32ck2030 FIND v(dout1_32) AT=1020.025n

.meas tran vdout1_33ck2030 FIND v(dout1_33) AT=1020.025n

.meas tran vdout1_34ck2030 FIND v(dout1_34) AT=1020.025n

.meas tran vdout1_35ck2030 FIND v(dout1_35) AT=1020.025n

.meas tran vdout1_36ck2030 FIND v(dout1_36) AT=1020.025n

.meas tran vdout1_37ck2030 FIND v(dout1_37) AT=1020.025n

.meas tran vdout1_38ck2030 FIND v(dout1_38) AT=1020.025n

.meas tran vdout1_39ck2030 FIND v(dout1_39) AT=1020.025n

.meas tran vdout1_40ck2030 FIND v(dout1_40) AT=1020.025n

.meas tran vdout1_41ck2030 FIND v(dout1_41) AT=1020.025n

.meas tran vdout1_42ck2030 FIND v(dout1_42) AT=1020.025n

.meas tran vdout1_43ck2030 FIND v(dout1_43) AT=1020.025n

.meas tran vdout1_44ck2030 FIND v(dout1_44) AT=1020.025n

.meas tran vdout1_45ck2030 FIND v(dout1_45) AT=1020.025n

.meas tran vdout1_46ck2030 FIND v(dout1_46) AT=1020.025n

.meas tran vdout1_47ck2030 FIND v(dout1_47) AT=1020.025n

.meas tran vdout1_48ck2030 FIND v(dout1_48) AT=1020.025n

.meas tran vdout1_49ck2030 FIND v(dout1_49) AT=1020.025n

.meas tran vdout1_50ck2030 FIND v(dout1_50) AT=1020.025n

.meas tran vdout1_51ck2030 FIND v(dout1_51) AT=1020.025n

.meas tran vdout1_52ck2030 FIND v(dout1_52) AT=1020.025n

.meas tran vdout1_53ck2030 FIND v(dout1_53) AT=1020.025n

.meas tran vdout1_54ck2030 FIND v(dout1_54) AT=1020.025n

.meas tran vdout1_55ck2030 FIND v(dout1_55) AT=1020.025n

.meas tran vdout1_56ck2030 FIND v(dout1_56) AT=1020.025n

.meas tran vdout1_57ck2030 FIND v(dout1_57) AT=1020.025n

.meas tran vdout1_58ck2030 FIND v(dout1_58) AT=1020.025n

.meas tran vdout1_59ck2030 FIND v(dout1_59) AT=1020.025n

.meas tran vdout1_60ck2030 FIND v(dout1_60) AT=1020.025n

.meas tran vdout1_61ck2030 FIND v(dout1_61) AT=1020.025n

.meas tran vdout1_62ck2030 FIND v(dout1_62) AT=1020.025n

.meas tran vdout1_63ck2030 FIND v(dout1_63) AT=1020.025n
