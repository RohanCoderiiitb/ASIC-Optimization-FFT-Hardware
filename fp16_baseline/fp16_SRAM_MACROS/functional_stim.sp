* Functional test stimulus file for 5ns period

* TT process corner
.include "/home/ihs24/OpenRAM/technology/freepdk45/models/tran_models/models_nom/PMOS_VTG.inc"
.include "/home/ihs24/OpenRAM/technology/freepdk45/models/tran_models/models_nom/NMOS_VTG.inc"
.include "/tmp/openram_ihs24_645353_temp/sram.sp"

* Global Power Supplies
Vvdd vdd 0 1.0

*Nodes gnd and 0 are the same global ground node in ngspice/hspice/xa. Otherwise, this source may be needed.
*Vgnd gnd 0 0.0

* Instantiation of the SRAM
Xsram_512x32_2rw din0_0 din0_1 din0_2 din0_3 din0_4 din0_5 din0_6 din0_7 din0_8 din0_9 din0_10 din0_11 din0_12 din0_13 din0_14 din0_15 din0_16 din0_17 din0_18 din0_19 din0_20 din0_21 din0_22 din0_23 din0_24 din0_25 din0_26 din0_27 din0_28 din0_29 din0_30 din0_31 din1_0 din1_1 din1_2 din1_3 din1_4 din1_5 din1_6 din1_7 din1_8 din1_9 din1_10 din1_11 din1_12 din1_13 din1_14 din1_15 din1_16 din1_17 din1_18 din1_19 din1_20 din1_21 din1_22 din1_23 din1_24 din1_25 din1_26 din1_27 din1_28 din1_29 din1_30 din1_31 a0_0 a0_1 a0_2 a0_3 a0_4 a0_5 a0_6 a0_7 a0_8 a1_0 a1_1 a1_2 a1_3 a1_4 a1_5 a1_6 a1_7 a1_8 CSB0 CSB1 WEB0 WEB1 clk0 clk1 dout0_0 dout0_1 dout0_2 dout0_3 dout0_4 dout0_5 dout0_6 dout0_7 dout0_8 dout0_9 dout0_10 dout0_11 dout0_12 dout0_13 dout0_14 dout0_15 dout0_16 dout0_17 dout0_18 dout0_19 dout0_20 dout0_21 dout0_22 dout0_23 dout0_24 dout0_25 dout0_26 dout0_27 dout0_28 dout0_29 dout0_30 dout0_31 dout1_0 dout1_1 dout1_2 dout1_3 dout1_4 dout1_5 dout1_6 dout1_7 dout1_8 dout1_9 dout1_10 dout1_11 dout1_12 dout1_13 dout1_14 dout1_15 dout1_16 dout1_17 dout1_18 dout1_19 dout1_20 dout1_21 dout1_22 dout1_23 dout1_24 dout1_25 dout1_26 dout1_27 dout1_28 dout1_29 dout1_30 dout1_31 vdd gnd sram_512x32_2rw

* SRAM output loads
CD00 dout0_0  0 0.8364f
CD01 dout0_1  0 0.8364f
CD02 dout0_2  0 0.8364f
CD03 dout0_3  0 0.8364f
CD04 dout0_4  0 0.8364f
CD05 dout0_5  0 0.8364f
CD06 dout0_6  0 0.8364f
CD07 dout0_7  0 0.8364f
CD08 dout0_8  0 0.8364f
CD09 dout0_9  0 0.8364f
CD010 dout0_10  0 0.8364f
CD011 dout0_11  0 0.8364f
CD012 dout0_12  0 0.8364f
CD013 dout0_13  0 0.8364f
CD014 dout0_14  0 0.8364f
CD015 dout0_15  0 0.8364f
CD016 dout0_16  0 0.8364f
CD017 dout0_17  0 0.8364f
CD018 dout0_18  0 0.8364f
CD019 dout0_19  0 0.8364f
CD020 dout0_20  0 0.8364f
CD021 dout0_21  0 0.8364f
CD022 dout0_22  0 0.8364f
CD023 dout0_23  0 0.8364f
CD024 dout0_24  0 0.8364f
CD025 dout0_25  0 0.8364f
CD026 dout0_26  0 0.8364f
CD027 dout0_27  0 0.8364f
CD028 dout0_28  0 0.8364f
CD029 dout0_29  0 0.8364f
CD030 dout0_30  0 0.8364f
CD031 dout0_31  0 0.8364f
CD10 dout1_0  0 0.8364f
CD11 dout1_1  0 0.8364f
CD12 dout1_2  0 0.8364f
CD13 dout1_3  0 0.8364f
CD14 dout1_4  0 0.8364f
CD15 dout1_5  0 0.8364f
CD16 dout1_6  0 0.8364f
CD17 dout1_7  0 0.8364f
CD18 dout1_8  0 0.8364f
CD19 dout1_9  0 0.8364f
CD110 dout1_10  0 0.8364f
CD111 dout1_11  0 0.8364f
CD112 dout1_12  0 0.8364f
CD113 dout1_13  0 0.8364f
CD114 dout1_14  0 0.8364f
CD115 dout1_15  0 0.8364f
CD116 dout1_16  0 0.8364f
CD117 dout1_17  0 0.8364f
CD118 dout1_18  0 0.8364f
CD119 dout1_19  0 0.8364f
CD120 dout1_20  0 0.8364f
CD121 dout1_21  0 0.8364f
CD122 dout1_22  0 0.8364f
CD123 dout1_23  0 0.8364f
CD124 dout1_24  0 0.8364f
CD125 dout1_25  0 0.8364f
CD126 dout1_26  0 0.8364f
CD127 dout1_27  0 0.8364f
CD128 dout1_28  0 0.8364f
CD129 dout1_29  0 0.8364f
CD130 dout1_30  0 0.8364f
CD131 dout1_31  0 0.8364f

* Important signals for debug
* bl:	xsram:xbank0:bl_0_1
* br:	xsram:xbank0:br_0_1
* s_en:	xsram:s_en
* q:	xsram:xbank0:xbitcell_array:xbitcell_array:xbit_r0_c0.Q
* qbar:	xsram:xbank0:xbitcell_array:xbitcell_array:xbit_r0_c0.Q_bar

* Sequence of operations
*	Idle during cycle 0 (0ns - 5ns)
*	Writing 00110001101101001010110000010001  to  address 000000000 (from port 0) during cycle 1 (5ns - 10ns)
*	Writing 11011100000101101110101010100111  to  address 111111100 (from port 1) during cycle 1 (5ns - 10ns)
*	Writing 11100100000101011100001000000001  to  address 000000011 (from port 0) during cycle 2 (10ns - 15ns)
*	Writing 10001110011110101000110010111010  to  address 000000000 (from port 1) during cycle 2 (10ns - 15ns)
*	Writing 11100101010100101101001001010110  to  address 111111101 (from port 0) during cycle 3 (15ns - 20ns)
*	Writing 10001000010111001000010110101100  to  address 000000000 (from port 1) during cycle 3 (15ns - 20ns)
*	Reading 11011100000101101110101010100111 from address 111111100 (from port 0) during cycle 4 (20ns - 25ns)
*	Reading 11100101010100101101001001010110 from address 111111101 (from port 1) during cycle 4 (20ns - 25ns)
*	Reading 11100101010100101101001001010110 from address 111111101 (from port 0) during cycle 5 (25ns - 30ns)
*	Writing 01110010001101111100011100100110  to  address 111111101 (from port 0) during cycle 6 (30ns - 35ns)
*	Writing 10110011000000011111101110100110  to  address 000000001 (from port 0) during cycle 7 (35ns - 40ns)
*	Writing 11100100000001110001001010001100  to  address 000000000 (from port 1) during cycle 7 (35ns - 40ns)
*	Writing 01011000110100100111110001001111  to  address 111111110 (from port 0) during cycle 8 (40ns - 45ns)
*	Reading 11100100000001110001001010001100 from address 000000000 (from port 1) during cycle 8 (40ns - 45ns)
*	Writing 00110001010100110101000011110111  to  address 111111101 (from port 0) during cycle 9 (45ns - 50ns)
*	Reading 11011100000101101110101010100111 from address 111111100 (from port 1) during cycle 9 (45ns - 50ns)
*	Writing 11010010111011110011100001100000  to  address 000000010 (from port 1) during cycle 10 (50ns - 55ns)
*	Reading 00110001010100110101000011110111 from address 111111101 (from port 0) during cycle 11 (55ns - 60ns)
*	Reading 11100100000101011100001000000001 from address 000000011 (from port 1) during cycle 11 (55ns - 60ns)
*	Reading 11100100000001110001001010001100 from address 000000000 (from port 1) during cycle 12 (60ns - 65ns)
*	Writing 10011010110010100101100111000101  to  address 111111101 (from port 0) during cycle 13 (65ns - 70ns)
*	Reading 10110011000000011111101110100110 from address 000000001 (from port 1) during cycle 13 (65ns - 70ns)
*	Reading 01011000110100100111110001001111 from address 111111110 (from port 0) during cycle 14 (70ns - 75ns)
*	Reading 10011010110010100101100111000101 from address 111111101 (from port 1) during cycle 15 (75ns - 80ns)
*	Writing 01101000100110001110010001010101  to  address 000000010 (from port 0) during cycle 16 (80ns - 85ns)
*	Reading 11100100000101011100001000000001 from address 000000011 (from port 1) during cycle 16 (80ns - 85ns)
*	Writing 01001101101111100110011111011100  to  address 000000000 (from port 1) during cycle 17 (85ns - 90ns)
*	Reading 01011000110100100111110001001111 from address 111111110 (from port 1) during cycle 18 (90ns - 95ns)
*	Reading 11100100000101011100001000000001 from address 000000011 (from port 0) during cycle 19 (95ns - 100ns)
*	Reading 01101000100110001110010001010101 from address 000000010 (from port 1) during cycle 19 (95ns - 100ns)
*	Writing 01111000000111110110010110111011  to  address 000000000 (from port 1) during cycle 20 (100ns - 105ns)
*	Reading 11100100000101011100001000000001 from address 000000011 (from port 0) during cycle 21 (105ns - 110ns)
*	Reading 10110011000000011111101110100110 from address 000000001 (from port 1) during cycle 21 (105ns - 110ns)
*	Writing 10000111100100011111100011101010  to  address 111111100 (from port 0) during cycle 22 (110ns - 115ns)
*	Reading 01111000000111110110010110111011 from address 000000000 (from port 1) during cycle 22 (110ns - 115ns)
*	Writing 10111001101001100010101100101111  to  address 000000010 (from port 1) during cycle 23 (115ns - 120ns)
*	Reading 10111001101001100010101100101111 from address 000000010 (from port 1) during cycle 24 (120ns - 125ns)
*	Writing 10110111110010010110000001011110  to  address 111111101 (from port 0) during cycle 25 (125ns - 130ns)
*	Writing 10011100111000011010001011000000  to  address 111111011 (from port 1) during cycle 25 (125ns - 130ns)
*	Reading 10111001101001100010101100101111 from address 000000010 (from port 0) during cycle 26 (130ns - 135ns)
*	Reading 10110011000000011111101110100110 from address 000000001 (from port 1) during cycle 26 (130ns - 135ns)
*	Reading 10000111100100011111100011101010 from address 111111100 (from port 1) during cycle 27 (135ns - 140ns)
*	Writing 00001111101100001010110000111111  to  address 000000000 (from port 0) during cycle 28 (140ns - 145ns)
*	Writing 01111001000100011010101011100101  to  address 000000000 (from port 0) during cycle 29 (145ns - 150ns)
*	Reading 10011100111000011010001011000000 from address 111111011 (from port 1) during cycle 29 (145ns - 150ns)
*	Reading 01011000110100100111110001001111 from address 111111110 (from port 0) during cycle 30 (150ns - 155ns)
*	Writing 00111111100111110001011110010011  to  address 000000000 (from port 1) during cycle 30 (150ns - 155ns)
*	Reading 01011000110100100111110001001111 from address 111111110 (from port 0) during cycle 31 (155ns - 160ns)
*	Reading 00111111100111110001011110010011 from address 000000000 (from port 1) during cycle 31 (155ns - 160ns)
*	Reading 01011000110100100111110001001111 from address 111111110 (from port 1) during cycle 32 (160ns - 165ns)
*	Reading 01011000110100100111110001001111 from address 111111110 (from port 0) during cycle 33 (165ns - 170ns)
*	Writing 11110000001100011110001011111001  to  address 000000011 (from port 1) during cycle 33 (165ns - 170ns)
*	Reading 11110000001100011110001011111001 from address 000000011 (from port 0) during cycle 34 (170ns - 175ns)
*	Reading 11110000001100011110001011111001 from address 000000011 (from port 1) during cycle 34 (170ns - 175ns)
*	Reading 10110011000000011111101110100110 from address 000000001 (from port 0) during cycle 36 (180ns - 185ns)
*	Reading 10110011000000011111101110100110 from address 000000001 (from port 1) during cycle 36 (180ns - 185ns)
*	Reading 01011000110100100111110001001111 from address 111111110 (from port 0) during cycle 37 (185ns - 190ns)
*	Reading 10110111110010010110000001011110 from address 111111101 (from port 1) during cycle 37 (185ns - 190ns)
*	Reading 10000111100100011111100011101010 from address 111111100 (from port 0) during cycle 38 (190ns - 195ns)
*	Reading 10000111100100011111100011101010 from address 111111100 (from port 0) during cycle 39 (195ns - 200ns)
*	Reading 11110000001100011110001011111001 from address 000000011 (from port 0) during cycle 40 (200ns - 205ns)
*	Reading 10110111110010010110000001011110 from address 111111101 (from port 1) during cycle 40 (200ns - 205ns)
*	Writing 11010010111001101000111001010000  to  address 111111110 (from port 1) during cycle 41 (205ns - 210ns)
*	Reading 11110000001100011110001011111001 from address 000000011 (from port 1) during cycle 42 (210ns - 215ns)
*	Reading 11110000001100011110001011111001 from address 000000011 (from port 0) during cycle 43 (215ns - 220ns)
*	Reading 11110000001100011110001011111001 from address 000000011 (from port 1) during cycle 43 (215ns - 220ns)
*	Reading 10011100111000011010001011000000 from address 111111011 (from port 0) during cycle 44 (220ns - 225ns)
*	Writing 10000110000110111110110110100011  to  address 111111100 (from port 1) during cycle 44 (220ns - 225ns)
*	Reading 10000110000110111110110110100011 from address 111111100 (from port 0) during cycle 45 (225ns - 230ns)
*	Reading 10110111110010010110000001011110 from address 111111101 (from port 1) during cycle 45 (225ns - 230ns)
*	Writing 00101111100111100101110111001000  to  address 000000000 (from port 0) during cycle 46 (230ns - 235ns)
*	Reading 10000110000110111110110110100011 from address 111111100 (from port 1) during cycle 46 (230ns - 235ns)
*	Writing 00001011010101110111100001100000  to  address 000000001 (from port 0) during cycle 47 (235ns - 240ns)
*	Writing 00100100010011100011000111111111  to  address 000000011 (from port 0) during cycle 48 (240ns - 245ns)
*	Writing 01110000111100110101010011001111  to  address 000000000 (from port 1) during cycle 48 (240ns - 245ns)
*	Writing 00001110010111101011000101100001  to  address 111111101 (from port 0) during cycle 49 (245ns - 250ns)
*	Reading 00100100010011100011000111111111 from address 000000011 (from port 1) during cycle 49 (245ns - 250ns)
*	Writing 00101010111100011000011010001100  to  address 000000010 (from port 0) during cycle 50 (250ns - 255ns)
*	Writing 01010100001001101111111100000101  to  address 000000001 (from port 1) during cycle 50 (250ns - 255ns)
*	Reading 10000110000110111110110110100011 from address 111111100 (from port 0) during cycle 51 (255ns - 260ns)
*	Reading 00001110010111101011000101100001 from address 111111101 (from port 1) during cycle 51 (255ns - 260ns)
*	Reading 00101010111100011000011010001100 from address 000000010 (from port 0) during cycle 52 (260ns - 265ns)
*	Writing 11001010010001010000101001100000  to  address 000000001 (from port 1) during cycle 52 (260ns - 265ns)
*	Reading 11001010010001010000101001100000 from address 000000001 (from port 1) during cycle 53 (265ns - 270ns)
*	Reading 10000110000110111110110110100011 from address 111111100 (from port 0) during cycle 54 (270ns - 275ns)
*	Reading 10011100111000011010001011000000 from address 111111011 (from port 1) during cycle 54 (270ns - 275ns)
*	Writing 11100110000000101000010111111101  to  address 000000010 (from port 0) during cycle 55 (275ns - 280ns)
*	Writing 00101111001001100001111100001111  to  address 111111100 (from port 1) during cycle 55 (275ns - 280ns)
*	Reading 00100100010011100011000111111111 from address 000000011 (from port 0) during cycle 56 (280ns - 285ns)
*	Reading 11001010010001010000101001100000 from address 000000001 (from port 1) during cycle 56 (280ns - 285ns)
*	Writing 00010110110001111000100001000001  to  address 111111100 (from port 0) during cycle 57 (285ns - 290ns)
*	Reading 00001110010111101011000101100001 from address 111111101 (from port 1) during cycle 57 (285ns - 290ns)
*	Reading 10011100111000011010001011000000 from address 111111011 (from port 0) during cycle 58 (290ns - 295ns)
*	Reading 11001010010001010000101001100000 from address 000000001 (from port 0) during cycle 59 (295ns - 300ns)
*	Reading 10011100111000011010001011000000 from address 111111011 (from port 1) during cycle 59 (295ns - 300ns)
*	Writing 01101001011001110010100001101011  to  address 000000001 (from port 0) during cycle 60 (300ns - 305ns)
*	Reading 11100110000000101000010111111101 from address 000000010 (from port 1) during cycle 60 (300ns - 305ns)
*	Reading 11100110000000101000010111111101 from address 000000010 (from port 0) during cycle 61 (305ns - 310ns)
*	Reading 00100100010011100011000111111111 from address 000000011 (from port 1) during cycle 61 (305ns - 310ns)
*	Writing 10010010101010111101000100100011  to  address 111111101 (from port 1) during cycle 62 (310ns - 315ns)
*	Reading 00010110110001111000100001000001 from address 111111100 (from port 0) during cycle 63 (315ns - 320ns)
*	Reading 01110000111100110101010011001111 from address 000000000 (from port 1) during cycle 63 (315ns - 320ns)
*	Reading 00100100010011100011000111111111 from address 000000011 (from port 0) during cycle 64 (320ns - 325ns)
*	Reading 00100100010011100011000111111111 from address 000000011 (from port 1) during cycle 64 (320ns - 325ns)
*	Reading 01101001011001110010100001101011 from address 000000001 (from port 1) during cycle 66 (330ns - 335ns)
*	Reading 11100110000000101000010111111101 from address 000000010 (from port 0) during cycle 67 (335ns - 340ns)
*	Reading 10011100111000011010001011000000 from address 111111011 (from port 1) during cycle 67 (335ns - 340ns)
*	Writing 10101100011101011001011101000111  to  address 000000001 (from port 0) during cycle 68 (340ns - 345ns)
*	Writing 00011101110011100000111100000001  to  address 111111011 (from port 0) during cycle 69 (345ns - 350ns)
*	Writing 00011110010001110110100101001001  to  address 111111100 (from port 1) during cycle 69 (345ns - 350ns)
*	Writing 10100101010101101011110101001111  to  address 111111011 (from port 0) during cycle 70 (350ns - 355ns)
*	Writing 00011001111110010010001001010010  to  address 000000001 (from port 1) during cycle 70 (350ns - 355ns)
*	Reading 01110000111100110101010011001111 from address 000000000 (from port 1) during cycle 71 (355ns - 360ns)
*	Reading 01110000111100110101010011001111 from address 000000000 (from port 0) during cycle 72 (360ns - 365ns)
*	Writing 01001000100100010000001011110110  to  address 000000011 (from port 1) during cycle 72 (360ns - 365ns)
*	Reading 11010010111001101000111001010000 from address 111111110 (from port 0) during cycle 73 (365ns - 370ns)
*	Reading 00011001111110010010001001010010 from address 000000001 (from port 1) during cycle 73 (365ns - 370ns)
*	Reading 11100110000000101000010111111101 from address 000000010 (from port 1) during cycle 74 (370ns - 375ns)
*	Reading 00011110010001110110100101001001 from address 111111100 (from port 0) during cycle 75 (375ns - 380ns)
*	Reading 10100101010101101011110101001111 from address 111111011 (from port 1) during cycle 75 (375ns - 380ns)
*	Reading 10010010101010111101000100100011 from address 111111101 (from port 0) during cycle 76 (380ns - 385ns)
*	Reading 01110000111100110101010011001111 from address 000000000 (from port 1) during cycle 78 (390ns - 395ns)
*	Reading 00011001111110010010001001010010 from address 000000001 (from port 0) during cycle 79 (395ns - 400ns)
*	Reading 11010010111001101000111001010000 from address 111111110 (from port 1) during cycle 79 (395ns - 400ns)
*	Reading 11010010111001101000111001010000 from address 111111110 (from port 0) during cycle 80 (400ns - 405ns)
*	Writing 00000111101110110000100010011100  to  address 000000010 (from port 1) during cycle 80 (400ns - 405ns)
*	Reading 01110000111100110101010011001111 from address 000000000 (from port 0) during cycle 81 (405ns - 410ns)
*	Writing 10001101101010110111101110111001  to  address 000000011 (from port 1) during cycle 81 (405ns - 410ns)
*	Reading 11010010111001101000111001010000 from address 111111110 (from port 1) during cycle 82 (410ns - 415ns)
*	Reading 00011001111110010010001001010010 from address 000000001 (from port 0) during cycle 83 (415ns - 420ns)
*	Reading 00011001111110010010001001010010 from address 000000001 (from port 0) during cycle 84 (420ns - 425ns)
*	Reading 00000111101110110000100010011100 from address 000000010 (from port 0) during cycle 85 (425ns - 430ns)
*	Reading 10100101010101101011110101001111 from address 111111011 (from port 1) during cycle 85 (425ns - 430ns)
*	Reading 01110000111100110101010011001111 from address 000000000 (from port 1) during cycle 86 (430ns - 435ns)
*	Writing 00011010100000000101111110010000  to  address 000000000 (from port 0) during cycle 87 (435ns - 440ns)
*	Writing 01111100000101011111111100001111  to  address 000000011 (from port 1) during cycle 88 (440ns - 445ns)
*	Reading 00011001111110010010001001010010 from address 000000001 (from port 1) during cycle 89 (445ns - 450ns)
*	Reading 11010010111001101000111001010000 from address 111111110 (from port 0) during cycle 90 (450ns - 455ns)
*	Reading 00011110010001110110100101001001 from address 111111100 (from port 1) during cycle 90 (450ns - 455ns)
*	Writing 11000010001010101101100101110001  to  address 111111101 (from port 0) during cycle 91 (455ns - 460ns)
*	Writing 11100100011001011110101100011110  to  address 111111110 (from port 0) during cycle 93 (465ns - 470ns)
*	Reading 00000111101110110000100010011100 from address 000000010 (from port 1) during cycle 94 (470ns - 475ns)
*	Reading 11100100011001011110101100011110 from address 111111110 (from port 0) during cycle 95 (475ns - 480ns)
*	Reading 00011110010001110110100101001001 from address 111111100 (from port 1) during cycle 95 (475ns - 480ns)
*	Reading 11000010001010101101100101110001 from address 111111101 (from port 0) during cycle 96 (480ns - 485ns)
*	Reading 10100101010101101011110101001111 from address 111111011 (from port 0) during cycle 97 (485ns - 490ns)
*	Reading 01111100000101011111111100001111 from address 000000011 (from port 1) during cycle 97 (485ns - 490ns)
*	Reading 00011010100000000101111110010000 from address 000000000 (from port 0) during cycle 98 (490ns - 495ns)
*	Reading 11000010001010101101100101110001 from address 111111101 (from port 1) during cycle 98 (490ns - 495ns)
*	Reading 00011110010001110110100101001001 from address 111111100 (from port 1) during cycle 99 (495ns - 500ns)
*	Reading 10100101010101101011110101001111 from address 111111011 (from port 0) during cycle 100 (500ns - 505ns)
*	Writing 10110000101100110111101000100101  to  address 000000000 (from port 1) during cycle 100 (500ns - 505ns)
*	Reading 01111100000101011111111100001111 from address 000000011 (from port 0) during cycle 101 (505ns - 510ns)
*	Writing 11110001101000001111000111010101  to  address 111111110 (from port 0) during cycle 102 (510ns - 515ns)
*	Reading 11000010001010101101100101110001 from address 111111101 (from port 0) during cycle 103 (515ns - 520ns)
*	Reading 01111100000101011111111100001111 from address 000000011 (from port 1) during cycle 103 (515ns - 520ns)
*	Reading 11110001101000001111000111010101 from address 111111110 (from port 1) during cycle 104 (520ns - 525ns)
*	Reading 11000010001010101101100101110001 from address 111111101 (from port 0) during cycle 105 (525ns - 530ns)
*	Reading 11110001101000001111000111010101 from address 111111110 (from port 0) during cycle 106 (530ns - 535ns)
*	Reading 00011001111110010010001001010010 from address 000000001 (from port 1) during cycle 106 (530ns - 535ns)
*	Reading 00011001111110010010001001010010 from address 000000001 (from port 0) during cycle 107 (535ns - 540ns)
*	Writing 01011100011000000001110001011011  to  address 000000010 (from port 1) during cycle 107 (535ns - 540ns)
*	Reading 01111100000101011111111100001111 from address 000000011 (from port 0) during cycle 108 (540ns - 545ns)
*	Writing 10010110100100110100001010111000  to  address 111111110 (from port 1) during cycle 108 (540ns - 545ns)
*	Writing 10101001010010110000110110111000  to  address 000000001 (from port 0) during cycle 109 (545ns - 550ns)
*	Reading 10101001010010110000110110111000 from address 000000001 (from port 0) during cycle 110 (550ns - 555ns)
*	Reading 11000010001010101101100101110001 from address 111111101 (from port 1) during cycle 110 (550ns - 555ns)
*	Reading 00011110010001110110100101001001 from address 111111100 (from port 1) during cycle 111 (555ns - 560ns)
*	Reading 00011110010001110110100101001001 from address 111111100 (from port 1) during cycle 112 (560ns - 565ns)
*	Reading 10110000101100110111101000100101 from address 000000000 (from port 1) during cycle 113 (565ns - 570ns)
*	Reading 10101001010010110000110110111000 from address 000000001 (from port 0) during cycle 114 (570ns - 575ns)
*	Reading 10110000101100110111101000100101 from address 000000000 (from port 0) during cycle 115 (575ns - 580ns)
*	Reading 10010110100100110100001010111000 from address 111111110 (from port 1) during cycle 115 (575ns - 580ns)
*	Reading 01111100000101011111111100001111 from address 000000011 (from port 1) during cycle 116 (580ns - 585ns)
*	Reading 01111100000101011111111100001111 from address 000000011 (from port 0) during cycle 117 (585ns - 590ns)
*	Reading 01111100000101011111111100001111 from address 000000011 (from port 0) during cycle 118 (590ns - 595ns)
*	Reading 10100101010101101011110101001111 from address 111111011 (from port 0) during cycle 119 (595ns - 600ns)
*	Reading 10010110100100110100001010111000 from address 111111110 (from port 1) during cycle 119 (595ns - 600ns)
*	Reading 10101001010010110000110110111000 from address 000000001 (from port 1) during cycle 120 (600ns - 605ns)
*	Reading 01011100011000000001110001011011 from address 000000010 (from port 0) during cycle 121 (605ns - 610ns)
*	Reading 00011110010001110110100101001001 from address 111111100 (from port 0) during cycle 122 (610ns - 615ns)
*	Reading 10100101010101101011110101001111 from address 111111011 (from port 1) during cycle 122 (610ns - 615ns)
*	Writing 11100101110111100011101001111010  to  address 000000000 (from port 0) during cycle 123 (615ns - 620ns)
*	Writing 00110011100101001000000001111010  to  address 000000000 (from port 0) during cycle 125 (625ns - 630ns)
*	Reading 10101001010010110000110110111000 from address 000000001 (from port 1) during cycle 125 (625ns - 630ns)
*	Reading 10100101010101101011110101001111 from address 111111011 (from port 1) during cycle 126 (630ns - 635ns)
*	Reading 11000010001010101101100101110001 from address 111111101 (from port 0) during cycle 127 (635ns - 640ns)
*	Reading 10010110100100110100001010111000 from address 111111110 (from port 0) during cycle 128 (640ns - 645ns)
*	Writing 00110101101000100010000011001100  to  address 000000011 (from port 0) during cycle 129 (645ns - 650ns)
*	Reading 00011110010001110110100101001001 from address 111111100 (from port 1) during cycle 129 (645ns - 650ns)
*	Reading 10100101010101101011110101001111 from address 111111011 (from port 1) during cycle 130 (650ns - 655ns)
*	Reading 01011100011000000001110001011011 from address 000000010 (from port 0) during cycle 131 (655ns - 660ns)
*	Writing 01111100101100111101101011000000  to  address 000000000 (from port 1) during cycle 131 (655ns - 660ns)
*	Reading 01011100011000000001110001011011 from address 000000010 (from port 0) during cycle 132 (660ns - 665ns)
*	Reading 10100101010101101011110101001111 from address 111111011 (from port 1) during cycle 132 (660ns - 665ns)
*	Reading 10101001010010110000110110111000 from address 000000001 (from port 0) during cycle 133 (665ns - 670ns)
*	Reading 00110101101000100010000011001100 from address 000000011 (from port 1) during cycle 133 (665ns - 670ns)
*	Reading 01111100101100111101101011000000 from address 000000000 (from port 0) during cycle 134 (670ns - 675ns)
*	Reading 11000010001010101101100101110001 from address 111111101 (from port 1) during cycle 134 (670ns - 675ns)
*	Reading 00011110010001110110100101001001 from address 111111100 (from port 0) during cycle 135 (675ns - 680ns)
*	Writing 01110010101111011010101010000101  to  address 111111100 (from port 0) during cycle 136 (680ns - 685ns)
*	Reading 01011100011000000001110001011011 from address 000000010 (from port 0) during cycle 137 (685ns - 690ns)
*	Reading 01110010101111011010101010000101 from address 111111100 (from port 1) during cycle 137 (685ns - 690ns)
*	Reading 11000010001010101101100101110001 from address 111111101 (from port 1) during cycle 138 (690ns - 695ns)
*	Reading 01011100011000000001110001011011 from address 000000010 (from port 0) during cycle 139 (695ns - 700ns)
*	Reading 00110101101000100010000011001100 from address 000000011 (from port 1) during cycle 140 (700ns - 705ns)
*	Reading 01110010101111011010101010000101 from address 111111100 (from port 0) during cycle 141 (705ns - 710ns)
*	Writing 10110100000101011110001100100000  to  address 111111101 (from port 0) during cycle 142 (710ns - 715ns)
*	Writing 10010101111100001110000110110100  to  address 000000001 (from port 1) during cycle 142 (710ns - 715ns)
*	Reading 00110101101000100010000011001100 from address 000000011 (from port 1) during cycle 143 (715ns - 720ns)
*	Writing 00101010011011100110100000000101  to  address 000000010 (from port 0) during cycle 144 (720ns - 725ns)
*	Reading 01111100101100111101101011000000 from address 000000000 (from port 0) during cycle 145 (725ns - 730ns)
*	Reading 10010110100100110100001010111000 from address 111111110 (from port 1) during cycle 145 (725ns - 730ns)
*	Reading 10110100000101011110001100100000 from address 111111101 (from port 0) during cycle 146 (730ns - 735ns)
*	Reading 10010110100100110100001010111000 from address 111111110 (from port 1) during cycle 146 (730ns - 735ns)
*	Writing 01000000001110000001101011000011  to  address 000000000 (from port 0) during cycle 147 (735ns - 740ns)
*	Reading 00101010011011100110100000000101 from address 000000010 (from port 1) during cycle 149 (745ns - 750ns)
*	Reading 10100101010101101011110101001111 from address 111111011 (from port 0) during cycle 151 (755ns - 760ns)
*	Reading 10010101111100001110000110110100 from address 000000001 (from port 1) during cycle 151 (755ns - 760ns)
*	Reading 00110101101000100010000011001100 from address 000000011 (from port 0) during cycle 152 (760ns - 765ns)
*	Writing 00010000001101010101010010111011  to  address 000000001 (from port 1) during cycle 152 (760ns - 765ns)
*	Reading 00101010011011100110100000000101 from address 000000010 (from port 0) during cycle 153 (765ns - 770ns)
*	Writing 10101110011110010101101110010100  to  address 000000000 (from port 0) during cycle 154 (770ns - 775ns)
*	Reading 10100101010101101011110101001111 from address 111111011 (from port 1) during cycle 155 (775ns - 780ns)
*	Writing 01000000110110011010110000100101  to  address 000000011 (from port 0) during cycle 156 (780ns - 785ns)
*	Writing 10000011110001111001100111110010  to  address 000000000 (from port 1) during cycle 156 (780ns - 785ns)
*	Reading 00101010011011100110100000000101 from address 000000010 (from port 1) during cycle 157 (785ns - 790ns)
*	Reading 01000000110110011010110000100101 from address 000000011 (from port 0) during cycle 158 (790ns - 795ns)
*	Writing 00110000100111111001011111111111  to  address 000000010 (from port 0) during cycle 159 (795ns - 800ns)
*	Reading 00110000100111111001011111111111 from address 000000010 (from port 0) during cycle 160 (800ns - 805ns)
*	Reading 10100101010101101011110101001111 from address 111111011 (from port 1) during cycle 160 (800ns - 805ns)
*	Reading 00110000100111111001011111111111 from address 000000010 (from port 0) during cycle 161 (805ns - 810ns)
*	Reading 10000011110001111001100111110010 from address 000000000 (from port 1) during cycle 161 (805ns - 810ns)
*	Writing 11000100101100010010101010100011  to  address 000000010 (from port 1) during cycle 162 (810ns - 815ns)
*	Writing 10010111010110111010011010011000  to  address 111111011 (from port 0) during cycle 164 (820ns - 825ns)
*	Reading 11000100101100010010101010100011 from address 000000010 (from port 0) during cycle 165 (825ns - 830ns)
*	Reading 10000011110001111001100111110010 from address 000000000 (from port 1) during cycle 165 (825ns - 830ns)
*	Reading 10010110100100110100001010111000 from address 111111110 (from port 0) during cycle 166 (830ns - 835ns)
*	Reading 01000000110110011010110000100101 from address 000000011 (from port 1) during cycle 166 (830ns - 835ns)
*	Reading 01110010101111011010101010000101 from address 111111100 (from port 0) during cycle 167 (835ns - 840ns)
*	Reading 00010000001101010101010010111011 from address 000000001 (from port 1) during cycle 167 (835ns - 840ns)
*	Reading 11000100101100010010101010100011 from address 000000010 (from port 0) during cycle 168 (840ns - 845ns)
*	Reading 10000011110001111001100111110010 from address 000000000 (from port 1) during cycle 168 (840ns - 845ns)
*	Reading 11000100101100010010101010100011 from address 000000010 (from port 0) during cycle 169 (845ns - 850ns)
*	Reading 01110010101111011010101010000101 from address 111111100 (from port 1) during cycle 169 (845ns - 850ns)
*	Writing 10000011001001110110101111011010  to  address 111111100 (from port 0) during cycle 170 (850ns - 855ns)
*	Reading 10010111010110111010011010011000 from address 111111011 (from port 1) during cycle 170 (850ns - 855ns)
*	Writing 00111011010011010011100000101111  to  address 111111101 (from port 0) during cycle 172 (860ns - 865ns)
*	Writing 00001110000100100011011010111010  to  address 111111011 (from port 1) during cycle 172 (860ns - 865ns)
*	Reading 01000000110110011010110000100101 from address 000000011 (from port 0) during cycle 173 (865ns - 870ns)
*	Reading 10010110100100110100001010111000 from address 111111110 (from port 1) during cycle 173 (865ns - 870ns)
*	Reading 11000100101100010010101010100011 from address 000000010 (from port 1) during cycle 174 (870ns - 875ns)
*	Reading 10010110100100110100001010111000 from address 111111110 (from port 0) during cycle 175 (875ns - 880ns)
*	Reading 00001110000100100011011010111010 from address 111111011 (from port 1) during cycle 175 (875ns - 880ns)
*	Reading 01000000110110011010110000100101 from address 000000011 (from port 0) during cycle 176 (880ns - 885ns)
*	Writing 01101010110101010011110111101000  to  address 111111110 (from port 1) during cycle 176 (880ns - 885ns)
*	Reading 01101010110101010011110111101000 from address 111111110 (from port 0) during cycle 177 (885ns - 890ns)
*	Reading 10000011110001111001100111110010 from address 000000000 (from port 1) during cycle 177 (885ns - 890ns)
*	Reading 01101010110101010011110111101000 from address 111111110 (from port 0) during cycle 178 (890ns - 895ns)
*	Reading 10000011110001111001100111110010 from address 000000000 (from port 0) during cycle 179 (895ns - 900ns)
*	Reading 00111011010011010011100000101111 from address 111111101 (from port 1) during cycle 180 (900ns - 905ns)
*	Writing 11101110100001111001001011001111  to  address 000000011 (from port 0) during cycle 181 (905ns - 910ns)
*	Reading 00111011010011010011100000101111 from address 111111101 (from port 1) during cycle 181 (905ns - 910ns)
*	Writing 01011100110110101010111001011110  to  address 111111110 (from port 0) during cycle 182 (910ns - 915ns)
*	Writing 01101101000000111010111001010011  to  address 000000011 (from port 1) during cycle 182 (910ns - 915ns)
*	Reading 00010000001101010101010010111011 from address 000000001 (from port 0) during cycle 183 (915ns - 920ns)
*	Reading 10000011001001110110101111011010 from address 111111100 (from port 1) during cycle 183 (915ns - 920ns)
*	Writing 00001000101100111011110111111010  to  address 111111011 (from port 0) during cycle 184 (920ns - 925ns)
*	Writing 11101001000111111001011101100011  to  address 000000001 (from port 1) during cycle 184 (920ns - 925ns)
*	Reading 01101101000000111010111001010011 from address 000000011 (from port 0) during cycle 186 (930ns - 935ns)
*	Writing 01011110010001100110010010111010  to  address 111111100 (from port 1) during cycle 186 (930ns - 935ns)
*	Writing 01110010110001010101101010010000  to  address 111111100 (from port 0) during cycle 187 (935ns - 940ns)
*	Writing 10010001100101101110000111000111  to  address 000000010 (from port 1) during cycle 187 (935ns - 940ns)
*	Reading 00111011010011010011100000101111 from address 111111101 (from port 0) during cycle 188 (940ns - 945ns)
*	Reading 01011100110110101010111001011110 from address 111111110 (from port 1) during cycle 188 (940ns - 945ns)
*	Reading 01110010110001010101101010010000 from address 111111100 (from port 1) during cycle 189 (945ns - 950ns)
*	Reading 10010001100101101110000111000111 from address 000000010 (from port 0) during cycle 190 (950ns - 955ns)
*	Writing 11101000001011101111010001000101  to  address 111111100 (from port 1) during cycle 190 (950ns - 955ns)
*	Writing 10000001111010110011010111110011  to  address 000000011 (from port 0) during cycle 191 (955ns - 960ns)
*	Writing 10011011000110111101010001010110  to  address 111111110 (from port 1) during cycle 191 (955ns - 960ns)
*	Writing 00101011110001111001011110110000  to  address 000000011 (from port 0) during cycle 192 (960ns - 965ns)
*	Reading 00101011110001111001011110110000 from address 000000011 (from port 0) during cycle 193 (965ns - 970ns)
*	Reading 00001000101100111011110111111010 from address 111111011 (from port 1) during cycle 193 (965ns - 970ns)
*	Writing 10100110000111100101101011011000  to  address 111111110 (from port 0) during cycle 194 (970ns - 975ns)
*	Reading 00001000101100111011110111111010 from address 111111011 (from port 1) during cycle 194 (970ns - 975ns)
*	Reading 00101011110001111001011110110000 from address 000000011 (from port 0) during cycle 195 (975ns - 980ns)
*	Reading 11101001000111111001011101100011 from address 000000001 (from port 1) during cycle 195 (975ns - 980ns)
*	Reading 00001000101100111011110111111010 from address 111111011 (from port 0) during cycle 196 (980ns - 985ns)
*	Reading 11101000001011101111010001000101 from address 111111100 (from port 1) during cycle 196 (980ns - 985ns)
*	Reading 10100110000111100101101011011000 from address 111111110 (from port 0) during cycle 197 (985ns - 990ns)
*	Writing 01101110101110001010010101011100  to  address 000000001 (from port 1) during cycle 197 (985ns - 990ns)
*	Writing 10101100000100000100111011001101  to  address 000000011 (from port 0) during cycle 198 (990ns - 995ns)
*	Reading 00001000101100111011110111111010 from address 111111011 (from port 0) during cycle 199 (995ns - 1000ns)
*	Reading 00111011010011010011100000101111 from address 111111101 (from port 0) during cycle 200 (1000ns - 1005ns)
*	Reading 10000011110001111001100111110010 from address 000000000 (from port 0) during cycle 201 (1005ns - 1010ns)
*	Writing 11010000111010010011101011101110  to  address 000000000 (from port 1) during cycle 201 (1005ns - 1010ns)
*	Reading 00001000101100111011110111111010 from address 111111011 (from port 0) during cycle 202 (1010ns - 1015ns)
*	Writing 10110111110101101010100001000101  to  address 000000001 (from port 0) during cycle 203 (1015ns - 1020ns)
*	Reading 10100110000111100101101011011000 from address 111111110 (from port 1) during cycle 203 (1015ns - 1020ns)
*	Reading 00111011010011010011100000101111 from address 111111101 (from port 0) during cycle 204 (1020ns - 1025ns)
*	Idle during cycle 205 (1025ns - 1030ns)

* Generation of data and address signals
* (time, data): [(0, 0), (5, 1), (10, 1), (15, 0), (20, 0), (25, 0), (30, 0), (35, 0), (40, 1), (45, 1), (50, 1), (55, 1), (60, 1), (65, 1), (70, 1), (75, 1), (80, 1), (85, 1), (90, 1), (95, 1), (100, 1), (105, 1), (110, 0), (115, 0), (120, 0), (125, 0), (130, 0), (135, 0), (140, 1), (145, 1), (150, 1), (155, 1), (160, 1), (165, 1), (170, 1), (175, 1), (180, 1), (185, 1), (190, 1), (195, 1), (200, 1), (205, 1), (210, 1), (215, 1), (220, 1), (225, 1), (230, 0), (235, 0), (240, 1), (245, 1), (250, 0), (255, 0), (260, 0), (265, 0), (270, 0), (275, 1), (280, 1), (285, 1), (290, 1), (295, 1), (300, 1), (305, 1), (310, 1), (315, 1), (320, 1), (325, 1), (330, 1), (335, 1), (340, 1), (345, 1), (350, 1), (355, 1), (360, 1), (365, 1), (370, 1), (375, 1), (380, 1), (385, 1), (390, 1), (395, 1), (400, 1), (405, 1), (410, 1), (415, 1), (420, 1), (425, 1), (430, 1), (435, 0), (440, 0), (445, 0), (450, 0), (455, 1), (460, 1), (465, 0), (470, 0), (475, 0), (480, 0), (485, 0), (490, 0), (495, 0), (500, 0), (505, 0), (510, 1), (515, 1), (520, 1), (525, 1), (530, 1), (535, 1), (540, 1), (545, 0), (550, 0), (555, 0), (560, 0), (565, 0), (570, 0), (575, 0), (580, 0), (585, 0), (590, 0), (595, 0), (600, 0), (605, 0), (610, 0), (615, 0), (620, 0), (625, 0), (630, 0), (635, 0), (640, 0), (645, 0), (650, 0), (655, 0), (660, 0), (665, 0), (670, 0), (675, 0), (680, 1), (685, 1), (690, 1), (695, 1), (700, 1), (705, 1), (710, 0), (715, 0), (720, 1), (725, 1), (730, 1), (735, 1), (740, 1), (745, 1), (750, 1), (755, 1), (760, 1), (765, 1), (770, 0), (775, 0), (780, 1), (785, 1), (790, 1), (795, 1), (800, 1), (805, 1), (810, 1), (815, 1), (820, 0), (825, 0), (830, 0), (835, 0), (840, 0), (845, 0), (850, 0), (855, 0), (860, 1), (865, 1), (870, 1), (875, 1), (880, 1), (885, 1), (890, 1), (895, 1), (900, 1), (905, 1), (910, 0), (915, 0), (920, 0), (925, 0), (930, 0), (935, 0), (940, 0), (945, 0), (950, 0), (955, 1), (960, 0), (965, 0), (970, 0), (975, 0), (980, 0), (985, 0), (990, 1), (995, 1), (1000, 1), (1005, 1), (1010, 1), (1015, 1), (1020, 1), (1025, 1)]
Vdin0_0  din0_0  0 PWL (0n 0.0v 4.745n 0.0v 4.755n 1.0v 9.745n 1.0v 9.755n 1.0v 14.745n 1.0v 14.755n 0.0v 19.745n 0.0v 19.755n 0.0v 24.745n 0.0v 24.755n 0.0v 29.745n 0.0v 29.755n 0.0v 34.745n 0.0v 34.755n 0.0v 39.745n 0.0v 39.755n 1.0v 44.745n 1.0v 44.755n 1.0v 49.745n 1.0v 49.755n 1.0v 54.745n 1.0v 54.755n 1.0v 59.745n 1.0v 59.755n 1.0v 64.745n 1.0v 64.755n 1.0v 69.745n 1.0v 69.755n 1.0v 74.745n 1.0v 74.755n 1.0v 79.745n 1.0v 79.755n 1.0v 84.745n 1.0v 84.755n 1.0v 89.745n 1.0v 89.755n 1.0v 94.745n 1.0v 94.755n 1.0v 99.745n 1.0v 99.755n 1.0v 104.745n 1.0v 104.755n 1.0v 109.745n 1.0v 109.755n 0.0v 114.745n 0.0v 114.755n 0.0v 119.745n 0.0v 119.755n 0.0v 124.745n 0.0v 124.755n 0.0v 129.745n 0.0v 129.755n 0.0v 134.745n 0.0v 134.755n 0.0v 139.745n 0.0v 139.755n 1.0v 144.745n 1.0v 144.755n 1.0v 149.745n 1.0v 149.755n 1.0v 154.745n 1.0v 154.755n 1.0v 159.745n 1.0v 159.755n 1.0v 164.745n 1.0v 164.755n 1.0v 169.745n 1.0v 169.755n 1.0v 174.745n 1.0v 174.755n 1.0v 179.745n 1.0v 179.755n 1.0v 184.745n 1.0v 184.755n 1.0v 189.745n 1.0v 189.755n 1.0v 194.745n 1.0v 194.755n 1.0v 199.745n 1.0v 199.755n 1.0v 204.745n 1.0v 204.755n 1.0v 209.745n 1.0v 209.755n 1.0v 214.745n 1.0v 214.755n 1.0v 219.745n 1.0v 219.755n 1.0v 224.745n 1.0v 224.755n 1.0v 229.745n 1.0v 229.755n 0.0v 234.745n 0.0v 234.755n 0.0v 239.745n 0.0v 239.755n 1.0v 244.745n 1.0v 244.755n 1.0v 249.745n 1.0v 249.755n 0.0v 254.745n 0.0v 254.755n 0.0v 259.745n 0.0v 259.755n 0.0v 264.745n 0.0v 264.755n 0.0v 269.745n 0.0v 269.755n 0.0v 274.745n 0.0v 274.755n 1.0v 279.745n 1.0v 279.755n 1.0v 284.745n 1.0v 284.755n 1.0v 289.745n 1.0v 289.755n 1.0v 294.745n 1.0v 294.755n 1.0v 299.745n 1.0v 299.755n 1.0v 304.745n 1.0v 304.755n 1.0v 309.745n 1.0v 309.755n 1.0v 314.745n 1.0v 314.755n 1.0v 319.745n 1.0v 319.755n 1.0v 324.745n 1.0v 324.755n 1.0v 329.745n 1.0v 329.755n 1.0v 334.745n 1.0v 334.755n 1.0v 339.745n 1.0v 339.755n 1.0v 344.745n 1.0v 344.755n 1.0v 349.745n 1.0v 349.755n 1.0v 354.745n 1.0v 354.755n 1.0v 359.745n 1.0v 359.755n 1.0v 364.745n 1.0v 364.755n 1.0v 369.745n 1.0v 369.755n 1.0v 374.745n 1.0v 374.755n 1.0v 379.745n 1.0v 379.755n 1.0v 384.745n 1.0v 384.755n 1.0v 389.745n 1.0v 389.755n 1.0v 394.745n 1.0v 394.755n 1.0v 399.745n 1.0v 399.755n 1.0v 404.745n 1.0v 404.755n 1.0v 409.745n 1.0v 409.755n 1.0v 414.745n 1.0v 414.755n 1.0v 419.745n 1.0v 419.755n 1.0v 424.745n 1.0v 424.755n 1.0v 429.745n 1.0v 429.755n 1.0v 434.745n 1.0v 434.755n 0.0v 439.745n 0.0v 439.755n 0.0v 444.745n 0.0v 444.755n 0.0v 449.745n 0.0v 449.755n 0.0v 454.745n 0.0v 454.755n 1.0v 459.745n 1.0v 459.755n 1.0v 464.745n 1.0v 464.755n 0.0v 469.745n 0.0v 469.755n 0.0v 474.745n 0.0v 474.755n 0.0v 479.745n 0.0v 479.755n 0.0v 484.745n 0.0v 484.755n 0.0v 489.745n 0.0v 489.755n 0.0v 494.745n 0.0v 494.755n 0.0v 499.745n 0.0v 499.755n 0.0v 504.745n 0.0v 504.755n 0.0v 509.745n 0.0v 509.755n 1.0v 514.745n 1.0v 514.755n 1.0v 519.745n 1.0v 519.755n 1.0v 524.745n 1.0v 524.755n 1.0v 529.745n 1.0v 529.755n 1.0v 534.745n 1.0v 534.755n 1.0v 539.745n 1.0v 539.755n 1.0v 544.745n 1.0v 544.755n 0.0v 549.745n 0.0v 549.755n 0.0v 554.745n 0.0v 554.755n 0.0v 559.745n 0.0v 559.755n 0.0v 564.745n 0.0v 564.755n 0.0v 569.745n 0.0v 569.755n 0.0v 574.745n 0.0v 574.755n 0.0v 579.745n 0.0v 579.755n 0.0v 584.745n 0.0v 584.755n 0.0v 589.745n 0.0v 589.755n 0.0v 594.745n 0.0v 594.755n 0.0v 599.745n 0.0v 599.755n 0.0v 604.745n 0.0v 604.755n 0.0v 609.745n 0.0v 609.755n 0.0v 614.745n 0.0v 614.755n 0.0v 619.745n 0.0v 619.755n 0.0v 624.745n 0.0v 624.755n 0.0v 629.745n 0.0v 629.755n 0.0v 634.745n 0.0v 634.755n 0.0v 639.745n 0.0v 639.755n 0.0v 644.745n 0.0v 644.755n 0.0v 649.745n 0.0v 649.755n 0.0v 654.745n 0.0v 654.755n 0.0v 659.745n 0.0v 659.755n 0.0v 664.745n 0.0v 664.755n 0.0v 669.745n 0.0v 669.755n 0.0v 674.745n 0.0v 674.755n 0.0v 679.745n 0.0v 679.755n 1.0v 684.745n 1.0v 684.755n 1.0v 689.745n 1.0v 689.755n 1.0v 694.745n 1.0v 694.755n 1.0v 699.745n 1.0v 699.755n 1.0v 704.745n 1.0v 704.755n 1.0v 709.745n 1.0v 709.755n 0.0v 714.745n 0.0v 714.755n 0.0v 719.745n 0.0v 719.755n 1.0v 724.745n 1.0v 724.755n 1.0v 729.745n 1.0v 729.755n 1.0v 734.745n 1.0v 734.755n 1.0v 739.745n 1.0v 739.755n 1.0v 744.745n 1.0v 744.755n 1.0v 749.745n 1.0v 749.755n 1.0v 754.745n 1.0v 754.755n 1.0v 759.745n 1.0v 759.755n 1.0v 764.745n 1.0v 764.755n 1.0v 769.745n 1.0v 769.755n 0.0v 774.745n 0.0v 774.755n 0.0v 779.745n 0.0v 779.755n 1.0v 784.745n 1.0v 784.755n 1.0v 789.745n 1.0v 789.755n 1.0v 794.745n 1.0v 794.755n 1.0v 799.745n 1.0v 799.755n 1.0v 804.745n 1.0v 804.755n 1.0v 809.745n 1.0v 809.755n 1.0v 814.745n 1.0v 814.755n 1.0v 819.745n 1.0v 819.755n 0.0v 824.745n 0.0v 824.755n 0.0v 829.745n 0.0v 829.755n 0.0v 834.745n 0.0v 834.755n 0.0v 839.745n 0.0v 839.755n 0.0v 844.745n 0.0v 844.755n 0.0v 849.745n 0.0v 849.755n 0.0v 854.745n 0.0v 854.755n 0.0v 859.745n 0.0v 859.755n 1.0v 864.745n 1.0v 864.755n 1.0v 869.745n 1.0v 869.755n 1.0v 874.745n 1.0v 874.755n 1.0v 879.745n 1.0v 879.755n 1.0v 884.745n 1.0v 884.755n 1.0v 889.745n 1.0v 889.755n 1.0v 894.745n 1.0v 894.755n 1.0v 899.745n 1.0v 899.755n 1.0v 904.745n 1.0v 904.755n 1.0v 909.745n 1.0v 909.755n 0.0v 914.745n 0.0v 914.755n 0.0v 919.745n 0.0v 919.755n 0.0v 924.745n 0.0v 924.755n 0.0v 929.745n 0.0v 929.755n 0.0v 934.745n 0.0v 934.755n 0.0v 939.745n 0.0v 939.755n 0.0v 944.745n 0.0v 944.755n 0.0v 949.745n 0.0v 949.755n 0.0v 954.745n 0.0v 954.755n 1.0v 959.745n 1.0v 959.755n 0.0v 964.745n 0.0v 964.755n 0.0v 969.745n 0.0v 969.755n 0.0v 974.745n 0.0v 974.755n 0.0v 979.745n 0.0v 979.755n 0.0v 984.745n 0.0v 984.755n 0.0v 989.745n 0.0v 989.755n 1.0v 994.745n 1.0v 994.755n 1.0v 999.745n 1.0v 999.755n 1.0v 1004.745n 1.0v 1004.755n 1.0v 1009.745n 1.0v 1009.755n 1.0v 1014.745n 1.0v 1014.755n 1.0v 1019.745n 1.0v 1019.755n 1.0v 1024.745n 1.0v 1024.755n 1.0v )
* (time, data): [(0, 0), (5, 0), (10, 0), (15, 1), (20, 1), (25, 1), (30, 1), (35, 1), (40, 1), (45, 1), (50, 1), (55, 1), (60, 1), (65, 0), (70, 0), (75, 0), (80, 0), (85, 0), (90, 0), (95, 0), (100, 0), (105, 0), (110, 1), (115, 1), (120, 1), (125, 1), (130, 1), (135, 1), (140, 1), (145, 0), (150, 0), (155, 0), (160, 0), (165, 0), (170, 0), (175, 0), (180, 0), (185, 0), (190, 0), (195, 0), (200, 0), (205, 0), (210, 0), (215, 0), (220, 0), (225, 0), (230, 0), (235, 0), (240, 1), (245, 0), (250, 0), (255, 0), (260, 0), (265, 0), (270, 0), (275, 0), (280, 0), (285, 0), (290, 0), (295, 0), (300, 1), (305, 1), (310, 1), (315, 1), (320, 1), (325, 1), (330, 1), (335, 1), (340, 1), (345, 0), (350, 1), (355, 1), (360, 1), (365, 1), (370, 1), (375, 1), (380, 1), (385, 1), (390, 1), (395, 1), (400, 1), (405, 1), (410, 1), (415, 1), (420, 1), (425, 1), (430, 1), (435, 0), (440, 0), (445, 0), (450, 0), (455, 0), (460, 0), (465, 1), (470, 1), (475, 1), (480, 1), (485, 1), (490, 1), (495, 1), (500, 1), (505, 1), (510, 0), (515, 0), (520, 0), (525, 0), (530, 0), (535, 0), (540, 0), (545, 0), (550, 0), (555, 0), (560, 0), (565, 0), (570, 0), (575, 0), (580, 0), (585, 0), (590, 0), (595, 0), (600, 0), (605, 0), (610, 0), (615, 1), (620, 1), (625, 1), (630, 1), (635, 1), (640, 1), (645, 0), (650, 0), (655, 0), (660, 0), (665, 0), (670, 0), (675, 0), (680, 0), (685, 0), (690, 0), (695, 0), (700, 0), (705, 0), (710, 0), (715, 0), (720, 0), (725, 0), (730, 0), (735, 1), (740, 1), (745, 1), (750, 1), (755, 1), (760, 1), (765, 1), (770, 0), (775, 0), (780, 0), (785, 0), (790, 0), (795, 1), (800, 1), (805, 1), (810, 1), (815, 1), (820, 0), (825, 0), (830, 0), (835, 0), (840, 0), (845, 0), (850, 1), (855, 1), (860, 1), (865, 1), (870, 1), (875, 1), (880, 1), (885, 1), (890, 1), (895, 1), (900, 1), (905, 1), (910, 1), (915, 1), (920, 1), (925, 1), (930, 1), (935, 0), (940, 0), (945, 0), (950, 0), (955, 1), (960, 0), (965, 0), (970, 0), (975, 0), (980, 0), (985, 0), (990, 0), (995, 0), (1000, 0), (1005, 0), (1010, 0), (1015, 0), (1020, 0), (1025, 0)]
Vdin0_1  din0_1  0 PWL (0n 0.0v 4.745n 0.0v 4.755n 0.0v 9.745n 0.0v 9.755n 0.0v 14.745n 0.0v 14.755n 1.0v 19.745n 1.0v 19.755n 1.0v 24.745n 1.0v 24.755n 1.0v 29.745n 1.0v 29.755n 1.0v 34.745n 1.0v 34.755n 1.0v 39.745n 1.0v 39.755n 1.0v 44.745n 1.0v 44.755n 1.0v 49.745n 1.0v 49.755n 1.0v 54.745n 1.0v 54.755n 1.0v 59.745n 1.0v 59.755n 1.0v 64.745n 1.0v 64.755n 0.0v 69.745n 0.0v 69.755n 0.0v 74.745n 0.0v 74.755n 0.0v 79.745n 0.0v 79.755n 0.0v 84.745n 0.0v 84.755n 0.0v 89.745n 0.0v 89.755n 0.0v 94.745n 0.0v 94.755n 0.0v 99.745n 0.0v 99.755n 0.0v 104.745n 0.0v 104.755n 0.0v 109.745n 0.0v 109.755n 1.0v 114.745n 1.0v 114.755n 1.0v 119.745n 1.0v 119.755n 1.0v 124.745n 1.0v 124.755n 1.0v 129.745n 1.0v 129.755n 1.0v 134.745n 1.0v 134.755n 1.0v 139.745n 1.0v 139.755n 1.0v 144.745n 1.0v 144.755n 0.0v 149.745n 0.0v 149.755n 0.0v 154.745n 0.0v 154.755n 0.0v 159.745n 0.0v 159.755n 0.0v 164.745n 0.0v 164.755n 0.0v 169.745n 0.0v 169.755n 0.0v 174.745n 0.0v 174.755n 0.0v 179.745n 0.0v 179.755n 0.0v 184.745n 0.0v 184.755n 0.0v 189.745n 0.0v 189.755n 0.0v 194.745n 0.0v 194.755n 0.0v 199.745n 0.0v 199.755n 0.0v 204.745n 0.0v 204.755n 0.0v 209.745n 0.0v 209.755n 0.0v 214.745n 0.0v 214.755n 0.0v 219.745n 0.0v 219.755n 0.0v 224.745n 0.0v 224.755n 0.0v 229.745n 0.0v 229.755n 0.0v 234.745n 0.0v 234.755n 0.0v 239.745n 0.0v 239.755n 1.0v 244.745n 1.0v 244.755n 0.0v 249.745n 0.0v 249.755n 0.0v 254.745n 0.0v 254.755n 0.0v 259.745n 0.0v 259.755n 0.0v 264.745n 0.0v 264.755n 0.0v 269.745n 0.0v 269.755n 0.0v 274.745n 0.0v 274.755n 0.0v 279.745n 0.0v 279.755n 0.0v 284.745n 0.0v 284.755n 0.0v 289.745n 0.0v 289.755n 0.0v 294.745n 0.0v 294.755n 0.0v 299.745n 0.0v 299.755n 1.0v 304.745n 1.0v 304.755n 1.0v 309.745n 1.0v 309.755n 1.0v 314.745n 1.0v 314.755n 1.0v 319.745n 1.0v 319.755n 1.0v 324.745n 1.0v 324.755n 1.0v 329.745n 1.0v 329.755n 1.0v 334.745n 1.0v 334.755n 1.0v 339.745n 1.0v 339.755n 1.0v 344.745n 1.0v 344.755n 0.0v 349.745n 0.0v 349.755n 1.0v 354.745n 1.0v 354.755n 1.0v 359.745n 1.0v 359.755n 1.0v 364.745n 1.0v 364.755n 1.0v 369.745n 1.0v 369.755n 1.0v 374.745n 1.0v 374.755n 1.0v 379.745n 1.0v 379.755n 1.0v 384.745n 1.0v 384.755n 1.0v 389.745n 1.0v 389.755n 1.0v 394.745n 1.0v 394.755n 1.0v 399.745n 1.0v 399.755n 1.0v 404.745n 1.0v 404.755n 1.0v 409.745n 1.0v 409.755n 1.0v 414.745n 1.0v 414.755n 1.0v 419.745n 1.0v 419.755n 1.0v 424.745n 1.0v 424.755n 1.0v 429.745n 1.0v 429.755n 1.0v 434.745n 1.0v 434.755n 0.0v 439.745n 0.0v 439.755n 0.0v 444.745n 0.0v 444.755n 0.0v 449.745n 0.0v 449.755n 0.0v 454.745n 0.0v 454.755n 0.0v 459.745n 0.0v 459.755n 0.0v 464.745n 0.0v 464.755n 1.0v 469.745n 1.0v 469.755n 1.0v 474.745n 1.0v 474.755n 1.0v 479.745n 1.0v 479.755n 1.0v 484.745n 1.0v 484.755n 1.0v 489.745n 1.0v 489.755n 1.0v 494.745n 1.0v 494.755n 1.0v 499.745n 1.0v 499.755n 1.0v 504.745n 1.0v 504.755n 1.0v 509.745n 1.0v 509.755n 0.0v 514.745n 0.0v 514.755n 0.0v 519.745n 0.0v 519.755n 0.0v 524.745n 0.0v 524.755n 0.0v 529.745n 0.0v 529.755n 0.0v 534.745n 0.0v 534.755n 0.0v 539.745n 0.0v 539.755n 0.0v 544.745n 0.0v 544.755n 0.0v 549.745n 0.0v 549.755n 0.0v 554.745n 0.0v 554.755n 0.0v 559.745n 0.0v 559.755n 0.0v 564.745n 0.0v 564.755n 0.0v 569.745n 0.0v 569.755n 0.0v 574.745n 0.0v 574.755n 0.0v 579.745n 0.0v 579.755n 0.0v 584.745n 0.0v 584.755n 0.0v 589.745n 0.0v 589.755n 0.0v 594.745n 0.0v 594.755n 0.0v 599.745n 0.0v 599.755n 0.0v 604.745n 0.0v 604.755n 0.0v 609.745n 0.0v 609.755n 0.0v 614.745n 0.0v 614.755n 1.0v 619.745n 1.0v 619.755n 1.0v 624.745n 1.0v 624.755n 1.0v 629.745n 1.0v 629.755n 1.0v 634.745n 1.0v 634.755n 1.0v 639.745n 1.0v 639.755n 1.0v 644.745n 1.0v 644.755n 0.0v 649.745n 0.0v 649.755n 0.0v 654.745n 0.0v 654.755n 0.0v 659.745n 0.0v 659.755n 0.0v 664.745n 0.0v 664.755n 0.0v 669.745n 0.0v 669.755n 0.0v 674.745n 0.0v 674.755n 0.0v 679.745n 0.0v 679.755n 0.0v 684.745n 0.0v 684.755n 0.0v 689.745n 0.0v 689.755n 0.0v 694.745n 0.0v 694.755n 0.0v 699.745n 0.0v 699.755n 0.0v 704.745n 0.0v 704.755n 0.0v 709.745n 0.0v 709.755n 0.0v 714.745n 0.0v 714.755n 0.0v 719.745n 0.0v 719.755n 0.0v 724.745n 0.0v 724.755n 0.0v 729.745n 0.0v 729.755n 0.0v 734.745n 0.0v 734.755n 1.0v 739.745n 1.0v 739.755n 1.0v 744.745n 1.0v 744.755n 1.0v 749.745n 1.0v 749.755n 1.0v 754.745n 1.0v 754.755n 1.0v 759.745n 1.0v 759.755n 1.0v 764.745n 1.0v 764.755n 1.0v 769.745n 1.0v 769.755n 0.0v 774.745n 0.0v 774.755n 0.0v 779.745n 0.0v 779.755n 0.0v 784.745n 0.0v 784.755n 0.0v 789.745n 0.0v 789.755n 0.0v 794.745n 0.0v 794.755n 1.0v 799.745n 1.0v 799.755n 1.0v 804.745n 1.0v 804.755n 1.0v 809.745n 1.0v 809.755n 1.0v 814.745n 1.0v 814.755n 1.0v 819.745n 1.0v 819.755n 0.0v 824.745n 0.0v 824.755n 0.0v 829.745n 0.0v 829.755n 0.0v 834.745n 0.0v 834.755n 0.0v 839.745n 0.0v 839.755n 0.0v 844.745n 0.0v 844.755n 0.0v 849.745n 0.0v 849.755n 1.0v 854.745n 1.0v 854.755n 1.0v 859.745n 1.0v 859.755n 1.0v 864.745n 1.0v 864.755n 1.0v 869.745n 1.0v 869.755n 1.0v 874.745n 1.0v 874.755n 1.0v 879.745n 1.0v 879.755n 1.0v 884.745n 1.0v 884.755n 1.0v 889.745n 1.0v 889.755n 1.0v 894.745n 1.0v 894.755n 1.0v 899.745n 1.0v 899.755n 1.0v 904.745n 1.0v 904.755n 1.0v 909.745n 1.0v 909.755n 1.0v 914.745n 1.0v 914.755n 1.0v 919.745n 1.0v 919.755n 1.0v 924.745n 1.0v 924.755n 1.0v 929.745n 1.0v 929.755n 1.0v 934.745n 1.0v 934.755n 0.0v 939.745n 0.0v 939.755n 0.0v 944.745n 0.0v 944.755n 0.0v 949.745n 0.0v 949.755n 0.0v 954.745n 0.0v 954.755n 1.0v 959.745n 1.0v 959.755n 0.0v 964.745n 0.0v 964.755n 0.0v 969.745n 0.0v 969.755n 0.0v 974.745n 0.0v 974.755n 0.0v 979.745n 0.0v 979.755n 0.0v 984.745n 0.0v 984.755n 0.0v 989.745n 0.0v 989.755n 0.0v 994.745n 0.0v 994.755n 0.0v 999.745n 0.0v 999.755n 0.0v 1004.745n 0.0v 1004.755n 0.0v 1009.745n 0.0v 1009.755n 0.0v 1014.745n 0.0v 1014.755n 0.0v 1019.745n 0.0v 1019.755n 0.0v 1024.745n 0.0v 1024.755n 0.0v )
* (time, data): [(0, 0), (5, 0), (10, 0), (15, 1), (20, 1), (25, 1), (30, 1), (35, 1), (40, 1), (45, 1), (50, 1), (55, 1), (60, 1), (65, 1), (70, 1), (75, 1), (80, 1), (85, 1), (90, 1), (95, 1), (100, 1), (105, 1), (110, 0), (115, 0), (120, 0), (125, 1), (130, 1), (135, 1), (140, 1), (145, 1), (150, 1), (155, 1), (160, 1), (165, 1), (170, 1), (175, 1), (180, 1), (185, 1), (190, 1), (195, 1), (200, 1), (205, 1), (210, 1), (215, 1), (220, 1), (225, 1), (230, 0), (235, 0), (240, 1), (245, 0), (250, 1), (255, 1), (260, 1), (265, 1), (270, 1), (275, 1), (280, 1), (285, 0), (290, 0), (295, 0), (300, 0), (305, 0), (310, 0), (315, 0), (320, 0), (325, 0), (330, 0), (335, 0), (340, 1), (345, 0), (350, 1), (355, 1), (360, 1), (365, 1), (370, 1), (375, 1), (380, 1), (385, 1), (390, 1), (395, 1), (400, 1), (405, 1), (410, 1), (415, 1), (420, 1), (425, 1), (430, 1), (435, 0), (440, 0), (445, 0), (450, 0), (455, 0), (460, 0), (465, 1), (470, 1), (475, 1), (480, 1), (485, 1), (490, 1), (495, 1), (500, 1), (505, 1), (510, 1), (515, 1), (520, 1), (525, 1), (530, 1), (535, 1), (540, 1), (545, 0), (550, 0), (555, 0), (560, 0), (565, 0), (570, 0), (575, 0), (580, 0), (585, 0), (590, 0), (595, 0), (600, 0), (605, 0), (610, 0), (615, 0), (620, 0), (625, 0), (630, 0), (635, 0), (640, 0), (645, 1), (650, 1), (655, 1), (660, 1), (665, 1), (670, 1), (675, 1), (680, 1), (685, 1), (690, 1), (695, 1), (700, 1), (705, 1), (710, 0), (715, 0), (720, 1), (725, 1), (730, 1), (735, 0), (740, 0), (745, 0), (750, 0), (755, 0), (760, 0), (765, 0), (770, 1), (775, 1), (780, 1), (785, 1), (790, 1), (795, 1), (800, 1), (805, 1), (810, 1), (815, 1), (820, 0), (825, 0), (830, 0), (835, 0), (840, 0), (845, 0), (850, 0), (855, 0), (860, 1), (865, 1), (870, 1), (875, 1), (880, 1), (885, 1), (890, 1), (895, 1), (900, 1), (905, 1), (910, 1), (915, 1), (920, 0), (925, 0), (930, 0), (935, 0), (940, 0), (945, 0), (950, 0), (955, 0), (960, 0), (965, 0), (970, 0), (975, 0), (980, 0), (985, 0), (990, 1), (995, 1), (1000, 1), (1005, 1), (1010, 1), (1015, 1), (1020, 1), (1025, 1)]
Vdin0_2  din0_2  0 PWL (0n 0.0v 4.745n 0.0v 4.755n 0.0v 9.745n 0.0v 9.755n 0.0v 14.745n 0.0v 14.755n 1.0v 19.745n 1.0v 19.755n 1.0v 24.745n 1.0v 24.755n 1.0v 29.745n 1.0v 29.755n 1.0v 34.745n 1.0v 34.755n 1.0v 39.745n 1.0v 39.755n 1.0v 44.745n 1.0v 44.755n 1.0v 49.745n 1.0v 49.755n 1.0v 54.745n 1.0v 54.755n 1.0v 59.745n 1.0v 59.755n 1.0v 64.745n 1.0v 64.755n 1.0v 69.745n 1.0v 69.755n 1.0v 74.745n 1.0v 74.755n 1.0v 79.745n 1.0v 79.755n 1.0v 84.745n 1.0v 84.755n 1.0v 89.745n 1.0v 89.755n 1.0v 94.745n 1.0v 94.755n 1.0v 99.745n 1.0v 99.755n 1.0v 104.745n 1.0v 104.755n 1.0v 109.745n 1.0v 109.755n 0.0v 114.745n 0.0v 114.755n 0.0v 119.745n 0.0v 119.755n 0.0v 124.745n 0.0v 124.755n 1.0v 129.745n 1.0v 129.755n 1.0v 134.745n 1.0v 134.755n 1.0v 139.745n 1.0v 139.755n 1.0v 144.745n 1.0v 144.755n 1.0v 149.745n 1.0v 149.755n 1.0v 154.745n 1.0v 154.755n 1.0v 159.745n 1.0v 159.755n 1.0v 164.745n 1.0v 164.755n 1.0v 169.745n 1.0v 169.755n 1.0v 174.745n 1.0v 174.755n 1.0v 179.745n 1.0v 179.755n 1.0v 184.745n 1.0v 184.755n 1.0v 189.745n 1.0v 189.755n 1.0v 194.745n 1.0v 194.755n 1.0v 199.745n 1.0v 199.755n 1.0v 204.745n 1.0v 204.755n 1.0v 209.745n 1.0v 209.755n 1.0v 214.745n 1.0v 214.755n 1.0v 219.745n 1.0v 219.755n 1.0v 224.745n 1.0v 224.755n 1.0v 229.745n 1.0v 229.755n 0.0v 234.745n 0.0v 234.755n 0.0v 239.745n 0.0v 239.755n 1.0v 244.745n 1.0v 244.755n 0.0v 249.745n 0.0v 249.755n 1.0v 254.745n 1.0v 254.755n 1.0v 259.745n 1.0v 259.755n 1.0v 264.745n 1.0v 264.755n 1.0v 269.745n 1.0v 269.755n 1.0v 274.745n 1.0v 274.755n 1.0v 279.745n 1.0v 279.755n 1.0v 284.745n 1.0v 284.755n 0.0v 289.745n 0.0v 289.755n 0.0v 294.745n 0.0v 294.755n 0.0v 299.745n 0.0v 299.755n 0.0v 304.745n 0.0v 304.755n 0.0v 309.745n 0.0v 309.755n 0.0v 314.745n 0.0v 314.755n 0.0v 319.745n 0.0v 319.755n 0.0v 324.745n 0.0v 324.755n 0.0v 329.745n 0.0v 329.755n 0.0v 334.745n 0.0v 334.755n 0.0v 339.745n 0.0v 339.755n 1.0v 344.745n 1.0v 344.755n 0.0v 349.745n 0.0v 349.755n 1.0v 354.745n 1.0v 354.755n 1.0v 359.745n 1.0v 359.755n 1.0v 364.745n 1.0v 364.755n 1.0v 369.745n 1.0v 369.755n 1.0v 374.745n 1.0v 374.755n 1.0v 379.745n 1.0v 379.755n 1.0v 384.745n 1.0v 384.755n 1.0v 389.745n 1.0v 389.755n 1.0v 394.745n 1.0v 394.755n 1.0v 399.745n 1.0v 399.755n 1.0v 404.745n 1.0v 404.755n 1.0v 409.745n 1.0v 409.755n 1.0v 414.745n 1.0v 414.755n 1.0v 419.745n 1.0v 419.755n 1.0v 424.745n 1.0v 424.755n 1.0v 429.745n 1.0v 429.755n 1.0v 434.745n 1.0v 434.755n 0.0v 439.745n 0.0v 439.755n 0.0v 444.745n 0.0v 444.755n 0.0v 449.745n 0.0v 449.755n 0.0v 454.745n 0.0v 454.755n 0.0v 459.745n 0.0v 459.755n 0.0v 464.745n 0.0v 464.755n 1.0v 469.745n 1.0v 469.755n 1.0v 474.745n 1.0v 474.755n 1.0v 479.745n 1.0v 479.755n 1.0v 484.745n 1.0v 484.755n 1.0v 489.745n 1.0v 489.755n 1.0v 494.745n 1.0v 494.755n 1.0v 499.745n 1.0v 499.755n 1.0v 504.745n 1.0v 504.755n 1.0v 509.745n 1.0v 509.755n 1.0v 514.745n 1.0v 514.755n 1.0v 519.745n 1.0v 519.755n 1.0v 524.745n 1.0v 524.755n 1.0v 529.745n 1.0v 529.755n 1.0v 534.745n 1.0v 534.755n 1.0v 539.745n 1.0v 539.755n 1.0v 544.745n 1.0v 544.755n 0.0v 549.745n 0.0v 549.755n 0.0v 554.745n 0.0v 554.755n 0.0v 559.745n 0.0v 559.755n 0.0v 564.745n 0.0v 564.755n 0.0v 569.745n 0.0v 569.755n 0.0v 574.745n 0.0v 574.755n 0.0v 579.745n 0.0v 579.755n 0.0v 584.745n 0.0v 584.755n 0.0v 589.745n 0.0v 589.755n 0.0v 594.745n 0.0v 594.755n 0.0v 599.745n 0.0v 599.755n 0.0v 604.745n 0.0v 604.755n 0.0v 609.745n 0.0v 609.755n 0.0v 614.745n 0.0v 614.755n 0.0v 619.745n 0.0v 619.755n 0.0v 624.745n 0.0v 624.755n 0.0v 629.745n 0.0v 629.755n 0.0v 634.745n 0.0v 634.755n 0.0v 639.745n 0.0v 639.755n 0.0v 644.745n 0.0v 644.755n 1.0v 649.745n 1.0v 649.755n 1.0v 654.745n 1.0v 654.755n 1.0v 659.745n 1.0v 659.755n 1.0v 664.745n 1.0v 664.755n 1.0v 669.745n 1.0v 669.755n 1.0v 674.745n 1.0v 674.755n 1.0v 679.745n 1.0v 679.755n 1.0v 684.745n 1.0v 684.755n 1.0v 689.745n 1.0v 689.755n 1.0v 694.745n 1.0v 694.755n 1.0v 699.745n 1.0v 699.755n 1.0v 704.745n 1.0v 704.755n 1.0v 709.745n 1.0v 709.755n 0.0v 714.745n 0.0v 714.755n 0.0v 719.745n 0.0v 719.755n 1.0v 724.745n 1.0v 724.755n 1.0v 729.745n 1.0v 729.755n 1.0v 734.745n 1.0v 734.755n 0.0v 739.745n 0.0v 739.755n 0.0v 744.745n 0.0v 744.755n 0.0v 749.745n 0.0v 749.755n 0.0v 754.745n 0.0v 754.755n 0.0v 759.745n 0.0v 759.755n 0.0v 764.745n 0.0v 764.755n 0.0v 769.745n 0.0v 769.755n 1.0v 774.745n 1.0v 774.755n 1.0v 779.745n 1.0v 779.755n 1.0v 784.745n 1.0v 784.755n 1.0v 789.745n 1.0v 789.755n 1.0v 794.745n 1.0v 794.755n 1.0v 799.745n 1.0v 799.755n 1.0v 804.745n 1.0v 804.755n 1.0v 809.745n 1.0v 809.755n 1.0v 814.745n 1.0v 814.755n 1.0v 819.745n 1.0v 819.755n 0.0v 824.745n 0.0v 824.755n 0.0v 829.745n 0.0v 829.755n 0.0v 834.745n 0.0v 834.755n 0.0v 839.745n 0.0v 839.755n 0.0v 844.745n 0.0v 844.755n 0.0v 849.745n 0.0v 849.755n 0.0v 854.745n 0.0v 854.755n 0.0v 859.745n 0.0v 859.755n 1.0v 864.745n 1.0v 864.755n 1.0v 869.745n 1.0v 869.755n 1.0v 874.745n 1.0v 874.755n 1.0v 879.745n 1.0v 879.755n 1.0v 884.745n 1.0v 884.755n 1.0v 889.745n 1.0v 889.755n 1.0v 894.745n 1.0v 894.755n 1.0v 899.745n 1.0v 899.755n 1.0v 904.745n 1.0v 904.755n 1.0v 909.745n 1.0v 909.755n 1.0v 914.745n 1.0v 914.755n 1.0v 919.745n 1.0v 919.755n 0.0v 924.745n 0.0v 924.755n 0.0v 929.745n 0.0v 929.755n 0.0v 934.745n 0.0v 934.755n 0.0v 939.745n 0.0v 939.755n 0.0v 944.745n 0.0v 944.755n 0.0v 949.745n 0.0v 949.755n 0.0v 954.745n 0.0v 954.755n 0.0v 959.745n 0.0v 959.755n 0.0v 964.745n 0.0v 964.755n 0.0v 969.745n 0.0v 969.755n 0.0v 974.745n 0.0v 974.755n 0.0v 979.745n 0.0v 979.755n 0.0v 984.745n 0.0v 984.755n 0.0v 989.745n 0.0v 989.755n 1.0v 994.745n 1.0v 994.755n 1.0v 999.745n 1.0v 999.755n 1.0v 1004.745n 1.0v 1004.755n 1.0v 1009.745n 1.0v 1009.755n 1.0v 1014.745n 1.0v 1014.755n 1.0v 1019.745n 1.0v 1019.755n 1.0v 1024.745n 1.0v 1024.755n 1.0v )
* (time, data): [(0, 0), (5, 0), (10, 0), (15, 0), (20, 0), (25, 0), (30, 0), (35, 0), (40, 1), (45, 0), (50, 0), (55, 0), (60, 0), (65, 0), (70, 0), (75, 0), (80, 0), (85, 0), (90, 0), (95, 0), (100, 0), (105, 0), (110, 1), (115, 1), (120, 1), (125, 1), (130, 1), (135, 1), (140, 1), (145, 0), (150, 0), (155, 0), (160, 0), (165, 0), (170, 0), (175, 0), (180, 0), (185, 0), (190, 0), (195, 0), (200, 0), (205, 0), (210, 0), (215, 0), (220, 0), (225, 0), (230, 1), (235, 0), (240, 1), (245, 0), (250, 1), (255, 1), (260, 1), (265, 1), (270, 1), (275, 1), (280, 1), (285, 0), (290, 0), (295, 0), (300, 1), (305, 1), (310, 1), (315, 1), (320, 1), (325, 1), (330, 1), (335, 1), (340, 0), (345, 0), (350, 1), (355, 1), (360, 1), (365, 1), (370, 1), (375, 1), (380, 1), (385, 1), (390, 1), (395, 1), (400, 1), (405, 1), (410, 1), (415, 1), (420, 1), (425, 1), (430, 1), (435, 0), (440, 0), (445, 0), (450, 0), (455, 0), (460, 0), (465, 1), (470, 1), (475, 1), (480, 1), (485, 1), (490, 1), (495, 1), (500, 1), (505, 1), (510, 0), (515, 0), (520, 0), (525, 0), (530, 0), (535, 0), (540, 0), (545, 1), (550, 1), (555, 1), (560, 1), (565, 1), (570, 1), (575, 1), (580, 1), (585, 1), (590, 1), (595, 1), (600, 1), (605, 1), (610, 1), (615, 1), (620, 1), (625, 1), (630, 1), (635, 1), (640, 1), (645, 1), (650, 1), (655, 1), (660, 1), (665, 1), (670, 1), (675, 1), (680, 0), (685, 0), (690, 0), (695, 0), (700, 0), (705, 0), (710, 0), (715, 0), (720, 0), (725, 0), (730, 0), (735, 0), (740, 0), (745, 0), (750, 0), (755, 0), (760, 0), (765, 0), (770, 0), (775, 0), (780, 0), (785, 0), (790, 0), (795, 1), (800, 1), (805, 1), (810, 1), (815, 1), (820, 1), (825, 1), (830, 1), (835, 1), (840, 1), (845, 1), (850, 1), (855, 1), (860, 1), (865, 1), (870, 1), (875, 1), (880, 1), (885, 1), (890, 1), (895, 1), (900, 1), (905, 1), (910, 1), (915, 1), (920, 1), (925, 1), (930, 1), (935, 0), (940, 0), (945, 0), (950, 0), (955, 0), (960, 0), (965, 0), (970, 1), (975, 1), (980, 1), (985, 1), (990, 1), (995, 1), (1000, 1), (1005, 1), (1010, 1), (1015, 0), (1020, 0), (1025, 0)]
Vdin0_3  din0_3  0 PWL (0n 0.0v 4.745n 0.0v 4.755n 0.0v 9.745n 0.0v 9.755n 0.0v 14.745n 0.0v 14.755n 0.0v 19.745n 0.0v 19.755n 0.0v 24.745n 0.0v 24.755n 0.0v 29.745n 0.0v 29.755n 0.0v 34.745n 0.0v 34.755n 0.0v 39.745n 0.0v 39.755n 1.0v 44.745n 1.0v 44.755n 0.0v 49.745n 0.0v 49.755n 0.0v 54.745n 0.0v 54.755n 0.0v 59.745n 0.0v 59.755n 0.0v 64.745n 0.0v 64.755n 0.0v 69.745n 0.0v 69.755n 0.0v 74.745n 0.0v 74.755n 0.0v 79.745n 0.0v 79.755n 0.0v 84.745n 0.0v 84.755n 0.0v 89.745n 0.0v 89.755n 0.0v 94.745n 0.0v 94.755n 0.0v 99.745n 0.0v 99.755n 0.0v 104.745n 0.0v 104.755n 0.0v 109.745n 0.0v 109.755n 1.0v 114.745n 1.0v 114.755n 1.0v 119.745n 1.0v 119.755n 1.0v 124.745n 1.0v 124.755n 1.0v 129.745n 1.0v 129.755n 1.0v 134.745n 1.0v 134.755n 1.0v 139.745n 1.0v 139.755n 1.0v 144.745n 1.0v 144.755n 0.0v 149.745n 0.0v 149.755n 0.0v 154.745n 0.0v 154.755n 0.0v 159.745n 0.0v 159.755n 0.0v 164.745n 0.0v 164.755n 0.0v 169.745n 0.0v 169.755n 0.0v 174.745n 0.0v 174.755n 0.0v 179.745n 0.0v 179.755n 0.0v 184.745n 0.0v 184.755n 0.0v 189.745n 0.0v 189.755n 0.0v 194.745n 0.0v 194.755n 0.0v 199.745n 0.0v 199.755n 0.0v 204.745n 0.0v 204.755n 0.0v 209.745n 0.0v 209.755n 0.0v 214.745n 0.0v 214.755n 0.0v 219.745n 0.0v 219.755n 0.0v 224.745n 0.0v 224.755n 0.0v 229.745n 0.0v 229.755n 1.0v 234.745n 1.0v 234.755n 0.0v 239.745n 0.0v 239.755n 1.0v 244.745n 1.0v 244.755n 0.0v 249.745n 0.0v 249.755n 1.0v 254.745n 1.0v 254.755n 1.0v 259.745n 1.0v 259.755n 1.0v 264.745n 1.0v 264.755n 1.0v 269.745n 1.0v 269.755n 1.0v 274.745n 1.0v 274.755n 1.0v 279.745n 1.0v 279.755n 1.0v 284.745n 1.0v 284.755n 0.0v 289.745n 0.0v 289.755n 0.0v 294.745n 0.0v 294.755n 0.0v 299.745n 0.0v 299.755n 1.0v 304.745n 1.0v 304.755n 1.0v 309.745n 1.0v 309.755n 1.0v 314.745n 1.0v 314.755n 1.0v 319.745n 1.0v 319.755n 1.0v 324.745n 1.0v 324.755n 1.0v 329.745n 1.0v 329.755n 1.0v 334.745n 1.0v 334.755n 1.0v 339.745n 1.0v 339.755n 0.0v 344.745n 0.0v 344.755n 0.0v 349.745n 0.0v 349.755n 1.0v 354.745n 1.0v 354.755n 1.0v 359.745n 1.0v 359.755n 1.0v 364.745n 1.0v 364.755n 1.0v 369.745n 1.0v 369.755n 1.0v 374.745n 1.0v 374.755n 1.0v 379.745n 1.0v 379.755n 1.0v 384.745n 1.0v 384.755n 1.0v 389.745n 1.0v 389.755n 1.0v 394.745n 1.0v 394.755n 1.0v 399.745n 1.0v 399.755n 1.0v 404.745n 1.0v 404.755n 1.0v 409.745n 1.0v 409.755n 1.0v 414.745n 1.0v 414.755n 1.0v 419.745n 1.0v 419.755n 1.0v 424.745n 1.0v 424.755n 1.0v 429.745n 1.0v 429.755n 1.0v 434.745n 1.0v 434.755n 0.0v 439.745n 0.0v 439.755n 0.0v 444.745n 0.0v 444.755n 0.0v 449.745n 0.0v 449.755n 0.0v 454.745n 0.0v 454.755n 0.0v 459.745n 0.0v 459.755n 0.0v 464.745n 0.0v 464.755n 1.0v 469.745n 1.0v 469.755n 1.0v 474.745n 1.0v 474.755n 1.0v 479.745n 1.0v 479.755n 1.0v 484.745n 1.0v 484.755n 1.0v 489.745n 1.0v 489.755n 1.0v 494.745n 1.0v 494.755n 1.0v 499.745n 1.0v 499.755n 1.0v 504.745n 1.0v 504.755n 1.0v 509.745n 1.0v 509.755n 0.0v 514.745n 0.0v 514.755n 0.0v 519.745n 0.0v 519.755n 0.0v 524.745n 0.0v 524.755n 0.0v 529.745n 0.0v 529.755n 0.0v 534.745n 0.0v 534.755n 0.0v 539.745n 0.0v 539.755n 0.0v 544.745n 0.0v 544.755n 1.0v 549.745n 1.0v 549.755n 1.0v 554.745n 1.0v 554.755n 1.0v 559.745n 1.0v 559.755n 1.0v 564.745n 1.0v 564.755n 1.0v 569.745n 1.0v 569.755n 1.0v 574.745n 1.0v 574.755n 1.0v 579.745n 1.0v 579.755n 1.0v 584.745n 1.0v 584.755n 1.0v 589.745n 1.0v 589.755n 1.0v 594.745n 1.0v 594.755n 1.0v 599.745n 1.0v 599.755n 1.0v 604.745n 1.0v 604.755n 1.0v 609.745n 1.0v 609.755n 1.0v 614.745n 1.0v 614.755n 1.0v 619.745n 1.0v 619.755n 1.0v 624.745n 1.0v 624.755n 1.0v 629.745n 1.0v 629.755n 1.0v 634.745n 1.0v 634.755n 1.0v 639.745n 1.0v 639.755n 1.0v 644.745n 1.0v 644.755n 1.0v 649.745n 1.0v 649.755n 1.0v 654.745n 1.0v 654.755n 1.0v 659.745n 1.0v 659.755n 1.0v 664.745n 1.0v 664.755n 1.0v 669.745n 1.0v 669.755n 1.0v 674.745n 1.0v 674.755n 1.0v 679.745n 1.0v 679.755n 0.0v 684.745n 0.0v 684.755n 0.0v 689.745n 0.0v 689.755n 0.0v 694.745n 0.0v 694.755n 0.0v 699.745n 0.0v 699.755n 0.0v 704.745n 0.0v 704.755n 0.0v 709.745n 0.0v 709.755n 0.0v 714.745n 0.0v 714.755n 0.0v 719.745n 0.0v 719.755n 0.0v 724.745n 0.0v 724.755n 0.0v 729.745n 0.0v 729.755n 0.0v 734.745n 0.0v 734.755n 0.0v 739.745n 0.0v 739.755n 0.0v 744.745n 0.0v 744.755n 0.0v 749.745n 0.0v 749.755n 0.0v 754.745n 0.0v 754.755n 0.0v 759.745n 0.0v 759.755n 0.0v 764.745n 0.0v 764.755n 0.0v 769.745n 0.0v 769.755n 0.0v 774.745n 0.0v 774.755n 0.0v 779.745n 0.0v 779.755n 0.0v 784.745n 0.0v 784.755n 0.0v 789.745n 0.0v 789.755n 0.0v 794.745n 0.0v 794.755n 1.0v 799.745n 1.0v 799.755n 1.0v 804.745n 1.0v 804.755n 1.0v 809.745n 1.0v 809.755n 1.0v 814.745n 1.0v 814.755n 1.0v 819.745n 1.0v 819.755n 1.0v 824.745n 1.0v 824.755n 1.0v 829.745n 1.0v 829.755n 1.0v 834.745n 1.0v 834.755n 1.0v 839.745n 1.0v 839.755n 1.0v 844.745n 1.0v 844.755n 1.0v 849.745n 1.0v 849.755n 1.0v 854.745n 1.0v 854.755n 1.0v 859.745n 1.0v 859.755n 1.0v 864.745n 1.0v 864.755n 1.0v 869.745n 1.0v 869.755n 1.0v 874.745n 1.0v 874.755n 1.0v 879.745n 1.0v 879.755n 1.0v 884.745n 1.0v 884.755n 1.0v 889.745n 1.0v 889.755n 1.0v 894.745n 1.0v 894.755n 1.0v 899.745n 1.0v 899.755n 1.0v 904.745n 1.0v 904.755n 1.0v 909.745n 1.0v 909.755n 1.0v 914.745n 1.0v 914.755n 1.0v 919.745n 1.0v 919.755n 1.0v 924.745n 1.0v 924.755n 1.0v 929.745n 1.0v 929.755n 1.0v 934.745n 1.0v 934.755n 0.0v 939.745n 0.0v 939.755n 0.0v 944.745n 0.0v 944.755n 0.0v 949.745n 0.0v 949.755n 0.0v 954.745n 0.0v 954.755n 0.0v 959.745n 0.0v 959.755n 0.0v 964.745n 0.0v 964.755n 0.0v 969.745n 0.0v 969.755n 1.0v 974.745n 1.0v 974.755n 1.0v 979.745n 1.0v 979.755n 1.0v 984.745n 1.0v 984.755n 1.0v 989.745n 1.0v 989.755n 1.0v 994.745n 1.0v 994.755n 1.0v 999.745n 1.0v 999.755n 1.0v 1004.745n 1.0v 1004.755n 1.0v 1009.745n 1.0v 1009.755n 1.0v 1014.745n 1.0v 1014.755n 0.0v 1019.745n 0.0v 1019.755n 0.0v 1024.745n 0.0v 1024.755n 0.0v )
* (time, data): [(0, 0), (5, 1), (10, 0), (15, 1), (20, 1), (25, 1), (30, 0), (35, 0), (40, 0), (45, 1), (50, 1), (55, 1), (60, 1), (65, 0), (70, 0), (75, 0), (80, 1), (85, 1), (90, 1), (95, 1), (100, 1), (105, 1), (110, 0), (115, 0), (120, 0), (125, 1), (130, 1), (135, 1), (140, 1), (145, 0), (150, 0), (155, 0), (160, 0), (165, 0), (170, 0), (175, 0), (180, 0), (185, 0), (190, 0), (195, 0), (200, 0), (205, 0), (210, 0), (215, 0), (220, 0), (225, 0), (230, 0), (235, 0), (240, 1), (245, 0), (250, 0), (255, 0), (260, 0), (265, 0), (270, 0), (275, 1), (280, 1), (285, 0), (290, 0), (295, 0), (300, 0), (305, 0), (310, 0), (315, 0), (320, 0), (325, 0), (330, 0), (335, 0), (340, 0), (345, 0), (350, 0), (355, 0), (360, 0), (365, 0), (370, 0), (375, 0), (380, 0), (385, 0), (390, 0), (395, 0), (400, 0), (405, 0), (410, 0), (415, 0), (420, 0), (425, 0), (430, 0), (435, 1), (440, 1), (445, 1), (450, 1), (455, 1), (460, 1), (465, 1), (470, 1), (475, 1), (480, 1), (485, 1), (490, 1), (495, 1), (500, 1), (505, 1), (510, 1), (515, 1), (520, 1), (525, 1), (530, 1), (535, 1), (540, 1), (545, 1), (550, 1), (555, 1), (560, 1), (565, 1), (570, 1), (575, 1), (580, 1), (585, 1), (590, 1), (595, 1), (600, 1), (605, 1), (610, 1), (615, 1), (620, 1), (625, 1), (630, 1), (635, 1), (640, 1), (645, 0), (650, 0), (655, 0), (660, 0), (665, 0), (670, 0), (675, 0), (680, 0), (685, 0), (690, 0), (695, 0), (700, 0), (705, 0), (710, 0), (715, 0), (720, 0), (725, 0), (730, 0), (735, 0), (740, 0), (745, 0), (750, 0), (755, 0), (760, 0), (765, 0), (770, 1), (775, 1), (780, 0), (785, 0), (790, 0), (795, 1), (800, 1), (805, 1), (810, 1), (815, 1), (820, 1), (825, 1), (830, 1), (835, 1), (840, 1), (845, 1), (850, 1), (855, 1), (860, 0), (865, 0), (870, 0), (875, 0), (880, 0), (885, 0), (890, 0), (895, 0), (900, 0), (905, 0), (910, 1), (915, 1), (920, 1), (925, 1), (930, 1), (935, 1), (940, 1), (945, 1), (950, 1), (955, 1), (960, 1), (965, 1), (970, 1), (975, 1), (980, 1), (985, 1), (990, 0), (995, 0), (1000, 0), (1005, 0), (1010, 0), (1015, 0), (1020, 0), (1025, 0)]
Vdin0_4  din0_4  0 PWL (0n 0.0v 4.745n 0.0v 4.755n 1.0v 9.745n 1.0v 9.755n 0.0v 14.745n 0.0v 14.755n 1.0v 19.745n 1.0v 19.755n 1.0v 24.745n 1.0v 24.755n 1.0v 29.745n 1.0v 29.755n 0.0v 34.745n 0.0v 34.755n 0.0v 39.745n 0.0v 39.755n 0.0v 44.745n 0.0v 44.755n 1.0v 49.745n 1.0v 49.755n 1.0v 54.745n 1.0v 54.755n 1.0v 59.745n 1.0v 59.755n 1.0v 64.745n 1.0v 64.755n 0.0v 69.745n 0.0v 69.755n 0.0v 74.745n 0.0v 74.755n 0.0v 79.745n 0.0v 79.755n 1.0v 84.745n 1.0v 84.755n 1.0v 89.745n 1.0v 89.755n 1.0v 94.745n 1.0v 94.755n 1.0v 99.745n 1.0v 99.755n 1.0v 104.745n 1.0v 104.755n 1.0v 109.745n 1.0v 109.755n 0.0v 114.745n 0.0v 114.755n 0.0v 119.745n 0.0v 119.755n 0.0v 124.745n 0.0v 124.755n 1.0v 129.745n 1.0v 129.755n 1.0v 134.745n 1.0v 134.755n 1.0v 139.745n 1.0v 139.755n 1.0v 144.745n 1.0v 144.755n 0.0v 149.745n 0.0v 149.755n 0.0v 154.745n 0.0v 154.755n 0.0v 159.745n 0.0v 159.755n 0.0v 164.745n 0.0v 164.755n 0.0v 169.745n 0.0v 169.755n 0.0v 174.745n 0.0v 174.755n 0.0v 179.745n 0.0v 179.755n 0.0v 184.745n 0.0v 184.755n 0.0v 189.745n 0.0v 189.755n 0.0v 194.745n 0.0v 194.755n 0.0v 199.745n 0.0v 199.755n 0.0v 204.745n 0.0v 204.755n 0.0v 209.745n 0.0v 209.755n 0.0v 214.745n 0.0v 214.755n 0.0v 219.745n 0.0v 219.755n 0.0v 224.745n 0.0v 224.755n 0.0v 229.745n 0.0v 229.755n 0.0v 234.745n 0.0v 234.755n 0.0v 239.745n 0.0v 239.755n 1.0v 244.745n 1.0v 244.755n 0.0v 249.745n 0.0v 249.755n 0.0v 254.745n 0.0v 254.755n 0.0v 259.745n 0.0v 259.755n 0.0v 264.745n 0.0v 264.755n 0.0v 269.745n 0.0v 269.755n 0.0v 274.745n 0.0v 274.755n 1.0v 279.745n 1.0v 279.755n 1.0v 284.745n 1.0v 284.755n 0.0v 289.745n 0.0v 289.755n 0.0v 294.745n 0.0v 294.755n 0.0v 299.745n 0.0v 299.755n 0.0v 304.745n 0.0v 304.755n 0.0v 309.745n 0.0v 309.755n 0.0v 314.745n 0.0v 314.755n 0.0v 319.745n 0.0v 319.755n 0.0v 324.745n 0.0v 324.755n 0.0v 329.745n 0.0v 329.755n 0.0v 334.745n 0.0v 334.755n 0.0v 339.745n 0.0v 339.755n 0.0v 344.745n 0.0v 344.755n 0.0v 349.745n 0.0v 349.755n 0.0v 354.745n 0.0v 354.755n 0.0v 359.745n 0.0v 359.755n 0.0v 364.745n 0.0v 364.755n 0.0v 369.745n 0.0v 369.755n 0.0v 374.745n 0.0v 374.755n 0.0v 379.745n 0.0v 379.755n 0.0v 384.745n 0.0v 384.755n 0.0v 389.745n 0.0v 389.755n 0.0v 394.745n 0.0v 394.755n 0.0v 399.745n 0.0v 399.755n 0.0v 404.745n 0.0v 404.755n 0.0v 409.745n 0.0v 409.755n 0.0v 414.745n 0.0v 414.755n 0.0v 419.745n 0.0v 419.755n 0.0v 424.745n 0.0v 424.755n 0.0v 429.745n 0.0v 429.755n 0.0v 434.745n 0.0v 434.755n 1.0v 439.745n 1.0v 439.755n 1.0v 444.745n 1.0v 444.755n 1.0v 449.745n 1.0v 449.755n 1.0v 454.745n 1.0v 454.755n 1.0v 459.745n 1.0v 459.755n 1.0v 464.745n 1.0v 464.755n 1.0v 469.745n 1.0v 469.755n 1.0v 474.745n 1.0v 474.755n 1.0v 479.745n 1.0v 479.755n 1.0v 484.745n 1.0v 484.755n 1.0v 489.745n 1.0v 489.755n 1.0v 494.745n 1.0v 494.755n 1.0v 499.745n 1.0v 499.755n 1.0v 504.745n 1.0v 504.755n 1.0v 509.745n 1.0v 509.755n 1.0v 514.745n 1.0v 514.755n 1.0v 519.745n 1.0v 519.755n 1.0v 524.745n 1.0v 524.755n 1.0v 529.745n 1.0v 529.755n 1.0v 534.745n 1.0v 534.755n 1.0v 539.745n 1.0v 539.755n 1.0v 544.745n 1.0v 544.755n 1.0v 549.745n 1.0v 549.755n 1.0v 554.745n 1.0v 554.755n 1.0v 559.745n 1.0v 559.755n 1.0v 564.745n 1.0v 564.755n 1.0v 569.745n 1.0v 569.755n 1.0v 574.745n 1.0v 574.755n 1.0v 579.745n 1.0v 579.755n 1.0v 584.745n 1.0v 584.755n 1.0v 589.745n 1.0v 589.755n 1.0v 594.745n 1.0v 594.755n 1.0v 599.745n 1.0v 599.755n 1.0v 604.745n 1.0v 604.755n 1.0v 609.745n 1.0v 609.755n 1.0v 614.745n 1.0v 614.755n 1.0v 619.745n 1.0v 619.755n 1.0v 624.745n 1.0v 624.755n 1.0v 629.745n 1.0v 629.755n 1.0v 634.745n 1.0v 634.755n 1.0v 639.745n 1.0v 639.755n 1.0v 644.745n 1.0v 644.755n 0.0v 649.745n 0.0v 649.755n 0.0v 654.745n 0.0v 654.755n 0.0v 659.745n 0.0v 659.755n 0.0v 664.745n 0.0v 664.755n 0.0v 669.745n 0.0v 669.755n 0.0v 674.745n 0.0v 674.755n 0.0v 679.745n 0.0v 679.755n 0.0v 684.745n 0.0v 684.755n 0.0v 689.745n 0.0v 689.755n 0.0v 694.745n 0.0v 694.755n 0.0v 699.745n 0.0v 699.755n 0.0v 704.745n 0.0v 704.755n 0.0v 709.745n 0.0v 709.755n 0.0v 714.745n 0.0v 714.755n 0.0v 719.745n 0.0v 719.755n 0.0v 724.745n 0.0v 724.755n 0.0v 729.745n 0.0v 729.755n 0.0v 734.745n 0.0v 734.755n 0.0v 739.745n 0.0v 739.755n 0.0v 744.745n 0.0v 744.755n 0.0v 749.745n 0.0v 749.755n 0.0v 754.745n 0.0v 754.755n 0.0v 759.745n 0.0v 759.755n 0.0v 764.745n 0.0v 764.755n 0.0v 769.745n 0.0v 769.755n 1.0v 774.745n 1.0v 774.755n 1.0v 779.745n 1.0v 779.755n 0.0v 784.745n 0.0v 784.755n 0.0v 789.745n 0.0v 789.755n 0.0v 794.745n 0.0v 794.755n 1.0v 799.745n 1.0v 799.755n 1.0v 804.745n 1.0v 804.755n 1.0v 809.745n 1.0v 809.755n 1.0v 814.745n 1.0v 814.755n 1.0v 819.745n 1.0v 819.755n 1.0v 824.745n 1.0v 824.755n 1.0v 829.745n 1.0v 829.755n 1.0v 834.745n 1.0v 834.755n 1.0v 839.745n 1.0v 839.755n 1.0v 844.745n 1.0v 844.755n 1.0v 849.745n 1.0v 849.755n 1.0v 854.745n 1.0v 854.755n 1.0v 859.745n 1.0v 859.755n 0.0v 864.745n 0.0v 864.755n 0.0v 869.745n 0.0v 869.755n 0.0v 874.745n 0.0v 874.755n 0.0v 879.745n 0.0v 879.755n 0.0v 884.745n 0.0v 884.755n 0.0v 889.745n 0.0v 889.755n 0.0v 894.745n 0.0v 894.755n 0.0v 899.745n 0.0v 899.755n 0.0v 904.745n 0.0v 904.755n 0.0v 909.745n 0.0v 909.755n 1.0v 914.745n 1.0v 914.755n 1.0v 919.745n 1.0v 919.755n 1.0v 924.745n 1.0v 924.755n 1.0v 929.745n 1.0v 929.755n 1.0v 934.745n 1.0v 934.755n 1.0v 939.745n 1.0v 939.755n 1.0v 944.745n 1.0v 944.755n 1.0v 949.745n 1.0v 949.755n 1.0v 954.745n 1.0v 954.755n 1.0v 959.745n 1.0v 959.755n 1.0v 964.745n 1.0v 964.755n 1.0v 969.745n 1.0v 969.755n 1.0v 974.745n 1.0v 974.755n 1.0v 979.745n 1.0v 979.755n 1.0v 984.745n 1.0v 984.755n 1.0v 989.745n 1.0v 989.755n 0.0v 994.745n 0.0v 994.755n 0.0v 999.745n 0.0v 999.755n 0.0v 1004.745n 0.0v 1004.755n 0.0v 1009.745n 0.0v 1009.755n 0.0v 1014.745n 0.0v 1014.755n 0.0v 1019.745n 0.0v 1019.755n 0.0v 1024.745n 0.0v 1024.755n 0.0v )
* (time, data): [(0, 0), (5, 0), (10, 0), (15, 0), (20, 0), (25, 0), (30, 1), (35, 1), (40, 0), (45, 1), (50, 1), (55, 1), (60, 1), (65, 0), (70, 0), (75, 0), (80, 0), (85, 0), (90, 0), (95, 0), (100, 0), (105, 0), (110, 1), (115, 1), (120, 1), (125, 0), (130, 0), (135, 0), (140, 1), (145, 1), (150, 1), (155, 1), (160, 1), (165, 1), (170, 1), (175, 1), (180, 1), (185, 1), (190, 1), (195, 1), (200, 1), (205, 1), (210, 1), (215, 1), (220, 1), (225, 1), (230, 0), (235, 1), (240, 1), (245, 1), (250, 0), (255, 0), (260, 0), (265, 0), (270, 0), (275, 1), (280, 1), (285, 0), (290, 0), (295, 0), (300, 1), (305, 1), (310, 1), (315, 1), (320, 1), (325, 1), (330, 1), (335, 1), (340, 0), (345, 0), (350, 0), (355, 0), (360, 0), (365, 0), (370, 0), (375, 0), (380, 0), (385, 0), (390, 0), (395, 0), (400, 0), (405, 0), (410, 0), (415, 0), (420, 0), (425, 0), (430, 0), (435, 0), (440, 0), (445, 0), (450, 0), (455, 1), (460, 1), (465, 0), (470, 0), (475, 0), (480, 0), (485, 0), (490, 0), (495, 0), (500, 0), (505, 0), (510, 0), (515, 0), (520, 0), (525, 0), (530, 0), (535, 0), (540, 0), (545, 1), (550, 1), (555, 1), (560, 1), (565, 1), (570, 1), (575, 1), (580, 1), (585, 1), (590, 1), (595, 1), (600, 1), (605, 1), (610, 1), (615, 1), (620, 1), (625, 1), (630, 1), (635, 1), (640, 1), (645, 0), (650, 0), (655, 0), (660, 0), (665, 0), (670, 0), (675, 0), (680, 0), (685, 0), (690, 0), (695, 0), (700, 0), (705, 0), (710, 1), (715, 1), (720, 0), (725, 0), (730, 0), (735, 0), (740, 0), (745, 0), (750, 0), (755, 0), (760, 0), (765, 0), (770, 0), (775, 0), (780, 1), (785, 1), (790, 1), (795, 1), (800, 1), (805, 1), (810, 1), (815, 1), (820, 0), (825, 0), (830, 0), (835, 0), (840, 0), (845, 0), (850, 0), (855, 0), (860, 1), (865, 1), (870, 1), (875, 1), (880, 1), (885, 1), (890, 1), (895, 1), (900, 1), (905, 0), (910, 0), (915, 0), (920, 1), (925, 1), (930, 1), (935, 0), (940, 0), (945, 0), (950, 0), (955, 1), (960, 1), (965, 1), (970, 0), (975, 0), (980, 0), (985, 0), (990, 0), (995, 0), (1000, 0), (1005, 0), (1010, 0), (1015, 0), (1020, 0), (1025, 0)]
Vdin0_5  din0_5  0 PWL (0n 0.0v 4.745n 0.0v 4.755n 0.0v 9.745n 0.0v 9.755n 0.0v 14.745n 0.0v 14.755n 0.0v 19.745n 0.0v 19.755n 0.0v 24.745n 0.0v 24.755n 0.0v 29.745n 0.0v 29.755n 1.0v 34.745n 1.0v 34.755n 1.0v 39.745n 1.0v 39.755n 0.0v 44.745n 0.0v 44.755n 1.0v 49.745n 1.0v 49.755n 1.0v 54.745n 1.0v 54.755n 1.0v 59.745n 1.0v 59.755n 1.0v 64.745n 1.0v 64.755n 0.0v 69.745n 0.0v 69.755n 0.0v 74.745n 0.0v 74.755n 0.0v 79.745n 0.0v 79.755n 0.0v 84.745n 0.0v 84.755n 0.0v 89.745n 0.0v 89.755n 0.0v 94.745n 0.0v 94.755n 0.0v 99.745n 0.0v 99.755n 0.0v 104.745n 0.0v 104.755n 0.0v 109.745n 0.0v 109.755n 1.0v 114.745n 1.0v 114.755n 1.0v 119.745n 1.0v 119.755n 1.0v 124.745n 1.0v 124.755n 0.0v 129.745n 0.0v 129.755n 0.0v 134.745n 0.0v 134.755n 0.0v 139.745n 0.0v 139.755n 1.0v 144.745n 1.0v 144.755n 1.0v 149.745n 1.0v 149.755n 1.0v 154.745n 1.0v 154.755n 1.0v 159.745n 1.0v 159.755n 1.0v 164.745n 1.0v 164.755n 1.0v 169.745n 1.0v 169.755n 1.0v 174.745n 1.0v 174.755n 1.0v 179.745n 1.0v 179.755n 1.0v 184.745n 1.0v 184.755n 1.0v 189.745n 1.0v 189.755n 1.0v 194.745n 1.0v 194.755n 1.0v 199.745n 1.0v 199.755n 1.0v 204.745n 1.0v 204.755n 1.0v 209.745n 1.0v 209.755n 1.0v 214.745n 1.0v 214.755n 1.0v 219.745n 1.0v 219.755n 1.0v 224.745n 1.0v 224.755n 1.0v 229.745n 1.0v 229.755n 0.0v 234.745n 0.0v 234.755n 1.0v 239.745n 1.0v 239.755n 1.0v 244.745n 1.0v 244.755n 1.0v 249.745n 1.0v 249.755n 0.0v 254.745n 0.0v 254.755n 0.0v 259.745n 0.0v 259.755n 0.0v 264.745n 0.0v 264.755n 0.0v 269.745n 0.0v 269.755n 0.0v 274.745n 0.0v 274.755n 1.0v 279.745n 1.0v 279.755n 1.0v 284.745n 1.0v 284.755n 0.0v 289.745n 0.0v 289.755n 0.0v 294.745n 0.0v 294.755n 0.0v 299.745n 0.0v 299.755n 1.0v 304.745n 1.0v 304.755n 1.0v 309.745n 1.0v 309.755n 1.0v 314.745n 1.0v 314.755n 1.0v 319.745n 1.0v 319.755n 1.0v 324.745n 1.0v 324.755n 1.0v 329.745n 1.0v 329.755n 1.0v 334.745n 1.0v 334.755n 1.0v 339.745n 1.0v 339.755n 0.0v 344.745n 0.0v 344.755n 0.0v 349.745n 0.0v 349.755n 0.0v 354.745n 0.0v 354.755n 0.0v 359.745n 0.0v 359.755n 0.0v 364.745n 0.0v 364.755n 0.0v 369.745n 0.0v 369.755n 0.0v 374.745n 0.0v 374.755n 0.0v 379.745n 0.0v 379.755n 0.0v 384.745n 0.0v 384.755n 0.0v 389.745n 0.0v 389.755n 0.0v 394.745n 0.0v 394.755n 0.0v 399.745n 0.0v 399.755n 0.0v 404.745n 0.0v 404.755n 0.0v 409.745n 0.0v 409.755n 0.0v 414.745n 0.0v 414.755n 0.0v 419.745n 0.0v 419.755n 0.0v 424.745n 0.0v 424.755n 0.0v 429.745n 0.0v 429.755n 0.0v 434.745n 0.0v 434.755n 0.0v 439.745n 0.0v 439.755n 0.0v 444.745n 0.0v 444.755n 0.0v 449.745n 0.0v 449.755n 0.0v 454.745n 0.0v 454.755n 1.0v 459.745n 1.0v 459.755n 1.0v 464.745n 1.0v 464.755n 0.0v 469.745n 0.0v 469.755n 0.0v 474.745n 0.0v 474.755n 0.0v 479.745n 0.0v 479.755n 0.0v 484.745n 0.0v 484.755n 0.0v 489.745n 0.0v 489.755n 0.0v 494.745n 0.0v 494.755n 0.0v 499.745n 0.0v 499.755n 0.0v 504.745n 0.0v 504.755n 0.0v 509.745n 0.0v 509.755n 0.0v 514.745n 0.0v 514.755n 0.0v 519.745n 0.0v 519.755n 0.0v 524.745n 0.0v 524.755n 0.0v 529.745n 0.0v 529.755n 0.0v 534.745n 0.0v 534.755n 0.0v 539.745n 0.0v 539.755n 0.0v 544.745n 0.0v 544.755n 1.0v 549.745n 1.0v 549.755n 1.0v 554.745n 1.0v 554.755n 1.0v 559.745n 1.0v 559.755n 1.0v 564.745n 1.0v 564.755n 1.0v 569.745n 1.0v 569.755n 1.0v 574.745n 1.0v 574.755n 1.0v 579.745n 1.0v 579.755n 1.0v 584.745n 1.0v 584.755n 1.0v 589.745n 1.0v 589.755n 1.0v 594.745n 1.0v 594.755n 1.0v 599.745n 1.0v 599.755n 1.0v 604.745n 1.0v 604.755n 1.0v 609.745n 1.0v 609.755n 1.0v 614.745n 1.0v 614.755n 1.0v 619.745n 1.0v 619.755n 1.0v 624.745n 1.0v 624.755n 1.0v 629.745n 1.0v 629.755n 1.0v 634.745n 1.0v 634.755n 1.0v 639.745n 1.0v 639.755n 1.0v 644.745n 1.0v 644.755n 0.0v 649.745n 0.0v 649.755n 0.0v 654.745n 0.0v 654.755n 0.0v 659.745n 0.0v 659.755n 0.0v 664.745n 0.0v 664.755n 0.0v 669.745n 0.0v 669.755n 0.0v 674.745n 0.0v 674.755n 0.0v 679.745n 0.0v 679.755n 0.0v 684.745n 0.0v 684.755n 0.0v 689.745n 0.0v 689.755n 0.0v 694.745n 0.0v 694.755n 0.0v 699.745n 0.0v 699.755n 0.0v 704.745n 0.0v 704.755n 0.0v 709.745n 0.0v 709.755n 1.0v 714.745n 1.0v 714.755n 1.0v 719.745n 1.0v 719.755n 0.0v 724.745n 0.0v 724.755n 0.0v 729.745n 0.0v 729.755n 0.0v 734.745n 0.0v 734.755n 0.0v 739.745n 0.0v 739.755n 0.0v 744.745n 0.0v 744.755n 0.0v 749.745n 0.0v 749.755n 0.0v 754.745n 0.0v 754.755n 0.0v 759.745n 0.0v 759.755n 0.0v 764.745n 0.0v 764.755n 0.0v 769.745n 0.0v 769.755n 0.0v 774.745n 0.0v 774.755n 0.0v 779.745n 0.0v 779.755n 1.0v 784.745n 1.0v 784.755n 1.0v 789.745n 1.0v 789.755n 1.0v 794.745n 1.0v 794.755n 1.0v 799.745n 1.0v 799.755n 1.0v 804.745n 1.0v 804.755n 1.0v 809.745n 1.0v 809.755n 1.0v 814.745n 1.0v 814.755n 1.0v 819.745n 1.0v 819.755n 0.0v 824.745n 0.0v 824.755n 0.0v 829.745n 0.0v 829.755n 0.0v 834.745n 0.0v 834.755n 0.0v 839.745n 0.0v 839.755n 0.0v 844.745n 0.0v 844.755n 0.0v 849.745n 0.0v 849.755n 0.0v 854.745n 0.0v 854.755n 0.0v 859.745n 0.0v 859.755n 1.0v 864.745n 1.0v 864.755n 1.0v 869.745n 1.0v 869.755n 1.0v 874.745n 1.0v 874.755n 1.0v 879.745n 1.0v 879.755n 1.0v 884.745n 1.0v 884.755n 1.0v 889.745n 1.0v 889.755n 1.0v 894.745n 1.0v 894.755n 1.0v 899.745n 1.0v 899.755n 1.0v 904.745n 1.0v 904.755n 0.0v 909.745n 0.0v 909.755n 0.0v 914.745n 0.0v 914.755n 0.0v 919.745n 0.0v 919.755n 1.0v 924.745n 1.0v 924.755n 1.0v 929.745n 1.0v 929.755n 1.0v 934.745n 1.0v 934.755n 0.0v 939.745n 0.0v 939.755n 0.0v 944.745n 0.0v 944.755n 0.0v 949.745n 0.0v 949.755n 0.0v 954.745n 0.0v 954.755n 1.0v 959.745n 1.0v 959.755n 1.0v 964.745n 1.0v 964.755n 1.0v 969.745n 1.0v 969.755n 0.0v 974.745n 0.0v 974.755n 0.0v 979.745n 0.0v 979.755n 0.0v 984.745n 0.0v 984.755n 0.0v 989.745n 0.0v 989.755n 0.0v 994.745n 0.0v 994.755n 0.0v 999.745n 0.0v 999.755n 0.0v 1004.745n 0.0v 1004.755n 0.0v 1009.745n 0.0v 1009.755n 0.0v 1014.745n 0.0v 1014.755n 0.0v 1019.745n 0.0v 1019.755n 0.0v 1024.745n 0.0v 1024.755n 0.0v )
* (time, data): [(0, 0), (5, 0), (10, 0), (15, 1), (20, 1), (25, 1), (30, 0), (35, 0), (40, 1), (45, 1), (50, 1), (55, 1), (60, 1), (65, 1), (70, 1), (75, 1), (80, 1), (85, 1), (90, 1), (95, 1), (100, 1), (105, 1), (110, 1), (115, 1), (120, 1), (125, 1), (130, 1), (135, 1), (140, 0), (145, 1), (150, 1), (155, 1), (160, 1), (165, 1), (170, 1), (175, 1), (180, 1), (185, 1), (190, 1), (195, 1), (200, 1), (205, 1), (210, 1), (215, 1), (220, 1), (225, 1), (230, 1), (235, 1), (240, 1), (245, 1), (250, 0), (255, 0), (260, 0), (265, 0), (270, 0), (275, 1), (280, 1), (285, 1), (290, 1), (295, 1), (300, 1), (305, 1), (310, 1), (315, 1), (320, 1), (325, 1), (330, 1), (335, 1), (340, 1), (345, 0), (350, 1), (355, 1), (360, 1), (365, 1), (370, 1), (375, 1), (380, 1), (385, 1), (390, 1), (395, 1), (400, 1), (405, 1), (410, 1), (415, 1), (420, 1), (425, 1), (430, 1), (435, 0), (440, 0), (445, 0), (450, 0), (455, 1), (460, 1), (465, 0), (470, 0), (475, 0), (480, 0), (485, 0), (490, 0), (495, 0), (500, 0), (505, 0), (510, 1), (515, 1), (520, 1), (525, 1), (530, 1), (535, 1), (540, 1), (545, 0), (550, 0), (555, 0), (560, 0), (565, 0), (570, 0), (575, 0), (580, 0), (585, 0), (590, 0), (595, 0), (600, 0), (605, 0), (610, 0), (615, 1), (620, 1), (625, 1), (630, 1), (635, 1), (640, 1), (645, 1), (650, 1), (655, 1), (660, 1), (665, 1), (670, 1), (675, 1), (680, 0), (685, 0), (690, 0), (695, 0), (700, 0), (705, 0), (710, 0), (715, 0), (720, 0), (725, 0), (730, 0), (735, 1), (740, 1), (745, 1), (750, 1), (755, 1), (760, 1), (765, 1), (770, 0), (775, 0), (780, 0), (785, 0), (790, 0), (795, 1), (800, 1), (805, 1), (810, 1), (815, 1), (820, 0), (825, 0), (830, 0), (835, 0), (840, 0), (845, 0), (850, 1), (855, 1), (860, 0), (865, 0), (870, 0), (875, 0), (880, 0), (885, 0), (890, 0), (895, 0), (900, 0), (905, 1), (910, 1), (915, 1), (920, 1), (925, 1), (930, 1), (935, 0), (940, 0), (945, 0), (950, 0), (955, 1), (960, 0), (965, 0), (970, 1), (975, 1), (980, 1), (985, 1), (990, 1), (995, 1), (1000, 1), (1005, 1), (1010, 1), (1015, 1), (1020, 1), (1025, 1)]
Vdin0_6  din0_6  0 PWL (0n 0.0v 4.745n 0.0v 4.755n 0.0v 9.745n 0.0v 9.755n 0.0v 14.745n 0.0v 14.755n 1.0v 19.745n 1.0v 19.755n 1.0v 24.745n 1.0v 24.755n 1.0v 29.745n 1.0v 29.755n 0.0v 34.745n 0.0v 34.755n 0.0v 39.745n 0.0v 39.755n 1.0v 44.745n 1.0v 44.755n 1.0v 49.745n 1.0v 49.755n 1.0v 54.745n 1.0v 54.755n 1.0v 59.745n 1.0v 59.755n 1.0v 64.745n 1.0v 64.755n 1.0v 69.745n 1.0v 69.755n 1.0v 74.745n 1.0v 74.755n 1.0v 79.745n 1.0v 79.755n 1.0v 84.745n 1.0v 84.755n 1.0v 89.745n 1.0v 89.755n 1.0v 94.745n 1.0v 94.755n 1.0v 99.745n 1.0v 99.755n 1.0v 104.745n 1.0v 104.755n 1.0v 109.745n 1.0v 109.755n 1.0v 114.745n 1.0v 114.755n 1.0v 119.745n 1.0v 119.755n 1.0v 124.745n 1.0v 124.755n 1.0v 129.745n 1.0v 129.755n 1.0v 134.745n 1.0v 134.755n 1.0v 139.745n 1.0v 139.755n 0.0v 144.745n 0.0v 144.755n 1.0v 149.745n 1.0v 149.755n 1.0v 154.745n 1.0v 154.755n 1.0v 159.745n 1.0v 159.755n 1.0v 164.745n 1.0v 164.755n 1.0v 169.745n 1.0v 169.755n 1.0v 174.745n 1.0v 174.755n 1.0v 179.745n 1.0v 179.755n 1.0v 184.745n 1.0v 184.755n 1.0v 189.745n 1.0v 189.755n 1.0v 194.745n 1.0v 194.755n 1.0v 199.745n 1.0v 199.755n 1.0v 204.745n 1.0v 204.755n 1.0v 209.745n 1.0v 209.755n 1.0v 214.745n 1.0v 214.755n 1.0v 219.745n 1.0v 219.755n 1.0v 224.745n 1.0v 224.755n 1.0v 229.745n 1.0v 229.755n 1.0v 234.745n 1.0v 234.755n 1.0v 239.745n 1.0v 239.755n 1.0v 244.745n 1.0v 244.755n 1.0v 249.745n 1.0v 249.755n 0.0v 254.745n 0.0v 254.755n 0.0v 259.745n 0.0v 259.755n 0.0v 264.745n 0.0v 264.755n 0.0v 269.745n 0.0v 269.755n 0.0v 274.745n 0.0v 274.755n 1.0v 279.745n 1.0v 279.755n 1.0v 284.745n 1.0v 284.755n 1.0v 289.745n 1.0v 289.755n 1.0v 294.745n 1.0v 294.755n 1.0v 299.745n 1.0v 299.755n 1.0v 304.745n 1.0v 304.755n 1.0v 309.745n 1.0v 309.755n 1.0v 314.745n 1.0v 314.755n 1.0v 319.745n 1.0v 319.755n 1.0v 324.745n 1.0v 324.755n 1.0v 329.745n 1.0v 329.755n 1.0v 334.745n 1.0v 334.755n 1.0v 339.745n 1.0v 339.755n 1.0v 344.745n 1.0v 344.755n 0.0v 349.745n 0.0v 349.755n 1.0v 354.745n 1.0v 354.755n 1.0v 359.745n 1.0v 359.755n 1.0v 364.745n 1.0v 364.755n 1.0v 369.745n 1.0v 369.755n 1.0v 374.745n 1.0v 374.755n 1.0v 379.745n 1.0v 379.755n 1.0v 384.745n 1.0v 384.755n 1.0v 389.745n 1.0v 389.755n 1.0v 394.745n 1.0v 394.755n 1.0v 399.745n 1.0v 399.755n 1.0v 404.745n 1.0v 404.755n 1.0v 409.745n 1.0v 409.755n 1.0v 414.745n 1.0v 414.755n 1.0v 419.745n 1.0v 419.755n 1.0v 424.745n 1.0v 424.755n 1.0v 429.745n 1.0v 429.755n 1.0v 434.745n 1.0v 434.755n 0.0v 439.745n 0.0v 439.755n 0.0v 444.745n 0.0v 444.755n 0.0v 449.745n 0.0v 449.755n 0.0v 454.745n 0.0v 454.755n 1.0v 459.745n 1.0v 459.755n 1.0v 464.745n 1.0v 464.755n 0.0v 469.745n 0.0v 469.755n 0.0v 474.745n 0.0v 474.755n 0.0v 479.745n 0.0v 479.755n 0.0v 484.745n 0.0v 484.755n 0.0v 489.745n 0.0v 489.755n 0.0v 494.745n 0.0v 494.755n 0.0v 499.745n 0.0v 499.755n 0.0v 504.745n 0.0v 504.755n 0.0v 509.745n 0.0v 509.755n 1.0v 514.745n 1.0v 514.755n 1.0v 519.745n 1.0v 519.755n 1.0v 524.745n 1.0v 524.755n 1.0v 529.745n 1.0v 529.755n 1.0v 534.745n 1.0v 534.755n 1.0v 539.745n 1.0v 539.755n 1.0v 544.745n 1.0v 544.755n 0.0v 549.745n 0.0v 549.755n 0.0v 554.745n 0.0v 554.755n 0.0v 559.745n 0.0v 559.755n 0.0v 564.745n 0.0v 564.755n 0.0v 569.745n 0.0v 569.755n 0.0v 574.745n 0.0v 574.755n 0.0v 579.745n 0.0v 579.755n 0.0v 584.745n 0.0v 584.755n 0.0v 589.745n 0.0v 589.755n 0.0v 594.745n 0.0v 594.755n 0.0v 599.745n 0.0v 599.755n 0.0v 604.745n 0.0v 604.755n 0.0v 609.745n 0.0v 609.755n 0.0v 614.745n 0.0v 614.755n 1.0v 619.745n 1.0v 619.755n 1.0v 624.745n 1.0v 624.755n 1.0v 629.745n 1.0v 629.755n 1.0v 634.745n 1.0v 634.755n 1.0v 639.745n 1.0v 639.755n 1.0v 644.745n 1.0v 644.755n 1.0v 649.745n 1.0v 649.755n 1.0v 654.745n 1.0v 654.755n 1.0v 659.745n 1.0v 659.755n 1.0v 664.745n 1.0v 664.755n 1.0v 669.745n 1.0v 669.755n 1.0v 674.745n 1.0v 674.755n 1.0v 679.745n 1.0v 679.755n 0.0v 684.745n 0.0v 684.755n 0.0v 689.745n 0.0v 689.755n 0.0v 694.745n 0.0v 694.755n 0.0v 699.745n 0.0v 699.755n 0.0v 704.745n 0.0v 704.755n 0.0v 709.745n 0.0v 709.755n 0.0v 714.745n 0.0v 714.755n 0.0v 719.745n 0.0v 719.755n 0.0v 724.745n 0.0v 724.755n 0.0v 729.745n 0.0v 729.755n 0.0v 734.745n 0.0v 734.755n 1.0v 739.745n 1.0v 739.755n 1.0v 744.745n 1.0v 744.755n 1.0v 749.745n 1.0v 749.755n 1.0v 754.745n 1.0v 754.755n 1.0v 759.745n 1.0v 759.755n 1.0v 764.745n 1.0v 764.755n 1.0v 769.745n 1.0v 769.755n 0.0v 774.745n 0.0v 774.755n 0.0v 779.745n 0.0v 779.755n 0.0v 784.745n 0.0v 784.755n 0.0v 789.745n 0.0v 789.755n 0.0v 794.745n 0.0v 794.755n 1.0v 799.745n 1.0v 799.755n 1.0v 804.745n 1.0v 804.755n 1.0v 809.745n 1.0v 809.755n 1.0v 814.745n 1.0v 814.755n 1.0v 819.745n 1.0v 819.755n 0.0v 824.745n 0.0v 824.755n 0.0v 829.745n 0.0v 829.755n 0.0v 834.745n 0.0v 834.755n 0.0v 839.745n 0.0v 839.755n 0.0v 844.745n 0.0v 844.755n 0.0v 849.745n 0.0v 849.755n 1.0v 854.745n 1.0v 854.755n 1.0v 859.745n 1.0v 859.755n 0.0v 864.745n 0.0v 864.755n 0.0v 869.745n 0.0v 869.755n 0.0v 874.745n 0.0v 874.755n 0.0v 879.745n 0.0v 879.755n 0.0v 884.745n 0.0v 884.755n 0.0v 889.745n 0.0v 889.755n 0.0v 894.745n 0.0v 894.755n 0.0v 899.745n 0.0v 899.755n 0.0v 904.745n 0.0v 904.755n 1.0v 909.745n 1.0v 909.755n 1.0v 914.745n 1.0v 914.755n 1.0v 919.745n 1.0v 919.755n 1.0v 924.745n 1.0v 924.755n 1.0v 929.745n 1.0v 929.755n 1.0v 934.745n 1.0v 934.755n 0.0v 939.745n 0.0v 939.755n 0.0v 944.745n 0.0v 944.755n 0.0v 949.745n 0.0v 949.755n 0.0v 954.745n 0.0v 954.755n 1.0v 959.745n 1.0v 959.755n 0.0v 964.745n 0.0v 964.755n 0.0v 969.745n 0.0v 969.755n 1.0v 974.745n 1.0v 974.755n 1.0v 979.745n 1.0v 979.755n 1.0v 984.745n 1.0v 984.755n 1.0v 989.745n 1.0v 989.755n 1.0v 994.745n 1.0v 994.755n 1.0v 999.745n 1.0v 999.755n 1.0v 1004.745n 1.0v 1004.755n 1.0v 1009.745n 1.0v 1009.755n 1.0v 1014.745n 1.0v 1014.755n 1.0v 1019.745n 1.0v 1019.755n 1.0v 1024.745n 1.0v 1024.755n 1.0v )
* (time, data): [(0, 0), (5, 0), (10, 0), (15, 0), (20, 0), (25, 0), (30, 0), (35, 1), (40, 0), (45, 1), (50, 1), (55, 1), (60, 1), (65, 1), (70, 1), (75, 1), (80, 0), (85, 0), (90, 0), (95, 0), (100, 0), (105, 0), (110, 1), (115, 1), (120, 1), (125, 0), (130, 0), (135, 0), (140, 0), (145, 1), (150, 1), (155, 1), (160, 1), (165, 1), (170, 1), (175, 1), (180, 1), (185, 1), (190, 1), (195, 1), (200, 1), (205, 1), (210, 1), (215, 1), (220, 1), (225, 1), (230, 1), (235, 0), (240, 1), (245, 0), (250, 1), (255, 1), (260, 1), (265, 1), (270, 1), (275, 1), (280, 1), (285, 0), (290, 0), (295, 0), (300, 0), (305, 0), (310, 0), (315, 0), (320, 0), (325, 0), (330, 0), (335, 0), (340, 0), (345, 0), (350, 0), (355, 0), (360, 0), (365, 0), (370, 0), (375, 0), (380, 0), (385, 0), (390, 0), (395, 0), (400, 0), (405, 0), (410, 0), (415, 0), (420, 0), (425, 0), (430, 0), (435, 1), (440, 1), (445, 1), (450, 1), (455, 0), (460, 0), (465, 0), (470, 0), (475, 0), (480, 0), (485, 0), (490, 0), (495, 0), (500, 0), (505, 0), (510, 1), (515, 1), (520, 1), (525, 1), (530, 1), (535, 1), (540, 1), (545, 1), (550, 1), (555, 1), (560, 1), (565, 1), (570, 1), (575, 1), (580, 1), (585, 1), (590, 1), (595, 1), (600, 1), (605, 1), (610, 1), (615, 0), (620, 0), (625, 0), (630, 0), (635, 0), (640, 0), (645, 1), (650, 1), (655, 1), (660, 1), (665, 1), (670, 1), (675, 1), (680, 1), (685, 1), (690, 1), (695, 1), (700, 1), (705, 1), (710, 0), (715, 0), (720, 0), (725, 0), (730, 0), (735, 1), (740, 1), (745, 1), (750, 1), (755, 1), (760, 1), (765, 1), (770, 1), (775, 1), (780, 0), (785, 0), (790, 0), (795, 1), (800, 1), (805, 1), (810, 1), (815, 1), (820, 1), (825, 1), (830, 1), (835, 1), (840, 1), (845, 1), (850, 1), (855, 1), (860, 0), (865, 0), (870, 0), (875, 0), (880, 0), (885, 0), (890, 0), (895, 0), (900, 0), (905, 1), (910, 0), (915, 0), (920, 1), (925, 1), (930, 1), (935, 1), (940, 1), (945, 1), (950, 1), (955, 1), (960, 1), (965, 1), (970, 1), (975, 1), (980, 1), (985, 1), (990, 1), (995, 1), (1000, 1), (1005, 1), (1010, 1), (1015, 0), (1020, 0), (1025, 0)]
Vdin0_7  din0_7  0 PWL (0n 0.0v 4.745n 0.0v 4.755n 0.0v 9.745n 0.0v 9.755n 0.0v 14.745n 0.0v 14.755n 0.0v 19.745n 0.0v 19.755n 0.0v 24.745n 0.0v 24.755n 0.0v 29.745n 0.0v 29.755n 0.0v 34.745n 0.0v 34.755n 1.0v 39.745n 1.0v 39.755n 0.0v 44.745n 0.0v 44.755n 1.0v 49.745n 1.0v 49.755n 1.0v 54.745n 1.0v 54.755n 1.0v 59.745n 1.0v 59.755n 1.0v 64.745n 1.0v 64.755n 1.0v 69.745n 1.0v 69.755n 1.0v 74.745n 1.0v 74.755n 1.0v 79.745n 1.0v 79.755n 0.0v 84.745n 0.0v 84.755n 0.0v 89.745n 0.0v 89.755n 0.0v 94.745n 0.0v 94.755n 0.0v 99.745n 0.0v 99.755n 0.0v 104.745n 0.0v 104.755n 0.0v 109.745n 0.0v 109.755n 1.0v 114.745n 1.0v 114.755n 1.0v 119.745n 1.0v 119.755n 1.0v 124.745n 1.0v 124.755n 0.0v 129.745n 0.0v 129.755n 0.0v 134.745n 0.0v 134.755n 0.0v 139.745n 0.0v 139.755n 0.0v 144.745n 0.0v 144.755n 1.0v 149.745n 1.0v 149.755n 1.0v 154.745n 1.0v 154.755n 1.0v 159.745n 1.0v 159.755n 1.0v 164.745n 1.0v 164.755n 1.0v 169.745n 1.0v 169.755n 1.0v 174.745n 1.0v 174.755n 1.0v 179.745n 1.0v 179.755n 1.0v 184.745n 1.0v 184.755n 1.0v 189.745n 1.0v 189.755n 1.0v 194.745n 1.0v 194.755n 1.0v 199.745n 1.0v 199.755n 1.0v 204.745n 1.0v 204.755n 1.0v 209.745n 1.0v 209.755n 1.0v 214.745n 1.0v 214.755n 1.0v 219.745n 1.0v 219.755n 1.0v 224.745n 1.0v 224.755n 1.0v 229.745n 1.0v 229.755n 1.0v 234.745n 1.0v 234.755n 0.0v 239.745n 0.0v 239.755n 1.0v 244.745n 1.0v 244.755n 0.0v 249.745n 0.0v 249.755n 1.0v 254.745n 1.0v 254.755n 1.0v 259.745n 1.0v 259.755n 1.0v 264.745n 1.0v 264.755n 1.0v 269.745n 1.0v 269.755n 1.0v 274.745n 1.0v 274.755n 1.0v 279.745n 1.0v 279.755n 1.0v 284.745n 1.0v 284.755n 0.0v 289.745n 0.0v 289.755n 0.0v 294.745n 0.0v 294.755n 0.0v 299.745n 0.0v 299.755n 0.0v 304.745n 0.0v 304.755n 0.0v 309.745n 0.0v 309.755n 0.0v 314.745n 0.0v 314.755n 0.0v 319.745n 0.0v 319.755n 0.0v 324.745n 0.0v 324.755n 0.0v 329.745n 0.0v 329.755n 0.0v 334.745n 0.0v 334.755n 0.0v 339.745n 0.0v 339.755n 0.0v 344.745n 0.0v 344.755n 0.0v 349.745n 0.0v 349.755n 0.0v 354.745n 0.0v 354.755n 0.0v 359.745n 0.0v 359.755n 0.0v 364.745n 0.0v 364.755n 0.0v 369.745n 0.0v 369.755n 0.0v 374.745n 0.0v 374.755n 0.0v 379.745n 0.0v 379.755n 0.0v 384.745n 0.0v 384.755n 0.0v 389.745n 0.0v 389.755n 0.0v 394.745n 0.0v 394.755n 0.0v 399.745n 0.0v 399.755n 0.0v 404.745n 0.0v 404.755n 0.0v 409.745n 0.0v 409.755n 0.0v 414.745n 0.0v 414.755n 0.0v 419.745n 0.0v 419.755n 0.0v 424.745n 0.0v 424.755n 0.0v 429.745n 0.0v 429.755n 0.0v 434.745n 0.0v 434.755n 1.0v 439.745n 1.0v 439.755n 1.0v 444.745n 1.0v 444.755n 1.0v 449.745n 1.0v 449.755n 1.0v 454.745n 1.0v 454.755n 0.0v 459.745n 0.0v 459.755n 0.0v 464.745n 0.0v 464.755n 0.0v 469.745n 0.0v 469.755n 0.0v 474.745n 0.0v 474.755n 0.0v 479.745n 0.0v 479.755n 0.0v 484.745n 0.0v 484.755n 0.0v 489.745n 0.0v 489.755n 0.0v 494.745n 0.0v 494.755n 0.0v 499.745n 0.0v 499.755n 0.0v 504.745n 0.0v 504.755n 0.0v 509.745n 0.0v 509.755n 1.0v 514.745n 1.0v 514.755n 1.0v 519.745n 1.0v 519.755n 1.0v 524.745n 1.0v 524.755n 1.0v 529.745n 1.0v 529.755n 1.0v 534.745n 1.0v 534.755n 1.0v 539.745n 1.0v 539.755n 1.0v 544.745n 1.0v 544.755n 1.0v 549.745n 1.0v 549.755n 1.0v 554.745n 1.0v 554.755n 1.0v 559.745n 1.0v 559.755n 1.0v 564.745n 1.0v 564.755n 1.0v 569.745n 1.0v 569.755n 1.0v 574.745n 1.0v 574.755n 1.0v 579.745n 1.0v 579.755n 1.0v 584.745n 1.0v 584.755n 1.0v 589.745n 1.0v 589.755n 1.0v 594.745n 1.0v 594.755n 1.0v 599.745n 1.0v 599.755n 1.0v 604.745n 1.0v 604.755n 1.0v 609.745n 1.0v 609.755n 1.0v 614.745n 1.0v 614.755n 0.0v 619.745n 0.0v 619.755n 0.0v 624.745n 0.0v 624.755n 0.0v 629.745n 0.0v 629.755n 0.0v 634.745n 0.0v 634.755n 0.0v 639.745n 0.0v 639.755n 0.0v 644.745n 0.0v 644.755n 1.0v 649.745n 1.0v 649.755n 1.0v 654.745n 1.0v 654.755n 1.0v 659.745n 1.0v 659.755n 1.0v 664.745n 1.0v 664.755n 1.0v 669.745n 1.0v 669.755n 1.0v 674.745n 1.0v 674.755n 1.0v 679.745n 1.0v 679.755n 1.0v 684.745n 1.0v 684.755n 1.0v 689.745n 1.0v 689.755n 1.0v 694.745n 1.0v 694.755n 1.0v 699.745n 1.0v 699.755n 1.0v 704.745n 1.0v 704.755n 1.0v 709.745n 1.0v 709.755n 0.0v 714.745n 0.0v 714.755n 0.0v 719.745n 0.0v 719.755n 0.0v 724.745n 0.0v 724.755n 0.0v 729.745n 0.0v 729.755n 0.0v 734.745n 0.0v 734.755n 1.0v 739.745n 1.0v 739.755n 1.0v 744.745n 1.0v 744.755n 1.0v 749.745n 1.0v 749.755n 1.0v 754.745n 1.0v 754.755n 1.0v 759.745n 1.0v 759.755n 1.0v 764.745n 1.0v 764.755n 1.0v 769.745n 1.0v 769.755n 1.0v 774.745n 1.0v 774.755n 1.0v 779.745n 1.0v 779.755n 0.0v 784.745n 0.0v 784.755n 0.0v 789.745n 0.0v 789.755n 0.0v 794.745n 0.0v 794.755n 1.0v 799.745n 1.0v 799.755n 1.0v 804.745n 1.0v 804.755n 1.0v 809.745n 1.0v 809.755n 1.0v 814.745n 1.0v 814.755n 1.0v 819.745n 1.0v 819.755n 1.0v 824.745n 1.0v 824.755n 1.0v 829.745n 1.0v 829.755n 1.0v 834.745n 1.0v 834.755n 1.0v 839.745n 1.0v 839.755n 1.0v 844.745n 1.0v 844.755n 1.0v 849.745n 1.0v 849.755n 1.0v 854.745n 1.0v 854.755n 1.0v 859.745n 1.0v 859.755n 0.0v 864.745n 0.0v 864.755n 0.0v 869.745n 0.0v 869.755n 0.0v 874.745n 0.0v 874.755n 0.0v 879.745n 0.0v 879.755n 0.0v 884.745n 0.0v 884.755n 0.0v 889.745n 0.0v 889.755n 0.0v 894.745n 0.0v 894.755n 0.0v 899.745n 0.0v 899.755n 0.0v 904.745n 0.0v 904.755n 1.0v 909.745n 1.0v 909.755n 0.0v 914.745n 0.0v 914.755n 0.0v 919.745n 0.0v 919.755n 1.0v 924.745n 1.0v 924.755n 1.0v 929.745n 1.0v 929.755n 1.0v 934.745n 1.0v 934.755n 1.0v 939.745n 1.0v 939.755n 1.0v 944.745n 1.0v 944.755n 1.0v 949.745n 1.0v 949.755n 1.0v 954.745n 1.0v 954.755n 1.0v 959.745n 1.0v 959.755n 1.0v 964.745n 1.0v 964.755n 1.0v 969.745n 1.0v 969.755n 1.0v 974.745n 1.0v 974.755n 1.0v 979.745n 1.0v 979.755n 1.0v 984.745n 1.0v 984.755n 1.0v 989.745n 1.0v 989.755n 1.0v 994.745n 1.0v 994.755n 1.0v 999.745n 1.0v 999.755n 1.0v 1004.745n 1.0v 1004.755n 1.0v 1009.745n 1.0v 1009.755n 1.0v 1014.745n 1.0v 1014.755n 0.0v 1019.745n 0.0v 1019.755n 0.0v 1024.745n 0.0v 1024.755n 0.0v )
* (time, data): [(0, 0), (5, 0), (10, 0), (15, 0), (20, 0), (25, 0), (30, 1), (35, 1), (40, 0), (45, 0), (50, 0), (55, 0), (60, 0), (65, 1), (70, 1), (75, 1), (80, 0), (85, 0), (90, 0), (95, 0), (100, 0), (105, 0), (110, 0), (115, 0), (120, 0), (125, 0), (130, 0), (135, 0), (140, 0), (145, 0), (150, 0), (155, 0), (160, 0), (165, 0), (170, 0), (175, 0), (180, 0), (185, 0), (190, 0), (195, 0), (200, 0), (205, 0), (210, 0), (215, 0), (220, 0), (225, 0), (230, 1), (235, 0), (240, 1), (245, 1), (250, 0), (255, 0), (260, 0), (265, 0), (270, 0), (275, 1), (280, 1), (285, 0), (290, 0), (295, 0), (300, 0), (305, 0), (310, 0), (315, 0), (320, 0), (325, 0), (330, 0), (335, 0), (340, 1), (345, 1), (350, 1), (355, 1), (360, 1), (365, 1), (370, 1), (375, 1), (380, 1), (385, 1), (390, 1), (395, 1), (400, 1), (405, 1), (410, 1), (415, 1), (420, 1), (425, 1), (430, 1), (435, 1), (440, 1), (445, 1), (450, 1), (455, 1), (460, 1), (465, 1), (470, 1), (475, 1), (480, 1), (485, 1), (490, 1), (495, 1), (500, 1), (505, 1), (510, 1), (515, 1), (520, 1), (525, 1), (530, 1), (535, 1), (540, 1), (545, 1), (550, 1), (555, 1), (560, 1), (565, 1), (570, 1), (575, 1), (580, 1), (585, 1), (590, 1), (595, 1), (600, 1), (605, 1), (610, 1), (615, 0), (620, 0), (625, 0), (630, 0), (635, 0), (640, 0), (645, 0), (650, 0), (655, 0), (660, 0), (665, 0), (670, 0), (675, 0), (680, 0), (685, 0), (690, 0), (695, 0), (700, 0), (705, 0), (710, 1), (715, 1), (720, 0), (725, 0), (730, 0), (735, 0), (740, 0), (745, 0), (750, 0), (755, 0), (760, 0), (765, 0), (770, 1), (775, 1), (780, 0), (785, 0), (790, 0), (795, 1), (800, 1), (805, 1), (810, 1), (815, 1), (820, 0), (825, 0), (830, 0), (835, 0), (840, 0), (845, 0), (850, 1), (855, 1), (860, 0), (865, 0), (870, 0), (875, 0), (880, 0), (885, 0), (890, 0), (895, 0), (900, 0), (905, 0), (910, 0), (915, 0), (920, 1), (925, 1), (930, 1), (935, 0), (940, 0), (945, 0), (950, 0), (955, 1), (960, 1), (965, 1), (970, 0), (975, 0), (980, 0), (985, 0), (990, 0), (995, 0), (1000, 0), (1005, 0), (1010, 0), (1015, 0), (1020, 0), (1025, 0)]
Vdin0_8  din0_8  0 PWL (0n 0.0v 4.745n 0.0v 4.755n 0.0v 9.745n 0.0v 9.755n 0.0v 14.745n 0.0v 14.755n 0.0v 19.745n 0.0v 19.755n 0.0v 24.745n 0.0v 24.755n 0.0v 29.745n 0.0v 29.755n 1.0v 34.745n 1.0v 34.755n 1.0v 39.745n 1.0v 39.755n 0.0v 44.745n 0.0v 44.755n 0.0v 49.745n 0.0v 49.755n 0.0v 54.745n 0.0v 54.755n 0.0v 59.745n 0.0v 59.755n 0.0v 64.745n 0.0v 64.755n 1.0v 69.745n 1.0v 69.755n 1.0v 74.745n 1.0v 74.755n 1.0v 79.745n 1.0v 79.755n 0.0v 84.745n 0.0v 84.755n 0.0v 89.745n 0.0v 89.755n 0.0v 94.745n 0.0v 94.755n 0.0v 99.745n 0.0v 99.755n 0.0v 104.745n 0.0v 104.755n 0.0v 109.745n 0.0v 109.755n 0.0v 114.745n 0.0v 114.755n 0.0v 119.745n 0.0v 119.755n 0.0v 124.745n 0.0v 124.755n 0.0v 129.745n 0.0v 129.755n 0.0v 134.745n 0.0v 134.755n 0.0v 139.745n 0.0v 139.755n 0.0v 144.745n 0.0v 144.755n 0.0v 149.745n 0.0v 149.755n 0.0v 154.745n 0.0v 154.755n 0.0v 159.745n 0.0v 159.755n 0.0v 164.745n 0.0v 164.755n 0.0v 169.745n 0.0v 169.755n 0.0v 174.745n 0.0v 174.755n 0.0v 179.745n 0.0v 179.755n 0.0v 184.745n 0.0v 184.755n 0.0v 189.745n 0.0v 189.755n 0.0v 194.745n 0.0v 194.755n 0.0v 199.745n 0.0v 199.755n 0.0v 204.745n 0.0v 204.755n 0.0v 209.745n 0.0v 209.755n 0.0v 214.745n 0.0v 214.755n 0.0v 219.745n 0.0v 219.755n 0.0v 224.745n 0.0v 224.755n 0.0v 229.745n 0.0v 229.755n 1.0v 234.745n 1.0v 234.755n 0.0v 239.745n 0.0v 239.755n 1.0v 244.745n 1.0v 244.755n 1.0v 249.745n 1.0v 249.755n 0.0v 254.745n 0.0v 254.755n 0.0v 259.745n 0.0v 259.755n 0.0v 264.745n 0.0v 264.755n 0.0v 269.745n 0.0v 269.755n 0.0v 274.745n 0.0v 274.755n 1.0v 279.745n 1.0v 279.755n 1.0v 284.745n 1.0v 284.755n 0.0v 289.745n 0.0v 289.755n 0.0v 294.745n 0.0v 294.755n 0.0v 299.745n 0.0v 299.755n 0.0v 304.745n 0.0v 304.755n 0.0v 309.745n 0.0v 309.755n 0.0v 314.745n 0.0v 314.755n 0.0v 319.745n 0.0v 319.755n 0.0v 324.745n 0.0v 324.755n 0.0v 329.745n 0.0v 329.755n 0.0v 334.745n 0.0v 334.755n 0.0v 339.745n 0.0v 339.755n 1.0v 344.745n 1.0v 344.755n 1.0v 349.745n 1.0v 349.755n 1.0v 354.745n 1.0v 354.755n 1.0v 359.745n 1.0v 359.755n 1.0v 364.745n 1.0v 364.755n 1.0v 369.745n 1.0v 369.755n 1.0v 374.745n 1.0v 374.755n 1.0v 379.745n 1.0v 379.755n 1.0v 384.745n 1.0v 384.755n 1.0v 389.745n 1.0v 389.755n 1.0v 394.745n 1.0v 394.755n 1.0v 399.745n 1.0v 399.755n 1.0v 404.745n 1.0v 404.755n 1.0v 409.745n 1.0v 409.755n 1.0v 414.745n 1.0v 414.755n 1.0v 419.745n 1.0v 419.755n 1.0v 424.745n 1.0v 424.755n 1.0v 429.745n 1.0v 429.755n 1.0v 434.745n 1.0v 434.755n 1.0v 439.745n 1.0v 439.755n 1.0v 444.745n 1.0v 444.755n 1.0v 449.745n 1.0v 449.755n 1.0v 454.745n 1.0v 454.755n 1.0v 459.745n 1.0v 459.755n 1.0v 464.745n 1.0v 464.755n 1.0v 469.745n 1.0v 469.755n 1.0v 474.745n 1.0v 474.755n 1.0v 479.745n 1.0v 479.755n 1.0v 484.745n 1.0v 484.755n 1.0v 489.745n 1.0v 489.755n 1.0v 494.745n 1.0v 494.755n 1.0v 499.745n 1.0v 499.755n 1.0v 504.745n 1.0v 504.755n 1.0v 509.745n 1.0v 509.755n 1.0v 514.745n 1.0v 514.755n 1.0v 519.745n 1.0v 519.755n 1.0v 524.745n 1.0v 524.755n 1.0v 529.745n 1.0v 529.755n 1.0v 534.745n 1.0v 534.755n 1.0v 539.745n 1.0v 539.755n 1.0v 544.745n 1.0v 544.755n 1.0v 549.745n 1.0v 549.755n 1.0v 554.745n 1.0v 554.755n 1.0v 559.745n 1.0v 559.755n 1.0v 564.745n 1.0v 564.755n 1.0v 569.745n 1.0v 569.755n 1.0v 574.745n 1.0v 574.755n 1.0v 579.745n 1.0v 579.755n 1.0v 584.745n 1.0v 584.755n 1.0v 589.745n 1.0v 589.755n 1.0v 594.745n 1.0v 594.755n 1.0v 599.745n 1.0v 599.755n 1.0v 604.745n 1.0v 604.755n 1.0v 609.745n 1.0v 609.755n 1.0v 614.745n 1.0v 614.755n 0.0v 619.745n 0.0v 619.755n 0.0v 624.745n 0.0v 624.755n 0.0v 629.745n 0.0v 629.755n 0.0v 634.745n 0.0v 634.755n 0.0v 639.745n 0.0v 639.755n 0.0v 644.745n 0.0v 644.755n 0.0v 649.745n 0.0v 649.755n 0.0v 654.745n 0.0v 654.755n 0.0v 659.745n 0.0v 659.755n 0.0v 664.745n 0.0v 664.755n 0.0v 669.745n 0.0v 669.755n 0.0v 674.745n 0.0v 674.755n 0.0v 679.745n 0.0v 679.755n 0.0v 684.745n 0.0v 684.755n 0.0v 689.745n 0.0v 689.755n 0.0v 694.745n 0.0v 694.755n 0.0v 699.745n 0.0v 699.755n 0.0v 704.745n 0.0v 704.755n 0.0v 709.745n 0.0v 709.755n 1.0v 714.745n 1.0v 714.755n 1.0v 719.745n 1.0v 719.755n 0.0v 724.745n 0.0v 724.755n 0.0v 729.745n 0.0v 729.755n 0.0v 734.745n 0.0v 734.755n 0.0v 739.745n 0.0v 739.755n 0.0v 744.745n 0.0v 744.755n 0.0v 749.745n 0.0v 749.755n 0.0v 754.745n 0.0v 754.755n 0.0v 759.745n 0.0v 759.755n 0.0v 764.745n 0.0v 764.755n 0.0v 769.745n 0.0v 769.755n 1.0v 774.745n 1.0v 774.755n 1.0v 779.745n 1.0v 779.755n 0.0v 784.745n 0.0v 784.755n 0.0v 789.745n 0.0v 789.755n 0.0v 794.745n 0.0v 794.755n 1.0v 799.745n 1.0v 799.755n 1.0v 804.745n 1.0v 804.755n 1.0v 809.745n 1.0v 809.755n 1.0v 814.745n 1.0v 814.755n 1.0v 819.745n 1.0v 819.755n 0.0v 824.745n 0.0v 824.755n 0.0v 829.745n 0.0v 829.755n 0.0v 834.745n 0.0v 834.755n 0.0v 839.745n 0.0v 839.755n 0.0v 844.745n 0.0v 844.755n 0.0v 849.745n 0.0v 849.755n 1.0v 854.745n 1.0v 854.755n 1.0v 859.745n 1.0v 859.755n 0.0v 864.745n 0.0v 864.755n 0.0v 869.745n 0.0v 869.755n 0.0v 874.745n 0.0v 874.755n 0.0v 879.745n 0.0v 879.755n 0.0v 884.745n 0.0v 884.755n 0.0v 889.745n 0.0v 889.755n 0.0v 894.745n 0.0v 894.755n 0.0v 899.745n 0.0v 899.755n 0.0v 904.745n 0.0v 904.755n 0.0v 909.745n 0.0v 909.755n 0.0v 914.745n 0.0v 914.755n 0.0v 919.745n 0.0v 919.755n 1.0v 924.745n 1.0v 924.755n 1.0v 929.745n 1.0v 929.755n 1.0v 934.745n 1.0v 934.755n 0.0v 939.745n 0.0v 939.755n 0.0v 944.745n 0.0v 944.755n 0.0v 949.745n 0.0v 949.755n 0.0v 954.745n 0.0v 954.755n 1.0v 959.745n 1.0v 959.755n 1.0v 964.745n 1.0v 964.755n 1.0v 969.745n 1.0v 969.755n 0.0v 974.745n 0.0v 974.755n 0.0v 979.745n 0.0v 979.755n 0.0v 984.745n 0.0v 984.755n 0.0v 989.745n 0.0v 989.755n 0.0v 994.745n 0.0v 994.755n 0.0v 999.745n 0.0v 999.755n 0.0v 1004.745n 0.0v 1004.755n 0.0v 1009.745n 0.0v 1009.755n 0.0v 1014.745n 0.0v 1014.755n 0.0v 1019.745n 0.0v 1019.755n 0.0v 1024.745n 0.0v 1024.755n 0.0v )
* (time, data): [(0, 0), (5, 0), (10, 1), (15, 1), (20, 1), (25, 1), (30, 1), (35, 1), (40, 0), (45, 0), (50, 0), (55, 0), (60, 0), (65, 0), (70, 0), (75, 0), (80, 0), (85, 0), (90, 0), (95, 0), (100, 0), (105, 0), (110, 0), (115, 0), (120, 0), (125, 0), (130, 0), (135, 0), (140, 0), (145, 1), (150, 1), (155, 1), (160, 1), (165, 1), (170, 1), (175, 1), (180, 1), (185, 1), (190, 1), (195, 1), (200, 1), (205, 1), (210, 1), (215, 1), (220, 1), (225, 1), (230, 0), (235, 0), (240, 0), (245, 0), (250, 1), (255, 1), (260, 1), (265, 1), (270, 1), (275, 0), (280, 0), (285, 0), (290, 0), (295, 0), (300, 0), (305, 0), (310, 0), (315, 0), (320, 0), (325, 0), (330, 0), (335, 0), (340, 1), (345, 1), (350, 0), (355, 0), (360, 0), (365, 0), (370, 0), (375, 0), (380, 0), (385, 0), (390, 0), (395, 0), (400, 0), (405, 0), (410, 0), (415, 0), (420, 0), (425, 0), (430, 0), (435, 1), (440, 1), (445, 1), (450, 1), (455, 0), (460, 0), (465, 1), (470, 1), (475, 1), (480, 1), (485, 1), (490, 1), (495, 1), (500, 1), (505, 1), (510, 0), (515, 0), (520, 0), (525, 0), (530, 0), (535, 0), (540, 0), (545, 0), (550, 0), (555, 0), (560, 0), (565, 0), (570, 0), (575, 0), (580, 0), (585, 0), (590, 0), (595, 0), (600, 0), (605, 0), (610, 0), (615, 1), (620, 1), (625, 0), (630, 0), (635, 0), (640, 0), (645, 0), (650, 0), (655, 0), (660, 0), (665, 0), (670, 0), (675, 0), (680, 1), (685, 1), (690, 1), (695, 1), (700, 1), (705, 1), (710, 1), (715, 1), (720, 0), (725, 0), (730, 0), (735, 1), (740, 1), (745, 1), (750, 1), (755, 1), (760, 1), (765, 1), (770, 1), (775, 1), (780, 0), (785, 0), (790, 0), (795, 1), (800, 1), (805, 1), (810, 1), (815, 1), (820, 1), (825, 1), (830, 1), (835, 1), (840, 1), (845, 1), (850, 1), (855, 1), (860, 0), (865, 0), (870, 0), (875, 0), (880, 0), (885, 0), (890, 0), (895, 0), (900, 0), (905, 1), (910, 1), (915, 1), (920, 0), (925, 0), (930, 0), (935, 1), (940, 1), (945, 1), (950, 1), (955, 0), (960, 1), (965, 1), (970, 1), (975, 1), (980, 1), (985, 1), (990, 1), (995, 1), (1000, 1), (1005, 1), (1010, 1), (1015, 0), (1020, 0), (1025, 0)]
Vdin0_9  din0_9  0 PWL (0n 0.0v 4.745n 0.0v 4.755n 0.0v 9.745n 0.0v 9.755n 1.0v 14.745n 1.0v 14.755n 1.0v 19.745n 1.0v 19.755n 1.0v 24.745n 1.0v 24.755n 1.0v 29.745n 1.0v 29.755n 1.0v 34.745n 1.0v 34.755n 1.0v 39.745n 1.0v 39.755n 0.0v 44.745n 0.0v 44.755n 0.0v 49.745n 0.0v 49.755n 0.0v 54.745n 0.0v 54.755n 0.0v 59.745n 0.0v 59.755n 0.0v 64.745n 0.0v 64.755n 0.0v 69.745n 0.0v 69.755n 0.0v 74.745n 0.0v 74.755n 0.0v 79.745n 0.0v 79.755n 0.0v 84.745n 0.0v 84.755n 0.0v 89.745n 0.0v 89.755n 0.0v 94.745n 0.0v 94.755n 0.0v 99.745n 0.0v 99.755n 0.0v 104.745n 0.0v 104.755n 0.0v 109.745n 0.0v 109.755n 0.0v 114.745n 0.0v 114.755n 0.0v 119.745n 0.0v 119.755n 0.0v 124.745n 0.0v 124.755n 0.0v 129.745n 0.0v 129.755n 0.0v 134.745n 0.0v 134.755n 0.0v 139.745n 0.0v 139.755n 0.0v 144.745n 0.0v 144.755n 1.0v 149.745n 1.0v 149.755n 1.0v 154.745n 1.0v 154.755n 1.0v 159.745n 1.0v 159.755n 1.0v 164.745n 1.0v 164.755n 1.0v 169.745n 1.0v 169.755n 1.0v 174.745n 1.0v 174.755n 1.0v 179.745n 1.0v 179.755n 1.0v 184.745n 1.0v 184.755n 1.0v 189.745n 1.0v 189.755n 1.0v 194.745n 1.0v 194.755n 1.0v 199.745n 1.0v 199.755n 1.0v 204.745n 1.0v 204.755n 1.0v 209.745n 1.0v 209.755n 1.0v 214.745n 1.0v 214.755n 1.0v 219.745n 1.0v 219.755n 1.0v 224.745n 1.0v 224.755n 1.0v 229.745n 1.0v 229.755n 0.0v 234.745n 0.0v 234.755n 0.0v 239.745n 0.0v 239.755n 0.0v 244.745n 0.0v 244.755n 0.0v 249.745n 0.0v 249.755n 1.0v 254.745n 1.0v 254.755n 1.0v 259.745n 1.0v 259.755n 1.0v 264.745n 1.0v 264.755n 1.0v 269.745n 1.0v 269.755n 1.0v 274.745n 1.0v 274.755n 0.0v 279.745n 0.0v 279.755n 0.0v 284.745n 0.0v 284.755n 0.0v 289.745n 0.0v 289.755n 0.0v 294.745n 0.0v 294.755n 0.0v 299.745n 0.0v 299.755n 0.0v 304.745n 0.0v 304.755n 0.0v 309.745n 0.0v 309.755n 0.0v 314.745n 0.0v 314.755n 0.0v 319.745n 0.0v 319.755n 0.0v 324.745n 0.0v 324.755n 0.0v 329.745n 0.0v 329.755n 0.0v 334.745n 0.0v 334.755n 0.0v 339.745n 0.0v 339.755n 1.0v 344.745n 1.0v 344.755n 1.0v 349.745n 1.0v 349.755n 0.0v 354.745n 0.0v 354.755n 0.0v 359.745n 0.0v 359.755n 0.0v 364.745n 0.0v 364.755n 0.0v 369.745n 0.0v 369.755n 0.0v 374.745n 0.0v 374.755n 0.0v 379.745n 0.0v 379.755n 0.0v 384.745n 0.0v 384.755n 0.0v 389.745n 0.0v 389.755n 0.0v 394.745n 0.0v 394.755n 0.0v 399.745n 0.0v 399.755n 0.0v 404.745n 0.0v 404.755n 0.0v 409.745n 0.0v 409.755n 0.0v 414.745n 0.0v 414.755n 0.0v 419.745n 0.0v 419.755n 0.0v 424.745n 0.0v 424.755n 0.0v 429.745n 0.0v 429.755n 0.0v 434.745n 0.0v 434.755n 1.0v 439.745n 1.0v 439.755n 1.0v 444.745n 1.0v 444.755n 1.0v 449.745n 1.0v 449.755n 1.0v 454.745n 1.0v 454.755n 0.0v 459.745n 0.0v 459.755n 0.0v 464.745n 0.0v 464.755n 1.0v 469.745n 1.0v 469.755n 1.0v 474.745n 1.0v 474.755n 1.0v 479.745n 1.0v 479.755n 1.0v 484.745n 1.0v 484.755n 1.0v 489.745n 1.0v 489.755n 1.0v 494.745n 1.0v 494.755n 1.0v 499.745n 1.0v 499.755n 1.0v 504.745n 1.0v 504.755n 1.0v 509.745n 1.0v 509.755n 0.0v 514.745n 0.0v 514.755n 0.0v 519.745n 0.0v 519.755n 0.0v 524.745n 0.0v 524.755n 0.0v 529.745n 0.0v 529.755n 0.0v 534.745n 0.0v 534.755n 0.0v 539.745n 0.0v 539.755n 0.0v 544.745n 0.0v 544.755n 0.0v 549.745n 0.0v 549.755n 0.0v 554.745n 0.0v 554.755n 0.0v 559.745n 0.0v 559.755n 0.0v 564.745n 0.0v 564.755n 0.0v 569.745n 0.0v 569.755n 0.0v 574.745n 0.0v 574.755n 0.0v 579.745n 0.0v 579.755n 0.0v 584.745n 0.0v 584.755n 0.0v 589.745n 0.0v 589.755n 0.0v 594.745n 0.0v 594.755n 0.0v 599.745n 0.0v 599.755n 0.0v 604.745n 0.0v 604.755n 0.0v 609.745n 0.0v 609.755n 0.0v 614.745n 0.0v 614.755n 1.0v 619.745n 1.0v 619.755n 1.0v 624.745n 1.0v 624.755n 0.0v 629.745n 0.0v 629.755n 0.0v 634.745n 0.0v 634.755n 0.0v 639.745n 0.0v 639.755n 0.0v 644.745n 0.0v 644.755n 0.0v 649.745n 0.0v 649.755n 0.0v 654.745n 0.0v 654.755n 0.0v 659.745n 0.0v 659.755n 0.0v 664.745n 0.0v 664.755n 0.0v 669.745n 0.0v 669.755n 0.0v 674.745n 0.0v 674.755n 0.0v 679.745n 0.0v 679.755n 1.0v 684.745n 1.0v 684.755n 1.0v 689.745n 1.0v 689.755n 1.0v 694.745n 1.0v 694.755n 1.0v 699.745n 1.0v 699.755n 1.0v 704.745n 1.0v 704.755n 1.0v 709.745n 1.0v 709.755n 1.0v 714.745n 1.0v 714.755n 1.0v 719.745n 1.0v 719.755n 0.0v 724.745n 0.0v 724.755n 0.0v 729.745n 0.0v 729.755n 0.0v 734.745n 0.0v 734.755n 1.0v 739.745n 1.0v 739.755n 1.0v 744.745n 1.0v 744.755n 1.0v 749.745n 1.0v 749.755n 1.0v 754.745n 1.0v 754.755n 1.0v 759.745n 1.0v 759.755n 1.0v 764.745n 1.0v 764.755n 1.0v 769.745n 1.0v 769.755n 1.0v 774.745n 1.0v 774.755n 1.0v 779.745n 1.0v 779.755n 0.0v 784.745n 0.0v 784.755n 0.0v 789.745n 0.0v 789.755n 0.0v 794.745n 0.0v 794.755n 1.0v 799.745n 1.0v 799.755n 1.0v 804.745n 1.0v 804.755n 1.0v 809.745n 1.0v 809.755n 1.0v 814.745n 1.0v 814.755n 1.0v 819.745n 1.0v 819.755n 1.0v 824.745n 1.0v 824.755n 1.0v 829.745n 1.0v 829.755n 1.0v 834.745n 1.0v 834.755n 1.0v 839.745n 1.0v 839.755n 1.0v 844.745n 1.0v 844.755n 1.0v 849.745n 1.0v 849.755n 1.0v 854.745n 1.0v 854.755n 1.0v 859.745n 1.0v 859.755n 0.0v 864.745n 0.0v 864.755n 0.0v 869.745n 0.0v 869.755n 0.0v 874.745n 0.0v 874.755n 0.0v 879.745n 0.0v 879.755n 0.0v 884.745n 0.0v 884.755n 0.0v 889.745n 0.0v 889.755n 0.0v 894.745n 0.0v 894.755n 0.0v 899.745n 0.0v 899.755n 0.0v 904.745n 0.0v 904.755n 1.0v 909.745n 1.0v 909.755n 1.0v 914.745n 1.0v 914.755n 1.0v 919.745n 1.0v 919.755n 0.0v 924.745n 0.0v 924.755n 0.0v 929.745n 0.0v 929.755n 0.0v 934.745n 0.0v 934.755n 1.0v 939.745n 1.0v 939.755n 1.0v 944.745n 1.0v 944.755n 1.0v 949.745n 1.0v 949.755n 1.0v 954.745n 1.0v 954.755n 0.0v 959.745n 0.0v 959.755n 1.0v 964.745n 1.0v 964.755n 1.0v 969.745n 1.0v 969.755n 1.0v 974.745n 1.0v 974.755n 1.0v 979.745n 1.0v 979.755n 1.0v 984.745n 1.0v 984.755n 1.0v 989.745n 1.0v 989.755n 1.0v 994.745n 1.0v 994.755n 1.0v 999.745n 1.0v 999.755n 1.0v 1004.745n 1.0v 1004.755n 1.0v 1009.745n 1.0v 1009.755n 1.0v 1014.745n 1.0v 1014.755n 0.0v 1019.745n 0.0v 1019.755n 0.0v 1024.745n 0.0v 1024.755n 0.0v )
* (time, data): [(0, 0), (5, 1), (10, 0), (15, 0), (20, 0), (25, 0), (30, 1), (35, 0), (40, 1), (45, 0), (50, 0), (55, 0), (60, 0), (65, 0), (70, 0), (75, 0), (80, 1), (85, 1), (90, 1), (95, 1), (100, 1), (105, 1), (110, 0), (115, 0), (120, 0), (125, 0), (130, 0), (135, 0), (140, 1), (145, 0), (150, 0), (155, 0), (160, 0), (165, 0), (170, 0), (175, 0), (180, 0), (185, 0), (190, 0), (195, 0), (200, 0), (205, 0), (210, 0), (215, 0), (220, 0), (225, 0), (230, 1), (235, 0), (240, 0), (245, 0), (250, 1), (255, 1), (260, 1), (265, 1), (270, 1), (275, 1), (280, 1), (285, 0), (290, 0), (295, 0), (300, 0), (305, 0), (310, 0), (315, 0), (320, 0), (325, 0), (330, 0), (335, 0), (340, 1), (345, 1), (350, 1), (355, 1), (360, 1), (365, 1), (370, 1), (375, 1), (380, 1), (385, 1), (390, 1), (395, 1), (400, 1), (405, 1), (410, 1), (415, 1), (420, 1), (425, 1), (430, 1), (435, 1), (440, 1), (445, 1), (450, 1), (455, 0), (460, 0), (465, 0), (470, 0), (475, 0), (480, 0), (485, 0), (490, 0), (495, 0), (500, 0), (505, 0), (510, 0), (515, 0), (520, 0), (525, 0), (530, 0), (535, 0), (540, 0), (545, 1), (550, 1), (555, 1), (560, 1), (565, 1), (570, 1), (575, 1), (580, 1), (585, 1), (590, 1), (595, 1), (600, 1), (605, 1), (610, 1), (615, 0), (620, 0), (625, 0), (630, 0), (635, 0), (640, 0), (645, 0), (650, 0), (655, 0), (660, 0), (665, 0), (670, 0), (675, 0), (680, 0), (685, 0), (690, 0), (695, 0), (700, 0), (705, 0), (710, 0), (715, 0), (720, 0), (725, 0), (730, 0), (735, 0), (740, 0), (745, 0), (750, 0), (755, 0), (760, 0), (765, 0), (770, 0), (775, 0), (780, 1), (785, 1), (790, 1), (795, 1), (800, 1), (805, 1), (810, 1), (815, 1), (820, 1), (825, 1), (830, 1), (835, 1), (840, 1), (845, 1), (850, 0), (855, 0), (860, 0), (865, 0), (870, 0), (875, 0), (880, 0), (885, 0), (890, 0), (895, 0), (900, 0), (905, 0), (910, 1), (915, 1), (920, 1), (925, 1), (930, 1), (935, 0), (940, 0), (945, 0), (950, 0), (955, 1), (960, 1), (965, 1), (970, 0), (975, 0), (980, 0), (985, 0), (990, 1), (995, 1), (1000, 1), (1005, 1), (1010, 1), (1015, 0), (1020, 0), (1025, 0)]
Vdin0_10  din0_10  0 PWL (0n 0.0v 4.745n 0.0v 4.755n 1.0v 9.745n 1.0v 9.755n 0.0v 14.745n 0.0v 14.755n 0.0v 19.745n 0.0v 19.755n 0.0v 24.745n 0.0v 24.755n 0.0v 29.745n 0.0v 29.755n 1.0v 34.745n 1.0v 34.755n 0.0v 39.745n 0.0v 39.755n 1.0v 44.745n 1.0v 44.755n 0.0v 49.745n 0.0v 49.755n 0.0v 54.745n 0.0v 54.755n 0.0v 59.745n 0.0v 59.755n 0.0v 64.745n 0.0v 64.755n 0.0v 69.745n 0.0v 69.755n 0.0v 74.745n 0.0v 74.755n 0.0v 79.745n 0.0v 79.755n 1.0v 84.745n 1.0v 84.755n 1.0v 89.745n 1.0v 89.755n 1.0v 94.745n 1.0v 94.755n 1.0v 99.745n 1.0v 99.755n 1.0v 104.745n 1.0v 104.755n 1.0v 109.745n 1.0v 109.755n 0.0v 114.745n 0.0v 114.755n 0.0v 119.745n 0.0v 119.755n 0.0v 124.745n 0.0v 124.755n 0.0v 129.745n 0.0v 129.755n 0.0v 134.745n 0.0v 134.755n 0.0v 139.745n 0.0v 139.755n 1.0v 144.745n 1.0v 144.755n 0.0v 149.745n 0.0v 149.755n 0.0v 154.745n 0.0v 154.755n 0.0v 159.745n 0.0v 159.755n 0.0v 164.745n 0.0v 164.755n 0.0v 169.745n 0.0v 169.755n 0.0v 174.745n 0.0v 174.755n 0.0v 179.745n 0.0v 179.755n 0.0v 184.745n 0.0v 184.755n 0.0v 189.745n 0.0v 189.755n 0.0v 194.745n 0.0v 194.755n 0.0v 199.745n 0.0v 199.755n 0.0v 204.745n 0.0v 204.755n 0.0v 209.745n 0.0v 209.755n 0.0v 214.745n 0.0v 214.755n 0.0v 219.745n 0.0v 219.755n 0.0v 224.745n 0.0v 224.755n 0.0v 229.745n 0.0v 229.755n 1.0v 234.745n 1.0v 234.755n 0.0v 239.745n 0.0v 239.755n 0.0v 244.745n 0.0v 244.755n 0.0v 249.745n 0.0v 249.755n 1.0v 254.745n 1.0v 254.755n 1.0v 259.745n 1.0v 259.755n 1.0v 264.745n 1.0v 264.755n 1.0v 269.745n 1.0v 269.755n 1.0v 274.745n 1.0v 274.755n 1.0v 279.745n 1.0v 279.755n 1.0v 284.745n 1.0v 284.755n 0.0v 289.745n 0.0v 289.755n 0.0v 294.745n 0.0v 294.755n 0.0v 299.745n 0.0v 299.755n 0.0v 304.745n 0.0v 304.755n 0.0v 309.745n 0.0v 309.755n 0.0v 314.745n 0.0v 314.755n 0.0v 319.745n 0.0v 319.755n 0.0v 324.745n 0.0v 324.755n 0.0v 329.745n 0.0v 329.755n 0.0v 334.745n 0.0v 334.755n 0.0v 339.745n 0.0v 339.755n 1.0v 344.745n 1.0v 344.755n 1.0v 349.745n 1.0v 349.755n 1.0v 354.745n 1.0v 354.755n 1.0v 359.745n 1.0v 359.755n 1.0v 364.745n 1.0v 364.755n 1.0v 369.745n 1.0v 369.755n 1.0v 374.745n 1.0v 374.755n 1.0v 379.745n 1.0v 379.755n 1.0v 384.745n 1.0v 384.755n 1.0v 389.745n 1.0v 389.755n 1.0v 394.745n 1.0v 394.755n 1.0v 399.745n 1.0v 399.755n 1.0v 404.745n 1.0v 404.755n 1.0v 409.745n 1.0v 409.755n 1.0v 414.745n 1.0v 414.755n 1.0v 419.745n 1.0v 419.755n 1.0v 424.745n 1.0v 424.755n 1.0v 429.745n 1.0v 429.755n 1.0v 434.745n 1.0v 434.755n 1.0v 439.745n 1.0v 439.755n 1.0v 444.745n 1.0v 444.755n 1.0v 449.745n 1.0v 449.755n 1.0v 454.745n 1.0v 454.755n 0.0v 459.745n 0.0v 459.755n 0.0v 464.745n 0.0v 464.755n 0.0v 469.745n 0.0v 469.755n 0.0v 474.745n 0.0v 474.755n 0.0v 479.745n 0.0v 479.755n 0.0v 484.745n 0.0v 484.755n 0.0v 489.745n 0.0v 489.755n 0.0v 494.745n 0.0v 494.755n 0.0v 499.745n 0.0v 499.755n 0.0v 504.745n 0.0v 504.755n 0.0v 509.745n 0.0v 509.755n 0.0v 514.745n 0.0v 514.755n 0.0v 519.745n 0.0v 519.755n 0.0v 524.745n 0.0v 524.755n 0.0v 529.745n 0.0v 529.755n 0.0v 534.745n 0.0v 534.755n 0.0v 539.745n 0.0v 539.755n 0.0v 544.745n 0.0v 544.755n 1.0v 549.745n 1.0v 549.755n 1.0v 554.745n 1.0v 554.755n 1.0v 559.745n 1.0v 559.755n 1.0v 564.745n 1.0v 564.755n 1.0v 569.745n 1.0v 569.755n 1.0v 574.745n 1.0v 574.755n 1.0v 579.745n 1.0v 579.755n 1.0v 584.745n 1.0v 584.755n 1.0v 589.745n 1.0v 589.755n 1.0v 594.745n 1.0v 594.755n 1.0v 599.745n 1.0v 599.755n 1.0v 604.745n 1.0v 604.755n 1.0v 609.745n 1.0v 609.755n 1.0v 614.745n 1.0v 614.755n 0.0v 619.745n 0.0v 619.755n 0.0v 624.745n 0.0v 624.755n 0.0v 629.745n 0.0v 629.755n 0.0v 634.745n 0.0v 634.755n 0.0v 639.745n 0.0v 639.755n 0.0v 644.745n 0.0v 644.755n 0.0v 649.745n 0.0v 649.755n 0.0v 654.745n 0.0v 654.755n 0.0v 659.745n 0.0v 659.755n 0.0v 664.745n 0.0v 664.755n 0.0v 669.745n 0.0v 669.755n 0.0v 674.745n 0.0v 674.755n 0.0v 679.745n 0.0v 679.755n 0.0v 684.745n 0.0v 684.755n 0.0v 689.745n 0.0v 689.755n 0.0v 694.745n 0.0v 694.755n 0.0v 699.745n 0.0v 699.755n 0.0v 704.745n 0.0v 704.755n 0.0v 709.745n 0.0v 709.755n 0.0v 714.745n 0.0v 714.755n 0.0v 719.745n 0.0v 719.755n 0.0v 724.745n 0.0v 724.755n 0.0v 729.745n 0.0v 729.755n 0.0v 734.745n 0.0v 734.755n 0.0v 739.745n 0.0v 739.755n 0.0v 744.745n 0.0v 744.755n 0.0v 749.745n 0.0v 749.755n 0.0v 754.745n 0.0v 754.755n 0.0v 759.745n 0.0v 759.755n 0.0v 764.745n 0.0v 764.755n 0.0v 769.745n 0.0v 769.755n 0.0v 774.745n 0.0v 774.755n 0.0v 779.745n 0.0v 779.755n 1.0v 784.745n 1.0v 784.755n 1.0v 789.745n 1.0v 789.755n 1.0v 794.745n 1.0v 794.755n 1.0v 799.745n 1.0v 799.755n 1.0v 804.745n 1.0v 804.755n 1.0v 809.745n 1.0v 809.755n 1.0v 814.745n 1.0v 814.755n 1.0v 819.745n 1.0v 819.755n 1.0v 824.745n 1.0v 824.755n 1.0v 829.745n 1.0v 829.755n 1.0v 834.745n 1.0v 834.755n 1.0v 839.745n 1.0v 839.755n 1.0v 844.745n 1.0v 844.755n 1.0v 849.745n 1.0v 849.755n 0.0v 854.745n 0.0v 854.755n 0.0v 859.745n 0.0v 859.755n 0.0v 864.745n 0.0v 864.755n 0.0v 869.745n 0.0v 869.755n 0.0v 874.745n 0.0v 874.755n 0.0v 879.745n 0.0v 879.755n 0.0v 884.745n 0.0v 884.755n 0.0v 889.745n 0.0v 889.755n 0.0v 894.745n 0.0v 894.755n 0.0v 899.745n 0.0v 899.755n 0.0v 904.745n 0.0v 904.755n 0.0v 909.745n 0.0v 909.755n 1.0v 914.745n 1.0v 914.755n 1.0v 919.745n 1.0v 919.755n 1.0v 924.745n 1.0v 924.755n 1.0v 929.745n 1.0v 929.755n 1.0v 934.745n 1.0v 934.755n 0.0v 939.745n 0.0v 939.755n 0.0v 944.745n 0.0v 944.755n 0.0v 949.745n 0.0v 949.755n 0.0v 954.745n 0.0v 954.755n 1.0v 959.745n 1.0v 959.755n 1.0v 964.745n 1.0v 964.755n 1.0v 969.745n 1.0v 969.755n 0.0v 974.745n 0.0v 974.755n 0.0v 979.745n 0.0v 979.755n 0.0v 984.745n 0.0v 984.755n 0.0v 989.745n 0.0v 989.755n 1.0v 994.745n 1.0v 994.755n 1.0v 999.745n 1.0v 999.755n 1.0v 1004.745n 1.0v 1004.755n 1.0v 1009.745n 1.0v 1009.755n 1.0v 1014.745n 1.0v 1014.755n 0.0v 1019.745n 0.0v 1019.755n 0.0v 1024.745n 0.0v 1024.755n 0.0v )
* (time, data): [(0, 0), (5, 1), (10, 0), (15, 0), (20, 0), (25, 0), (30, 0), (35, 1), (40, 1), (45, 0), (50, 0), (55, 0), (60, 0), (65, 1), (70, 1), (75, 1), (80, 0), (85, 0), (90, 0), (95, 0), (100, 0), (105, 0), (110, 1), (115, 1), (120, 1), (125, 0), (130, 0), (135, 0), (140, 1), (145, 1), (150, 1), (155, 1), (160, 1), (165, 1), (170, 1), (175, 1), (180, 1), (185, 1), (190, 1), (195, 1), (200, 1), (205, 1), (210, 1), (215, 1), (220, 1), (225, 1), (230, 1), (235, 1), (240, 0), (245, 0), (250, 0), (255, 0), (260, 0), (265, 0), (270, 0), (275, 0), (280, 0), (285, 1), (290, 1), (295, 1), (300, 1), (305, 1), (310, 1), (315, 1), (320, 1), (325, 1), (330, 1), (335, 1), (340, 0), (345, 1), (350, 1), (355, 1), (360, 1), (365, 1), (370, 1), (375, 1), (380, 1), (385, 1), (390, 1), (395, 1), (400, 1), (405, 1), (410, 1), (415, 1), (420, 1), (425, 1), (430, 1), (435, 1), (440, 1), (445, 1), (450, 1), (455, 1), (460, 1), (465, 1), (470, 1), (475, 1), (480, 1), (485, 1), (490, 1), (495, 1), (500, 1), (505, 1), (510, 0), (515, 0), (520, 0), (525, 0), (530, 0), (535, 0), (540, 0), (545, 1), (550, 1), (555, 1), (560, 1), (565, 1), (570, 1), (575, 1), (580, 1), (585, 1), (590, 1), (595, 1), (600, 1), (605, 1), (610, 1), (615, 1), (620, 1), (625, 0), (630, 0), (635, 0), (640, 0), (645, 0), (650, 0), (655, 0), (660, 0), (665, 0), (670, 0), (675, 0), (680, 1), (685, 1), (690, 1), (695, 1), (700, 1), (705, 1), (710, 0), (715, 0), (720, 1), (725, 1), (730, 1), (735, 1), (740, 1), (745, 1), (750, 1), (755, 1), (760, 1), (765, 1), (770, 1), (775, 1), (780, 1), (785, 1), (790, 1), (795, 0), (800, 0), (805, 0), (810, 0), (815, 0), (820, 0), (825, 0), (830, 0), (835, 0), (840, 0), (845, 0), (850, 1), (855, 1), (860, 1), (865, 1), (870, 1), (875, 1), (880, 1), (885, 1), (890, 1), (895, 1), (900, 1), (905, 0), (910, 1), (915, 1), (920, 1), (925, 1), (930, 1), (935, 1), (940, 1), (945, 1), (950, 1), (955, 0), (960, 0), (965, 0), (970, 1), (975, 1), (980, 1), (985, 1), (990, 1), (995, 1), (1000, 1), (1005, 1), (1010, 1), (1015, 1), (1020, 1), (1025, 1)]
Vdin0_11  din0_11  0 PWL (0n 0.0v 4.745n 0.0v 4.755n 1.0v 9.745n 1.0v 9.755n 0.0v 14.745n 0.0v 14.755n 0.0v 19.745n 0.0v 19.755n 0.0v 24.745n 0.0v 24.755n 0.0v 29.745n 0.0v 29.755n 0.0v 34.745n 0.0v 34.755n 1.0v 39.745n 1.0v 39.755n 1.0v 44.745n 1.0v 44.755n 0.0v 49.745n 0.0v 49.755n 0.0v 54.745n 0.0v 54.755n 0.0v 59.745n 0.0v 59.755n 0.0v 64.745n 0.0v 64.755n 1.0v 69.745n 1.0v 69.755n 1.0v 74.745n 1.0v 74.755n 1.0v 79.745n 1.0v 79.755n 0.0v 84.745n 0.0v 84.755n 0.0v 89.745n 0.0v 89.755n 0.0v 94.745n 0.0v 94.755n 0.0v 99.745n 0.0v 99.755n 0.0v 104.745n 0.0v 104.755n 0.0v 109.745n 0.0v 109.755n 1.0v 114.745n 1.0v 114.755n 1.0v 119.745n 1.0v 119.755n 1.0v 124.745n 1.0v 124.755n 0.0v 129.745n 0.0v 129.755n 0.0v 134.745n 0.0v 134.755n 0.0v 139.745n 0.0v 139.755n 1.0v 144.745n 1.0v 144.755n 1.0v 149.745n 1.0v 149.755n 1.0v 154.745n 1.0v 154.755n 1.0v 159.745n 1.0v 159.755n 1.0v 164.745n 1.0v 164.755n 1.0v 169.745n 1.0v 169.755n 1.0v 174.745n 1.0v 174.755n 1.0v 179.745n 1.0v 179.755n 1.0v 184.745n 1.0v 184.755n 1.0v 189.745n 1.0v 189.755n 1.0v 194.745n 1.0v 194.755n 1.0v 199.745n 1.0v 199.755n 1.0v 204.745n 1.0v 204.755n 1.0v 209.745n 1.0v 209.755n 1.0v 214.745n 1.0v 214.755n 1.0v 219.745n 1.0v 219.755n 1.0v 224.745n 1.0v 224.755n 1.0v 229.745n 1.0v 229.755n 1.0v 234.745n 1.0v 234.755n 1.0v 239.745n 1.0v 239.755n 0.0v 244.745n 0.0v 244.755n 0.0v 249.745n 0.0v 249.755n 0.0v 254.745n 0.0v 254.755n 0.0v 259.745n 0.0v 259.755n 0.0v 264.745n 0.0v 264.755n 0.0v 269.745n 0.0v 269.755n 0.0v 274.745n 0.0v 274.755n 0.0v 279.745n 0.0v 279.755n 0.0v 284.745n 0.0v 284.755n 1.0v 289.745n 1.0v 289.755n 1.0v 294.745n 1.0v 294.755n 1.0v 299.745n 1.0v 299.755n 1.0v 304.745n 1.0v 304.755n 1.0v 309.745n 1.0v 309.755n 1.0v 314.745n 1.0v 314.755n 1.0v 319.745n 1.0v 319.755n 1.0v 324.745n 1.0v 324.755n 1.0v 329.745n 1.0v 329.755n 1.0v 334.745n 1.0v 334.755n 1.0v 339.745n 1.0v 339.755n 0.0v 344.745n 0.0v 344.755n 1.0v 349.745n 1.0v 349.755n 1.0v 354.745n 1.0v 354.755n 1.0v 359.745n 1.0v 359.755n 1.0v 364.745n 1.0v 364.755n 1.0v 369.745n 1.0v 369.755n 1.0v 374.745n 1.0v 374.755n 1.0v 379.745n 1.0v 379.755n 1.0v 384.745n 1.0v 384.755n 1.0v 389.745n 1.0v 389.755n 1.0v 394.745n 1.0v 394.755n 1.0v 399.745n 1.0v 399.755n 1.0v 404.745n 1.0v 404.755n 1.0v 409.745n 1.0v 409.755n 1.0v 414.745n 1.0v 414.755n 1.0v 419.745n 1.0v 419.755n 1.0v 424.745n 1.0v 424.755n 1.0v 429.745n 1.0v 429.755n 1.0v 434.745n 1.0v 434.755n 1.0v 439.745n 1.0v 439.755n 1.0v 444.745n 1.0v 444.755n 1.0v 449.745n 1.0v 449.755n 1.0v 454.745n 1.0v 454.755n 1.0v 459.745n 1.0v 459.755n 1.0v 464.745n 1.0v 464.755n 1.0v 469.745n 1.0v 469.755n 1.0v 474.745n 1.0v 474.755n 1.0v 479.745n 1.0v 479.755n 1.0v 484.745n 1.0v 484.755n 1.0v 489.745n 1.0v 489.755n 1.0v 494.745n 1.0v 494.755n 1.0v 499.745n 1.0v 499.755n 1.0v 504.745n 1.0v 504.755n 1.0v 509.745n 1.0v 509.755n 0.0v 514.745n 0.0v 514.755n 0.0v 519.745n 0.0v 519.755n 0.0v 524.745n 0.0v 524.755n 0.0v 529.745n 0.0v 529.755n 0.0v 534.745n 0.0v 534.755n 0.0v 539.745n 0.0v 539.755n 0.0v 544.745n 0.0v 544.755n 1.0v 549.745n 1.0v 549.755n 1.0v 554.745n 1.0v 554.755n 1.0v 559.745n 1.0v 559.755n 1.0v 564.745n 1.0v 564.755n 1.0v 569.745n 1.0v 569.755n 1.0v 574.745n 1.0v 574.755n 1.0v 579.745n 1.0v 579.755n 1.0v 584.745n 1.0v 584.755n 1.0v 589.745n 1.0v 589.755n 1.0v 594.745n 1.0v 594.755n 1.0v 599.745n 1.0v 599.755n 1.0v 604.745n 1.0v 604.755n 1.0v 609.745n 1.0v 609.755n 1.0v 614.745n 1.0v 614.755n 1.0v 619.745n 1.0v 619.755n 1.0v 624.745n 1.0v 624.755n 0.0v 629.745n 0.0v 629.755n 0.0v 634.745n 0.0v 634.755n 0.0v 639.745n 0.0v 639.755n 0.0v 644.745n 0.0v 644.755n 0.0v 649.745n 0.0v 649.755n 0.0v 654.745n 0.0v 654.755n 0.0v 659.745n 0.0v 659.755n 0.0v 664.745n 0.0v 664.755n 0.0v 669.745n 0.0v 669.755n 0.0v 674.745n 0.0v 674.755n 0.0v 679.745n 0.0v 679.755n 1.0v 684.745n 1.0v 684.755n 1.0v 689.745n 1.0v 689.755n 1.0v 694.745n 1.0v 694.755n 1.0v 699.745n 1.0v 699.755n 1.0v 704.745n 1.0v 704.755n 1.0v 709.745n 1.0v 709.755n 0.0v 714.745n 0.0v 714.755n 0.0v 719.745n 0.0v 719.755n 1.0v 724.745n 1.0v 724.755n 1.0v 729.745n 1.0v 729.755n 1.0v 734.745n 1.0v 734.755n 1.0v 739.745n 1.0v 739.755n 1.0v 744.745n 1.0v 744.755n 1.0v 749.745n 1.0v 749.755n 1.0v 754.745n 1.0v 754.755n 1.0v 759.745n 1.0v 759.755n 1.0v 764.745n 1.0v 764.755n 1.0v 769.745n 1.0v 769.755n 1.0v 774.745n 1.0v 774.755n 1.0v 779.745n 1.0v 779.755n 1.0v 784.745n 1.0v 784.755n 1.0v 789.745n 1.0v 789.755n 1.0v 794.745n 1.0v 794.755n 0.0v 799.745n 0.0v 799.755n 0.0v 804.745n 0.0v 804.755n 0.0v 809.745n 0.0v 809.755n 0.0v 814.745n 0.0v 814.755n 0.0v 819.745n 0.0v 819.755n 0.0v 824.745n 0.0v 824.755n 0.0v 829.745n 0.0v 829.755n 0.0v 834.745n 0.0v 834.755n 0.0v 839.745n 0.0v 839.755n 0.0v 844.745n 0.0v 844.755n 0.0v 849.745n 0.0v 849.755n 1.0v 854.745n 1.0v 854.755n 1.0v 859.745n 1.0v 859.755n 1.0v 864.745n 1.0v 864.755n 1.0v 869.745n 1.0v 869.755n 1.0v 874.745n 1.0v 874.755n 1.0v 879.745n 1.0v 879.755n 1.0v 884.745n 1.0v 884.755n 1.0v 889.745n 1.0v 889.755n 1.0v 894.745n 1.0v 894.755n 1.0v 899.745n 1.0v 899.755n 1.0v 904.745n 1.0v 904.755n 0.0v 909.745n 0.0v 909.755n 1.0v 914.745n 1.0v 914.755n 1.0v 919.745n 1.0v 919.755n 1.0v 924.745n 1.0v 924.755n 1.0v 929.745n 1.0v 929.755n 1.0v 934.745n 1.0v 934.755n 1.0v 939.745n 1.0v 939.755n 1.0v 944.745n 1.0v 944.755n 1.0v 949.745n 1.0v 949.755n 1.0v 954.745n 1.0v 954.755n 0.0v 959.745n 0.0v 959.755n 0.0v 964.745n 0.0v 964.755n 0.0v 969.745n 0.0v 969.755n 1.0v 974.745n 1.0v 974.755n 1.0v 979.745n 1.0v 979.755n 1.0v 984.745n 1.0v 984.755n 1.0v 989.745n 1.0v 989.755n 1.0v 994.745n 1.0v 994.755n 1.0v 999.745n 1.0v 999.755n 1.0v 1004.745n 1.0v 1004.755n 1.0v 1009.745n 1.0v 1009.755n 1.0v 1014.745n 1.0v 1014.755n 1.0v 1019.745n 1.0v 1019.755n 1.0v 1024.745n 1.0v 1024.755n 1.0v )
* (time, data): [(0, 0), (5, 0), (10, 0), (15, 1), (20, 1), (25, 1), (30, 0), (35, 1), (40, 1), (45, 1), (50, 1), (55, 1), (60, 1), (65, 1), (70, 1), (75, 1), (80, 0), (85, 0), (90, 0), (95, 0), (100, 0), (105, 0), (110, 1), (115, 1), (120, 1), (125, 0), (130, 0), (135, 0), (140, 0), (145, 0), (150, 0), (155, 0), (160, 0), (165, 0), (170, 0), (175, 0), (180, 0), (185, 0), (190, 0), (195, 0), (200, 0), (205, 0), (210, 0), (215, 0), (220, 0), (225, 0), (230, 1), (235, 1), (240, 1), (245, 1), (250, 0), (255, 0), (260, 0), (265, 0), (270, 0), (275, 0), (280, 0), (285, 0), (290, 0), (295, 0), (300, 0), (305, 0), (310, 0), (315, 0), (320, 0), (325, 0), (330, 0), (335, 0), (340, 1), (345, 0), (350, 1), (355, 1), (360, 1), (365, 1), (370, 1), (375, 1), (380, 1), (385, 1), (390, 1), (395, 1), (400, 1), (405, 1), (410, 1), (415, 1), (420, 1), (425, 1), (430, 1), (435, 1), (440, 1), (445, 1), (450, 1), (455, 1), (460, 1), (465, 0), (470, 0), (475, 0), (480, 0), (485, 0), (490, 0), (495, 0), (500, 0), (505, 0), (510, 1), (515, 1), (520, 1), (525, 1), (530, 1), (535, 1), (540, 1), (545, 0), (550, 0), (555, 0), (560, 0), (565, 0), (570, 0), (575, 0), (580, 0), (585, 0), (590, 0), (595, 0), (600, 0), (605, 0), (610, 0), (615, 1), (620, 1), (625, 0), (630, 0), (635, 0), (640, 0), (645, 0), (650, 0), (655, 0), (660, 0), (665, 0), (670, 0), (675, 0), (680, 0), (685, 0), (690, 0), (695, 0), (700, 0), (705, 0), (710, 0), (715, 0), (720, 0), (725, 0), (730, 0), (735, 1), (740, 1), (745, 1), (750, 1), (755, 1), (760, 1), (765, 1), (770, 1), (775, 1), (780, 0), (785, 0), (790, 0), (795, 1), (800, 1), (805, 1), (810, 1), (815, 1), (820, 0), (825, 0), (830, 0), (835, 0), (840, 0), (845, 0), (850, 0), (855, 0), (860, 1), (865, 1), (870, 1), (875, 1), (880, 1), (885, 1), (890, 1), (895, 1), (900, 1), (905, 1), (910, 0), (915, 0), (920, 1), (925, 1), (930, 1), (935, 1), (940, 1), (945, 1), (950, 1), (955, 1), (960, 1), (965, 1), (970, 1), (975, 1), (980, 1), (985, 1), (990, 0), (995, 0), (1000, 0), (1005, 0), (1010, 0), (1015, 0), (1020, 0), (1025, 0)]
Vdin0_12  din0_12  0 PWL (0n 0.0v 4.745n 0.0v 4.755n 0.0v 9.745n 0.0v 9.755n 0.0v 14.745n 0.0v 14.755n 1.0v 19.745n 1.0v 19.755n 1.0v 24.745n 1.0v 24.755n 1.0v 29.745n 1.0v 29.755n 0.0v 34.745n 0.0v 34.755n 1.0v 39.745n 1.0v 39.755n 1.0v 44.745n 1.0v 44.755n 1.0v 49.745n 1.0v 49.755n 1.0v 54.745n 1.0v 54.755n 1.0v 59.745n 1.0v 59.755n 1.0v 64.745n 1.0v 64.755n 1.0v 69.745n 1.0v 69.755n 1.0v 74.745n 1.0v 74.755n 1.0v 79.745n 1.0v 79.755n 0.0v 84.745n 0.0v 84.755n 0.0v 89.745n 0.0v 89.755n 0.0v 94.745n 0.0v 94.755n 0.0v 99.745n 0.0v 99.755n 0.0v 104.745n 0.0v 104.755n 0.0v 109.745n 0.0v 109.755n 1.0v 114.745n 1.0v 114.755n 1.0v 119.745n 1.0v 119.755n 1.0v 124.745n 1.0v 124.755n 0.0v 129.745n 0.0v 129.755n 0.0v 134.745n 0.0v 134.755n 0.0v 139.745n 0.0v 139.755n 0.0v 144.745n 0.0v 144.755n 0.0v 149.745n 0.0v 149.755n 0.0v 154.745n 0.0v 154.755n 0.0v 159.745n 0.0v 159.755n 0.0v 164.745n 0.0v 164.755n 0.0v 169.745n 0.0v 169.755n 0.0v 174.745n 0.0v 174.755n 0.0v 179.745n 0.0v 179.755n 0.0v 184.745n 0.0v 184.755n 0.0v 189.745n 0.0v 189.755n 0.0v 194.745n 0.0v 194.755n 0.0v 199.745n 0.0v 199.755n 0.0v 204.745n 0.0v 204.755n 0.0v 209.745n 0.0v 209.755n 0.0v 214.745n 0.0v 214.755n 0.0v 219.745n 0.0v 219.755n 0.0v 224.745n 0.0v 224.755n 0.0v 229.745n 0.0v 229.755n 1.0v 234.745n 1.0v 234.755n 1.0v 239.745n 1.0v 239.755n 1.0v 244.745n 1.0v 244.755n 1.0v 249.745n 1.0v 249.755n 0.0v 254.745n 0.0v 254.755n 0.0v 259.745n 0.0v 259.755n 0.0v 264.745n 0.0v 264.755n 0.0v 269.745n 0.0v 269.755n 0.0v 274.745n 0.0v 274.755n 0.0v 279.745n 0.0v 279.755n 0.0v 284.745n 0.0v 284.755n 0.0v 289.745n 0.0v 289.755n 0.0v 294.745n 0.0v 294.755n 0.0v 299.745n 0.0v 299.755n 0.0v 304.745n 0.0v 304.755n 0.0v 309.745n 0.0v 309.755n 0.0v 314.745n 0.0v 314.755n 0.0v 319.745n 0.0v 319.755n 0.0v 324.745n 0.0v 324.755n 0.0v 329.745n 0.0v 329.755n 0.0v 334.745n 0.0v 334.755n 0.0v 339.745n 0.0v 339.755n 1.0v 344.745n 1.0v 344.755n 0.0v 349.745n 0.0v 349.755n 1.0v 354.745n 1.0v 354.755n 1.0v 359.745n 1.0v 359.755n 1.0v 364.745n 1.0v 364.755n 1.0v 369.745n 1.0v 369.755n 1.0v 374.745n 1.0v 374.755n 1.0v 379.745n 1.0v 379.755n 1.0v 384.745n 1.0v 384.755n 1.0v 389.745n 1.0v 389.755n 1.0v 394.745n 1.0v 394.755n 1.0v 399.745n 1.0v 399.755n 1.0v 404.745n 1.0v 404.755n 1.0v 409.745n 1.0v 409.755n 1.0v 414.745n 1.0v 414.755n 1.0v 419.745n 1.0v 419.755n 1.0v 424.745n 1.0v 424.755n 1.0v 429.745n 1.0v 429.755n 1.0v 434.745n 1.0v 434.755n 1.0v 439.745n 1.0v 439.755n 1.0v 444.745n 1.0v 444.755n 1.0v 449.745n 1.0v 449.755n 1.0v 454.745n 1.0v 454.755n 1.0v 459.745n 1.0v 459.755n 1.0v 464.745n 1.0v 464.755n 0.0v 469.745n 0.0v 469.755n 0.0v 474.745n 0.0v 474.755n 0.0v 479.745n 0.0v 479.755n 0.0v 484.745n 0.0v 484.755n 0.0v 489.745n 0.0v 489.755n 0.0v 494.745n 0.0v 494.755n 0.0v 499.745n 0.0v 499.755n 0.0v 504.745n 0.0v 504.755n 0.0v 509.745n 0.0v 509.755n 1.0v 514.745n 1.0v 514.755n 1.0v 519.745n 1.0v 519.755n 1.0v 524.745n 1.0v 524.755n 1.0v 529.745n 1.0v 529.755n 1.0v 534.745n 1.0v 534.755n 1.0v 539.745n 1.0v 539.755n 1.0v 544.745n 1.0v 544.755n 0.0v 549.745n 0.0v 549.755n 0.0v 554.745n 0.0v 554.755n 0.0v 559.745n 0.0v 559.755n 0.0v 564.745n 0.0v 564.755n 0.0v 569.745n 0.0v 569.755n 0.0v 574.745n 0.0v 574.755n 0.0v 579.745n 0.0v 579.755n 0.0v 584.745n 0.0v 584.755n 0.0v 589.745n 0.0v 589.755n 0.0v 594.745n 0.0v 594.755n 0.0v 599.745n 0.0v 599.755n 0.0v 604.745n 0.0v 604.755n 0.0v 609.745n 0.0v 609.755n 0.0v 614.745n 0.0v 614.755n 1.0v 619.745n 1.0v 619.755n 1.0v 624.745n 1.0v 624.755n 0.0v 629.745n 0.0v 629.755n 0.0v 634.745n 0.0v 634.755n 0.0v 639.745n 0.0v 639.755n 0.0v 644.745n 0.0v 644.755n 0.0v 649.745n 0.0v 649.755n 0.0v 654.745n 0.0v 654.755n 0.0v 659.745n 0.0v 659.755n 0.0v 664.745n 0.0v 664.755n 0.0v 669.745n 0.0v 669.755n 0.0v 674.745n 0.0v 674.755n 0.0v 679.745n 0.0v 679.755n 0.0v 684.745n 0.0v 684.755n 0.0v 689.745n 0.0v 689.755n 0.0v 694.745n 0.0v 694.755n 0.0v 699.745n 0.0v 699.755n 0.0v 704.745n 0.0v 704.755n 0.0v 709.745n 0.0v 709.755n 0.0v 714.745n 0.0v 714.755n 0.0v 719.745n 0.0v 719.755n 0.0v 724.745n 0.0v 724.755n 0.0v 729.745n 0.0v 729.755n 0.0v 734.745n 0.0v 734.755n 1.0v 739.745n 1.0v 739.755n 1.0v 744.745n 1.0v 744.755n 1.0v 749.745n 1.0v 749.755n 1.0v 754.745n 1.0v 754.755n 1.0v 759.745n 1.0v 759.755n 1.0v 764.745n 1.0v 764.755n 1.0v 769.745n 1.0v 769.755n 1.0v 774.745n 1.0v 774.755n 1.0v 779.745n 1.0v 779.755n 0.0v 784.745n 0.0v 784.755n 0.0v 789.745n 0.0v 789.755n 0.0v 794.745n 0.0v 794.755n 1.0v 799.745n 1.0v 799.755n 1.0v 804.745n 1.0v 804.755n 1.0v 809.745n 1.0v 809.755n 1.0v 814.745n 1.0v 814.755n 1.0v 819.745n 1.0v 819.755n 0.0v 824.745n 0.0v 824.755n 0.0v 829.745n 0.0v 829.755n 0.0v 834.745n 0.0v 834.755n 0.0v 839.745n 0.0v 839.755n 0.0v 844.745n 0.0v 844.755n 0.0v 849.745n 0.0v 849.755n 0.0v 854.745n 0.0v 854.755n 0.0v 859.745n 0.0v 859.755n 1.0v 864.745n 1.0v 864.755n 1.0v 869.745n 1.0v 869.755n 1.0v 874.745n 1.0v 874.755n 1.0v 879.745n 1.0v 879.755n 1.0v 884.745n 1.0v 884.755n 1.0v 889.745n 1.0v 889.755n 1.0v 894.745n 1.0v 894.755n 1.0v 899.745n 1.0v 899.755n 1.0v 904.745n 1.0v 904.755n 1.0v 909.745n 1.0v 909.755n 0.0v 914.745n 0.0v 914.755n 0.0v 919.745n 0.0v 919.755n 1.0v 924.745n 1.0v 924.755n 1.0v 929.745n 1.0v 929.755n 1.0v 934.745n 1.0v 934.755n 1.0v 939.745n 1.0v 939.755n 1.0v 944.745n 1.0v 944.755n 1.0v 949.745n 1.0v 949.755n 1.0v 954.745n 1.0v 954.755n 1.0v 959.745n 1.0v 959.755n 1.0v 964.745n 1.0v 964.755n 1.0v 969.745n 1.0v 969.755n 1.0v 974.745n 1.0v 974.755n 1.0v 979.745n 1.0v 979.755n 1.0v 984.745n 1.0v 984.755n 1.0v 989.745n 1.0v 989.755n 0.0v 994.745n 0.0v 994.755n 0.0v 999.745n 0.0v 999.755n 0.0v 1004.745n 0.0v 1004.755n 0.0v 1009.745n 0.0v 1009.755n 0.0v 1014.745n 0.0v 1014.755n 0.0v 1019.745n 0.0v 1019.755n 0.0v 1024.745n 0.0v 1024.755n 0.0v )
* (time, data): [(0, 0), (5, 1), (10, 0), (15, 0), (20, 0), (25, 0), (30, 0), (35, 1), (40, 1), (45, 0), (50, 0), (55, 0), (60, 0), (65, 0), (70, 0), (75, 0), (80, 1), (85, 1), (90, 1), (95, 1), (100, 1), (105, 1), (110, 1), (115, 1), (120, 1), (125, 1), (130, 1), (135, 1), (140, 1), (145, 1), (150, 1), (155, 1), (160, 1), (165, 1), (170, 1), (175, 1), (180, 1), (185, 1), (190, 1), (195, 1), (200, 1), (205, 1), (210, 1), (215, 1), (220, 1), (225, 1), (230, 0), (235, 1), (240, 1), (245, 1), (250, 0), (255, 0), (260, 0), (265, 0), (270, 0), (275, 0), (280, 0), (285, 0), (290, 0), (295, 0), (300, 1), (305, 1), (310, 1), (315, 1), (320, 1), (325, 1), (330, 1), (335, 1), (340, 0), (345, 0), (350, 1), (355, 1), (360, 1), (365, 1), (370, 1), (375, 1), (380, 1), (385, 1), (390, 1), (395, 1), (400, 1), (405, 1), (410, 1), (415, 1), (420, 1), (425, 1), (430, 1), (435, 0), (440, 0), (445, 0), (450, 0), (455, 0), (460, 0), (465, 1), (470, 1), (475, 1), (480, 1), (485, 1), (490, 1), (495, 1), (500, 1), (505, 1), (510, 1), (515, 1), (520, 1), (525, 1), (530, 1), (535, 1), (540, 1), (545, 0), (550, 0), (555, 0), (560, 0), (565, 0), (570, 0), (575, 0), (580, 0), (585, 0), (590, 0), (595, 0), (600, 0), (605, 0), (610, 0), (615, 1), (620, 1), (625, 0), (630, 0), (635, 0), (640, 0), (645, 1), (650, 1), (655, 1), (660, 1), (665, 1), (670, 1), (675, 1), (680, 1), (685, 1), (690, 1), (695, 1), (700, 1), (705, 1), (710, 1), (715, 1), (720, 1), (725, 1), (730, 1), (735, 0), (740, 0), (745, 0), (750, 0), (755, 0), (760, 0), (765, 0), (770, 0), (775, 0), (780, 1), (785, 1), (790, 1), (795, 0), (800, 0), (805, 0), (810, 0), (815, 0), (820, 1), (825, 1), (830, 1), (835, 1), (840, 1), (845, 1), (850, 1), (855, 1), (860, 1), (865, 1), (870, 1), (875, 1), (880, 1), (885, 1), (890, 1), (895, 1), (900, 1), (905, 0), (910, 1), (915, 1), (920, 1), (925, 1), (930, 1), (935, 0), (940, 0), (945, 0), (950, 0), (955, 1), (960, 0), (965, 0), (970, 0), (975, 0), (980, 0), (985, 0), (990, 0), (995, 0), (1000, 0), (1005, 0), (1010, 0), (1015, 1), (1020, 1), (1025, 1)]
Vdin0_13  din0_13  0 PWL (0n 0.0v 4.745n 0.0v 4.755n 1.0v 9.745n 1.0v 9.755n 0.0v 14.745n 0.0v 14.755n 0.0v 19.745n 0.0v 19.755n 0.0v 24.745n 0.0v 24.755n 0.0v 29.745n 0.0v 29.755n 0.0v 34.745n 0.0v 34.755n 1.0v 39.745n 1.0v 39.755n 1.0v 44.745n 1.0v 44.755n 0.0v 49.745n 0.0v 49.755n 0.0v 54.745n 0.0v 54.755n 0.0v 59.745n 0.0v 59.755n 0.0v 64.745n 0.0v 64.755n 0.0v 69.745n 0.0v 69.755n 0.0v 74.745n 0.0v 74.755n 0.0v 79.745n 0.0v 79.755n 1.0v 84.745n 1.0v 84.755n 1.0v 89.745n 1.0v 89.755n 1.0v 94.745n 1.0v 94.755n 1.0v 99.745n 1.0v 99.755n 1.0v 104.745n 1.0v 104.755n 1.0v 109.745n 1.0v 109.755n 1.0v 114.745n 1.0v 114.755n 1.0v 119.745n 1.0v 119.755n 1.0v 124.745n 1.0v 124.755n 1.0v 129.745n 1.0v 129.755n 1.0v 134.745n 1.0v 134.755n 1.0v 139.745n 1.0v 139.755n 1.0v 144.745n 1.0v 144.755n 1.0v 149.745n 1.0v 149.755n 1.0v 154.745n 1.0v 154.755n 1.0v 159.745n 1.0v 159.755n 1.0v 164.745n 1.0v 164.755n 1.0v 169.745n 1.0v 169.755n 1.0v 174.745n 1.0v 174.755n 1.0v 179.745n 1.0v 179.755n 1.0v 184.745n 1.0v 184.755n 1.0v 189.745n 1.0v 189.755n 1.0v 194.745n 1.0v 194.755n 1.0v 199.745n 1.0v 199.755n 1.0v 204.745n 1.0v 204.755n 1.0v 209.745n 1.0v 209.755n 1.0v 214.745n 1.0v 214.755n 1.0v 219.745n 1.0v 219.755n 1.0v 224.745n 1.0v 224.755n 1.0v 229.745n 1.0v 229.755n 0.0v 234.745n 0.0v 234.755n 1.0v 239.745n 1.0v 239.755n 1.0v 244.745n 1.0v 244.755n 1.0v 249.745n 1.0v 249.755n 0.0v 254.745n 0.0v 254.755n 0.0v 259.745n 0.0v 259.755n 0.0v 264.745n 0.0v 264.755n 0.0v 269.745n 0.0v 269.755n 0.0v 274.745n 0.0v 274.755n 0.0v 279.745n 0.0v 279.755n 0.0v 284.745n 0.0v 284.755n 0.0v 289.745n 0.0v 289.755n 0.0v 294.745n 0.0v 294.755n 0.0v 299.745n 0.0v 299.755n 1.0v 304.745n 1.0v 304.755n 1.0v 309.745n 1.0v 309.755n 1.0v 314.745n 1.0v 314.755n 1.0v 319.745n 1.0v 319.755n 1.0v 324.745n 1.0v 324.755n 1.0v 329.745n 1.0v 329.755n 1.0v 334.745n 1.0v 334.755n 1.0v 339.745n 1.0v 339.755n 0.0v 344.745n 0.0v 344.755n 0.0v 349.745n 0.0v 349.755n 1.0v 354.745n 1.0v 354.755n 1.0v 359.745n 1.0v 359.755n 1.0v 364.745n 1.0v 364.755n 1.0v 369.745n 1.0v 369.755n 1.0v 374.745n 1.0v 374.755n 1.0v 379.745n 1.0v 379.755n 1.0v 384.745n 1.0v 384.755n 1.0v 389.745n 1.0v 389.755n 1.0v 394.745n 1.0v 394.755n 1.0v 399.745n 1.0v 399.755n 1.0v 404.745n 1.0v 404.755n 1.0v 409.745n 1.0v 409.755n 1.0v 414.745n 1.0v 414.755n 1.0v 419.745n 1.0v 419.755n 1.0v 424.745n 1.0v 424.755n 1.0v 429.745n 1.0v 429.755n 1.0v 434.745n 1.0v 434.755n 0.0v 439.745n 0.0v 439.755n 0.0v 444.745n 0.0v 444.755n 0.0v 449.745n 0.0v 449.755n 0.0v 454.745n 0.0v 454.755n 0.0v 459.745n 0.0v 459.755n 0.0v 464.745n 0.0v 464.755n 1.0v 469.745n 1.0v 469.755n 1.0v 474.745n 1.0v 474.755n 1.0v 479.745n 1.0v 479.755n 1.0v 484.745n 1.0v 484.755n 1.0v 489.745n 1.0v 489.755n 1.0v 494.745n 1.0v 494.755n 1.0v 499.745n 1.0v 499.755n 1.0v 504.745n 1.0v 504.755n 1.0v 509.745n 1.0v 509.755n 1.0v 514.745n 1.0v 514.755n 1.0v 519.745n 1.0v 519.755n 1.0v 524.745n 1.0v 524.755n 1.0v 529.745n 1.0v 529.755n 1.0v 534.745n 1.0v 534.755n 1.0v 539.745n 1.0v 539.755n 1.0v 544.745n 1.0v 544.755n 0.0v 549.745n 0.0v 549.755n 0.0v 554.745n 0.0v 554.755n 0.0v 559.745n 0.0v 559.755n 0.0v 564.745n 0.0v 564.755n 0.0v 569.745n 0.0v 569.755n 0.0v 574.745n 0.0v 574.755n 0.0v 579.745n 0.0v 579.755n 0.0v 584.745n 0.0v 584.755n 0.0v 589.745n 0.0v 589.755n 0.0v 594.745n 0.0v 594.755n 0.0v 599.745n 0.0v 599.755n 0.0v 604.745n 0.0v 604.755n 0.0v 609.745n 0.0v 609.755n 0.0v 614.745n 0.0v 614.755n 1.0v 619.745n 1.0v 619.755n 1.0v 624.745n 1.0v 624.755n 0.0v 629.745n 0.0v 629.755n 0.0v 634.745n 0.0v 634.755n 0.0v 639.745n 0.0v 639.755n 0.0v 644.745n 0.0v 644.755n 1.0v 649.745n 1.0v 649.755n 1.0v 654.745n 1.0v 654.755n 1.0v 659.745n 1.0v 659.755n 1.0v 664.745n 1.0v 664.755n 1.0v 669.745n 1.0v 669.755n 1.0v 674.745n 1.0v 674.755n 1.0v 679.745n 1.0v 679.755n 1.0v 684.745n 1.0v 684.755n 1.0v 689.745n 1.0v 689.755n 1.0v 694.745n 1.0v 694.755n 1.0v 699.745n 1.0v 699.755n 1.0v 704.745n 1.0v 704.755n 1.0v 709.745n 1.0v 709.755n 1.0v 714.745n 1.0v 714.755n 1.0v 719.745n 1.0v 719.755n 1.0v 724.745n 1.0v 724.755n 1.0v 729.745n 1.0v 729.755n 1.0v 734.745n 1.0v 734.755n 0.0v 739.745n 0.0v 739.755n 0.0v 744.745n 0.0v 744.755n 0.0v 749.745n 0.0v 749.755n 0.0v 754.745n 0.0v 754.755n 0.0v 759.745n 0.0v 759.755n 0.0v 764.745n 0.0v 764.755n 0.0v 769.745n 0.0v 769.755n 0.0v 774.745n 0.0v 774.755n 0.0v 779.745n 0.0v 779.755n 1.0v 784.745n 1.0v 784.755n 1.0v 789.745n 1.0v 789.755n 1.0v 794.745n 1.0v 794.755n 0.0v 799.745n 0.0v 799.755n 0.0v 804.745n 0.0v 804.755n 0.0v 809.745n 0.0v 809.755n 0.0v 814.745n 0.0v 814.755n 0.0v 819.745n 0.0v 819.755n 1.0v 824.745n 1.0v 824.755n 1.0v 829.745n 1.0v 829.755n 1.0v 834.745n 1.0v 834.755n 1.0v 839.745n 1.0v 839.755n 1.0v 844.745n 1.0v 844.755n 1.0v 849.745n 1.0v 849.755n 1.0v 854.745n 1.0v 854.755n 1.0v 859.745n 1.0v 859.755n 1.0v 864.745n 1.0v 864.755n 1.0v 869.745n 1.0v 869.755n 1.0v 874.745n 1.0v 874.755n 1.0v 879.745n 1.0v 879.755n 1.0v 884.745n 1.0v 884.755n 1.0v 889.745n 1.0v 889.755n 1.0v 894.745n 1.0v 894.755n 1.0v 899.745n 1.0v 899.755n 1.0v 904.745n 1.0v 904.755n 0.0v 909.745n 0.0v 909.755n 1.0v 914.745n 1.0v 914.755n 1.0v 919.745n 1.0v 919.755n 1.0v 924.745n 1.0v 924.755n 1.0v 929.745n 1.0v 929.755n 1.0v 934.745n 1.0v 934.755n 0.0v 939.745n 0.0v 939.755n 0.0v 944.745n 0.0v 944.755n 0.0v 949.745n 0.0v 949.755n 0.0v 954.745n 0.0v 954.755n 1.0v 959.745n 1.0v 959.755n 0.0v 964.745n 0.0v 964.755n 0.0v 969.745n 0.0v 969.755n 0.0v 974.745n 0.0v 974.755n 0.0v 979.745n 0.0v 979.755n 0.0v 984.745n 0.0v 984.755n 0.0v 989.745n 0.0v 989.755n 0.0v 994.745n 0.0v 994.755n 0.0v 999.745n 0.0v 999.755n 0.0v 1004.745n 0.0v 1004.755n 0.0v 1009.745n 0.0v 1009.755n 0.0v 1014.745n 0.0v 1014.755n 1.0v 1019.745n 1.0v 1019.755n 1.0v 1024.745n 1.0v 1024.755n 1.0v )
* (time, data): [(0, 0), (5, 0), (10, 1), (15, 1), (20, 1), (25, 1), (30, 1), (35, 1), (40, 1), (45, 1), (50, 1), (55, 1), (60, 1), (65, 1), (70, 1), (75, 1), (80, 1), (85, 1), (90, 1), (95, 1), (100, 1), (105, 1), (110, 1), (115, 1), (120, 1), (125, 1), (130, 1), (135, 1), (140, 0), (145, 0), (150, 0), (155, 0), (160, 0), (165, 0), (170, 0), (175, 0), (180, 0), (185, 0), (190, 0), (195, 0), (200, 0), (205, 0), (210, 0), (215, 0), (220, 0), (225, 0), (230, 1), (235, 1), (240, 0), (245, 0), (250, 0), (255, 0), (260, 0), (265, 0), (270, 0), (275, 0), (280, 0), (285, 0), (290, 0), (295, 0), (300, 0), (305, 0), (310, 0), (315, 0), (320, 0), (325, 0), (330, 0), (335, 0), (340, 0), (345, 0), (350, 0), (355, 0), (360, 0), (365, 0), (370, 0), (375, 0), (380, 0), (385, 0), (390, 0), (395, 0), (400, 0), (405, 0), (410, 0), (415, 0), (420, 0), (425, 0), (430, 0), (435, 1), (440, 1), (445, 1), (450, 1), (455, 1), (460, 1), (465, 1), (470, 1), (475, 1), (480, 1), (485, 1), (490, 1), (495, 1), (500, 1), (505, 1), (510, 1), (515, 1), (520, 1), (525, 1), (530, 1), (535, 1), (540, 1), (545, 0), (550, 0), (555, 0), (560, 0), (565, 0), (570, 0), (575, 0), (580, 0), (585, 0), (590, 0), (595, 0), (600, 0), (605, 0), (610, 0), (615, 0), (620, 0), (625, 0), (630, 0), (635, 0), (640, 0), (645, 0), (650, 0), (655, 0), (660, 0), (665, 0), (670, 0), (675, 0), (680, 0), (685, 0), (690, 0), (695, 0), (700, 0), (705, 0), (710, 1), (715, 1), (720, 1), (725, 1), (730, 1), (735, 0), (740, 0), (745, 0), (750, 0), (755, 0), (760, 0), (765, 0), (770, 1), (775, 1), (780, 0), (785, 0), (790, 0), (795, 0), (800, 0), (805, 0), (810, 0), (815, 0), (820, 0), (825, 0), (830, 0), (835, 0), (840, 0), (845, 0), (850, 1), (855, 1), (860, 0), (865, 0), (870, 0), (875, 0), (880, 0), (885, 0), (890, 0), (895, 0), (900, 0), (905, 0), (910, 0), (915, 0), (920, 0), (925, 0), (930, 0), (935, 1), (940, 1), (945, 1), (950, 1), (955, 0), (960, 0), (965, 0), (970, 1), (975, 1), (980, 1), (985, 1), (990, 1), (995, 1), (1000, 1), (1005, 1), (1010, 1), (1015, 0), (1020, 0), (1025, 0)]
Vdin0_14  din0_14  0 PWL (0n 0.0v 4.745n 0.0v 4.755n 0.0v 9.745n 0.0v 9.755n 1.0v 14.745n 1.0v 14.755n 1.0v 19.745n 1.0v 19.755n 1.0v 24.745n 1.0v 24.755n 1.0v 29.745n 1.0v 29.755n 1.0v 34.745n 1.0v 34.755n 1.0v 39.745n 1.0v 39.755n 1.0v 44.745n 1.0v 44.755n 1.0v 49.745n 1.0v 49.755n 1.0v 54.745n 1.0v 54.755n 1.0v 59.745n 1.0v 59.755n 1.0v 64.745n 1.0v 64.755n 1.0v 69.745n 1.0v 69.755n 1.0v 74.745n 1.0v 74.755n 1.0v 79.745n 1.0v 79.755n 1.0v 84.745n 1.0v 84.755n 1.0v 89.745n 1.0v 89.755n 1.0v 94.745n 1.0v 94.755n 1.0v 99.745n 1.0v 99.755n 1.0v 104.745n 1.0v 104.755n 1.0v 109.745n 1.0v 109.755n 1.0v 114.745n 1.0v 114.755n 1.0v 119.745n 1.0v 119.755n 1.0v 124.745n 1.0v 124.755n 1.0v 129.745n 1.0v 129.755n 1.0v 134.745n 1.0v 134.755n 1.0v 139.745n 1.0v 139.755n 0.0v 144.745n 0.0v 144.755n 0.0v 149.745n 0.0v 149.755n 0.0v 154.745n 0.0v 154.755n 0.0v 159.745n 0.0v 159.755n 0.0v 164.745n 0.0v 164.755n 0.0v 169.745n 0.0v 169.755n 0.0v 174.745n 0.0v 174.755n 0.0v 179.745n 0.0v 179.755n 0.0v 184.745n 0.0v 184.755n 0.0v 189.745n 0.0v 189.755n 0.0v 194.745n 0.0v 194.755n 0.0v 199.745n 0.0v 199.755n 0.0v 204.745n 0.0v 204.755n 0.0v 209.745n 0.0v 209.755n 0.0v 214.745n 0.0v 214.755n 0.0v 219.745n 0.0v 219.755n 0.0v 224.745n 0.0v 224.755n 0.0v 229.745n 0.0v 229.755n 1.0v 234.745n 1.0v 234.755n 1.0v 239.745n 1.0v 239.755n 0.0v 244.745n 0.0v 244.755n 0.0v 249.745n 0.0v 249.755n 0.0v 254.745n 0.0v 254.755n 0.0v 259.745n 0.0v 259.755n 0.0v 264.745n 0.0v 264.755n 0.0v 269.745n 0.0v 269.755n 0.0v 274.745n 0.0v 274.755n 0.0v 279.745n 0.0v 279.755n 0.0v 284.745n 0.0v 284.755n 0.0v 289.745n 0.0v 289.755n 0.0v 294.745n 0.0v 294.755n 0.0v 299.745n 0.0v 299.755n 0.0v 304.745n 0.0v 304.755n 0.0v 309.745n 0.0v 309.755n 0.0v 314.745n 0.0v 314.755n 0.0v 319.745n 0.0v 319.755n 0.0v 324.745n 0.0v 324.755n 0.0v 329.745n 0.0v 329.755n 0.0v 334.745n 0.0v 334.755n 0.0v 339.745n 0.0v 339.755n 0.0v 344.745n 0.0v 344.755n 0.0v 349.745n 0.0v 349.755n 0.0v 354.745n 0.0v 354.755n 0.0v 359.745n 0.0v 359.755n 0.0v 364.745n 0.0v 364.755n 0.0v 369.745n 0.0v 369.755n 0.0v 374.745n 0.0v 374.755n 0.0v 379.745n 0.0v 379.755n 0.0v 384.745n 0.0v 384.755n 0.0v 389.745n 0.0v 389.755n 0.0v 394.745n 0.0v 394.755n 0.0v 399.745n 0.0v 399.755n 0.0v 404.745n 0.0v 404.755n 0.0v 409.745n 0.0v 409.755n 0.0v 414.745n 0.0v 414.755n 0.0v 419.745n 0.0v 419.755n 0.0v 424.745n 0.0v 424.755n 0.0v 429.745n 0.0v 429.755n 0.0v 434.745n 0.0v 434.755n 1.0v 439.745n 1.0v 439.755n 1.0v 444.745n 1.0v 444.755n 1.0v 449.745n 1.0v 449.755n 1.0v 454.745n 1.0v 454.755n 1.0v 459.745n 1.0v 459.755n 1.0v 464.745n 1.0v 464.755n 1.0v 469.745n 1.0v 469.755n 1.0v 474.745n 1.0v 474.755n 1.0v 479.745n 1.0v 479.755n 1.0v 484.745n 1.0v 484.755n 1.0v 489.745n 1.0v 489.755n 1.0v 494.745n 1.0v 494.755n 1.0v 499.745n 1.0v 499.755n 1.0v 504.745n 1.0v 504.755n 1.0v 509.745n 1.0v 509.755n 1.0v 514.745n 1.0v 514.755n 1.0v 519.745n 1.0v 519.755n 1.0v 524.745n 1.0v 524.755n 1.0v 529.745n 1.0v 529.755n 1.0v 534.745n 1.0v 534.755n 1.0v 539.745n 1.0v 539.755n 1.0v 544.745n 1.0v 544.755n 0.0v 549.745n 0.0v 549.755n 0.0v 554.745n 0.0v 554.755n 0.0v 559.745n 0.0v 559.755n 0.0v 564.745n 0.0v 564.755n 0.0v 569.745n 0.0v 569.755n 0.0v 574.745n 0.0v 574.755n 0.0v 579.745n 0.0v 579.755n 0.0v 584.745n 0.0v 584.755n 0.0v 589.745n 0.0v 589.755n 0.0v 594.745n 0.0v 594.755n 0.0v 599.745n 0.0v 599.755n 0.0v 604.745n 0.0v 604.755n 0.0v 609.745n 0.0v 609.755n 0.0v 614.745n 0.0v 614.755n 0.0v 619.745n 0.0v 619.755n 0.0v 624.745n 0.0v 624.755n 0.0v 629.745n 0.0v 629.755n 0.0v 634.745n 0.0v 634.755n 0.0v 639.745n 0.0v 639.755n 0.0v 644.745n 0.0v 644.755n 0.0v 649.745n 0.0v 649.755n 0.0v 654.745n 0.0v 654.755n 0.0v 659.745n 0.0v 659.755n 0.0v 664.745n 0.0v 664.755n 0.0v 669.745n 0.0v 669.755n 0.0v 674.745n 0.0v 674.755n 0.0v 679.745n 0.0v 679.755n 0.0v 684.745n 0.0v 684.755n 0.0v 689.745n 0.0v 689.755n 0.0v 694.745n 0.0v 694.755n 0.0v 699.745n 0.0v 699.755n 0.0v 704.745n 0.0v 704.755n 0.0v 709.745n 0.0v 709.755n 1.0v 714.745n 1.0v 714.755n 1.0v 719.745n 1.0v 719.755n 1.0v 724.745n 1.0v 724.755n 1.0v 729.745n 1.0v 729.755n 1.0v 734.745n 1.0v 734.755n 0.0v 739.745n 0.0v 739.755n 0.0v 744.745n 0.0v 744.755n 0.0v 749.745n 0.0v 749.755n 0.0v 754.745n 0.0v 754.755n 0.0v 759.745n 0.0v 759.755n 0.0v 764.745n 0.0v 764.755n 0.0v 769.745n 0.0v 769.755n 1.0v 774.745n 1.0v 774.755n 1.0v 779.745n 1.0v 779.755n 0.0v 784.745n 0.0v 784.755n 0.0v 789.745n 0.0v 789.755n 0.0v 794.745n 0.0v 794.755n 0.0v 799.745n 0.0v 799.755n 0.0v 804.745n 0.0v 804.755n 0.0v 809.745n 0.0v 809.755n 0.0v 814.745n 0.0v 814.755n 0.0v 819.745n 0.0v 819.755n 0.0v 824.745n 0.0v 824.755n 0.0v 829.745n 0.0v 829.755n 0.0v 834.745n 0.0v 834.755n 0.0v 839.745n 0.0v 839.755n 0.0v 844.745n 0.0v 844.755n 0.0v 849.745n 0.0v 849.755n 1.0v 854.745n 1.0v 854.755n 1.0v 859.745n 1.0v 859.755n 0.0v 864.745n 0.0v 864.755n 0.0v 869.745n 0.0v 869.755n 0.0v 874.745n 0.0v 874.755n 0.0v 879.745n 0.0v 879.755n 0.0v 884.745n 0.0v 884.755n 0.0v 889.745n 0.0v 889.755n 0.0v 894.745n 0.0v 894.755n 0.0v 899.745n 0.0v 899.755n 0.0v 904.745n 0.0v 904.755n 0.0v 909.745n 0.0v 909.755n 0.0v 914.745n 0.0v 914.755n 0.0v 919.745n 0.0v 919.755n 0.0v 924.745n 0.0v 924.755n 0.0v 929.745n 0.0v 929.755n 0.0v 934.745n 0.0v 934.755n 1.0v 939.745n 1.0v 939.755n 1.0v 944.745n 1.0v 944.755n 1.0v 949.745n 1.0v 949.755n 1.0v 954.745n 1.0v 954.755n 0.0v 959.745n 0.0v 959.755n 0.0v 964.745n 0.0v 964.755n 0.0v 969.745n 0.0v 969.755n 1.0v 974.745n 1.0v 974.755n 1.0v 979.745n 1.0v 979.755n 1.0v 984.745n 1.0v 984.755n 1.0v 989.745n 1.0v 989.755n 1.0v 994.745n 1.0v 994.755n 1.0v 999.745n 1.0v 999.755n 1.0v 1004.745n 1.0v 1004.755n 1.0v 1009.745n 1.0v 1009.755n 1.0v 1014.745n 1.0v 1014.755n 0.0v 1019.745n 0.0v 1019.755n 0.0v 1024.745n 0.0v 1024.755n 0.0v )
* (time, data): [(0, 0), (5, 1), (10, 1), (15, 1), (20, 1), (25, 1), (30, 1), (35, 1), (40, 0), (45, 0), (50, 0), (55, 0), (60, 0), (65, 0), (70, 0), (75, 0), (80, 1), (85, 1), (90, 1), (95, 1), (100, 1), (105, 1), (110, 1), (115, 1), (120, 1), (125, 0), (130, 0), (135, 0), (140, 1), (145, 1), (150, 1), (155, 1), (160, 1), (165, 1), (170, 1), (175, 1), (180, 1), (185, 1), (190, 1), (195, 1), (200, 1), (205, 1), (210, 1), (215, 1), (220, 1), (225, 1), (230, 0), (235, 0), (240, 0), (245, 1), (250, 1), (255, 1), (260, 1), (265, 1), (270, 1), (275, 1), (280, 1), (285, 1), (290, 1), (295, 1), (300, 0), (305, 0), (310, 0), (315, 0), (320, 0), (325, 0), (330, 0), (335, 0), (340, 1), (345, 0), (350, 1), (355, 1), (360, 1), (365, 1), (370, 1), (375, 1), (380, 1), (385, 1), (390, 1), (395, 1), (400, 1), (405, 1), (410, 1), (415, 1), (420, 1), (425, 1), (430, 1), (435, 0), (440, 0), (445, 0), (450, 0), (455, 1), (460, 1), (465, 1), (470, 1), (475, 1), (480, 1), (485, 1), (490, 1), (495, 1), (500, 1), (505, 1), (510, 1), (515, 1), (520, 1), (525, 1), (530, 1), (535, 1), (540, 1), (545, 0), (550, 0), (555, 0), (560, 0), (565, 0), (570, 0), (575, 0), (580, 0), (585, 0), (590, 0), (595, 0), (600, 0), (605, 0), (610, 0), (615, 0), (620, 0), (625, 1), (630, 1), (635, 1), (640, 1), (645, 0), (650, 0), (655, 0), (660, 0), (665, 0), (670, 0), (675, 0), (680, 1), (685, 1), (690, 1), (695, 1), (700, 1), (705, 1), (710, 1), (715, 1), (720, 0), (725, 0), (730, 0), (735, 0), (740, 0), (745, 0), (750, 0), (755, 0), (760, 0), (765, 0), (770, 0), (775, 0), (780, 1), (785, 1), (790, 1), (795, 1), (800, 1), (805, 1), (810, 1), (815, 1), (820, 1), (825, 1), (830, 1), (835, 1), (840, 1), (845, 1), (850, 0), (855, 0), (860, 0), (865, 0), (870, 0), (875, 0), (880, 0), (885, 0), (890, 0), (895, 0), (900, 0), (905, 1), (910, 1), (915, 1), (920, 1), (925, 1), (930, 1), (935, 0), (940, 0), (945, 0), (950, 0), (955, 0), (960, 1), (965, 1), (970, 0), (975, 0), (980, 0), (985, 0), (990, 0), (995, 0), (1000, 0), (1005, 0), (1010, 0), (1015, 1), (1020, 1), (1025, 1)]
Vdin0_15  din0_15  0 PWL (0n 0.0v 4.745n 0.0v 4.755n 1.0v 9.745n 1.0v 9.755n 1.0v 14.745n 1.0v 14.755n 1.0v 19.745n 1.0v 19.755n 1.0v 24.745n 1.0v 24.755n 1.0v 29.745n 1.0v 29.755n 1.0v 34.745n 1.0v 34.755n 1.0v 39.745n 1.0v 39.755n 0.0v 44.745n 0.0v 44.755n 0.0v 49.745n 0.0v 49.755n 0.0v 54.745n 0.0v 54.755n 0.0v 59.745n 0.0v 59.755n 0.0v 64.745n 0.0v 64.755n 0.0v 69.745n 0.0v 69.755n 0.0v 74.745n 0.0v 74.755n 0.0v 79.745n 0.0v 79.755n 1.0v 84.745n 1.0v 84.755n 1.0v 89.745n 1.0v 89.755n 1.0v 94.745n 1.0v 94.755n 1.0v 99.745n 1.0v 99.755n 1.0v 104.745n 1.0v 104.755n 1.0v 109.745n 1.0v 109.755n 1.0v 114.745n 1.0v 114.755n 1.0v 119.745n 1.0v 119.755n 1.0v 124.745n 1.0v 124.755n 0.0v 129.745n 0.0v 129.755n 0.0v 134.745n 0.0v 134.755n 0.0v 139.745n 0.0v 139.755n 1.0v 144.745n 1.0v 144.755n 1.0v 149.745n 1.0v 149.755n 1.0v 154.745n 1.0v 154.755n 1.0v 159.745n 1.0v 159.755n 1.0v 164.745n 1.0v 164.755n 1.0v 169.745n 1.0v 169.755n 1.0v 174.745n 1.0v 174.755n 1.0v 179.745n 1.0v 179.755n 1.0v 184.745n 1.0v 184.755n 1.0v 189.745n 1.0v 189.755n 1.0v 194.745n 1.0v 194.755n 1.0v 199.745n 1.0v 199.755n 1.0v 204.745n 1.0v 204.755n 1.0v 209.745n 1.0v 209.755n 1.0v 214.745n 1.0v 214.755n 1.0v 219.745n 1.0v 219.755n 1.0v 224.745n 1.0v 224.755n 1.0v 229.745n 1.0v 229.755n 0.0v 234.745n 0.0v 234.755n 0.0v 239.745n 0.0v 239.755n 0.0v 244.745n 0.0v 244.755n 1.0v 249.745n 1.0v 249.755n 1.0v 254.745n 1.0v 254.755n 1.0v 259.745n 1.0v 259.755n 1.0v 264.745n 1.0v 264.755n 1.0v 269.745n 1.0v 269.755n 1.0v 274.745n 1.0v 274.755n 1.0v 279.745n 1.0v 279.755n 1.0v 284.745n 1.0v 284.755n 1.0v 289.745n 1.0v 289.755n 1.0v 294.745n 1.0v 294.755n 1.0v 299.745n 1.0v 299.755n 0.0v 304.745n 0.0v 304.755n 0.0v 309.745n 0.0v 309.755n 0.0v 314.745n 0.0v 314.755n 0.0v 319.745n 0.0v 319.755n 0.0v 324.745n 0.0v 324.755n 0.0v 329.745n 0.0v 329.755n 0.0v 334.745n 0.0v 334.755n 0.0v 339.745n 0.0v 339.755n 1.0v 344.745n 1.0v 344.755n 0.0v 349.745n 0.0v 349.755n 1.0v 354.745n 1.0v 354.755n 1.0v 359.745n 1.0v 359.755n 1.0v 364.745n 1.0v 364.755n 1.0v 369.745n 1.0v 369.755n 1.0v 374.745n 1.0v 374.755n 1.0v 379.745n 1.0v 379.755n 1.0v 384.745n 1.0v 384.755n 1.0v 389.745n 1.0v 389.755n 1.0v 394.745n 1.0v 394.755n 1.0v 399.745n 1.0v 399.755n 1.0v 404.745n 1.0v 404.755n 1.0v 409.745n 1.0v 409.755n 1.0v 414.745n 1.0v 414.755n 1.0v 419.745n 1.0v 419.755n 1.0v 424.745n 1.0v 424.755n 1.0v 429.745n 1.0v 429.755n 1.0v 434.745n 1.0v 434.755n 0.0v 439.745n 0.0v 439.755n 0.0v 444.745n 0.0v 444.755n 0.0v 449.745n 0.0v 449.755n 0.0v 454.745n 0.0v 454.755n 1.0v 459.745n 1.0v 459.755n 1.0v 464.745n 1.0v 464.755n 1.0v 469.745n 1.0v 469.755n 1.0v 474.745n 1.0v 474.755n 1.0v 479.745n 1.0v 479.755n 1.0v 484.745n 1.0v 484.755n 1.0v 489.745n 1.0v 489.755n 1.0v 494.745n 1.0v 494.755n 1.0v 499.745n 1.0v 499.755n 1.0v 504.745n 1.0v 504.755n 1.0v 509.745n 1.0v 509.755n 1.0v 514.745n 1.0v 514.755n 1.0v 519.745n 1.0v 519.755n 1.0v 524.745n 1.0v 524.755n 1.0v 529.745n 1.0v 529.755n 1.0v 534.745n 1.0v 534.755n 1.0v 539.745n 1.0v 539.755n 1.0v 544.745n 1.0v 544.755n 0.0v 549.745n 0.0v 549.755n 0.0v 554.745n 0.0v 554.755n 0.0v 559.745n 0.0v 559.755n 0.0v 564.745n 0.0v 564.755n 0.0v 569.745n 0.0v 569.755n 0.0v 574.745n 0.0v 574.755n 0.0v 579.745n 0.0v 579.755n 0.0v 584.745n 0.0v 584.755n 0.0v 589.745n 0.0v 589.755n 0.0v 594.745n 0.0v 594.755n 0.0v 599.745n 0.0v 599.755n 0.0v 604.745n 0.0v 604.755n 0.0v 609.745n 0.0v 609.755n 0.0v 614.745n 0.0v 614.755n 0.0v 619.745n 0.0v 619.755n 0.0v 624.745n 0.0v 624.755n 1.0v 629.745n 1.0v 629.755n 1.0v 634.745n 1.0v 634.755n 1.0v 639.745n 1.0v 639.755n 1.0v 644.745n 1.0v 644.755n 0.0v 649.745n 0.0v 649.755n 0.0v 654.745n 0.0v 654.755n 0.0v 659.745n 0.0v 659.755n 0.0v 664.745n 0.0v 664.755n 0.0v 669.745n 0.0v 669.755n 0.0v 674.745n 0.0v 674.755n 0.0v 679.745n 0.0v 679.755n 1.0v 684.745n 1.0v 684.755n 1.0v 689.745n 1.0v 689.755n 1.0v 694.745n 1.0v 694.755n 1.0v 699.745n 1.0v 699.755n 1.0v 704.745n 1.0v 704.755n 1.0v 709.745n 1.0v 709.755n 1.0v 714.745n 1.0v 714.755n 1.0v 719.745n 1.0v 719.755n 0.0v 724.745n 0.0v 724.755n 0.0v 729.745n 0.0v 729.755n 0.0v 734.745n 0.0v 734.755n 0.0v 739.745n 0.0v 739.755n 0.0v 744.745n 0.0v 744.755n 0.0v 749.745n 0.0v 749.755n 0.0v 754.745n 0.0v 754.755n 0.0v 759.745n 0.0v 759.755n 0.0v 764.745n 0.0v 764.755n 0.0v 769.745n 0.0v 769.755n 0.0v 774.745n 0.0v 774.755n 0.0v 779.745n 0.0v 779.755n 1.0v 784.745n 1.0v 784.755n 1.0v 789.745n 1.0v 789.755n 1.0v 794.745n 1.0v 794.755n 1.0v 799.745n 1.0v 799.755n 1.0v 804.745n 1.0v 804.755n 1.0v 809.745n 1.0v 809.755n 1.0v 814.745n 1.0v 814.755n 1.0v 819.745n 1.0v 819.755n 1.0v 824.745n 1.0v 824.755n 1.0v 829.745n 1.0v 829.755n 1.0v 834.745n 1.0v 834.755n 1.0v 839.745n 1.0v 839.755n 1.0v 844.745n 1.0v 844.755n 1.0v 849.745n 1.0v 849.755n 0.0v 854.745n 0.0v 854.755n 0.0v 859.745n 0.0v 859.755n 0.0v 864.745n 0.0v 864.755n 0.0v 869.745n 0.0v 869.755n 0.0v 874.745n 0.0v 874.755n 0.0v 879.745n 0.0v 879.755n 0.0v 884.745n 0.0v 884.755n 0.0v 889.745n 0.0v 889.755n 0.0v 894.745n 0.0v 894.755n 0.0v 899.745n 0.0v 899.755n 0.0v 904.745n 0.0v 904.755n 1.0v 909.745n 1.0v 909.755n 1.0v 914.745n 1.0v 914.755n 1.0v 919.745n 1.0v 919.755n 1.0v 924.745n 1.0v 924.755n 1.0v 929.745n 1.0v 929.755n 1.0v 934.745n 1.0v 934.755n 0.0v 939.745n 0.0v 939.755n 0.0v 944.745n 0.0v 944.755n 0.0v 949.745n 0.0v 949.755n 0.0v 954.745n 0.0v 954.755n 0.0v 959.745n 0.0v 959.755n 1.0v 964.745n 1.0v 964.755n 1.0v 969.745n 1.0v 969.755n 0.0v 974.745n 0.0v 974.755n 0.0v 979.745n 0.0v 979.755n 0.0v 984.745n 0.0v 984.755n 0.0v 989.745n 0.0v 989.755n 0.0v 994.745n 0.0v 994.755n 0.0v 999.745n 0.0v 999.755n 0.0v 1004.745n 0.0v 1004.755n 0.0v 1009.745n 0.0v 1009.755n 0.0v 1014.745n 0.0v 1014.755n 1.0v 1019.745n 1.0v 1019.755n 1.0v 1024.745n 1.0v 1024.755n 1.0v )
* (time, data): [(0, 0), (5, 0), (10, 1), (15, 0), (20, 0), (25, 0), (30, 1), (35, 1), (40, 0), (45, 1), (50, 1), (55, 1), (60, 1), (65, 0), (70, 0), (75, 0), (80, 0), (85, 0), (90, 0), (95, 0), (100, 0), (105, 0), (110, 1), (115, 1), (120, 1), (125, 1), (130, 1), (135, 1), (140, 0), (145, 1), (150, 1), (155, 1), (160, 1), (165, 1), (170, 1), (175, 1), (180, 1), (185, 1), (190, 1), (195, 1), (200, 1), (205, 1), (210, 1), (215, 1), (220, 1), (225, 1), (230, 0), (235, 1), (240, 0), (245, 0), (250, 1), (255, 1), (260, 1), (265, 1), (270, 1), (275, 0), (280, 0), (285, 1), (290, 1), (295, 1), (300, 1), (305, 1), (310, 1), (315, 1), (320, 1), (325, 1), (330, 1), (335, 1), (340, 1), (345, 0), (350, 0), (355, 0), (360, 0), (365, 0), (370, 0), (375, 0), (380, 0), (385, 0), (390, 0), (395, 0), (400, 0), (405, 0), (410, 0), (415, 0), (420, 0), (425, 0), (430, 0), (435, 0), (440, 0), (445, 0), (450, 0), (455, 0), (460, 0), (465, 1), (470, 1), (475, 1), (480, 1), (485, 1), (490, 1), (495, 1), (500, 1), (505, 1), (510, 0), (515, 0), (520, 0), (525, 0), (530, 0), (535, 0), (540, 0), (545, 1), (550, 1), (555, 1), (560, 1), (565, 1), (570, 1), (575, 1), (580, 1), (585, 1), (590, 1), (595, 1), (600, 1), (605, 1), (610, 1), (615, 0), (620, 0), (625, 0), (630, 0), (635, 0), (640, 0), (645, 0), (650, 0), (655, 0), (660, 0), (665, 0), (670, 0), (675, 0), (680, 1), (685, 1), (690, 1), (695, 1), (700, 1), (705, 1), (710, 1), (715, 1), (720, 0), (725, 0), (730, 0), (735, 0), (740, 0), (745, 0), (750, 0), (755, 0), (760, 0), (765, 0), (770, 1), (775, 1), (780, 1), (785, 1), (790, 1), (795, 1), (800, 1), (805, 1), (810, 1), (815, 1), (820, 1), (825, 1), (830, 1), (835, 1), (840, 1), (845, 1), (850, 1), (855, 1), (860, 1), (865, 1), (870, 1), (875, 1), (880, 1), (885, 1), (890, 1), (895, 1), (900, 1), (905, 1), (910, 0), (915, 0), (920, 1), (925, 1), (930, 1), (935, 1), (940, 1), (945, 1), (950, 1), (955, 1), (960, 1), (965, 1), (970, 0), (975, 0), (980, 0), (985, 0), (990, 0), (995, 0), (1000, 0), (1005, 0), (1010, 0), (1015, 0), (1020, 0), (1025, 0)]
Vdin0_16  din0_16  0 PWL (0n 0.0v 4.745n 0.0v 4.755n 0.0v 9.745n 0.0v 9.755n 1.0v 14.745n 1.0v 14.755n 0.0v 19.745n 0.0v 19.755n 0.0v 24.745n 0.0v 24.755n 0.0v 29.745n 0.0v 29.755n 1.0v 34.745n 1.0v 34.755n 1.0v 39.745n 1.0v 39.755n 0.0v 44.745n 0.0v 44.755n 1.0v 49.745n 1.0v 49.755n 1.0v 54.745n 1.0v 54.755n 1.0v 59.745n 1.0v 59.755n 1.0v 64.745n 1.0v 64.755n 0.0v 69.745n 0.0v 69.755n 0.0v 74.745n 0.0v 74.755n 0.0v 79.745n 0.0v 79.755n 0.0v 84.745n 0.0v 84.755n 0.0v 89.745n 0.0v 89.755n 0.0v 94.745n 0.0v 94.755n 0.0v 99.745n 0.0v 99.755n 0.0v 104.745n 0.0v 104.755n 0.0v 109.745n 0.0v 109.755n 1.0v 114.745n 1.0v 114.755n 1.0v 119.745n 1.0v 119.755n 1.0v 124.745n 1.0v 124.755n 1.0v 129.745n 1.0v 129.755n 1.0v 134.745n 1.0v 134.755n 1.0v 139.745n 1.0v 139.755n 0.0v 144.745n 0.0v 144.755n 1.0v 149.745n 1.0v 149.755n 1.0v 154.745n 1.0v 154.755n 1.0v 159.745n 1.0v 159.755n 1.0v 164.745n 1.0v 164.755n 1.0v 169.745n 1.0v 169.755n 1.0v 174.745n 1.0v 174.755n 1.0v 179.745n 1.0v 179.755n 1.0v 184.745n 1.0v 184.755n 1.0v 189.745n 1.0v 189.755n 1.0v 194.745n 1.0v 194.755n 1.0v 199.745n 1.0v 199.755n 1.0v 204.745n 1.0v 204.755n 1.0v 209.745n 1.0v 209.755n 1.0v 214.745n 1.0v 214.755n 1.0v 219.745n 1.0v 219.755n 1.0v 224.745n 1.0v 224.755n 1.0v 229.745n 1.0v 229.755n 0.0v 234.745n 0.0v 234.755n 1.0v 239.745n 1.0v 239.755n 0.0v 244.745n 0.0v 244.755n 0.0v 249.745n 0.0v 249.755n 1.0v 254.745n 1.0v 254.755n 1.0v 259.745n 1.0v 259.755n 1.0v 264.745n 1.0v 264.755n 1.0v 269.745n 1.0v 269.755n 1.0v 274.745n 1.0v 274.755n 0.0v 279.745n 0.0v 279.755n 0.0v 284.745n 0.0v 284.755n 1.0v 289.745n 1.0v 289.755n 1.0v 294.745n 1.0v 294.755n 1.0v 299.745n 1.0v 299.755n 1.0v 304.745n 1.0v 304.755n 1.0v 309.745n 1.0v 309.755n 1.0v 314.745n 1.0v 314.755n 1.0v 319.745n 1.0v 319.755n 1.0v 324.745n 1.0v 324.755n 1.0v 329.745n 1.0v 329.755n 1.0v 334.745n 1.0v 334.755n 1.0v 339.745n 1.0v 339.755n 1.0v 344.745n 1.0v 344.755n 0.0v 349.745n 0.0v 349.755n 0.0v 354.745n 0.0v 354.755n 0.0v 359.745n 0.0v 359.755n 0.0v 364.745n 0.0v 364.755n 0.0v 369.745n 0.0v 369.755n 0.0v 374.745n 0.0v 374.755n 0.0v 379.745n 0.0v 379.755n 0.0v 384.745n 0.0v 384.755n 0.0v 389.745n 0.0v 389.755n 0.0v 394.745n 0.0v 394.755n 0.0v 399.745n 0.0v 399.755n 0.0v 404.745n 0.0v 404.755n 0.0v 409.745n 0.0v 409.755n 0.0v 414.745n 0.0v 414.755n 0.0v 419.745n 0.0v 419.755n 0.0v 424.745n 0.0v 424.755n 0.0v 429.745n 0.0v 429.755n 0.0v 434.745n 0.0v 434.755n 0.0v 439.745n 0.0v 439.755n 0.0v 444.745n 0.0v 444.755n 0.0v 449.745n 0.0v 449.755n 0.0v 454.745n 0.0v 454.755n 0.0v 459.745n 0.0v 459.755n 0.0v 464.745n 0.0v 464.755n 1.0v 469.745n 1.0v 469.755n 1.0v 474.745n 1.0v 474.755n 1.0v 479.745n 1.0v 479.755n 1.0v 484.745n 1.0v 484.755n 1.0v 489.745n 1.0v 489.755n 1.0v 494.745n 1.0v 494.755n 1.0v 499.745n 1.0v 499.755n 1.0v 504.745n 1.0v 504.755n 1.0v 509.745n 1.0v 509.755n 0.0v 514.745n 0.0v 514.755n 0.0v 519.745n 0.0v 519.755n 0.0v 524.745n 0.0v 524.755n 0.0v 529.745n 0.0v 529.755n 0.0v 534.745n 0.0v 534.755n 0.0v 539.745n 0.0v 539.755n 0.0v 544.745n 0.0v 544.755n 1.0v 549.745n 1.0v 549.755n 1.0v 554.745n 1.0v 554.755n 1.0v 559.745n 1.0v 559.755n 1.0v 564.745n 1.0v 564.755n 1.0v 569.745n 1.0v 569.755n 1.0v 574.745n 1.0v 574.755n 1.0v 579.745n 1.0v 579.755n 1.0v 584.745n 1.0v 584.755n 1.0v 589.745n 1.0v 589.755n 1.0v 594.745n 1.0v 594.755n 1.0v 599.745n 1.0v 599.755n 1.0v 604.745n 1.0v 604.755n 1.0v 609.745n 1.0v 609.755n 1.0v 614.745n 1.0v 614.755n 0.0v 619.745n 0.0v 619.755n 0.0v 624.745n 0.0v 624.755n 0.0v 629.745n 0.0v 629.755n 0.0v 634.745n 0.0v 634.755n 0.0v 639.745n 0.0v 639.755n 0.0v 644.745n 0.0v 644.755n 0.0v 649.745n 0.0v 649.755n 0.0v 654.745n 0.0v 654.755n 0.0v 659.745n 0.0v 659.755n 0.0v 664.745n 0.0v 664.755n 0.0v 669.745n 0.0v 669.755n 0.0v 674.745n 0.0v 674.755n 0.0v 679.745n 0.0v 679.755n 1.0v 684.745n 1.0v 684.755n 1.0v 689.745n 1.0v 689.755n 1.0v 694.745n 1.0v 694.755n 1.0v 699.745n 1.0v 699.755n 1.0v 704.745n 1.0v 704.755n 1.0v 709.745n 1.0v 709.755n 1.0v 714.745n 1.0v 714.755n 1.0v 719.745n 1.0v 719.755n 0.0v 724.745n 0.0v 724.755n 0.0v 729.745n 0.0v 729.755n 0.0v 734.745n 0.0v 734.755n 0.0v 739.745n 0.0v 739.755n 0.0v 744.745n 0.0v 744.755n 0.0v 749.745n 0.0v 749.755n 0.0v 754.745n 0.0v 754.755n 0.0v 759.745n 0.0v 759.755n 0.0v 764.745n 0.0v 764.755n 0.0v 769.745n 0.0v 769.755n 1.0v 774.745n 1.0v 774.755n 1.0v 779.745n 1.0v 779.755n 1.0v 784.745n 1.0v 784.755n 1.0v 789.745n 1.0v 789.755n 1.0v 794.745n 1.0v 794.755n 1.0v 799.745n 1.0v 799.755n 1.0v 804.745n 1.0v 804.755n 1.0v 809.745n 1.0v 809.755n 1.0v 814.745n 1.0v 814.755n 1.0v 819.745n 1.0v 819.755n 1.0v 824.745n 1.0v 824.755n 1.0v 829.745n 1.0v 829.755n 1.0v 834.745n 1.0v 834.755n 1.0v 839.745n 1.0v 839.755n 1.0v 844.745n 1.0v 844.755n 1.0v 849.745n 1.0v 849.755n 1.0v 854.745n 1.0v 854.755n 1.0v 859.745n 1.0v 859.755n 1.0v 864.745n 1.0v 864.755n 1.0v 869.745n 1.0v 869.755n 1.0v 874.745n 1.0v 874.755n 1.0v 879.745n 1.0v 879.755n 1.0v 884.745n 1.0v 884.755n 1.0v 889.745n 1.0v 889.755n 1.0v 894.745n 1.0v 894.755n 1.0v 899.745n 1.0v 899.755n 1.0v 904.745n 1.0v 904.755n 1.0v 909.745n 1.0v 909.755n 0.0v 914.745n 0.0v 914.755n 0.0v 919.745n 0.0v 919.755n 1.0v 924.745n 1.0v 924.755n 1.0v 929.745n 1.0v 929.755n 1.0v 934.745n 1.0v 934.755n 1.0v 939.745n 1.0v 939.755n 1.0v 944.745n 1.0v 944.755n 1.0v 949.745n 1.0v 949.755n 1.0v 954.745n 1.0v 954.755n 1.0v 959.745n 1.0v 959.755n 1.0v 964.745n 1.0v 964.755n 1.0v 969.745n 1.0v 969.755n 0.0v 974.745n 0.0v 974.755n 0.0v 979.745n 0.0v 979.755n 0.0v 984.745n 0.0v 984.755n 0.0v 989.745n 0.0v 989.755n 0.0v 994.745n 0.0v 994.755n 0.0v 999.745n 0.0v 999.755n 0.0v 1004.745n 0.0v 1004.755n 0.0v 1009.745n 0.0v 1009.755n 0.0v 1014.745n 0.0v 1014.755n 0.0v 1019.745n 0.0v 1019.755n 0.0v 1024.745n 0.0v 1024.755n 0.0v )
* (time, data): [(0, 0), (5, 0), (10, 0), (15, 1), (20, 1), (25, 1), (30, 1), (35, 0), (40, 1), (45, 1), (50, 1), (55, 1), (60, 1), (65, 1), (70, 1), (75, 1), (80, 0), (85, 0), (90, 0), (95, 0), (100, 0), (105, 0), (110, 0), (115, 0), (120, 0), (125, 0), (130, 0), (135, 0), (140, 0), (145, 0), (150, 0), (155, 0), (160, 0), (165, 0), (170, 0), (175, 0), (180, 0), (185, 0), (190, 0), (195, 0), (200, 0), (205, 0), (210, 0), (215, 0), (220, 0), (225, 0), (230, 1), (235, 1), (240, 1), (245, 1), (250, 0), (255, 0), (260, 0), (265, 0), (270, 0), (275, 1), (280, 1), (285, 1), (290, 1), (295, 1), (300, 1), (305, 1), (310, 1), (315, 1), (320, 1), (325, 1), (330, 1), (335, 1), (340, 0), (345, 1), (350, 1), (355, 1), (360, 1), (365, 1), (370, 1), (375, 1), (380, 1), (385, 1), (390, 1), (395, 1), (400, 1), (405, 1), (410, 1), (415, 1), (420, 1), (425, 1), (430, 1), (435, 0), (440, 0), (445, 0), (450, 0), (455, 1), (460, 1), (465, 0), (470, 0), (475, 0), (480, 0), (485, 0), (490, 0), (495, 0), (500, 0), (505, 0), (510, 0), (515, 0), (520, 0), (525, 0), (530, 0), (535, 0), (540, 0), (545, 1), (550, 1), (555, 1), (560, 1), (565, 1), (570, 1), (575, 1), (580, 1), (585, 1), (590, 1), (595, 1), (600, 1), (605, 1), (610, 1), (615, 1), (620, 1), (625, 0), (630, 0), (635, 0), (640, 0), (645, 1), (650, 1), (655, 1), (660, 1), (665, 1), (670, 1), (675, 1), (680, 0), (685, 0), (690, 0), (695, 0), (700, 0), (705, 0), (710, 0), (715, 0), (720, 1), (725, 1), (730, 1), (735, 0), (740, 0), (745, 0), (750, 0), (755, 0), (760, 0), (765, 0), (770, 0), (775, 0), (780, 0), (785, 0), (790, 0), (795, 1), (800, 1), (805, 1), (810, 1), (815, 1), (820, 1), (825, 1), (830, 1), (835, 1), (840, 1), (845, 1), (850, 1), (855, 1), (860, 0), (865, 0), (870, 0), (875, 0), (880, 0), (885, 0), (890, 0), (895, 0), (900, 0), (905, 1), (910, 1), (915, 1), (920, 1), (925, 1), (930, 1), (935, 0), (940, 0), (945, 0), (950, 0), (955, 1), (960, 1), (965, 1), (970, 1), (975, 1), (980, 1), (985, 1), (990, 0), (995, 0), (1000, 0), (1005, 0), (1010, 0), (1015, 1), (1020, 1), (1025, 1)]
Vdin0_17  din0_17  0 PWL (0n 0.0v 4.745n 0.0v 4.755n 0.0v 9.745n 0.0v 9.755n 0.0v 14.745n 0.0v 14.755n 1.0v 19.745n 1.0v 19.755n 1.0v 24.745n 1.0v 24.755n 1.0v 29.745n 1.0v 29.755n 1.0v 34.745n 1.0v 34.755n 0.0v 39.745n 0.0v 39.755n 1.0v 44.745n 1.0v 44.755n 1.0v 49.745n 1.0v 49.755n 1.0v 54.745n 1.0v 54.755n 1.0v 59.745n 1.0v 59.755n 1.0v 64.745n 1.0v 64.755n 1.0v 69.745n 1.0v 69.755n 1.0v 74.745n 1.0v 74.755n 1.0v 79.745n 1.0v 79.755n 0.0v 84.745n 0.0v 84.755n 0.0v 89.745n 0.0v 89.755n 0.0v 94.745n 0.0v 94.755n 0.0v 99.745n 0.0v 99.755n 0.0v 104.745n 0.0v 104.755n 0.0v 109.745n 0.0v 109.755n 0.0v 114.745n 0.0v 114.755n 0.0v 119.745n 0.0v 119.755n 0.0v 124.745n 0.0v 124.755n 0.0v 129.745n 0.0v 129.755n 0.0v 134.745n 0.0v 134.755n 0.0v 139.745n 0.0v 139.755n 0.0v 144.745n 0.0v 144.755n 0.0v 149.745n 0.0v 149.755n 0.0v 154.745n 0.0v 154.755n 0.0v 159.745n 0.0v 159.755n 0.0v 164.745n 0.0v 164.755n 0.0v 169.745n 0.0v 169.755n 0.0v 174.745n 0.0v 174.755n 0.0v 179.745n 0.0v 179.755n 0.0v 184.745n 0.0v 184.755n 0.0v 189.745n 0.0v 189.755n 0.0v 194.745n 0.0v 194.755n 0.0v 199.745n 0.0v 199.755n 0.0v 204.745n 0.0v 204.755n 0.0v 209.745n 0.0v 209.755n 0.0v 214.745n 0.0v 214.755n 0.0v 219.745n 0.0v 219.755n 0.0v 224.745n 0.0v 224.755n 0.0v 229.745n 0.0v 229.755n 1.0v 234.745n 1.0v 234.755n 1.0v 239.745n 1.0v 239.755n 1.0v 244.745n 1.0v 244.755n 1.0v 249.745n 1.0v 249.755n 0.0v 254.745n 0.0v 254.755n 0.0v 259.745n 0.0v 259.755n 0.0v 264.745n 0.0v 264.755n 0.0v 269.745n 0.0v 269.755n 0.0v 274.745n 0.0v 274.755n 1.0v 279.745n 1.0v 279.755n 1.0v 284.745n 1.0v 284.755n 1.0v 289.745n 1.0v 289.755n 1.0v 294.745n 1.0v 294.755n 1.0v 299.745n 1.0v 299.755n 1.0v 304.745n 1.0v 304.755n 1.0v 309.745n 1.0v 309.755n 1.0v 314.745n 1.0v 314.755n 1.0v 319.745n 1.0v 319.755n 1.0v 324.745n 1.0v 324.755n 1.0v 329.745n 1.0v 329.755n 1.0v 334.745n 1.0v 334.755n 1.0v 339.745n 1.0v 339.755n 0.0v 344.745n 0.0v 344.755n 1.0v 349.745n 1.0v 349.755n 1.0v 354.745n 1.0v 354.755n 1.0v 359.745n 1.0v 359.755n 1.0v 364.745n 1.0v 364.755n 1.0v 369.745n 1.0v 369.755n 1.0v 374.745n 1.0v 374.755n 1.0v 379.745n 1.0v 379.755n 1.0v 384.745n 1.0v 384.755n 1.0v 389.745n 1.0v 389.755n 1.0v 394.745n 1.0v 394.755n 1.0v 399.745n 1.0v 399.755n 1.0v 404.745n 1.0v 404.755n 1.0v 409.745n 1.0v 409.755n 1.0v 414.745n 1.0v 414.755n 1.0v 419.745n 1.0v 419.755n 1.0v 424.745n 1.0v 424.755n 1.0v 429.745n 1.0v 429.755n 1.0v 434.745n 1.0v 434.755n 0.0v 439.745n 0.0v 439.755n 0.0v 444.745n 0.0v 444.755n 0.0v 449.745n 0.0v 449.755n 0.0v 454.745n 0.0v 454.755n 1.0v 459.745n 1.0v 459.755n 1.0v 464.745n 1.0v 464.755n 0.0v 469.745n 0.0v 469.755n 0.0v 474.745n 0.0v 474.755n 0.0v 479.745n 0.0v 479.755n 0.0v 484.745n 0.0v 484.755n 0.0v 489.745n 0.0v 489.755n 0.0v 494.745n 0.0v 494.755n 0.0v 499.745n 0.0v 499.755n 0.0v 504.745n 0.0v 504.755n 0.0v 509.745n 0.0v 509.755n 0.0v 514.745n 0.0v 514.755n 0.0v 519.745n 0.0v 519.755n 0.0v 524.745n 0.0v 524.755n 0.0v 529.745n 0.0v 529.755n 0.0v 534.745n 0.0v 534.755n 0.0v 539.745n 0.0v 539.755n 0.0v 544.745n 0.0v 544.755n 1.0v 549.745n 1.0v 549.755n 1.0v 554.745n 1.0v 554.755n 1.0v 559.745n 1.0v 559.755n 1.0v 564.745n 1.0v 564.755n 1.0v 569.745n 1.0v 569.755n 1.0v 574.745n 1.0v 574.755n 1.0v 579.745n 1.0v 579.755n 1.0v 584.745n 1.0v 584.755n 1.0v 589.745n 1.0v 589.755n 1.0v 594.745n 1.0v 594.755n 1.0v 599.745n 1.0v 599.755n 1.0v 604.745n 1.0v 604.755n 1.0v 609.745n 1.0v 609.755n 1.0v 614.745n 1.0v 614.755n 1.0v 619.745n 1.0v 619.755n 1.0v 624.745n 1.0v 624.755n 0.0v 629.745n 0.0v 629.755n 0.0v 634.745n 0.0v 634.755n 0.0v 639.745n 0.0v 639.755n 0.0v 644.745n 0.0v 644.755n 1.0v 649.745n 1.0v 649.755n 1.0v 654.745n 1.0v 654.755n 1.0v 659.745n 1.0v 659.755n 1.0v 664.745n 1.0v 664.755n 1.0v 669.745n 1.0v 669.755n 1.0v 674.745n 1.0v 674.755n 1.0v 679.745n 1.0v 679.755n 0.0v 684.745n 0.0v 684.755n 0.0v 689.745n 0.0v 689.755n 0.0v 694.745n 0.0v 694.755n 0.0v 699.745n 0.0v 699.755n 0.0v 704.745n 0.0v 704.755n 0.0v 709.745n 0.0v 709.755n 0.0v 714.745n 0.0v 714.755n 0.0v 719.745n 0.0v 719.755n 1.0v 724.745n 1.0v 724.755n 1.0v 729.745n 1.0v 729.755n 1.0v 734.745n 1.0v 734.755n 0.0v 739.745n 0.0v 739.755n 0.0v 744.745n 0.0v 744.755n 0.0v 749.745n 0.0v 749.755n 0.0v 754.745n 0.0v 754.755n 0.0v 759.745n 0.0v 759.755n 0.0v 764.745n 0.0v 764.755n 0.0v 769.745n 0.0v 769.755n 0.0v 774.745n 0.0v 774.755n 0.0v 779.745n 0.0v 779.755n 0.0v 784.745n 0.0v 784.755n 0.0v 789.745n 0.0v 789.755n 0.0v 794.745n 0.0v 794.755n 1.0v 799.745n 1.0v 799.755n 1.0v 804.745n 1.0v 804.755n 1.0v 809.745n 1.0v 809.755n 1.0v 814.745n 1.0v 814.755n 1.0v 819.745n 1.0v 819.755n 1.0v 824.745n 1.0v 824.755n 1.0v 829.745n 1.0v 829.755n 1.0v 834.745n 1.0v 834.755n 1.0v 839.745n 1.0v 839.755n 1.0v 844.745n 1.0v 844.755n 1.0v 849.745n 1.0v 849.755n 1.0v 854.745n 1.0v 854.755n 1.0v 859.745n 1.0v 859.755n 0.0v 864.745n 0.0v 864.755n 0.0v 869.745n 0.0v 869.755n 0.0v 874.745n 0.0v 874.755n 0.0v 879.745n 0.0v 879.755n 0.0v 884.745n 0.0v 884.755n 0.0v 889.745n 0.0v 889.755n 0.0v 894.745n 0.0v 894.755n 0.0v 899.745n 0.0v 899.755n 0.0v 904.745n 0.0v 904.755n 1.0v 909.745n 1.0v 909.755n 1.0v 914.745n 1.0v 914.755n 1.0v 919.745n 1.0v 919.755n 1.0v 924.745n 1.0v 924.755n 1.0v 929.745n 1.0v 929.755n 1.0v 934.745n 1.0v 934.755n 0.0v 939.745n 0.0v 939.755n 0.0v 944.745n 0.0v 944.755n 0.0v 949.745n 0.0v 949.755n 0.0v 954.745n 0.0v 954.755n 1.0v 959.745n 1.0v 959.755n 1.0v 964.745n 1.0v 964.755n 1.0v 969.745n 1.0v 969.755n 1.0v 974.745n 1.0v 974.755n 1.0v 979.745n 1.0v 979.755n 1.0v 984.745n 1.0v 984.755n 1.0v 989.745n 1.0v 989.755n 0.0v 994.745n 0.0v 994.755n 0.0v 999.745n 0.0v 999.755n 0.0v 1004.745n 0.0v 1004.755n 0.0v 1009.745n 0.0v 1009.755n 0.0v 1014.745n 0.0v 1014.755n 1.0v 1019.745n 1.0v 1019.755n 1.0v 1024.745n 1.0v 1024.755n 1.0v )
* (time, data): [(0, 0), (5, 1), (10, 1), (15, 0), (20, 0), (25, 0), (30, 1), (35, 0), (40, 0), (45, 0), (50, 0), (55, 0), (60, 0), (65, 0), (70, 0), (75, 0), (80, 0), (85, 0), (90, 0), (95, 0), (100, 0), (105, 0), (110, 0), (115, 0), (120, 0), (125, 0), (130, 0), (135, 0), (140, 0), (145, 0), (150, 0), (155, 0), (160, 0), (165, 0), (170, 0), (175, 0), (180, 0), (185, 0), (190, 0), (195, 0), (200, 0), (205, 0), (210, 0), (215, 0), (220, 0), (225, 0), (230, 1), (235, 1), (240, 1), (245, 1), (250, 0), (255, 0), (260, 0), (265, 0), (270, 0), (275, 0), (280, 0), (285, 1), (290, 1), (295, 1), (300, 1), (305, 1), (310, 1), (315, 1), (320, 1), (325, 1), (330, 1), (335, 1), (340, 1), (345, 1), (350, 1), (355, 1), (360, 1), (365, 1), (370, 1), (375, 1), (380, 1), (385, 1), (390, 1), (395, 1), (400, 1), (405, 1), (410, 1), (415, 1), (420, 1), (425, 1), (430, 1), (435, 0), (440, 0), (445, 0), (450, 0), (455, 0), (460, 0), (465, 1), (470, 1), (475, 1), (480, 1), (485, 1), (490, 1), (495, 1), (500, 1), (505, 1), (510, 0), (515, 0), (520, 0), (525, 0), (530, 0), (535, 0), (540, 0), (545, 0), (550, 0), (555, 0), (560, 0), (565, 0), (570, 0), (575, 0), (580, 0), (585, 0), (590, 0), (595, 0), (600, 0), (605, 0), (610, 0), (615, 1), (620, 1), (625, 1), (630, 1), (635, 1), (640, 1), (645, 0), (650, 0), (655, 0), (660, 0), (665, 0), (670, 0), (675, 0), (680, 1), (685, 1), (690, 1), (695, 1), (700, 1), (705, 1), (710, 1), (715, 1), (720, 1), (725, 1), (730, 1), (735, 0), (740, 0), (745, 0), (750, 0), (755, 0), (760, 0), (765, 0), (770, 0), (775, 0), (780, 0), (785, 0), (790, 0), (795, 1), (800, 1), (805, 1), (810, 1), (815, 1), (820, 0), (825, 0), (830, 0), (835, 0), (840, 0), (845, 0), (850, 1), (855, 1), (860, 1), (865, 1), (870, 1), (875, 1), (880, 1), (885, 1), (890, 1), (895, 1), (900, 1), (905, 1), (910, 0), (915, 0), (920, 0), (925, 0), (930, 0), (935, 1), (940, 1), (945, 1), (950, 1), (955, 0), (960, 1), (965, 1), (970, 1), (975, 1), (980, 1), (985, 1), (990, 0), (995, 0), (1000, 0), (1005, 0), (1010, 0), (1015, 1), (1020, 1), (1025, 1)]
Vdin0_18  din0_18  0 PWL (0n 0.0v 4.745n 0.0v 4.755n 1.0v 9.745n 1.0v 9.755n 1.0v 14.745n 1.0v 14.755n 0.0v 19.745n 0.0v 19.755n 0.0v 24.745n 0.0v 24.755n 0.0v 29.745n 0.0v 29.755n 1.0v 34.745n 1.0v 34.755n 0.0v 39.745n 0.0v 39.755n 0.0v 44.745n 0.0v 44.755n 0.0v 49.745n 0.0v 49.755n 0.0v 54.745n 0.0v 54.755n 0.0v 59.745n 0.0v 59.755n 0.0v 64.745n 0.0v 64.755n 0.0v 69.745n 0.0v 69.755n 0.0v 74.745n 0.0v 74.755n 0.0v 79.745n 0.0v 79.755n 0.0v 84.745n 0.0v 84.755n 0.0v 89.745n 0.0v 89.755n 0.0v 94.745n 0.0v 94.755n 0.0v 99.745n 0.0v 99.755n 0.0v 104.745n 0.0v 104.755n 0.0v 109.745n 0.0v 109.755n 0.0v 114.745n 0.0v 114.755n 0.0v 119.745n 0.0v 119.755n 0.0v 124.745n 0.0v 124.755n 0.0v 129.745n 0.0v 129.755n 0.0v 134.745n 0.0v 134.755n 0.0v 139.745n 0.0v 139.755n 0.0v 144.745n 0.0v 144.755n 0.0v 149.745n 0.0v 149.755n 0.0v 154.745n 0.0v 154.755n 0.0v 159.745n 0.0v 159.755n 0.0v 164.745n 0.0v 164.755n 0.0v 169.745n 0.0v 169.755n 0.0v 174.745n 0.0v 174.755n 0.0v 179.745n 0.0v 179.755n 0.0v 184.745n 0.0v 184.755n 0.0v 189.745n 0.0v 189.755n 0.0v 194.745n 0.0v 194.755n 0.0v 199.745n 0.0v 199.755n 0.0v 204.745n 0.0v 204.755n 0.0v 209.745n 0.0v 209.755n 0.0v 214.745n 0.0v 214.755n 0.0v 219.745n 0.0v 219.755n 0.0v 224.745n 0.0v 224.755n 0.0v 229.745n 0.0v 229.755n 1.0v 234.745n 1.0v 234.755n 1.0v 239.745n 1.0v 239.755n 1.0v 244.745n 1.0v 244.755n 1.0v 249.745n 1.0v 249.755n 0.0v 254.745n 0.0v 254.755n 0.0v 259.745n 0.0v 259.755n 0.0v 264.745n 0.0v 264.755n 0.0v 269.745n 0.0v 269.755n 0.0v 274.745n 0.0v 274.755n 0.0v 279.745n 0.0v 279.755n 0.0v 284.745n 0.0v 284.755n 1.0v 289.745n 1.0v 289.755n 1.0v 294.745n 1.0v 294.755n 1.0v 299.745n 1.0v 299.755n 1.0v 304.745n 1.0v 304.755n 1.0v 309.745n 1.0v 309.755n 1.0v 314.745n 1.0v 314.755n 1.0v 319.745n 1.0v 319.755n 1.0v 324.745n 1.0v 324.755n 1.0v 329.745n 1.0v 329.755n 1.0v 334.745n 1.0v 334.755n 1.0v 339.745n 1.0v 339.755n 1.0v 344.745n 1.0v 344.755n 1.0v 349.745n 1.0v 349.755n 1.0v 354.745n 1.0v 354.755n 1.0v 359.745n 1.0v 359.755n 1.0v 364.745n 1.0v 364.755n 1.0v 369.745n 1.0v 369.755n 1.0v 374.745n 1.0v 374.755n 1.0v 379.745n 1.0v 379.755n 1.0v 384.745n 1.0v 384.755n 1.0v 389.745n 1.0v 389.755n 1.0v 394.745n 1.0v 394.755n 1.0v 399.745n 1.0v 399.755n 1.0v 404.745n 1.0v 404.755n 1.0v 409.745n 1.0v 409.755n 1.0v 414.745n 1.0v 414.755n 1.0v 419.745n 1.0v 419.755n 1.0v 424.745n 1.0v 424.755n 1.0v 429.745n 1.0v 429.755n 1.0v 434.745n 1.0v 434.755n 0.0v 439.745n 0.0v 439.755n 0.0v 444.745n 0.0v 444.755n 0.0v 449.745n 0.0v 449.755n 0.0v 454.745n 0.0v 454.755n 0.0v 459.745n 0.0v 459.755n 0.0v 464.745n 0.0v 464.755n 1.0v 469.745n 1.0v 469.755n 1.0v 474.745n 1.0v 474.755n 1.0v 479.745n 1.0v 479.755n 1.0v 484.745n 1.0v 484.755n 1.0v 489.745n 1.0v 489.755n 1.0v 494.745n 1.0v 494.755n 1.0v 499.745n 1.0v 499.755n 1.0v 504.745n 1.0v 504.755n 1.0v 509.745n 1.0v 509.755n 0.0v 514.745n 0.0v 514.755n 0.0v 519.745n 0.0v 519.755n 0.0v 524.745n 0.0v 524.755n 0.0v 529.745n 0.0v 529.755n 0.0v 534.745n 0.0v 534.755n 0.0v 539.745n 0.0v 539.755n 0.0v 544.745n 0.0v 544.755n 0.0v 549.745n 0.0v 549.755n 0.0v 554.745n 0.0v 554.755n 0.0v 559.745n 0.0v 559.755n 0.0v 564.745n 0.0v 564.755n 0.0v 569.745n 0.0v 569.755n 0.0v 574.745n 0.0v 574.755n 0.0v 579.745n 0.0v 579.755n 0.0v 584.745n 0.0v 584.755n 0.0v 589.745n 0.0v 589.755n 0.0v 594.745n 0.0v 594.755n 0.0v 599.745n 0.0v 599.755n 0.0v 604.745n 0.0v 604.755n 0.0v 609.745n 0.0v 609.755n 0.0v 614.745n 0.0v 614.755n 1.0v 619.745n 1.0v 619.755n 1.0v 624.745n 1.0v 624.755n 1.0v 629.745n 1.0v 629.755n 1.0v 634.745n 1.0v 634.755n 1.0v 639.745n 1.0v 639.755n 1.0v 644.745n 1.0v 644.755n 0.0v 649.745n 0.0v 649.755n 0.0v 654.745n 0.0v 654.755n 0.0v 659.745n 0.0v 659.755n 0.0v 664.745n 0.0v 664.755n 0.0v 669.745n 0.0v 669.755n 0.0v 674.745n 0.0v 674.755n 0.0v 679.745n 0.0v 679.755n 1.0v 684.745n 1.0v 684.755n 1.0v 689.745n 1.0v 689.755n 1.0v 694.745n 1.0v 694.755n 1.0v 699.745n 1.0v 699.755n 1.0v 704.745n 1.0v 704.755n 1.0v 709.745n 1.0v 709.755n 1.0v 714.745n 1.0v 714.755n 1.0v 719.745n 1.0v 719.755n 1.0v 724.745n 1.0v 724.755n 1.0v 729.745n 1.0v 729.755n 1.0v 734.745n 1.0v 734.755n 0.0v 739.745n 0.0v 739.755n 0.0v 744.745n 0.0v 744.755n 0.0v 749.745n 0.0v 749.755n 0.0v 754.745n 0.0v 754.755n 0.0v 759.745n 0.0v 759.755n 0.0v 764.745n 0.0v 764.755n 0.0v 769.745n 0.0v 769.755n 0.0v 774.745n 0.0v 774.755n 0.0v 779.745n 0.0v 779.755n 0.0v 784.745n 0.0v 784.755n 0.0v 789.745n 0.0v 789.755n 0.0v 794.745n 0.0v 794.755n 1.0v 799.745n 1.0v 799.755n 1.0v 804.745n 1.0v 804.755n 1.0v 809.745n 1.0v 809.755n 1.0v 814.745n 1.0v 814.755n 1.0v 819.745n 1.0v 819.755n 0.0v 824.745n 0.0v 824.755n 0.0v 829.745n 0.0v 829.755n 0.0v 834.745n 0.0v 834.755n 0.0v 839.745n 0.0v 839.755n 0.0v 844.745n 0.0v 844.755n 0.0v 849.745n 0.0v 849.755n 1.0v 854.745n 1.0v 854.755n 1.0v 859.745n 1.0v 859.755n 1.0v 864.745n 1.0v 864.755n 1.0v 869.745n 1.0v 869.755n 1.0v 874.745n 1.0v 874.755n 1.0v 879.745n 1.0v 879.755n 1.0v 884.745n 1.0v 884.755n 1.0v 889.745n 1.0v 889.755n 1.0v 894.745n 1.0v 894.755n 1.0v 899.745n 1.0v 899.755n 1.0v 904.745n 1.0v 904.755n 1.0v 909.745n 1.0v 909.755n 0.0v 914.745n 0.0v 914.755n 0.0v 919.745n 0.0v 919.755n 0.0v 924.745n 0.0v 924.755n 0.0v 929.745n 0.0v 929.755n 0.0v 934.745n 0.0v 934.755n 1.0v 939.745n 1.0v 939.755n 1.0v 944.745n 1.0v 944.755n 1.0v 949.745n 1.0v 949.755n 1.0v 954.745n 1.0v 954.755n 0.0v 959.745n 0.0v 959.755n 1.0v 964.745n 1.0v 964.755n 1.0v 969.745n 1.0v 969.755n 1.0v 974.745n 1.0v 974.755n 1.0v 979.745n 1.0v 979.755n 1.0v 984.745n 1.0v 984.755n 1.0v 989.745n 1.0v 989.755n 0.0v 994.745n 0.0v 994.755n 0.0v 999.745n 0.0v 999.755n 0.0v 1004.745n 0.0v 1004.755n 0.0v 1009.745n 0.0v 1009.755n 0.0v 1014.745n 0.0v 1014.755n 1.0v 1019.745n 1.0v 1019.755n 1.0v 1024.745n 1.0v 1024.755n 1.0v )
* (time, data): [(0, 0), (5, 0), (10, 0), (15, 0), (20, 0), (25, 0), (30, 0), (35, 0), (40, 0), (45, 0), (50, 0), (55, 0), (60, 0), (65, 1), (70, 1), (75, 1), (80, 1), (85, 1), (90, 1), (95, 1), (100, 1), (105, 1), (110, 0), (115, 0), (120, 0), (125, 1), (130, 1), (135, 1), (140, 0), (145, 0), (150, 0), (155, 0), (160, 0), (165, 0), (170, 0), (175, 0), (180, 0), (185, 0), (190, 0), (195, 0), (200, 0), (205, 0), (210, 0), (215, 0), (220, 0), (225, 0), (230, 1), (235, 0), (240, 1), (245, 1), (250, 0), (255, 0), (260, 0), (265, 0), (270, 0), (275, 0), (280, 0), (285, 0), (290, 0), (295, 0), (300, 0), (305, 0), (310, 0), (315, 0), (320, 0), (325, 0), (330, 0), (335, 0), (340, 0), (345, 1), (350, 0), (355, 0), (360, 0), (365, 0), (370, 0), (375, 0), (380, 0), (385, 0), (390, 0), (395, 0), (400, 0), (405, 0), (410, 0), (415, 0), (420, 0), (425, 0), (430, 0), (435, 0), (440, 0), (445, 0), (450, 0), (455, 1), (460, 1), (465, 0), (470, 0), (475, 0), (480, 0), (485, 0), (490, 0), (495, 0), (500, 0), (505, 0), (510, 0), (515, 0), (520, 0), (525, 0), (530, 0), (535, 0), (540, 0), (545, 1), (550, 1), (555, 1), (560, 1), (565, 1), (570, 1), (575, 1), (580, 1), (585, 1), (590, 1), (595, 1), (600, 1), (605, 1), (610, 1), (615, 1), (620, 1), (625, 0), (630, 0), (635, 0), (640, 0), (645, 0), (650, 0), (655, 0), (660, 0), (665, 0), (670, 0), (675, 0), (680, 1), (685, 1), (690, 1), (695, 1), (700, 1), (705, 1), (710, 0), (715, 0), (720, 1), (725, 1), (730, 1), (735, 1), (740, 1), (745, 1), (750, 1), (755, 1), (760, 1), (765, 1), (770, 1), (775, 1), (780, 1), (785, 1), (790, 1), (795, 1), (800, 1), (805, 1), (810, 1), (815, 1), (820, 1), (825, 1), (830, 1), (835, 1), (840, 1), (845, 1), (850, 0), (855, 0), (860, 1), (865, 1), (870, 1), (875, 1), (880, 1), (885, 1), (890, 1), (895, 1), (900, 1), (905, 0), (910, 1), (915, 1), (920, 0), (925, 0), (930, 0), (935, 0), (940, 0), (945, 0), (950, 0), (955, 1), (960, 0), (965, 0), (970, 1), (975, 1), (980, 1), (985, 1), (990, 0), (995, 0), (1000, 0), (1005, 0), (1010, 0), (1015, 0), (1020, 0), (1025, 0)]
Vdin0_19  din0_19  0 PWL (0n 0.0v 4.745n 0.0v 4.755n 0.0v 9.745n 0.0v 9.755n 0.0v 14.745n 0.0v 14.755n 0.0v 19.745n 0.0v 19.755n 0.0v 24.745n 0.0v 24.755n 0.0v 29.745n 0.0v 29.755n 0.0v 34.745n 0.0v 34.755n 0.0v 39.745n 0.0v 39.755n 0.0v 44.745n 0.0v 44.755n 0.0v 49.745n 0.0v 49.755n 0.0v 54.745n 0.0v 54.755n 0.0v 59.745n 0.0v 59.755n 0.0v 64.745n 0.0v 64.755n 1.0v 69.745n 1.0v 69.755n 1.0v 74.745n 1.0v 74.755n 1.0v 79.745n 1.0v 79.755n 1.0v 84.745n 1.0v 84.755n 1.0v 89.745n 1.0v 89.755n 1.0v 94.745n 1.0v 94.755n 1.0v 99.745n 1.0v 99.755n 1.0v 104.745n 1.0v 104.755n 1.0v 109.745n 1.0v 109.755n 0.0v 114.745n 0.0v 114.755n 0.0v 119.745n 0.0v 119.755n 0.0v 124.745n 0.0v 124.755n 1.0v 129.745n 1.0v 129.755n 1.0v 134.745n 1.0v 134.755n 1.0v 139.745n 1.0v 139.755n 0.0v 144.745n 0.0v 144.755n 0.0v 149.745n 0.0v 149.755n 0.0v 154.745n 0.0v 154.755n 0.0v 159.745n 0.0v 159.755n 0.0v 164.745n 0.0v 164.755n 0.0v 169.745n 0.0v 169.755n 0.0v 174.745n 0.0v 174.755n 0.0v 179.745n 0.0v 179.755n 0.0v 184.745n 0.0v 184.755n 0.0v 189.745n 0.0v 189.755n 0.0v 194.745n 0.0v 194.755n 0.0v 199.745n 0.0v 199.755n 0.0v 204.745n 0.0v 204.755n 0.0v 209.745n 0.0v 209.755n 0.0v 214.745n 0.0v 214.755n 0.0v 219.745n 0.0v 219.755n 0.0v 224.745n 0.0v 224.755n 0.0v 229.745n 0.0v 229.755n 1.0v 234.745n 1.0v 234.755n 0.0v 239.745n 0.0v 239.755n 1.0v 244.745n 1.0v 244.755n 1.0v 249.745n 1.0v 249.755n 0.0v 254.745n 0.0v 254.755n 0.0v 259.745n 0.0v 259.755n 0.0v 264.745n 0.0v 264.755n 0.0v 269.745n 0.0v 269.755n 0.0v 274.745n 0.0v 274.755n 0.0v 279.745n 0.0v 279.755n 0.0v 284.745n 0.0v 284.755n 0.0v 289.745n 0.0v 289.755n 0.0v 294.745n 0.0v 294.755n 0.0v 299.745n 0.0v 299.755n 0.0v 304.745n 0.0v 304.755n 0.0v 309.745n 0.0v 309.755n 0.0v 314.745n 0.0v 314.755n 0.0v 319.745n 0.0v 319.755n 0.0v 324.745n 0.0v 324.755n 0.0v 329.745n 0.0v 329.755n 0.0v 334.745n 0.0v 334.755n 0.0v 339.745n 0.0v 339.755n 0.0v 344.745n 0.0v 344.755n 1.0v 349.745n 1.0v 349.755n 0.0v 354.745n 0.0v 354.755n 0.0v 359.745n 0.0v 359.755n 0.0v 364.745n 0.0v 364.755n 0.0v 369.745n 0.0v 369.755n 0.0v 374.745n 0.0v 374.755n 0.0v 379.745n 0.0v 379.755n 0.0v 384.745n 0.0v 384.755n 0.0v 389.745n 0.0v 389.755n 0.0v 394.745n 0.0v 394.755n 0.0v 399.745n 0.0v 399.755n 0.0v 404.745n 0.0v 404.755n 0.0v 409.745n 0.0v 409.755n 0.0v 414.745n 0.0v 414.755n 0.0v 419.745n 0.0v 419.755n 0.0v 424.745n 0.0v 424.755n 0.0v 429.745n 0.0v 429.755n 0.0v 434.745n 0.0v 434.755n 0.0v 439.745n 0.0v 439.755n 0.0v 444.745n 0.0v 444.755n 0.0v 449.745n 0.0v 449.755n 0.0v 454.745n 0.0v 454.755n 1.0v 459.745n 1.0v 459.755n 1.0v 464.745n 1.0v 464.755n 0.0v 469.745n 0.0v 469.755n 0.0v 474.745n 0.0v 474.755n 0.0v 479.745n 0.0v 479.755n 0.0v 484.745n 0.0v 484.755n 0.0v 489.745n 0.0v 489.755n 0.0v 494.745n 0.0v 494.755n 0.0v 499.745n 0.0v 499.755n 0.0v 504.745n 0.0v 504.755n 0.0v 509.745n 0.0v 509.755n 0.0v 514.745n 0.0v 514.755n 0.0v 519.745n 0.0v 519.755n 0.0v 524.745n 0.0v 524.755n 0.0v 529.745n 0.0v 529.755n 0.0v 534.745n 0.0v 534.755n 0.0v 539.745n 0.0v 539.755n 0.0v 544.745n 0.0v 544.755n 1.0v 549.745n 1.0v 549.755n 1.0v 554.745n 1.0v 554.755n 1.0v 559.745n 1.0v 559.755n 1.0v 564.745n 1.0v 564.755n 1.0v 569.745n 1.0v 569.755n 1.0v 574.745n 1.0v 574.755n 1.0v 579.745n 1.0v 579.755n 1.0v 584.745n 1.0v 584.755n 1.0v 589.745n 1.0v 589.755n 1.0v 594.745n 1.0v 594.755n 1.0v 599.745n 1.0v 599.755n 1.0v 604.745n 1.0v 604.755n 1.0v 609.745n 1.0v 609.755n 1.0v 614.745n 1.0v 614.755n 1.0v 619.745n 1.0v 619.755n 1.0v 624.745n 1.0v 624.755n 0.0v 629.745n 0.0v 629.755n 0.0v 634.745n 0.0v 634.755n 0.0v 639.745n 0.0v 639.755n 0.0v 644.745n 0.0v 644.755n 0.0v 649.745n 0.0v 649.755n 0.0v 654.745n 0.0v 654.755n 0.0v 659.745n 0.0v 659.755n 0.0v 664.745n 0.0v 664.755n 0.0v 669.745n 0.0v 669.755n 0.0v 674.745n 0.0v 674.755n 0.0v 679.745n 0.0v 679.755n 1.0v 684.745n 1.0v 684.755n 1.0v 689.745n 1.0v 689.755n 1.0v 694.745n 1.0v 694.755n 1.0v 699.745n 1.0v 699.755n 1.0v 704.745n 1.0v 704.755n 1.0v 709.745n 1.0v 709.755n 0.0v 714.745n 0.0v 714.755n 0.0v 719.745n 0.0v 719.755n 1.0v 724.745n 1.0v 724.755n 1.0v 729.745n 1.0v 729.755n 1.0v 734.745n 1.0v 734.755n 1.0v 739.745n 1.0v 739.755n 1.0v 744.745n 1.0v 744.755n 1.0v 749.745n 1.0v 749.755n 1.0v 754.745n 1.0v 754.755n 1.0v 759.745n 1.0v 759.755n 1.0v 764.745n 1.0v 764.755n 1.0v 769.745n 1.0v 769.755n 1.0v 774.745n 1.0v 774.755n 1.0v 779.745n 1.0v 779.755n 1.0v 784.745n 1.0v 784.755n 1.0v 789.745n 1.0v 789.755n 1.0v 794.745n 1.0v 794.755n 1.0v 799.745n 1.0v 799.755n 1.0v 804.745n 1.0v 804.755n 1.0v 809.745n 1.0v 809.755n 1.0v 814.745n 1.0v 814.755n 1.0v 819.745n 1.0v 819.755n 1.0v 824.745n 1.0v 824.755n 1.0v 829.745n 1.0v 829.755n 1.0v 834.745n 1.0v 834.755n 1.0v 839.745n 1.0v 839.755n 1.0v 844.745n 1.0v 844.755n 1.0v 849.745n 1.0v 849.755n 0.0v 854.745n 0.0v 854.755n 0.0v 859.745n 0.0v 859.755n 1.0v 864.745n 1.0v 864.755n 1.0v 869.745n 1.0v 869.755n 1.0v 874.745n 1.0v 874.755n 1.0v 879.745n 1.0v 879.755n 1.0v 884.745n 1.0v 884.755n 1.0v 889.745n 1.0v 889.755n 1.0v 894.745n 1.0v 894.755n 1.0v 899.745n 1.0v 899.755n 1.0v 904.745n 1.0v 904.755n 0.0v 909.745n 0.0v 909.755n 1.0v 914.745n 1.0v 914.755n 1.0v 919.745n 1.0v 919.755n 0.0v 924.745n 0.0v 924.755n 0.0v 929.745n 0.0v 929.755n 0.0v 934.745n 0.0v 934.755n 0.0v 939.745n 0.0v 939.755n 0.0v 944.745n 0.0v 944.755n 0.0v 949.745n 0.0v 949.755n 0.0v 954.745n 0.0v 954.755n 1.0v 959.745n 1.0v 959.755n 0.0v 964.745n 0.0v 964.755n 0.0v 969.745n 0.0v 969.755n 1.0v 974.745n 1.0v 974.755n 1.0v 979.745n 1.0v 979.755n 1.0v 984.745n 1.0v 984.755n 1.0v 989.745n 1.0v 989.755n 0.0v 994.745n 0.0v 994.755n 0.0v 999.745n 0.0v 999.755n 0.0v 1004.745n 0.0v 1004.755n 0.0v 1009.745n 0.0v 1009.755n 0.0v 1014.745n 0.0v 1014.755n 0.0v 1019.745n 0.0v 1019.755n 0.0v 1024.745n 0.0v 1024.755n 0.0v )
* (time, data): [(0, 0), (5, 1), (10, 1), (15, 1), (20, 1), (25, 1), (30, 1), (35, 0), (40, 1), (45, 1), (50, 1), (55, 1), (60, 1), (65, 0), (70, 0), (75, 0), (80, 1), (85, 1), (90, 1), (95, 1), (100, 1), (105, 1), (110, 1), (115, 1), (120, 1), (125, 0), (130, 0), (135, 0), (140, 1), (145, 1), (150, 1), (155, 1), (160, 1), (165, 1), (170, 1), (175, 1), (180, 1), (185, 1), (190, 1), (195, 1), (200, 1), (205, 1), (210, 1), (215, 1), (220, 1), (225, 1), (230, 1), (235, 1), (240, 0), (245, 1), (250, 1), (255, 1), (260, 1), (265, 1), (270, 1), (275, 0), (280, 0), (285, 0), (290, 0), (295, 0), (300, 0), (305, 0), (310, 0), (315, 0), (320, 0), (325, 0), (330, 0), (335, 0), (340, 1), (345, 0), (350, 1), (355, 1), (360, 1), (365, 1), (370, 1), (375, 1), (380, 1), (385, 1), (390, 1), (395, 1), (400, 1), (405, 1), (410, 1), (415, 1), (420, 1), (425, 1), (430, 1), (435, 0), (440, 0), (445, 0), (450, 0), (455, 0), (460, 0), (465, 0), (470, 0), (475, 0), (480, 0), (485, 0), (490, 0), (495, 0), (500, 0), (505, 0), (510, 0), (515, 0), (520, 0), (525, 0), (530, 0), (535, 0), (540, 0), (545, 0), (550, 0), (555, 0), (560, 0), (565, 0), (570, 0), (575, 0), (580, 0), (585, 0), (590, 0), (595, 0), (600, 0), (605, 0), (610, 0), (615, 1), (620, 1), (625, 1), (630, 1), (635, 1), (640, 1), (645, 0), (650, 0), (655, 0), (660, 0), (665, 0), (670, 0), (675, 0), (680, 1), (685, 1), (690, 1), (695, 1), (700, 1), (705, 1), (710, 1), (715, 1), (720, 0), (725, 0), (730, 0), (735, 1), (740, 1), (745, 1), (750, 1), (755, 1), (760, 1), (765, 1), (770, 1), (775, 1), (780, 1), (785, 1), (790, 1), (795, 1), (800, 1), (805, 1), (810, 1), (815, 1), (820, 1), (825, 1), (830, 1), (835, 1), (840, 1), (845, 1), (850, 0), (855, 0), (860, 0), (865, 0), (870, 0), (875, 0), (880, 0), (885, 0), (890, 0), (895, 0), (900, 0), (905, 0), (910, 1), (915, 1), (920, 1), (925, 1), (930, 1), (935, 0), (940, 0), (945, 0), (950, 0), (955, 0), (960, 0), (965, 0), (970, 1), (975, 1), (980, 1), (985, 1), (990, 1), (995, 1), (1000, 1), (1005, 1), (1010, 1), (1015, 1), (1020, 1), (1025, 1)]
Vdin0_20  din0_20  0 PWL (0n 0.0v 4.745n 0.0v 4.755n 1.0v 9.745n 1.0v 9.755n 1.0v 14.745n 1.0v 14.755n 1.0v 19.745n 1.0v 19.755n 1.0v 24.745n 1.0v 24.755n 1.0v 29.745n 1.0v 29.755n 1.0v 34.745n 1.0v 34.755n 0.0v 39.745n 0.0v 39.755n 1.0v 44.745n 1.0v 44.755n 1.0v 49.745n 1.0v 49.755n 1.0v 54.745n 1.0v 54.755n 1.0v 59.745n 1.0v 59.755n 1.0v 64.745n 1.0v 64.755n 0.0v 69.745n 0.0v 69.755n 0.0v 74.745n 0.0v 74.755n 0.0v 79.745n 0.0v 79.755n 1.0v 84.745n 1.0v 84.755n 1.0v 89.745n 1.0v 89.755n 1.0v 94.745n 1.0v 94.755n 1.0v 99.745n 1.0v 99.755n 1.0v 104.745n 1.0v 104.755n 1.0v 109.745n 1.0v 109.755n 1.0v 114.745n 1.0v 114.755n 1.0v 119.745n 1.0v 119.755n 1.0v 124.745n 1.0v 124.755n 0.0v 129.745n 0.0v 129.755n 0.0v 134.745n 0.0v 134.755n 0.0v 139.745n 0.0v 139.755n 1.0v 144.745n 1.0v 144.755n 1.0v 149.745n 1.0v 149.755n 1.0v 154.745n 1.0v 154.755n 1.0v 159.745n 1.0v 159.755n 1.0v 164.745n 1.0v 164.755n 1.0v 169.745n 1.0v 169.755n 1.0v 174.745n 1.0v 174.755n 1.0v 179.745n 1.0v 179.755n 1.0v 184.745n 1.0v 184.755n 1.0v 189.745n 1.0v 189.755n 1.0v 194.745n 1.0v 194.755n 1.0v 199.745n 1.0v 199.755n 1.0v 204.745n 1.0v 204.755n 1.0v 209.745n 1.0v 209.755n 1.0v 214.745n 1.0v 214.755n 1.0v 219.745n 1.0v 219.755n 1.0v 224.745n 1.0v 224.755n 1.0v 229.745n 1.0v 229.755n 1.0v 234.745n 1.0v 234.755n 1.0v 239.745n 1.0v 239.755n 0.0v 244.745n 0.0v 244.755n 1.0v 249.745n 1.0v 249.755n 1.0v 254.745n 1.0v 254.755n 1.0v 259.745n 1.0v 259.755n 1.0v 264.745n 1.0v 264.755n 1.0v 269.745n 1.0v 269.755n 1.0v 274.745n 1.0v 274.755n 0.0v 279.745n 0.0v 279.755n 0.0v 284.745n 0.0v 284.755n 0.0v 289.745n 0.0v 289.755n 0.0v 294.745n 0.0v 294.755n 0.0v 299.745n 0.0v 299.755n 0.0v 304.745n 0.0v 304.755n 0.0v 309.745n 0.0v 309.755n 0.0v 314.745n 0.0v 314.755n 0.0v 319.745n 0.0v 319.755n 0.0v 324.745n 0.0v 324.755n 0.0v 329.745n 0.0v 329.755n 0.0v 334.745n 0.0v 334.755n 0.0v 339.745n 0.0v 339.755n 1.0v 344.745n 1.0v 344.755n 0.0v 349.745n 0.0v 349.755n 1.0v 354.745n 1.0v 354.755n 1.0v 359.745n 1.0v 359.755n 1.0v 364.745n 1.0v 364.755n 1.0v 369.745n 1.0v 369.755n 1.0v 374.745n 1.0v 374.755n 1.0v 379.745n 1.0v 379.755n 1.0v 384.745n 1.0v 384.755n 1.0v 389.745n 1.0v 389.755n 1.0v 394.745n 1.0v 394.755n 1.0v 399.745n 1.0v 399.755n 1.0v 404.745n 1.0v 404.755n 1.0v 409.745n 1.0v 409.755n 1.0v 414.745n 1.0v 414.755n 1.0v 419.745n 1.0v 419.755n 1.0v 424.745n 1.0v 424.755n 1.0v 429.745n 1.0v 429.755n 1.0v 434.745n 1.0v 434.755n 0.0v 439.745n 0.0v 439.755n 0.0v 444.745n 0.0v 444.755n 0.0v 449.745n 0.0v 449.755n 0.0v 454.745n 0.0v 454.755n 0.0v 459.745n 0.0v 459.755n 0.0v 464.745n 0.0v 464.755n 0.0v 469.745n 0.0v 469.755n 0.0v 474.745n 0.0v 474.755n 0.0v 479.745n 0.0v 479.755n 0.0v 484.745n 0.0v 484.755n 0.0v 489.745n 0.0v 489.755n 0.0v 494.745n 0.0v 494.755n 0.0v 499.745n 0.0v 499.755n 0.0v 504.745n 0.0v 504.755n 0.0v 509.745n 0.0v 509.755n 0.0v 514.745n 0.0v 514.755n 0.0v 519.745n 0.0v 519.755n 0.0v 524.745n 0.0v 524.755n 0.0v 529.745n 0.0v 529.755n 0.0v 534.745n 0.0v 534.755n 0.0v 539.745n 0.0v 539.755n 0.0v 544.745n 0.0v 544.755n 0.0v 549.745n 0.0v 549.755n 0.0v 554.745n 0.0v 554.755n 0.0v 559.745n 0.0v 559.755n 0.0v 564.745n 0.0v 564.755n 0.0v 569.745n 0.0v 569.755n 0.0v 574.745n 0.0v 574.755n 0.0v 579.745n 0.0v 579.755n 0.0v 584.745n 0.0v 584.755n 0.0v 589.745n 0.0v 589.755n 0.0v 594.745n 0.0v 594.755n 0.0v 599.745n 0.0v 599.755n 0.0v 604.745n 0.0v 604.755n 0.0v 609.745n 0.0v 609.755n 0.0v 614.745n 0.0v 614.755n 1.0v 619.745n 1.0v 619.755n 1.0v 624.745n 1.0v 624.755n 1.0v 629.745n 1.0v 629.755n 1.0v 634.745n 1.0v 634.755n 1.0v 639.745n 1.0v 639.755n 1.0v 644.745n 1.0v 644.755n 0.0v 649.745n 0.0v 649.755n 0.0v 654.745n 0.0v 654.755n 0.0v 659.745n 0.0v 659.755n 0.0v 664.745n 0.0v 664.755n 0.0v 669.745n 0.0v 669.755n 0.0v 674.745n 0.0v 674.755n 0.0v 679.745n 0.0v 679.755n 1.0v 684.745n 1.0v 684.755n 1.0v 689.745n 1.0v 689.755n 1.0v 694.745n 1.0v 694.755n 1.0v 699.745n 1.0v 699.755n 1.0v 704.745n 1.0v 704.755n 1.0v 709.745n 1.0v 709.755n 1.0v 714.745n 1.0v 714.755n 1.0v 719.745n 1.0v 719.755n 0.0v 724.745n 0.0v 724.755n 0.0v 729.745n 0.0v 729.755n 0.0v 734.745n 0.0v 734.755n 1.0v 739.745n 1.0v 739.755n 1.0v 744.745n 1.0v 744.755n 1.0v 749.745n 1.0v 749.755n 1.0v 754.745n 1.0v 754.755n 1.0v 759.745n 1.0v 759.755n 1.0v 764.745n 1.0v 764.755n 1.0v 769.745n 1.0v 769.755n 1.0v 774.745n 1.0v 774.755n 1.0v 779.745n 1.0v 779.755n 1.0v 784.745n 1.0v 784.755n 1.0v 789.745n 1.0v 789.755n 1.0v 794.745n 1.0v 794.755n 1.0v 799.745n 1.0v 799.755n 1.0v 804.745n 1.0v 804.755n 1.0v 809.745n 1.0v 809.755n 1.0v 814.745n 1.0v 814.755n 1.0v 819.745n 1.0v 819.755n 1.0v 824.745n 1.0v 824.755n 1.0v 829.745n 1.0v 829.755n 1.0v 834.745n 1.0v 834.755n 1.0v 839.745n 1.0v 839.755n 1.0v 844.745n 1.0v 844.755n 1.0v 849.745n 1.0v 849.755n 0.0v 854.745n 0.0v 854.755n 0.0v 859.745n 0.0v 859.755n 0.0v 864.745n 0.0v 864.755n 0.0v 869.745n 0.0v 869.755n 0.0v 874.745n 0.0v 874.755n 0.0v 879.745n 0.0v 879.755n 0.0v 884.745n 0.0v 884.755n 0.0v 889.745n 0.0v 889.755n 0.0v 894.745n 0.0v 894.755n 0.0v 899.745n 0.0v 899.755n 0.0v 904.745n 0.0v 904.755n 0.0v 909.745n 0.0v 909.755n 1.0v 914.745n 1.0v 914.755n 1.0v 919.745n 1.0v 919.755n 1.0v 924.745n 1.0v 924.755n 1.0v 929.745n 1.0v 929.755n 1.0v 934.745n 1.0v 934.755n 0.0v 939.745n 0.0v 939.755n 0.0v 944.745n 0.0v 944.755n 0.0v 949.745n 0.0v 949.755n 0.0v 954.745n 0.0v 954.755n 0.0v 959.745n 0.0v 959.755n 0.0v 964.745n 0.0v 964.755n 0.0v 969.745n 0.0v 969.755n 1.0v 974.745n 1.0v 974.755n 1.0v 979.745n 1.0v 979.755n 1.0v 984.745n 1.0v 984.755n 1.0v 989.745n 1.0v 989.755n 1.0v 994.745n 1.0v 994.755n 1.0v 999.745n 1.0v 999.755n 1.0v 1004.745n 1.0v 1004.755n 1.0v 1009.745n 1.0v 1009.755n 1.0v 1014.745n 1.0v 1014.755n 1.0v 1019.745n 1.0v 1019.755n 1.0v 1024.745n 1.0v 1024.755n 1.0v )
* (time, data): [(0, 0), (5, 1), (10, 0), (15, 0), (20, 0), (25, 0), (30, 1), (35, 0), (40, 0), (45, 0), (50, 0), (55, 0), (60, 0), (65, 0), (70, 0), (75, 0), (80, 0), (85, 0), (90, 0), (95, 0), (100, 0), (105, 0), (110, 0), (115, 0), (120, 0), (125, 0), (130, 0), (135, 0), (140, 1), (145, 0), (150, 0), (155, 0), (160, 0), (165, 0), (170, 0), (175, 0), (180, 0), (185, 0), (190, 0), (195, 0), (200, 0), (205, 0), (210, 0), (215, 0), (220, 0), (225, 0), (230, 0), (235, 0), (240, 0), (245, 0), (250, 1), (255, 1), (260, 1), (265, 1), (270, 1), (275, 0), (280, 0), (285, 0), (290, 0), (295, 0), (300, 1), (305, 1), (310, 1), (315, 1), (320, 1), (325, 1), (330, 1), (335, 1), (340, 1), (345, 0), (350, 0), (355, 0), (360, 0), (365, 0), (370, 0), (375, 0), (380, 0), (385, 0), (390, 0), (395, 0), (400, 0), (405, 0), (410, 0), (415, 0), (420, 0), (425, 0), (430, 0), (435, 0), (440, 0), (445, 0), (450, 0), (455, 1), (460, 1), (465, 1), (470, 1), (475, 1), (480, 1), (485, 1), (490, 1), (495, 1), (500, 1), (505, 1), (510, 1), (515, 1), (520, 1), (525, 1), (530, 1), (535, 1), (540, 1), (545, 0), (550, 0), (555, 0), (560, 0), (565, 0), (570, 0), (575, 0), (580, 0), (585, 0), (590, 0), (595, 0), (600, 0), (605, 0), (610, 0), (615, 0), (620, 0), (625, 0), (630, 0), (635, 0), (640, 0), (645, 1), (650, 1), (655, 1), (660, 1), (665, 1), (670, 1), (675, 1), (680, 1), (685, 1), (690, 1), (695, 1), (700, 1), (705, 1), (710, 0), (715, 0), (720, 1), (725, 1), (730, 1), (735, 1), (740, 1), (745, 1), (750, 1), (755, 1), (760, 1), (765, 1), (770, 1), (775, 1), (780, 0), (785, 0), (790, 0), (795, 0), (800, 0), (805, 0), (810, 0), (815, 0), (820, 0), (825, 0), (830, 0), (835, 0), (840, 0), (845, 0), (850, 1), (855, 1), (860, 0), (865, 0), (870, 0), (875, 0), (880, 0), (885, 0), (890, 0), (895, 0), (900, 0), (905, 0), (910, 0), (915, 0), (920, 1), (925, 1), (930, 1), (935, 0), (940, 0), (945, 0), (950, 0), (955, 1), (960, 0), (965, 0), (970, 0), (975, 0), (980, 0), (985, 0), (990, 0), (995, 0), (1000, 0), (1005, 0), (1010, 0), (1015, 0), (1020, 0), (1025, 0)]
Vdin0_21  din0_21  0 PWL (0n 0.0v 4.745n 0.0v 4.755n 1.0v 9.745n 1.0v 9.755n 0.0v 14.745n 0.0v 14.755n 0.0v 19.745n 0.0v 19.755n 0.0v 24.745n 0.0v 24.755n 0.0v 29.745n 0.0v 29.755n 1.0v 34.745n 1.0v 34.755n 0.0v 39.745n 0.0v 39.755n 0.0v 44.745n 0.0v 44.755n 0.0v 49.745n 0.0v 49.755n 0.0v 54.745n 0.0v 54.755n 0.0v 59.745n 0.0v 59.755n 0.0v 64.745n 0.0v 64.755n 0.0v 69.745n 0.0v 69.755n 0.0v 74.745n 0.0v 74.755n 0.0v 79.745n 0.0v 79.755n 0.0v 84.745n 0.0v 84.755n 0.0v 89.745n 0.0v 89.755n 0.0v 94.745n 0.0v 94.755n 0.0v 99.745n 0.0v 99.755n 0.0v 104.745n 0.0v 104.755n 0.0v 109.745n 0.0v 109.755n 0.0v 114.745n 0.0v 114.755n 0.0v 119.745n 0.0v 119.755n 0.0v 124.745n 0.0v 124.755n 0.0v 129.745n 0.0v 129.755n 0.0v 134.745n 0.0v 134.755n 0.0v 139.745n 0.0v 139.755n 1.0v 144.745n 1.0v 144.755n 0.0v 149.745n 0.0v 149.755n 0.0v 154.745n 0.0v 154.755n 0.0v 159.745n 0.0v 159.755n 0.0v 164.745n 0.0v 164.755n 0.0v 169.745n 0.0v 169.755n 0.0v 174.745n 0.0v 174.755n 0.0v 179.745n 0.0v 179.755n 0.0v 184.745n 0.0v 184.755n 0.0v 189.745n 0.0v 189.755n 0.0v 194.745n 0.0v 194.755n 0.0v 199.745n 0.0v 199.755n 0.0v 204.745n 0.0v 204.755n 0.0v 209.745n 0.0v 209.755n 0.0v 214.745n 0.0v 214.755n 0.0v 219.745n 0.0v 219.755n 0.0v 224.745n 0.0v 224.755n 0.0v 229.745n 0.0v 229.755n 0.0v 234.745n 0.0v 234.755n 0.0v 239.745n 0.0v 239.755n 0.0v 244.745n 0.0v 244.755n 0.0v 249.745n 0.0v 249.755n 1.0v 254.745n 1.0v 254.755n 1.0v 259.745n 1.0v 259.755n 1.0v 264.745n 1.0v 264.755n 1.0v 269.745n 1.0v 269.755n 1.0v 274.745n 1.0v 274.755n 0.0v 279.745n 0.0v 279.755n 0.0v 284.745n 0.0v 284.755n 0.0v 289.745n 0.0v 289.755n 0.0v 294.745n 0.0v 294.755n 0.0v 299.745n 0.0v 299.755n 1.0v 304.745n 1.0v 304.755n 1.0v 309.745n 1.0v 309.755n 1.0v 314.745n 1.0v 314.755n 1.0v 319.745n 1.0v 319.755n 1.0v 324.745n 1.0v 324.755n 1.0v 329.745n 1.0v 329.755n 1.0v 334.745n 1.0v 334.755n 1.0v 339.745n 1.0v 339.755n 1.0v 344.745n 1.0v 344.755n 0.0v 349.745n 0.0v 349.755n 0.0v 354.745n 0.0v 354.755n 0.0v 359.745n 0.0v 359.755n 0.0v 364.745n 0.0v 364.755n 0.0v 369.745n 0.0v 369.755n 0.0v 374.745n 0.0v 374.755n 0.0v 379.745n 0.0v 379.755n 0.0v 384.745n 0.0v 384.755n 0.0v 389.745n 0.0v 389.755n 0.0v 394.745n 0.0v 394.755n 0.0v 399.745n 0.0v 399.755n 0.0v 404.745n 0.0v 404.755n 0.0v 409.745n 0.0v 409.755n 0.0v 414.745n 0.0v 414.755n 0.0v 419.745n 0.0v 419.755n 0.0v 424.745n 0.0v 424.755n 0.0v 429.745n 0.0v 429.755n 0.0v 434.745n 0.0v 434.755n 0.0v 439.745n 0.0v 439.755n 0.0v 444.745n 0.0v 444.755n 0.0v 449.745n 0.0v 449.755n 0.0v 454.745n 0.0v 454.755n 1.0v 459.745n 1.0v 459.755n 1.0v 464.745n 1.0v 464.755n 1.0v 469.745n 1.0v 469.755n 1.0v 474.745n 1.0v 474.755n 1.0v 479.745n 1.0v 479.755n 1.0v 484.745n 1.0v 484.755n 1.0v 489.745n 1.0v 489.755n 1.0v 494.745n 1.0v 494.755n 1.0v 499.745n 1.0v 499.755n 1.0v 504.745n 1.0v 504.755n 1.0v 509.745n 1.0v 509.755n 1.0v 514.745n 1.0v 514.755n 1.0v 519.745n 1.0v 519.755n 1.0v 524.745n 1.0v 524.755n 1.0v 529.745n 1.0v 529.755n 1.0v 534.745n 1.0v 534.755n 1.0v 539.745n 1.0v 539.755n 1.0v 544.745n 1.0v 544.755n 0.0v 549.745n 0.0v 549.755n 0.0v 554.745n 0.0v 554.755n 0.0v 559.745n 0.0v 559.755n 0.0v 564.745n 0.0v 564.755n 0.0v 569.745n 0.0v 569.755n 0.0v 574.745n 0.0v 574.755n 0.0v 579.745n 0.0v 579.755n 0.0v 584.745n 0.0v 584.755n 0.0v 589.745n 0.0v 589.755n 0.0v 594.745n 0.0v 594.755n 0.0v 599.745n 0.0v 599.755n 0.0v 604.745n 0.0v 604.755n 0.0v 609.745n 0.0v 609.755n 0.0v 614.745n 0.0v 614.755n 0.0v 619.745n 0.0v 619.755n 0.0v 624.745n 0.0v 624.755n 0.0v 629.745n 0.0v 629.755n 0.0v 634.745n 0.0v 634.755n 0.0v 639.745n 0.0v 639.755n 0.0v 644.745n 0.0v 644.755n 1.0v 649.745n 1.0v 649.755n 1.0v 654.745n 1.0v 654.755n 1.0v 659.745n 1.0v 659.755n 1.0v 664.745n 1.0v 664.755n 1.0v 669.745n 1.0v 669.755n 1.0v 674.745n 1.0v 674.755n 1.0v 679.745n 1.0v 679.755n 1.0v 684.745n 1.0v 684.755n 1.0v 689.745n 1.0v 689.755n 1.0v 694.745n 1.0v 694.755n 1.0v 699.745n 1.0v 699.755n 1.0v 704.745n 1.0v 704.755n 1.0v 709.745n 1.0v 709.755n 0.0v 714.745n 0.0v 714.755n 0.0v 719.745n 0.0v 719.755n 1.0v 724.745n 1.0v 724.755n 1.0v 729.745n 1.0v 729.755n 1.0v 734.745n 1.0v 734.755n 1.0v 739.745n 1.0v 739.755n 1.0v 744.745n 1.0v 744.755n 1.0v 749.745n 1.0v 749.755n 1.0v 754.745n 1.0v 754.755n 1.0v 759.745n 1.0v 759.755n 1.0v 764.745n 1.0v 764.755n 1.0v 769.745n 1.0v 769.755n 1.0v 774.745n 1.0v 774.755n 1.0v 779.745n 1.0v 779.755n 0.0v 784.745n 0.0v 784.755n 0.0v 789.745n 0.0v 789.755n 0.0v 794.745n 0.0v 794.755n 0.0v 799.745n 0.0v 799.755n 0.0v 804.745n 0.0v 804.755n 0.0v 809.745n 0.0v 809.755n 0.0v 814.745n 0.0v 814.755n 0.0v 819.745n 0.0v 819.755n 0.0v 824.745n 0.0v 824.755n 0.0v 829.745n 0.0v 829.755n 0.0v 834.745n 0.0v 834.755n 0.0v 839.745n 0.0v 839.755n 0.0v 844.745n 0.0v 844.755n 0.0v 849.745n 0.0v 849.755n 1.0v 854.745n 1.0v 854.755n 1.0v 859.745n 1.0v 859.755n 0.0v 864.745n 0.0v 864.755n 0.0v 869.745n 0.0v 869.755n 0.0v 874.745n 0.0v 874.755n 0.0v 879.745n 0.0v 879.755n 0.0v 884.745n 0.0v 884.755n 0.0v 889.745n 0.0v 889.755n 0.0v 894.745n 0.0v 894.755n 0.0v 899.745n 0.0v 899.755n 0.0v 904.745n 0.0v 904.755n 0.0v 909.745n 0.0v 909.755n 0.0v 914.745n 0.0v 914.755n 0.0v 919.745n 0.0v 919.755n 1.0v 924.745n 1.0v 924.755n 1.0v 929.745n 1.0v 929.755n 1.0v 934.745n 1.0v 934.755n 0.0v 939.745n 0.0v 939.755n 0.0v 944.745n 0.0v 944.755n 0.0v 949.745n 0.0v 949.755n 0.0v 954.745n 0.0v 954.755n 1.0v 959.745n 1.0v 959.755n 0.0v 964.745n 0.0v 964.755n 0.0v 969.745n 0.0v 969.755n 0.0v 974.745n 0.0v 974.755n 0.0v 979.745n 0.0v 979.755n 0.0v 984.745n 0.0v 984.755n 0.0v 989.745n 0.0v 989.755n 0.0v 994.745n 0.0v 994.755n 0.0v 999.745n 0.0v 999.755n 0.0v 1004.745n 0.0v 1004.755n 0.0v 1009.745n 0.0v 1009.755n 0.0v 1014.745n 0.0v 1014.755n 0.0v 1019.745n 0.0v 1019.755n 0.0v 1024.745n 0.0v 1024.755n 0.0v )
* (time, data): [(0, 0), (5, 0), (10, 0), (15, 1), (20, 1), (25, 1), (30, 0), (35, 0), (40, 1), (45, 1), (50, 1), (55, 1), (60, 1), (65, 1), (70, 1), (75, 1), (80, 0), (85, 0), (90, 0), (95, 0), (100, 0), (105, 0), (110, 0), (115, 0), (120, 0), (125, 1), (130, 1), (135, 1), (140, 0), (145, 0), (150, 0), (155, 0), (160, 0), (165, 0), (170, 0), (175, 0), (180, 0), (185, 0), (190, 0), (195, 0), (200, 0), (205, 0), (210, 0), (215, 0), (220, 0), (225, 0), (230, 0), (235, 1), (240, 1), (245, 1), (250, 1), (255, 1), (260, 1), (265, 1), (270, 1), (275, 0), (280, 0), (285, 1), (290, 1), (295, 1), (300, 1), (305, 1), (310, 1), (315, 1), (320, 1), (325, 1), (330, 1), (335, 1), (340, 1), (345, 1), (350, 1), (355, 1), (360, 1), (365, 1), (370, 1), (375, 1), (380, 1), (385, 1), (390, 1), (395, 1), (400, 1), (405, 1), (410, 1), (415, 1), (420, 1), (425, 1), (430, 1), (435, 0), (440, 0), (445, 0), (450, 0), (455, 0), (460, 0), (465, 1), (470, 1), (475, 1), (480, 1), (485, 1), (490, 1), (495, 1), (500, 1), (505, 1), (510, 0), (515, 0), (520, 0), (525, 0), (530, 0), (535, 0), (540, 0), (545, 1), (550, 1), (555, 1), (560, 1), (565, 1), (570, 1), (575, 1), (580, 1), (585, 1), (590, 1), (595, 1), (600, 1), (605, 1), (610, 1), (615, 1), (620, 1), (625, 0), (630, 0), (635, 0), (640, 0), (645, 0), (650, 0), (655, 0), (660, 0), (665, 0), (670, 0), (675, 0), (680, 0), (685, 0), (690, 0), (695, 0), (700, 0), (705, 0), (710, 0), (715, 0), (720, 1), (725, 1), (730, 1), (735, 0), (740, 0), (745, 0), (750, 0), (755, 0), (760, 0), (765, 0), (770, 1), (775, 1), (780, 1), (785, 1), (790, 1), (795, 0), (800, 0), (805, 0), (810, 0), (815, 0), (820, 1), (825, 1), (830, 1), (835, 1), (840, 1), (845, 1), (850, 0), (855, 0), (860, 1), (865, 1), (870, 1), (875, 1), (880, 1), (885, 1), (890, 1), (895, 1), (900, 1), (905, 0), (910, 1), (915, 1), (920, 0), (925, 0), (930, 0), (935, 1), (940, 1), (945, 1), (950, 1), (955, 1), (960, 1), (965, 1), (970, 0), (975, 0), (980, 0), (985, 0), (990, 0), (995, 0), (1000, 0), (1005, 0), (1010, 0), (1015, 1), (1020, 1), (1025, 1)]
Vdin0_22  din0_22  0 PWL (0n 0.0v 4.745n 0.0v 4.755n 0.0v 9.745n 0.0v 9.755n 0.0v 14.745n 0.0v 14.755n 1.0v 19.745n 1.0v 19.755n 1.0v 24.745n 1.0v 24.755n 1.0v 29.745n 1.0v 29.755n 0.0v 34.745n 0.0v 34.755n 0.0v 39.745n 0.0v 39.755n 1.0v 44.745n 1.0v 44.755n 1.0v 49.745n 1.0v 49.755n 1.0v 54.745n 1.0v 54.755n 1.0v 59.745n 1.0v 59.755n 1.0v 64.745n 1.0v 64.755n 1.0v 69.745n 1.0v 69.755n 1.0v 74.745n 1.0v 74.755n 1.0v 79.745n 1.0v 79.755n 0.0v 84.745n 0.0v 84.755n 0.0v 89.745n 0.0v 89.755n 0.0v 94.745n 0.0v 94.755n 0.0v 99.745n 0.0v 99.755n 0.0v 104.745n 0.0v 104.755n 0.0v 109.745n 0.0v 109.755n 0.0v 114.745n 0.0v 114.755n 0.0v 119.745n 0.0v 119.755n 0.0v 124.745n 0.0v 124.755n 1.0v 129.745n 1.0v 129.755n 1.0v 134.745n 1.0v 134.755n 1.0v 139.745n 1.0v 139.755n 0.0v 144.745n 0.0v 144.755n 0.0v 149.745n 0.0v 149.755n 0.0v 154.745n 0.0v 154.755n 0.0v 159.745n 0.0v 159.755n 0.0v 164.745n 0.0v 164.755n 0.0v 169.745n 0.0v 169.755n 0.0v 174.745n 0.0v 174.755n 0.0v 179.745n 0.0v 179.755n 0.0v 184.745n 0.0v 184.755n 0.0v 189.745n 0.0v 189.755n 0.0v 194.745n 0.0v 194.755n 0.0v 199.745n 0.0v 199.755n 0.0v 204.745n 0.0v 204.755n 0.0v 209.745n 0.0v 209.755n 0.0v 214.745n 0.0v 214.755n 0.0v 219.745n 0.0v 219.755n 0.0v 224.745n 0.0v 224.755n 0.0v 229.745n 0.0v 229.755n 0.0v 234.745n 0.0v 234.755n 1.0v 239.745n 1.0v 239.755n 1.0v 244.745n 1.0v 244.755n 1.0v 249.745n 1.0v 249.755n 1.0v 254.745n 1.0v 254.755n 1.0v 259.745n 1.0v 259.755n 1.0v 264.745n 1.0v 264.755n 1.0v 269.745n 1.0v 269.755n 1.0v 274.745n 1.0v 274.755n 0.0v 279.745n 0.0v 279.755n 0.0v 284.745n 0.0v 284.755n 1.0v 289.745n 1.0v 289.755n 1.0v 294.745n 1.0v 294.755n 1.0v 299.745n 1.0v 299.755n 1.0v 304.745n 1.0v 304.755n 1.0v 309.745n 1.0v 309.755n 1.0v 314.745n 1.0v 314.755n 1.0v 319.745n 1.0v 319.755n 1.0v 324.745n 1.0v 324.755n 1.0v 329.745n 1.0v 329.755n 1.0v 334.745n 1.0v 334.755n 1.0v 339.745n 1.0v 339.755n 1.0v 344.745n 1.0v 344.755n 1.0v 349.745n 1.0v 349.755n 1.0v 354.745n 1.0v 354.755n 1.0v 359.745n 1.0v 359.755n 1.0v 364.745n 1.0v 364.755n 1.0v 369.745n 1.0v 369.755n 1.0v 374.745n 1.0v 374.755n 1.0v 379.745n 1.0v 379.755n 1.0v 384.745n 1.0v 384.755n 1.0v 389.745n 1.0v 389.755n 1.0v 394.745n 1.0v 394.755n 1.0v 399.745n 1.0v 399.755n 1.0v 404.745n 1.0v 404.755n 1.0v 409.745n 1.0v 409.755n 1.0v 414.745n 1.0v 414.755n 1.0v 419.745n 1.0v 419.755n 1.0v 424.745n 1.0v 424.755n 1.0v 429.745n 1.0v 429.755n 1.0v 434.745n 1.0v 434.755n 0.0v 439.745n 0.0v 439.755n 0.0v 444.745n 0.0v 444.755n 0.0v 449.745n 0.0v 449.755n 0.0v 454.745n 0.0v 454.755n 0.0v 459.745n 0.0v 459.755n 0.0v 464.745n 0.0v 464.755n 1.0v 469.745n 1.0v 469.755n 1.0v 474.745n 1.0v 474.755n 1.0v 479.745n 1.0v 479.755n 1.0v 484.745n 1.0v 484.755n 1.0v 489.745n 1.0v 489.755n 1.0v 494.745n 1.0v 494.755n 1.0v 499.745n 1.0v 499.755n 1.0v 504.745n 1.0v 504.755n 1.0v 509.745n 1.0v 509.755n 0.0v 514.745n 0.0v 514.755n 0.0v 519.745n 0.0v 519.755n 0.0v 524.745n 0.0v 524.755n 0.0v 529.745n 0.0v 529.755n 0.0v 534.745n 0.0v 534.755n 0.0v 539.745n 0.0v 539.755n 0.0v 544.745n 0.0v 544.755n 1.0v 549.745n 1.0v 549.755n 1.0v 554.745n 1.0v 554.755n 1.0v 559.745n 1.0v 559.755n 1.0v 564.745n 1.0v 564.755n 1.0v 569.745n 1.0v 569.755n 1.0v 574.745n 1.0v 574.755n 1.0v 579.745n 1.0v 579.755n 1.0v 584.745n 1.0v 584.755n 1.0v 589.745n 1.0v 589.755n 1.0v 594.745n 1.0v 594.755n 1.0v 599.745n 1.0v 599.755n 1.0v 604.745n 1.0v 604.755n 1.0v 609.745n 1.0v 609.755n 1.0v 614.745n 1.0v 614.755n 1.0v 619.745n 1.0v 619.755n 1.0v 624.745n 1.0v 624.755n 0.0v 629.745n 0.0v 629.755n 0.0v 634.745n 0.0v 634.755n 0.0v 639.745n 0.0v 639.755n 0.0v 644.745n 0.0v 644.755n 0.0v 649.745n 0.0v 649.755n 0.0v 654.745n 0.0v 654.755n 0.0v 659.745n 0.0v 659.755n 0.0v 664.745n 0.0v 664.755n 0.0v 669.745n 0.0v 669.755n 0.0v 674.745n 0.0v 674.755n 0.0v 679.745n 0.0v 679.755n 0.0v 684.745n 0.0v 684.755n 0.0v 689.745n 0.0v 689.755n 0.0v 694.745n 0.0v 694.755n 0.0v 699.745n 0.0v 699.755n 0.0v 704.745n 0.0v 704.755n 0.0v 709.745n 0.0v 709.755n 0.0v 714.745n 0.0v 714.755n 0.0v 719.745n 0.0v 719.755n 1.0v 724.745n 1.0v 724.755n 1.0v 729.745n 1.0v 729.755n 1.0v 734.745n 1.0v 734.755n 0.0v 739.745n 0.0v 739.755n 0.0v 744.745n 0.0v 744.755n 0.0v 749.745n 0.0v 749.755n 0.0v 754.745n 0.0v 754.755n 0.0v 759.745n 0.0v 759.755n 0.0v 764.745n 0.0v 764.755n 0.0v 769.745n 0.0v 769.755n 1.0v 774.745n 1.0v 774.755n 1.0v 779.745n 1.0v 779.755n 1.0v 784.745n 1.0v 784.755n 1.0v 789.745n 1.0v 789.755n 1.0v 794.745n 1.0v 794.755n 0.0v 799.745n 0.0v 799.755n 0.0v 804.745n 0.0v 804.755n 0.0v 809.745n 0.0v 809.755n 0.0v 814.745n 0.0v 814.755n 0.0v 819.745n 0.0v 819.755n 1.0v 824.745n 1.0v 824.755n 1.0v 829.745n 1.0v 829.755n 1.0v 834.745n 1.0v 834.755n 1.0v 839.745n 1.0v 839.755n 1.0v 844.745n 1.0v 844.755n 1.0v 849.745n 1.0v 849.755n 0.0v 854.745n 0.0v 854.755n 0.0v 859.745n 0.0v 859.755n 1.0v 864.745n 1.0v 864.755n 1.0v 869.745n 1.0v 869.755n 1.0v 874.745n 1.0v 874.755n 1.0v 879.745n 1.0v 879.755n 1.0v 884.745n 1.0v 884.755n 1.0v 889.745n 1.0v 889.755n 1.0v 894.745n 1.0v 894.755n 1.0v 899.745n 1.0v 899.755n 1.0v 904.745n 1.0v 904.755n 0.0v 909.745n 0.0v 909.755n 1.0v 914.745n 1.0v 914.755n 1.0v 919.745n 1.0v 919.755n 0.0v 924.745n 0.0v 924.755n 0.0v 929.745n 0.0v 929.755n 0.0v 934.745n 0.0v 934.755n 1.0v 939.745n 1.0v 939.755n 1.0v 944.745n 1.0v 944.755n 1.0v 949.745n 1.0v 949.755n 1.0v 954.745n 1.0v 954.755n 1.0v 959.745n 1.0v 959.755n 1.0v 964.745n 1.0v 964.755n 1.0v 969.745n 1.0v 969.755n 0.0v 974.745n 0.0v 974.755n 0.0v 979.745n 0.0v 979.755n 0.0v 984.745n 0.0v 984.755n 0.0v 989.745n 0.0v 989.755n 0.0v 994.745n 0.0v 994.755n 0.0v 999.745n 0.0v 999.755n 0.0v 1004.745n 0.0v 1004.755n 0.0v 1009.745n 0.0v 1009.755n 0.0v 1014.745n 0.0v 1014.755n 1.0v 1019.745n 1.0v 1019.755n 1.0v 1024.745n 1.0v 1024.755n 1.0v )
* (time, data): [(0, 0), (5, 1), (10, 0), (15, 0), (20, 0), (25, 0), (30, 0), (35, 0), (40, 1), (45, 0), (50, 0), (55, 0), (60, 0), (65, 1), (70, 1), (75, 1), (80, 1), (85, 1), (90, 1), (95, 1), (100, 1), (105, 1), (110, 1), (115, 1), (120, 1), (125, 1), (130, 1), (135, 1), (140, 1), (145, 0), (150, 0), (155, 0), (160, 0), (165, 0), (170, 0), (175, 0), (180, 0), (185, 0), (190, 0), (195, 0), (200, 0), (205, 0), (210, 0), (215, 0), (220, 0), (225, 0), (230, 1), (235, 0), (240, 0), (245, 0), (250, 1), (255, 1), (260, 1), (265, 1), (270, 1), (275, 0), (280, 0), (285, 1), (290, 1), (295, 1), (300, 0), (305, 0), (310, 0), (315, 0), (320, 0), (325, 0), (330, 0), (335, 0), (340, 0), (345, 1), (350, 0), (355, 0), (360, 0), (365, 0), (370, 0), (375, 0), (380, 0), (385, 0), (390, 0), (395, 0), (400, 0), (405, 0), (410, 0), (415, 0), (420, 0), (425, 0), (430, 0), (435, 1), (440, 1), (445, 1), (450, 1), (455, 0), (460, 0), (465, 0), (470, 0), (475, 0), (480, 0), (485, 0), (490, 0), (495, 0), (500, 0), (505, 0), (510, 1), (515, 1), (520, 1), (525, 1), (530, 1), (535, 1), (540, 1), (545, 0), (550, 0), (555, 0), (560, 0), (565, 0), (570, 0), (575, 0), (580, 0), (585, 0), (590, 0), (595, 0), (600, 0), (605, 0), (610, 0), (615, 1), (620, 1), (625, 1), (630, 1), (635, 1), (640, 1), (645, 1), (650, 1), (655, 1), (660, 1), (665, 1), (670, 1), (675, 1), (680, 1), (685, 1), (690, 1), (695, 1), (700, 1), (705, 1), (710, 0), (715, 0), (720, 0), (725, 0), (730, 0), (735, 0), (740, 0), (745, 0), (750, 0), (755, 0), (760, 0), (765, 0), (770, 0), (775, 0), (780, 1), (785, 1), (790, 1), (795, 1), (800, 1), (805, 1), (810, 1), (815, 1), (820, 0), (825, 0), (830, 0), (835, 0), (840, 0), (845, 0), (850, 0), (855, 0), (860, 0), (865, 0), (870, 0), (875, 0), (880, 0), (885, 0), (890, 0), (895, 0), (900, 0), (905, 1), (910, 1), (915, 1), (920, 1), (925, 1), (930, 1), (935, 1), (940, 1), (945, 1), (950, 1), (955, 1), (960, 1), (965, 1), (970, 0), (975, 0), (980, 0), (985, 0), (990, 0), (995, 0), (1000, 0), (1005, 0), (1010, 0), (1015, 1), (1020, 1), (1025, 1)]
Vdin0_23  din0_23  0 PWL (0n 0.0v 4.745n 0.0v 4.755n 1.0v 9.745n 1.0v 9.755n 0.0v 14.745n 0.0v 14.755n 0.0v 19.745n 0.0v 19.755n 0.0v 24.745n 0.0v 24.755n 0.0v 29.745n 0.0v 29.755n 0.0v 34.745n 0.0v 34.755n 0.0v 39.745n 0.0v 39.755n 1.0v 44.745n 1.0v 44.755n 0.0v 49.745n 0.0v 49.755n 0.0v 54.745n 0.0v 54.755n 0.0v 59.745n 0.0v 59.755n 0.0v 64.745n 0.0v 64.755n 1.0v 69.745n 1.0v 69.755n 1.0v 74.745n 1.0v 74.755n 1.0v 79.745n 1.0v 79.755n 1.0v 84.745n 1.0v 84.755n 1.0v 89.745n 1.0v 89.755n 1.0v 94.745n 1.0v 94.755n 1.0v 99.745n 1.0v 99.755n 1.0v 104.745n 1.0v 104.755n 1.0v 109.745n 1.0v 109.755n 1.0v 114.745n 1.0v 114.755n 1.0v 119.745n 1.0v 119.755n 1.0v 124.745n 1.0v 124.755n 1.0v 129.745n 1.0v 129.755n 1.0v 134.745n 1.0v 134.755n 1.0v 139.745n 1.0v 139.755n 1.0v 144.745n 1.0v 144.755n 0.0v 149.745n 0.0v 149.755n 0.0v 154.745n 0.0v 154.755n 0.0v 159.745n 0.0v 159.755n 0.0v 164.745n 0.0v 164.755n 0.0v 169.745n 0.0v 169.755n 0.0v 174.745n 0.0v 174.755n 0.0v 179.745n 0.0v 179.755n 0.0v 184.745n 0.0v 184.755n 0.0v 189.745n 0.0v 189.755n 0.0v 194.745n 0.0v 194.755n 0.0v 199.745n 0.0v 199.755n 0.0v 204.745n 0.0v 204.755n 0.0v 209.745n 0.0v 209.755n 0.0v 214.745n 0.0v 214.755n 0.0v 219.745n 0.0v 219.755n 0.0v 224.745n 0.0v 224.755n 0.0v 229.745n 0.0v 229.755n 1.0v 234.745n 1.0v 234.755n 0.0v 239.745n 0.0v 239.755n 0.0v 244.745n 0.0v 244.755n 0.0v 249.745n 0.0v 249.755n 1.0v 254.745n 1.0v 254.755n 1.0v 259.745n 1.0v 259.755n 1.0v 264.745n 1.0v 264.755n 1.0v 269.745n 1.0v 269.755n 1.0v 274.745n 1.0v 274.755n 0.0v 279.745n 0.0v 279.755n 0.0v 284.745n 0.0v 284.755n 1.0v 289.745n 1.0v 289.755n 1.0v 294.745n 1.0v 294.755n 1.0v 299.745n 1.0v 299.755n 0.0v 304.745n 0.0v 304.755n 0.0v 309.745n 0.0v 309.755n 0.0v 314.745n 0.0v 314.755n 0.0v 319.745n 0.0v 319.755n 0.0v 324.745n 0.0v 324.755n 0.0v 329.745n 0.0v 329.755n 0.0v 334.745n 0.0v 334.755n 0.0v 339.745n 0.0v 339.755n 0.0v 344.745n 0.0v 344.755n 1.0v 349.745n 1.0v 349.755n 0.0v 354.745n 0.0v 354.755n 0.0v 359.745n 0.0v 359.755n 0.0v 364.745n 0.0v 364.755n 0.0v 369.745n 0.0v 369.755n 0.0v 374.745n 0.0v 374.755n 0.0v 379.745n 0.0v 379.755n 0.0v 384.745n 0.0v 384.755n 0.0v 389.745n 0.0v 389.755n 0.0v 394.745n 0.0v 394.755n 0.0v 399.745n 0.0v 399.755n 0.0v 404.745n 0.0v 404.755n 0.0v 409.745n 0.0v 409.755n 0.0v 414.745n 0.0v 414.755n 0.0v 419.745n 0.0v 419.755n 0.0v 424.745n 0.0v 424.755n 0.0v 429.745n 0.0v 429.755n 0.0v 434.745n 0.0v 434.755n 1.0v 439.745n 1.0v 439.755n 1.0v 444.745n 1.0v 444.755n 1.0v 449.745n 1.0v 449.755n 1.0v 454.745n 1.0v 454.755n 0.0v 459.745n 0.0v 459.755n 0.0v 464.745n 0.0v 464.755n 0.0v 469.745n 0.0v 469.755n 0.0v 474.745n 0.0v 474.755n 0.0v 479.745n 0.0v 479.755n 0.0v 484.745n 0.0v 484.755n 0.0v 489.745n 0.0v 489.755n 0.0v 494.745n 0.0v 494.755n 0.0v 499.745n 0.0v 499.755n 0.0v 504.745n 0.0v 504.755n 0.0v 509.745n 0.0v 509.755n 1.0v 514.745n 1.0v 514.755n 1.0v 519.745n 1.0v 519.755n 1.0v 524.745n 1.0v 524.755n 1.0v 529.745n 1.0v 529.755n 1.0v 534.745n 1.0v 534.755n 1.0v 539.745n 1.0v 539.755n 1.0v 544.745n 1.0v 544.755n 0.0v 549.745n 0.0v 549.755n 0.0v 554.745n 0.0v 554.755n 0.0v 559.745n 0.0v 559.755n 0.0v 564.745n 0.0v 564.755n 0.0v 569.745n 0.0v 569.755n 0.0v 574.745n 0.0v 574.755n 0.0v 579.745n 0.0v 579.755n 0.0v 584.745n 0.0v 584.755n 0.0v 589.745n 0.0v 589.755n 0.0v 594.745n 0.0v 594.755n 0.0v 599.745n 0.0v 599.755n 0.0v 604.745n 0.0v 604.755n 0.0v 609.745n 0.0v 609.755n 0.0v 614.745n 0.0v 614.755n 1.0v 619.745n 1.0v 619.755n 1.0v 624.745n 1.0v 624.755n 1.0v 629.745n 1.0v 629.755n 1.0v 634.745n 1.0v 634.755n 1.0v 639.745n 1.0v 639.755n 1.0v 644.745n 1.0v 644.755n 1.0v 649.745n 1.0v 649.755n 1.0v 654.745n 1.0v 654.755n 1.0v 659.745n 1.0v 659.755n 1.0v 664.745n 1.0v 664.755n 1.0v 669.745n 1.0v 669.755n 1.0v 674.745n 1.0v 674.755n 1.0v 679.745n 1.0v 679.755n 1.0v 684.745n 1.0v 684.755n 1.0v 689.745n 1.0v 689.755n 1.0v 694.745n 1.0v 694.755n 1.0v 699.745n 1.0v 699.755n 1.0v 704.745n 1.0v 704.755n 1.0v 709.745n 1.0v 709.755n 0.0v 714.745n 0.0v 714.755n 0.0v 719.745n 0.0v 719.755n 0.0v 724.745n 0.0v 724.755n 0.0v 729.745n 0.0v 729.755n 0.0v 734.745n 0.0v 734.755n 0.0v 739.745n 0.0v 739.755n 0.0v 744.745n 0.0v 744.755n 0.0v 749.745n 0.0v 749.755n 0.0v 754.745n 0.0v 754.755n 0.0v 759.745n 0.0v 759.755n 0.0v 764.745n 0.0v 764.755n 0.0v 769.745n 0.0v 769.755n 0.0v 774.745n 0.0v 774.755n 0.0v 779.745n 0.0v 779.755n 1.0v 784.745n 1.0v 784.755n 1.0v 789.745n 1.0v 789.755n 1.0v 794.745n 1.0v 794.755n 1.0v 799.745n 1.0v 799.755n 1.0v 804.745n 1.0v 804.755n 1.0v 809.745n 1.0v 809.755n 1.0v 814.745n 1.0v 814.755n 1.0v 819.745n 1.0v 819.755n 0.0v 824.745n 0.0v 824.755n 0.0v 829.745n 0.0v 829.755n 0.0v 834.745n 0.0v 834.755n 0.0v 839.745n 0.0v 839.755n 0.0v 844.745n 0.0v 844.755n 0.0v 849.745n 0.0v 849.755n 0.0v 854.745n 0.0v 854.755n 0.0v 859.745n 0.0v 859.755n 0.0v 864.745n 0.0v 864.755n 0.0v 869.745n 0.0v 869.755n 0.0v 874.745n 0.0v 874.755n 0.0v 879.745n 0.0v 879.755n 0.0v 884.745n 0.0v 884.755n 0.0v 889.745n 0.0v 889.755n 0.0v 894.745n 0.0v 894.755n 0.0v 899.745n 0.0v 899.755n 0.0v 904.745n 0.0v 904.755n 1.0v 909.745n 1.0v 909.755n 1.0v 914.745n 1.0v 914.755n 1.0v 919.745n 1.0v 919.755n 1.0v 924.745n 1.0v 924.755n 1.0v 929.745n 1.0v 929.755n 1.0v 934.745n 1.0v 934.755n 1.0v 939.745n 1.0v 939.755n 1.0v 944.745n 1.0v 944.755n 1.0v 949.745n 1.0v 949.755n 1.0v 954.745n 1.0v 954.755n 1.0v 959.745n 1.0v 959.755n 1.0v 964.745n 1.0v 964.755n 1.0v 969.745n 1.0v 969.755n 0.0v 974.745n 0.0v 974.755n 0.0v 979.745n 0.0v 979.755n 0.0v 984.745n 0.0v 984.755n 0.0v 989.745n 0.0v 989.755n 0.0v 994.745n 0.0v 994.755n 0.0v 999.745n 0.0v 999.755n 0.0v 1004.745n 0.0v 1004.755n 0.0v 1009.745n 0.0v 1009.755n 0.0v 1014.745n 0.0v 1014.755n 1.0v 1019.745n 1.0v 1019.755n 1.0v 1024.745n 1.0v 1024.755n 1.0v )
* (time, data): [(0, 0), (5, 1), (10, 0), (15, 1), (20, 1), (25, 1), (30, 0), (35, 1), (40, 0), (45, 1), (50, 1), (55, 1), (60, 1), (65, 0), (70, 0), (75, 0), (80, 0), (85, 0), (90, 0), (95, 0), (100, 0), (105, 0), (110, 1), (115, 1), (120, 1), (125, 1), (130, 1), (135, 1), (140, 1), (145, 1), (150, 1), (155, 1), (160, 1), (165, 1), (170, 1), (175, 1), (180, 1), (185, 1), (190, 1), (195, 1), (200, 1), (205, 1), (210, 1), (215, 1), (220, 1), (225, 1), (230, 1), (235, 1), (240, 0), (245, 0), (250, 0), (255, 0), (260, 0), (265, 0), (270, 0), (275, 0), (280, 0), (285, 0), (290, 0), (295, 0), (300, 1), (305, 1), (310, 1), (315, 1), (320, 1), (325, 1), (330, 1), (335, 1), (340, 0), (345, 1), (350, 1), (355, 1), (360, 1), (365, 1), (370, 1), (375, 1), (380, 1), (385, 1), (390, 1), (395, 1), (400, 1), (405, 1), (410, 1), (415, 1), (420, 1), (425, 1), (430, 1), (435, 0), (440, 0), (445, 0), (450, 0), (455, 0), (460, 0), (465, 0), (470, 0), (475, 0), (480, 0), (485, 0), (490, 0), (495, 0), (500, 0), (505, 0), (510, 1), (515, 1), (520, 1), (525, 1), (530, 1), (535, 1), (540, 1), (545, 1), (550, 1), (555, 1), (560, 1), (565, 1), (570, 1), (575, 1), (580, 1), (585, 1), (590, 1), (595, 1), (600, 1), (605, 1), (610, 1), (615, 1), (620, 1), (625, 1), (630, 1), (635, 1), (640, 1), (645, 1), (650, 1), (655, 1), (660, 1), (665, 1), (670, 1), (675, 1), (680, 0), (685, 0), (690, 0), (695, 0), (700, 0), (705, 0), (710, 0), (715, 0), (720, 0), (725, 0), (730, 0), (735, 0), (740, 0), (745, 0), (750, 0), (755, 0), (760, 0), (765, 0), (770, 0), (775, 0), (780, 0), (785, 0), (790, 0), (795, 0), (800, 0), (805, 0), (810, 0), (815, 0), (820, 1), (825, 1), (830, 1), (835, 1), (840, 1), (845, 1), (850, 1), (855, 1), (860, 1), (865, 1), (870, 1), (875, 1), (880, 1), (885, 1), (890, 1), (895, 1), (900, 1), (905, 0), (910, 0), (915, 0), (920, 0), (925, 0), (930, 0), (935, 0), (940, 0), (945, 0), (950, 0), (955, 1), (960, 1), (965, 1), (970, 0), (975, 0), (980, 0), (985, 0), (990, 0), (995, 0), (1000, 0), (1005, 0), (1010, 0), (1015, 1), (1020, 1), (1025, 1)]
Vdin0_24  din0_24  0 PWL (0n 0.0v 4.745n 0.0v 4.755n 1.0v 9.745n 1.0v 9.755n 0.0v 14.745n 0.0v 14.755n 1.0v 19.745n 1.0v 19.755n 1.0v 24.745n 1.0v 24.755n 1.0v 29.745n 1.0v 29.755n 0.0v 34.745n 0.0v 34.755n 1.0v 39.745n 1.0v 39.755n 0.0v 44.745n 0.0v 44.755n 1.0v 49.745n 1.0v 49.755n 1.0v 54.745n 1.0v 54.755n 1.0v 59.745n 1.0v 59.755n 1.0v 64.745n 1.0v 64.755n 0.0v 69.745n 0.0v 69.755n 0.0v 74.745n 0.0v 74.755n 0.0v 79.745n 0.0v 79.755n 0.0v 84.745n 0.0v 84.755n 0.0v 89.745n 0.0v 89.755n 0.0v 94.745n 0.0v 94.755n 0.0v 99.745n 0.0v 99.755n 0.0v 104.745n 0.0v 104.755n 0.0v 109.745n 0.0v 109.755n 1.0v 114.745n 1.0v 114.755n 1.0v 119.745n 1.0v 119.755n 1.0v 124.745n 1.0v 124.755n 1.0v 129.745n 1.0v 129.755n 1.0v 134.745n 1.0v 134.755n 1.0v 139.745n 1.0v 139.755n 1.0v 144.745n 1.0v 144.755n 1.0v 149.745n 1.0v 149.755n 1.0v 154.745n 1.0v 154.755n 1.0v 159.745n 1.0v 159.755n 1.0v 164.745n 1.0v 164.755n 1.0v 169.745n 1.0v 169.755n 1.0v 174.745n 1.0v 174.755n 1.0v 179.745n 1.0v 179.755n 1.0v 184.745n 1.0v 184.755n 1.0v 189.745n 1.0v 189.755n 1.0v 194.745n 1.0v 194.755n 1.0v 199.745n 1.0v 199.755n 1.0v 204.745n 1.0v 204.755n 1.0v 209.745n 1.0v 209.755n 1.0v 214.745n 1.0v 214.755n 1.0v 219.745n 1.0v 219.755n 1.0v 224.745n 1.0v 224.755n 1.0v 229.745n 1.0v 229.755n 1.0v 234.745n 1.0v 234.755n 1.0v 239.745n 1.0v 239.755n 0.0v 244.745n 0.0v 244.755n 0.0v 249.745n 0.0v 249.755n 0.0v 254.745n 0.0v 254.755n 0.0v 259.745n 0.0v 259.755n 0.0v 264.745n 0.0v 264.755n 0.0v 269.745n 0.0v 269.755n 0.0v 274.745n 0.0v 274.755n 0.0v 279.745n 0.0v 279.755n 0.0v 284.745n 0.0v 284.755n 0.0v 289.745n 0.0v 289.755n 0.0v 294.745n 0.0v 294.755n 0.0v 299.745n 0.0v 299.755n 1.0v 304.745n 1.0v 304.755n 1.0v 309.745n 1.0v 309.755n 1.0v 314.745n 1.0v 314.755n 1.0v 319.745n 1.0v 319.755n 1.0v 324.745n 1.0v 324.755n 1.0v 329.745n 1.0v 329.755n 1.0v 334.745n 1.0v 334.755n 1.0v 339.745n 1.0v 339.755n 0.0v 344.745n 0.0v 344.755n 1.0v 349.745n 1.0v 349.755n 1.0v 354.745n 1.0v 354.755n 1.0v 359.745n 1.0v 359.755n 1.0v 364.745n 1.0v 364.755n 1.0v 369.745n 1.0v 369.755n 1.0v 374.745n 1.0v 374.755n 1.0v 379.745n 1.0v 379.755n 1.0v 384.745n 1.0v 384.755n 1.0v 389.745n 1.0v 389.755n 1.0v 394.745n 1.0v 394.755n 1.0v 399.745n 1.0v 399.755n 1.0v 404.745n 1.0v 404.755n 1.0v 409.745n 1.0v 409.755n 1.0v 414.745n 1.0v 414.755n 1.0v 419.745n 1.0v 419.755n 1.0v 424.745n 1.0v 424.755n 1.0v 429.745n 1.0v 429.755n 1.0v 434.745n 1.0v 434.755n 0.0v 439.745n 0.0v 439.755n 0.0v 444.745n 0.0v 444.755n 0.0v 449.745n 0.0v 449.755n 0.0v 454.745n 0.0v 454.755n 0.0v 459.745n 0.0v 459.755n 0.0v 464.745n 0.0v 464.755n 0.0v 469.745n 0.0v 469.755n 0.0v 474.745n 0.0v 474.755n 0.0v 479.745n 0.0v 479.755n 0.0v 484.745n 0.0v 484.755n 0.0v 489.745n 0.0v 489.755n 0.0v 494.745n 0.0v 494.755n 0.0v 499.745n 0.0v 499.755n 0.0v 504.745n 0.0v 504.755n 0.0v 509.745n 0.0v 509.755n 1.0v 514.745n 1.0v 514.755n 1.0v 519.745n 1.0v 519.755n 1.0v 524.745n 1.0v 524.755n 1.0v 529.745n 1.0v 529.755n 1.0v 534.745n 1.0v 534.755n 1.0v 539.745n 1.0v 539.755n 1.0v 544.745n 1.0v 544.755n 1.0v 549.745n 1.0v 549.755n 1.0v 554.745n 1.0v 554.755n 1.0v 559.745n 1.0v 559.755n 1.0v 564.745n 1.0v 564.755n 1.0v 569.745n 1.0v 569.755n 1.0v 574.745n 1.0v 574.755n 1.0v 579.745n 1.0v 579.755n 1.0v 584.745n 1.0v 584.755n 1.0v 589.745n 1.0v 589.755n 1.0v 594.745n 1.0v 594.755n 1.0v 599.745n 1.0v 599.755n 1.0v 604.745n 1.0v 604.755n 1.0v 609.745n 1.0v 609.755n 1.0v 614.745n 1.0v 614.755n 1.0v 619.745n 1.0v 619.755n 1.0v 624.745n 1.0v 624.755n 1.0v 629.745n 1.0v 629.755n 1.0v 634.745n 1.0v 634.755n 1.0v 639.745n 1.0v 639.755n 1.0v 644.745n 1.0v 644.755n 1.0v 649.745n 1.0v 649.755n 1.0v 654.745n 1.0v 654.755n 1.0v 659.745n 1.0v 659.755n 1.0v 664.745n 1.0v 664.755n 1.0v 669.745n 1.0v 669.755n 1.0v 674.745n 1.0v 674.755n 1.0v 679.745n 1.0v 679.755n 0.0v 684.745n 0.0v 684.755n 0.0v 689.745n 0.0v 689.755n 0.0v 694.745n 0.0v 694.755n 0.0v 699.745n 0.0v 699.755n 0.0v 704.745n 0.0v 704.755n 0.0v 709.745n 0.0v 709.755n 0.0v 714.745n 0.0v 714.755n 0.0v 719.745n 0.0v 719.755n 0.0v 724.745n 0.0v 724.755n 0.0v 729.745n 0.0v 729.755n 0.0v 734.745n 0.0v 734.755n 0.0v 739.745n 0.0v 739.755n 0.0v 744.745n 0.0v 744.755n 0.0v 749.745n 0.0v 749.755n 0.0v 754.745n 0.0v 754.755n 0.0v 759.745n 0.0v 759.755n 0.0v 764.745n 0.0v 764.755n 0.0v 769.745n 0.0v 769.755n 0.0v 774.745n 0.0v 774.755n 0.0v 779.745n 0.0v 779.755n 0.0v 784.745n 0.0v 784.755n 0.0v 789.745n 0.0v 789.755n 0.0v 794.745n 0.0v 794.755n 0.0v 799.745n 0.0v 799.755n 0.0v 804.745n 0.0v 804.755n 0.0v 809.745n 0.0v 809.755n 0.0v 814.745n 0.0v 814.755n 0.0v 819.745n 0.0v 819.755n 1.0v 824.745n 1.0v 824.755n 1.0v 829.745n 1.0v 829.755n 1.0v 834.745n 1.0v 834.755n 1.0v 839.745n 1.0v 839.755n 1.0v 844.745n 1.0v 844.755n 1.0v 849.745n 1.0v 849.755n 1.0v 854.745n 1.0v 854.755n 1.0v 859.745n 1.0v 859.755n 1.0v 864.745n 1.0v 864.755n 1.0v 869.745n 1.0v 869.755n 1.0v 874.745n 1.0v 874.755n 1.0v 879.745n 1.0v 879.755n 1.0v 884.745n 1.0v 884.755n 1.0v 889.745n 1.0v 889.755n 1.0v 894.745n 1.0v 894.755n 1.0v 899.745n 1.0v 899.755n 1.0v 904.745n 1.0v 904.755n 0.0v 909.745n 0.0v 909.755n 0.0v 914.745n 0.0v 914.755n 0.0v 919.745n 0.0v 919.755n 0.0v 924.745n 0.0v 924.755n 0.0v 929.745n 0.0v 929.755n 0.0v 934.745n 0.0v 934.755n 0.0v 939.745n 0.0v 939.755n 0.0v 944.745n 0.0v 944.755n 0.0v 949.745n 0.0v 949.755n 0.0v 954.745n 0.0v 954.755n 1.0v 959.745n 1.0v 959.755n 1.0v 964.745n 1.0v 964.755n 1.0v 969.745n 1.0v 969.755n 0.0v 974.745n 0.0v 974.755n 0.0v 979.745n 0.0v 979.755n 0.0v 984.745n 0.0v 984.755n 0.0v 989.745n 0.0v 989.755n 0.0v 994.745n 0.0v 994.755n 0.0v 999.745n 0.0v 999.755n 0.0v 1004.745n 0.0v 1004.755n 0.0v 1009.745n 0.0v 1009.755n 0.0v 1014.745n 0.0v 1014.755n 1.0v 1019.745n 1.0v 1019.755n 1.0v 1024.745n 1.0v 1024.755n 1.0v )
* (time, data): [(0, 0), (5, 0), (10, 0), (15, 0), (20, 0), (25, 0), (30, 1), (35, 1), (40, 0), (45, 0), (50, 0), (55, 0), (60, 0), (65, 1), (70, 1), (75, 1), (80, 0), (85, 0), (90, 0), (95, 0), (100, 0), (105, 0), (110, 1), (115, 1), (120, 1), (125, 1), (130, 1), (135, 1), (140, 1), (145, 0), (150, 0), (155, 0), (160, 0), (165, 0), (170, 0), (175, 0), (180, 0), (185, 0), (190, 0), (195, 0), (200, 0), (205, 0), (210, 0), (215, 0), (220, 0), (225, 0), (230, 1), (235, 1), (240, 0), (245, 1), (250, 1), (255, 1), (260, 1), (265, 1), (270, 1), (275, 1), (280, 1), (285, 1), (290, 1), (295, 1), (300, 0), (305, 0), (310, 0), (315, 0), (320, 0), (325, 0), (330, 0), (335, 0), (340, 0), (345, 0), (350, 0), (355, 0), (360, 0), (365, 0), (370, 0), (375, 0), (380, 0), (385, 0), (390, 0), (395, 0), (400, 0), (405, 0), (410, 0), (415, 0), (420, 0), (425, 0), (430, 0), (435, 1), (440, 1), (445, 1), (450, 1), (455, 1), (460, 1), (465, 0), (470, 0), (475, 0), (480, 0), (485, 0), (490, 0), (495, 0), (500, 0), (505, 0), (510, 0), (515, 0), (520, 0), (525, 0), (530, 0), (535, 0), (540, 0), (545, 0), (550, 0), (555, 0), (560, 0), (565, 0), (570, 0), (575, 0), (580, 0), (585, 0), (590, 0), (595, 0), (600, 0), (605, 0), (610, 0), (615, 0), (620, 0), (625, 1), (630, 1), (635, 1), (640, 1), (645, 0), (650, 0), (655, 0), (660, 0), (665, 0), (670, 0), (675, 0), (680, 1), (685, 1), (690, 1), (695, 1), (700, 1), (705, 1), (710, 0), (715, 0), (720, 1), (725, 1), (730, 1), (735, 0), (740, 0), (745, 0), (750, 0), (755, 0), (760, 0), (765, 0), (770, 1), (775, 1), (780, 0), (785, 0), (790, 0), (795, 0), (800, 0), (805, 0), (810, 0), (815, 0), (820, 1), (825, 1), (830, 1), (835, 1), (840, 1), (845, 1), (850, 1), (855, 1), (860, 1), (865, 1), (870, 1), (875, 1), (880, 1), (885, 1), (890, 1), (895, 1), (900, 1), (905, 1), (910, 0), (915, 0), (920, 0), (925, 0), (930, 0), (935, 1), (940, 1), (945, 1), (950, 1), (955, 0), (960, 1), (965, 1), (970, 1), (975, 1), (980, 1), (985, 1), (990, 0), (995, 0), (1000, 0), (1005, 0), (1010, 0), (1015, 1), (1020, 1), (1025, 1)]
Vdin0_25  din0_25  0 PWL (0n 0.0v 4.745n 0.0v 4.755n 0.0v 9.745n 0.0v 9.755n 0.0v 14.745n 0.0v 14.755n 0.0v 19.745n 0.0v 19.755n 0.0v 24.745n 0.0v 24.755n 0.0v 29.745n 0.0v 29.755n 1.0v 34.745n 1.0v 34.755n 1.0v 39.745n 1.0v 39.755n 0.0v 44.745n 0.0v 44.755n 0.0v 49.745n 0.0v 49.755n 0.0v 54.745n 0.0v 54.755n 0.0v 59.745n 0.0v 59.755n 0.0v 64.745n 0.0v 64.755n 1.0v 69.745n 1.0v 69.755n 1.0v 74.745n 1.0v 74.755n 1.0v 79.745n 1.0v 79.755n 0.0v 84.745n 0.0v 84.755n 0.0v 89.745n 0.0v 89.755n 0.0v 94.745n 0.0v 94.755n 0.0v 99.745n 0.0v 99.755n 0.0v 104.745n 0.0v 104.755n 0.0v 109.745n 0.0v 109.755n 1.0v 114.745n 1.0v 114.755n 1.0v 119.745n 1.0v 119.755n 1.0v 124.745n 1.0v 124.755n 1.0v 129.745n 1.0v 129.755n 1.0v 134.745n 1.0v 134.755n 1.0v 139.745n 1.0v 139.755n 1.0v 144.745n 1.0v 144.755n 0.0v 149.745n 0.0v 149.755n 0.0v 154.745n 0.0v 154.755n 0.0v 159.745n 0.0v 159.755n 0.0v 164.745n 0.0v 164.755n 0.0v 169.745n 0.0v 169.755n 0.0v 174.745n 0.0v 174.755n 0.0v 179.745n 0.0v 179.755n 0.0v 184.745n 0.0v 184.755n 0.0v 189.745n 0.0v 189.755n 0.0v 194.745n 0.0v 194.755n 0.0v 199.745n 0.0v 199.755n 0.0v 204.745n 0.0v 204.755n 0.0v 209.745n 0.0v 209.755n 0.0v 214.745n 0.0v 214.755n 0.0v 219.745n 0.0v 219.755n 0.0v 224.745n 0.0v 224.755n 0.0v 229.745n 0.0v 229.755n 1.0v 234.745n 1.0v 234.755n 1.0v 239.745n 1.0v 239.755n 0.0v 244.745n 0.0v 244.755n 1.0v 249.745n 1.0v 249.755n 1.0v 254.745n 1.0v 254.755n 1.0v 259.745n 1.0v 259.755n 1.0v 264.745n 1.0v 264.755n 1.0v 269.745n 1.0v 269.755n 1.0v 274.745n 1.0v 274.755n 1.0v 279.745n 1.0v 279.755n 1.0v 284.745n 1.0v 284.755n 1.0v 289.745n 1.0v 289.755n 1.0v 294.745n 1.0v 294.755n 1.0v 299.745n 1.0v 299.755n 0.0v 304.745n 0.0v 304.755n 0.0v 309.745n 0.0v 309.755n 0.0v 314.745n 0.0v 314.755n 0.0v 319.745n 0.0v 319.755n 0.0v 324.745n 0.0v 324.755n 0.0v 329.745n 0.0v 329.755n 0.0v 334.745n 0.0v 334.755n 0.0v 339.745n 0.0v 339.755n 0.0v 344.745n 0.0v 344.755n 0.0v 349.745n 0.0v 349.755n 0.0v 354.745n 0.0v 354.755n 0.0v 359.745n 0.0v 359.755n 0.0v 364.745n 0.0v 364.755n 0.0v 369.745n 0.0v 369.755n 0.0v 374.745n 0.0v 374.755n 0.0v 379.745n 0.0v 379.755n 0.0v 384.745n 0.0v 384.755n 0.0v 389.745n 0.0v 389.755n 0.0v 394.745n 0.0v 394.755n 0.0v 399.745n 0.0v 399.755n 0.0v 404.745n 0.0v 404.755n 0.0v 409.745n 0.0v 409.755n 0.0v 414.745n 0.0v 414.755n 0.0v 419.745n 0.0v 419.755n 0.0v 424.745n 0.0v 424.755n 0.0v 429.745n 0.0v 429.755n 0.0v 434.745n 0.0v 434.755n 1.0v 439.745n 1.0v 439.755n 1.0v 444.745n 1.0v 444.755n 1.0v 449.745n 1.0v 449.755n 1.0v 454.745n 1.0v 454.755n 1.0v 459.745n 1.0v 459.755n 1.0v 464.745n 1.0v 464.755n 0.0v 469.745n 0.0v 469.755n 0.0v 474.745n 0.0v 474.755n 0.0v 479.745n 0.0v 479.755n 0.0v 484.745n 0.0v 484.755n 0.0v 489.745n 0.0v 489.755n 0.0v 494.745n 0.0v 494.755n 0.0v 499.745n 0.0v 499.755n 0.0v 504.745n 0.0v 504.755n 0.0v 509.745n 0.0v 509.755n 0.0v 514.745n 0.0v 514.755n 0.0v 519.745n 0.0v 519.755n 0.0v 524.745n 0.0v 524.755n 0.0v 529.745n 0.0v 529.755n 0.0v 534.745n 0.0v 534.755n 0.0v 539.745n 0.0v 539.755n 0.0v 544.745n 0.0v 544.755n 0.0v 549.745n 0.0v 549.755n 0.0v 554.745n 0.0v 554.755n 0.0v 559.745n 0.0v 559.755n 0.0v 564.745n 0.0v 564.755n 0.0v 569.745n 0.0v 569.755n 0.0v 574.745n 0.0v 574.755n 0.0v 579.745n 0.0v 579.755n 0.0v 584.745n 0.0v 584.755n 0.0v 589.745n 0.0v 589.755n 0.0v 594.745n 0.0v 594.755n 0.0v 599.745n 0.0v 599.755n 0.0v 604.745n 0.0v 604.755n 0.0v 609.745n 0.0v 609.755n 0.0v 614.745n 0.0v 614.755n 0.0v 619.745n 0.0v 619.755n 0.0v 624.745n 0.0v 624.755n 1.0v 629.745n 1.0v 629.755n 1.0v 634.745n 1.0v 634.755n 1.0v 639.745n 1.0v 639.755n 1.0v 644.745n 1.0v 644.755n 0.0v 649.745n 0.0v 649.755n 0.0v 654.745n 0.0v 654.755n 0.0v 659.745n 0.0v 659.755n 0.0v 664.745n 0.0v 664.755n 0.0v 669.745n 0.0v 669.755n 0.0v 674.745n 0.0v 674.755n 0.0v 679.745n 0.0v 679.755n 1.0v 684.745n 1.0v 684.755n 1.0v 689.745n 1.0v 689.755n 1.0v 694.745n 1.0v 694.755n 1.0v 699.745n 1.0v 699.755n 1.0v 704.745n 1.0v 704.755n 1.0v 709.745n 1.0v 709.755n 0.0v 714.745n 0.0v 714.755n 0.0v 719.745n 0.0v 719.755n 1.0v 724.745n 1.0v 724.755n 1.0v 729.745n 1.0v 729.755n 1.0v 734.745n 1.0v 734.755n 0.0v 739.745n 0.0v 739.755n 0.0v 744.745n 0.0v 744.755n 0.0v 749.745n 0.0v 749.755n 0.0v 754.745n 0.0v 754.755n 0.0v 759.745n 0.0v 759.755n 0.0v 764.745n 0.0v 764.755n 0.0v 769.745n 0.0v 769.755n 1.0v 774.745n 1.0v 774.755n 1.0v 779.745n 1.0v 779.755n 0.0v 784.745n 0.0v 784.755n 0.0v 789.745n 0.0v 789.755n 0.0v 794.745n 0.0v 794.755n 0.0v 799.745n 0.0v 799.755n 0.0v 804.745n 0.0v 804.755n 0.0v 809.745n 0.0v 809.755n 0.0v 814.745n 0.0v 814.755n 0.0v 819.745n 0.0v 819.755n 1.0v 824.745n 1.0v 824.755n 1.0v 829.745n 1.0v 829.755n 1.0v 834.745n 1.0v 834.755n 1.0v 839.745n 1.0v 839.755n 1.0v 844.745n 1.0v 844.755n 1.0v 849.745n 1.0v 849.755n 1.0v 854.745n 1.0v 854.755n 1.0v 859.745n 1.0v 859.755n 1.0v 864.745n 1.0v 864.755n 1.0v 869.745n 1.0v 869.755n 1.0v 874.745n 1.0v 874.755n 1.0v 879.745n 1.0v 879.755n 1.0v 884.745n 1.0v 884.755n 1.0v 889.745n 1.0v 889.755n 1.0v 894.745n 1.0v 894.755n 1.0v 899.745n 1.0v 899.755n 1.0v 904.745n 1.0v 904.755n 1.0v 909.745n 1.0v 909.755n 0.0v 914.745n 0.0v 914.755n 0.0v 919.745n 0.0v 919.755n 0.0v 924.745n 0.0v 924.755n 0.0v 929.745n 0.0v 929.755n 0.0v 934.745n 0.0v 934.755n 1.0v 939.745n 1.0v 939.755n 1.0v 944.745n 1.0v 944.755n 1.0v 949.745n 1.0v 949.755n 1.0v 954.745n 1.0v 954.755n 0.0v 959.745n 0.0v 959.755n 1.0v 964.745n 1.0v 964.755n 1.0v 969.745n 1.0v 969.755n 1.0v 974.745n 1.0v 974.755n 1.0v 979.745n 1.0v 979.755n 1.0v 984.745n 1.0v 984.755n 1.0v 989.745n 1.0v 989.755n 0.0v 994.745n 0.0v 994.755n 0.0v 999.745n 0.0v 999.755n 0.0v 1004.745n 0.0v 1004.755n 0.0v 1009.745n 0.0v 1009.755n 0.0v 1014.745n 0.0v 1014.755n 1.0v 1019.745n 1.0v 1019.755n 1.0v 1024.745n 1.0v 1024.755n 1.0v )
* (time, data): [(0, 0), (5, 0), (10, 1), (15, 1), (20, 1), (25, 1), (30, 0), (35, 0), (40, 0), (45, 0), (50, 0), (55, 0), (60, 0), (65, 0), (70, 0), (75, 0), (80, 0), (85, 0), (90, 0), (95, 0), (100, 0), (105, 0), (110, 1), (115, 1), (120, 1), (125, 1), (130, 1), (135, 1), (140, 1), (145, 0), (150, 0), (155, 0), (160, 0), (165, 0), (170, 0), (175, 0), (180, 0), (185, 0), (190, 0), (195, 0), (200, 0), (205, 0), (210, 0), (215, 0), (220, 0), (225, 0), (230, 1), (235, 0), (240, 1), (245, 1), (250, 0), (255, 0), (260, 0), (265, 0), (270, 0), (275, 1), (280, 1), (285, 1), (290, 1), (295, 1), (300, 0), (305, 0), (310, 0), (315, 0), (320, 0), (325, 0), (330, 0), (335, 0), (340, 1), (345, 1), (350, 1), (355, 1), (360, 1), (365, 1), (370, 1), (375, 1), (380, 1), (385, 1), (390, 1), (395, 1), (400, 1), (405, 1), (410, 1), (415, 1), (420, 1), (425, 1), (430, 1), (435, 0), (440, 0), (445, 0), (450, 0), (455, 0), (460, 0), (465, 1), (470, 1), (475, 1), (480, 1), (485, 1), (490, 1), (495, 1), (500, 1), (505, 1), (510, 0), (515, 0), (520, 0), (525, 0), (530, 0), (535, 0), (540, 0), (545, 0), (550, 0), (555, 0), (560, 0), (565, 0), (570, 0), (575, 0), (580, 0), (585, 0), (590, 0), (595, 0), (600, 0), (605, 0), (610, 0), (615, 1), (620, 1), (625, 0), (630, 0), (635, 0), (640, 0), (645, 1), (650, 1), (655, 1), (660, 1), (665, 1), (670, 1), (675, 1), (680, 0), (685, 0), (690, 0), (695, 0), (700, 0), (705, 0), (710, 1), (715, 1), (720, 0), (725, 0), (730, 0), (735, 0), (740, 0), (745, 0), (750, 0), (755, 0), (760, 0), (765, 0), (770, 1), (775, 1), (780, 0), (785, 0), (790, 0), (795, 0), (800, 0), (805, 0), (810, 0), (815, 0), (820, 1), (825, 1), (830, 1), (835, 1), (840, 1), (845, 1), (850, 0), (855, 0), (860, 0), (865, 0), (870, 0), (875, 0), (880, 0), (885, 0), (890, 0), (895, 0), (900, 0), (905, 1), (910, 1), (915, 1), (920, 0), (925, 0), (930, 0), (935, 0), (940, 0), (945, 0), (950, 0), (955, 0), (960, 0), (965, 0), (970, 1), (975, 1), (980, 1), (985, 1), (990, 1), (995, 1), (1000, 1), (1005, 1), (1010, 1), (1015, 1), (1020, 1), (1025, 1)]
Vdin0_26  din0_26  0 PWL (0n 0.0v 4.745n 0.0v 4.755n 0.0v 9.745n 0.0v 9.755n 1.0v 14.745n 1.0v 14.755n 1.0v 19.745n 1.0v 19.755n 1.0v 24.745n 1.0v 24.755n 1.0v 29.745n 1.0v 29.755n 0.0v 34.745n 0.0v 34.755n 0.0v 39.745n 0.0v 39.755n 0.0v 44.745n 0.0v 44.755n 0.0v 49.745n 0.0v 49.755n 0.0v 54.745n 0.0v 54.755n 0.0v 59.745n 0.0v 59.755n 0.0v 64.745n 0.0v 64.755n 0.0v 69.745n 0.0v 69.755n 0.0v 74.745n 0.0v 74.755n 0.0v 79.745n 0.0v 79.755n 0.0v 84.745n 0.0v 84.755n 0.0v 89.745n 0.0v 89.755n 0.0v 94.745n 0.0v 94.755n 0.0v 99.745n 0.0v 99.755n 0.0v 104.745n 0.0v 104.755n 0.0v 109.745n 0.0v 109.755n 1.0v 114.745n 1.0v 114.755n 1.0v 119.745n 1.0v 119.755n 1.0v 124.745n 1.0v 124.755n 1.0v 129.745n 1.0v 129.755n 1.0v 134.745n 1.0v 134.755n 1.0v 139.745n 1.0v 139.755n 1.0v 144.745n 1.0v 144.755n 0.0v 149.745n 0.0v 149.755n 0.0v 154.745n 0.0v 154.755n 0.0v 159.745n 0.0v 159.755n 0.0v 164.745n 0.0v 164.755n 0.0v 169.745n 0.0v 169.755n 0.0v 174.745n 0.0v 174.755n 0.0v 179.745n 0.0v 179.755n 0.0v 184.745n 0.0v 184.755n 0.0v 189.745n 0.0v 189.755n 0.0v 194.745n 0.0v 194.755n 0.0v 199.745n 0.0v 199.755n 0.0v 204.745n 0.0v 204.755n 0.0v 209.745n 0.0v 209.755n 0.0v 214.745n 0.0v 214.755n 0.0v 219.745n 0.0v 219.755n 0.0v 224.745n 0.0v 224.755n 0.0v 229.745n 0.0v 229.755n 1.0v 234.745n 1.0v 234.755n 0.0v 239.745n 0.0v 239.755n 1.0v 244.745n 1.0v 244.755n 1.0v 249.745n 1.0v 249.755n 0.0v 254.745n 0.0v 254.755n 0.0v 259.745n 0.0v 259.755n 0.0v 264.745n 0.0v 264.755n 0.0v 269.745n 0.0v 269.755n 0.0v 274.745n 0.0v 274.755n 1.0v 279.745n 1.0v 279.755n 1.0v 284.745n 1.0v 284.755n 1.0v 289.745n 1.0v 289.755n 1.0v 294.745n 1.0v 294.755n 1.0v 299.745n 1.0v 299.755n 0.0v 304.745n 0.0v 304.755n 0.0v 309.745n 0.0v 309.755n 0.0v 314.745n 0.0v 314.755n 0.0v 319.745n 0.0v 319.755n 0.0v 324.745n 0.0v 324.755n 0.0v 329.745n 0.0v 329.755n 0.0v 334.745n 0.0v 334.755n 0.0v 339.745n 0.0v 339.755n 1.0v 344.745n 1.0v 344.755n 1.0v 349.745n 1.0v 349.755n 1.0v 354.745n 1.0v 354.755n 1.0v 359.745n 1.0v 359.755n 1.0v 364.745n 1.0v 364.755n 1.0v 369.745n 1.0v 369.755n 1.0v 374.745n 1.0v 374.755n 1.0v 379.745n 1.0v 379.755n 1.0v 384.745n 1.0v 384.755n 1.0v 389.745n 1.0v 389.755n 1.0v 394.745n 1.0v 394.755n 1.0v 399.745n 1.0v 399.755n 1.0v 404.745n 1.0v 404.755n 1.0v 409.745n 1.0v 409.755n 1.0v 414.745n 1.0v 414.755n 1.0v 419.745n 1.0v 419.755n 1.0v 424.745n 1.0v 424.755n 1.0v 429.745n 1.0v 429.755n 1.0v 434.745n 1.0v 434.755n 0.0v 439.745n 0.0v 439.755n 0.0v 444.745n 0.0v 444.755n 0.0v 449.745n 0.0v 449.755n 0.0v 454.745n 0.0v 454.755n 0.0v 459.745n 0.0v 459.755n 0.0v 464.745n 0.0v 464.755n 1.0v 469.745n 1.0v 469.755n 1.0v 474.745n 1.0v 474.755n 1.0v 479.745n 1.0v 479.755n 1.0v 484.745n 1.0v 484.755n 1.0v 489.745n 1.0v 489.755n 1.0v 494.745n 1.0v 494.755n 1.0v 499.745n 1.0v 499.755n 1.0v 504.745n 1.0v 504.755n 1.0v 509.745n 1.0v 509.755n 0.0v 514.745n 0.0v 514.755n 0.0v 519.745n 0.0v 519.755n 0.0v 524.745n 0.0v 524.755n 0.0v 529.745n 0.0v 529.755n 0.0v 534.745n 0.0v 534.755n 0.0v 539.745n 0.0v 539.755n 0.0v 544.745n 0.0v 544.755n 0.0v 549.745n 0.0v 549.755n 0.0v 554.745n 0.0v 554.755n 0.0v 559.745n 0.0v 559.755n 0.0v 564.745n 0.0v 564.755n 0.0v 569.745n 0.0v 569.755n 0.0v 574.745n 0.0v 574.755n 0.0v 579.745n 0.0v 579.755n 0.0v 584.745n 0.0v 584.755n 0.0v 589.745n 0.0v 589.755n 0.0v 594.745n 0.0v 594.755n 0.0v 599.745n 0.0v 599.755n 0.0v 604.745n 0.0v 604.755n 0.0v 609.745n 0.0v 609.755n 0.0v 614.745n 0.0v 614.755n 1.0v 619.745n 1.0v 619.755n 1.0v 624.745n 1.0v 624.755n 0.0v 629.745n 0.0v 629.755n 0.0v 634.745n 0.0v 634.755n 0.0v 639.745n 0.0v 639.755n 0.0v 644.745n 0.0v 644.755n 1.0v 649.745n 1.0v 649.755n 1.0v 654.745n 1.0v 654.755n 1.0v 659.745n 1.0v 659.755n 1.0v 664.745n 1.0v 664.755n 1.0v 669.745n 1.0v 669.755n 1.0v 674.745n 1.0v 674.755n 1.0v 679.745n 1.0v 679.755n 0.0v 684.745n 0.0v 684.755n 0.0v 689.745n 0.0v 689.755n 0.0v 694.745n 0.0v 694.755n 0.0v 699.745n 0.0v 699.755n 0.0v 704.745n 0.0v 704.755n 0.0v 709.745n 0.0v 709.755n 1.0v 714.745n 1.0v 714.755n 1.0v 719.745n 1.0v 719.755n 0.0v 724.745n 0.0v 724.755n 0.0v 729.745n 0.0v 729.755n 0.0v 734.745n 0.0v 734.755n 0.0v 739.745n 0.0v 739.755n 0.0v 744.745n 0.0v 744.755n 0.0v 749.745n 0.0v 749.755n 0.0v 754.745n 0.0v 754.755n 0.0v 759.745n 0.0v 759.755n 0.0v 764.745n 0.0v 764.755n 0.0v 769.745n 0.0v 769.755n 1.0v 774.745n 1.0v 774.755n 1.0v 779.745n 1.0v 779.755n 0.0v 784.745n 0.0v 784.755n 0.0v 789.745n 0.0v 789.755n 0.0v 794.745n 0.0v 794.755n 0.0v 799.745n 0.0v 799.755n 0.0v 804.745n 0.0v 804.755n 0.0v 809.745n 0.0v 809.755n 0.0v 814.745n 0.0v 814.755n 0.0v 819.745n 0.0v 819.755n 1.0v 824.745n 1.0v 824.755n 1.0v 829.745n 1.0v 829.755n 1.0v 834.745n 1.0v 834.755n 1.0v 839.745n 1.0v 839.755n 1.0v 844.745n 1.0v 844.755n 1.0v 849.745n 1.0v 849.755n 0.0v 854.745n 0.0v 854.755n 0.0v 859.745n 0.0v 859.755n 0.0v 864.745n 0.0v 864.755n 0.0v 869.745n 0.0v 869.755n 0.0v 874.745n 0.0v 874.755n 0.0v 879.745n 0.0v 879.755n 0.0v 884.745n 0.0v 884.755n 0.0v 889.745n 0.0v 889.755n 0.0v 894.745n 0.0v 894.755n 0.0v 899.745n 0.0v 899.755n 0.0v 904.745n 0.0v 904.755n 1.0v 909.745n 1.0v 909.755n 1.0v 914.745n 1.0v 914.755n 1.0v 919.745n 1.0v 919.755n 0.0v 924.745n 0.0v 924.755n 0.0v 929.745n 0.0v 929.755n 0.0v 934.745n 0.0v 934.755n 0.0v 939.745n 0.0v 939.755n 0.0v 944.745n 0.0v 944.755n 0.0v 949.745n 0.0v 949.755n 0.0v 954.745n 0.0v 954.755n 0.0v 959.745n 0.0v 959.755n 0.0v 964.745n 0.0v 964.755n 0.0v 969.745n 0.0v 969.755n 1.0v 974.745n 1.0v 974.755n 1.0v 979.745n 1.0v 979.755n 1.0v 984.745n 1.0v 984.755n 1.0v 989.745n 1.0v 989.755n 1.0v 994.745n 1.0v 994.755n 1.0v 999.745n 1.0v 999.755n 1.0v 1004.745n 1.0v 1004.755n 1.0v 1009.745n 1.0v 1009.755n 1.0v 1014.745n 1.0v 1014.755n 1.0v 1019.745n 1.0v 1019.755n 1.0v 1024.745n 1.0v 1024.755n 1.0v )
* (time, data): [(0, 0), (5, 0), (10, 0), (15, 0), (20, 0), (25, 0), (30, 0), (35, 0), (40, 1), (45, 0), (50, 0), (55, 0), (60, 0), (65, 1), (70, 1), (75, 1), (80, 1), (85, 1), (90, 1), (95, 1), (100, 1), (105, 1), (110, 0), (115, 0), (120, 0), (125, 0), (130, 0), (135, 0), (140, 1), (145, 1), (150, 1), (155, 1), (160, 1), (165, 1), (170, 1), (175, 1), (180, 1), (185, 1), (190, 1), (195, 1), (200, 1), (205, 1), (210, 1), (215, 1), (220, 1), (225, 1), (230, 1), (235, 1), (240, 0), (245, 1), (250, 1), (255, 1), (260, 1), (265, 1), (270, 1), (275, 0), (280, 0), (285, 0), (290, 0), (295, 0), (300, 1), (305, 1), (310, 1), (315, 1), (320, 1), (325, 1), (330, 1), (335, 1), (340, 1), (345, 1), (350, 0), (355, 0), (360, 0), (365, 0), (370, 0), (375, 0), (380, 0), (385, 0), (390, 0), (395, 0), (400, 0), (405, 0), (410, 0), (415, 0), (420, 0), (425, 0), (430, 0), (435, 1), (440, 1), (445, 1), (450, 1), (455, 0), (460, 0), (465, 0), (470, 0), (475, 0), (480, 0), (485, 0), (490, 0), (495, 0), (500, 0), (505, 0), (510, 0), (515, 0), (520, 0), (525, 0), (530, 0), (535, 0), (540, 0), (545, 1), (550, 1), (555, 1), (560, 1), (565, 1), (570, 1), (575, 1), (580, 1), (585, 1), (590, 1), (595, 1), (600, 1), (605, 1), (610, 1), (615, 0), (620, 0), (625, 0), (630, 0), (635, 0), (640, 0), (645, 0), (650, 0), (655, 0), (660, 0), (665, 0), (670, 0), (675, 0), (680, 0), (685, 0), (690, 0), (695, 0), (700, 0), (705, 0), (710, 0), (715, 0), (720, 1), (725, 1), (730, 1), (735, 0), (740, 0), (745, 0), (750, 0), (755, 0), (760, 0), (765, 0), (770, 1), (775, 1), (780, 0), (785, 0), (790, 0), (795, 0), (800, 0), (805, 0), (810, 0), (815, 0), (820, 0), (825, 0), (830, 0), (835, 0), (840, 0), (845, 0), (850, 0), (855, 0), (860, 1), (865, 1), (870, 1), (875, 1), (880, 1), (885, 1), (890, 1), (895, 1), (900, 1), (905, 1), (910, 1), (915, 1), (920, 1), (925, 1), (930, 1), (935, 0), (940, 0), (945, 0), (950, 0), (955, 0), (960, 1), (965, 1), (970, 0), (975, 0), (980, 0), (985, 0), (990, 1), (995, 1), (1000, 1), (1005, 1), (1010, 1), (1015, 0), (1020, 0), (1025, 0)]
Vdin0_27  din0_27  0 PWL (0n 0.0v 4.745n 0.0v 4.755n 0.0v 9.745n 0.0v 9.755n 0.0v 14.745n 0.0v 14.755n 0.0v 19.745n 0.0v 19.755n 0.0v 24.745n 0.0v 24.755n 0.0v 29.745n 0.0v 29.755n 0.0v 34.745n 0.0v 34.755n 0.0v 39.745n 0.0v 39.755n 1.0v 44.745n 1.0v 44.755n 0.0v 49.745n 0.0v 49.755n 0.0v 54.745n 0.0v 54.755n 0.0v 59.745n 0.0v 59.755n 0.0v 64.745n 0.0v 64.755n 1.0v 69.745n 1.0v 69.755n 1.0v 74.745n 1.0v 74.755n 1.0v 79.745n 1.0v 79.755n 1.0v 84.745n 1.0v 84.755n 1.0v 89.745n 1.0v 89.755n 1.0v 94.745n 1.0v 94.755n 1.0v 99.745n 1.0v 99.755n 1.0v 104.745n 1.0v 104.755n 1.0v 109.745n 1.0v 109.755n 0.0v 114.745n 0.0v 114.755n 0.0v 119.745n 0.0v 119.755n 0.0v 124.745n 0.0v 124.755n 0.0v 129.745n 0.0v 129.755n 0.0v 134.745n 0.0v 134.755n 0.0v 139.745n 0.0v 139.755n 1.0v 144.745n 1.0v 144.755n 1.0v 149.745n 1.0v 149.755n 1.0v 154.745n 1.0v 154.755n 1.0v 159.745n 1.0v 159.755n 1.0v 164.745n 1.0v 164.755n 1.0v 169.745n 1.0v 169.755n 1.0v 174.745n 1.0v 174.755n 1.0v 179.745n 1.0v 179.755n 1.0v 184.745n 1.0v 184.755n 1.0v 189.745n 1.0v 189.755n 1.0v 194.745n 1.0v 194.755n 1.0v 199.745n 1.0v 199.755n 1.0v 204.745n 1.0v 204.755n 1.0v 209.745n 1.0v 209.755n 1.0v 214.745n 1.0v 214.755n 1.0v 219.745n 1.0v 219.755n 1.0v 224.745n 1.0v 224.755n 1.0v 229.745n 1.0v 229.755n 1.0v 234.745n 1.0v 234.755n 1.0v 239.745n 1.0v 239.755n 0.0v 244.745n 0.0v 244.755n 1.0v 249.745n 1.0v 249.755n 1.0v 254.745n 1.0v 254.755n 1.0v 259.745n 1.0v 259.755n 1.0v 264.745n 1.0v 264.755n 1.0v 269.745n 1.0v 269.755n 1.0v 274.745n 1.0v 274.755n 0.0v 279.745n 0.0v 279.755n 0.0v 284.745n 0.0v 284.755n 0.0v 289.745n 0.0v 289.755n 0.0v 294.745n 0.0v 294.755n 0.0v 299.745n 0.0v 299.755n 1.0v 304.745n 1.0v 304.755n 1.0v 309.745n 1.0v 309.755n 1.0v 314.745n 1.0v 314.755n 1.0v 319.745n 1.0v 319.755n 1.0v 324.745n 1.0v 324.755n 1.0v 329.745n 1.0v 329.755n 1.0v 334.745n 1.0v 334.755n 1.0v 339.745n 1.0v 339.755n 1.0v 344.745n 1.0v 344.755n 1.0v 349.745n 1.0v 349.755n 0.0v 354.745n 0.0v 354.755n 0.0v 359.745n 0.0v 359.755n 0.0v 364.745n 0.0v 364.755n 0.0v 369.745n 0.0v 369.755n 0.0v 374.745n 0.0v 374.755n 0.0v 379.745n 0.0v 379.755n 0.0v 384.745n 0.0v 384.755n 0.0v 389.745n 0.0v 389.755n 0.0v 394.745n 0.0v 394.755n 0.0v 399.745n 0.0v 399.755n 0.0v 404.745n 0.0v 404.755n 0.0v 409.745n 0.0v 409.755n 0.0v 414.745n 0.0v 414.755n 0.0v 419.745n 0.0v 419.755n 0.0v 424.745n 0.0v 424.755n 0.0v 429.745n 0.0v 429.755n 0.0v 434.745n 0.0v 434.755n 1.0v 439.745n 1.0v 439.755n 1.0v 444.745n 1.0v 444.755n 1.0v 449.745n 1.0v 449.755n 1.0v 454.745n 1.0v 454.755n 0.0v 459.745n 0.0v 459.755n 0.0v 464.745n 0.0v 464.755n 0.0v 469.745n 0.0v 469.755n 0.0v 474.745n 0.0v 474.755n 0.0v 479.745n 0.0v 479.755n 0.0v 484.745n 0.0v 484.755n 0.0v 489.745n 0.0v 489.755n 0.0v 494.745n 0.0v 494.755n 0.0v 499.745n 0.0v 499.755n 0.0v 504.745n 0.0v 504.755n 0.0v 509.745n 0.0v 509.755n 0.0v 514.745n 0.0v 514.755n 0.0v 519.745n 0.0v 519.755n 0.0v 524.745n 0.0v 524.755n 0.0v 529.745n 0.0v 529.755n 0.0v 534.745n 0.0v 534.755n 0.0v 539.745n 0.0v 539.755n 0.0v 544.745n 0.0v 544.755n 1.0v 549.745n 1.0v 549.755n 1.0v 554.745n 1.0v 554.755n 1.0v 559.745n 1.0v 559.755n 1.0v 564.745n 1.0v 564.755n 1.0v 569.745n 1.0v 569.755n 1.0v 574.745n 1.0v 574.755n 1.0v 579.745n 1.0v 579.755n 1.0v 584.745n 1.0v 584.755n 1.0v 589.745n 1.0v 589.755n 1.0v 594.745n 1.0v 594.755n 1.0v 599.745n 1.0v 599.755n 1.0v 604.745n 1.0v 604.755n 1.0v 609.745n 1.0v 609.755n 1.0v 614.745n 1.0v 614.755n 0.0v 619.745n 0.0v 619.755n 0.0v 624.745n 0.0v 624.755n 0.0v 629.745n 0.0v 629.755n 0.0v 634.745n 0.0v 634.755n 0.0v 639.745n 0.0v 639.755n 0.0v 644.745n 0.0v 644.755n 0.0v 649.745n 0.0v 649.755n 0.0v 654.745n 0.0v 654.755n 0.0v 659.745n 0.0v 659.755n 0.0v 664.745n 0.0v 664.755n 0.0v 669.745n 0.0v 669.755n 0.0v 674.745n 0.0v 674.755n 0.0v 679.745n 0.0v 679.755n 0.0v 684.745n 0.0v 684.755n 0.0v 689.745n 0.0v 689.755n 0.0v 694.745n 0.0v 694.755n 0.0v 699.745n 0.0v 699.755n 0.0v 704.745n 0.0v 704.755n 0.0v 709.745n 0.0v 709.755n 0.0v 714.745n 0.0v 714.755n 0.0v 719.745n 0.0v 719.755n 1.0v 724.745n 1.0v 724.755n 1.0v 729.745n 1.0v 729.755n 1.0v 734.745n 1.0v 734.755n 0.0v 739.745n 0.0v 739.755n 0.0v 744.745n 0.0v 744.755n 0.0v 749.745n 0.0v 749.755n 0.0v 754.745n 0.0v 754.755n 0.0v 759.745n 0.0v 759.755n 0.0v 764.745n 0.0v 764.755n 0.0v 769.745n 0.0v 769.755n 1.0v 774.745n 1.0v 774.755n 1.0v 779.745n 1.0v 779.755n 0.0v 784.745n 0.0v 784.755n 0.0v 789.745n 0.0v 789.755n 0.0v 794.745n 0.0v 794.755n 0.0v 799.745n 0.0v 799.755n 0.0v 804.745n 0.0v 804.755n 0.0v 809.745n 0.0v 809.755n 0.0v 814.745n 0.0v 814.755n 0.0v 819.745n 0.0v 819.755n 0.0v 824.745n 0.0v 824.755n 0.0v 829.745n 0.0v 829.755n 0.0v 834.745n 0.0v 834.755n 0.0v 839.745n 0.0v 839.755n 0.0v 844.745n 0.0v 844.755n 0.0v 849.745n 0.0v 849.755n 0.0v 854.745n 0.0v 854.755n 0.0v 859.745n 0.0v 859.755n 1.0v 864.745n 1.0v 864.755n 1.0v 869.745n 1.0v 869.755n 1.0v 874.745n 1.0v 874.755n 1.0v 879.745n 1.0v 879.755n 1.0v 884.745n 1.0v 884.755n 1.0v 889.745n 1.0v 889.755n 1.0v 894.745n 1.0v 894.755n 1.0v 899.745n 1.0v 899.755n 1.0v 904.745n 1.0v 904.755n 1.0v 909.745n 1.0v 909.755n 1.0v 914.745n 1.0v 914.755n 1.0v 919.745n 1.0v 919.755n 1.0v 924.745n 1.0v 924.755n 1.0v 929.745n 1.0v 929.755n 1.0v 934.745n 1.0v 934.755n 0.0v 939.745n 0.0v 939.755n 0.0v 944.745n 0.0v 944.755n 0.0v 949.745n 0.0v 949.755n 0.0v 954.745n 0.0v 954.755n 0.0v 959.745n 0.0v 959.755n 1.0v 964.745n 1.0v 964.755n 1.0v 969.745n 1.0v 969.755n 0.0v 974.745n 0.0v 974.755n 0.0v 979.745n 0.0v 979.755n 0.0v 984.745n 0.0v 984.755n 0.0v 989.745n 0.0v 989.755n 1.0v 994.745n 1.0v 994.755n 1.0v 999.745n 1.0v 999.755n 1.0v 1004.745n 1.0v 1004.755n 1.0v 1009.745n 1.0v 1009.755n 1.0v 1014.745n 1.0v 1014.755n 0.0v 1019.745n 0.0v 1019.755n 0.0v 1024.745n 0.0v 1024.755n 0.0v )
* (time, data): [(0, 0), (5, 1), (10, 0), (15, 0), (20, 0), (25, 0), (30, 1), (35, 1), (40, 1), (45, 1), (50, 1), (55, 1), (60, 1), (65, 1), (70, 1), (75, 1), (80, 0), (85, 0), (90, 0), (95, 0), (100, 0), (105, 0), (110, 0), (115, 0), (120, 0), (125, 1), (130, 1), (135, 1), (140, 0), (145, 1), (150, 1), (155, 1), (160, 1), (165, 1), (170, 1), (175, 1), (180, 1), (185, 1), (190, 1), (195, 1), (200, 1), (205, 1), (210, 1), (215, 1), (220, 1), (225, 1), (230, 0), (235, 0), (240, 0), (245, 0), (250, 0), (255, 0), (260, 0), (265, 0), (270, 0), (275, 0), (280, 0), (285, 1), (290, 1), (295, 1), (300, 0), (305, 0), (310, 0), (315, 0), (320, 0), (325, 0), (330, 0), (335, 0), (340, 0), (345, 1), (350, 0), (355, 0), (360, 0), (365, 0), (370, 0), (375, 0), (380, 0), (385, 0), (390, 0), (395, 0), (400, 0), (405, 0), (410, 0), (415, 0), (420, 0), (425, 0), (430, 0), (435, 1), (440, 1), (445, 1), (450, 1), (455, 0), (460, 0), (465, 0), (470, 0), (475, 0), (480, 0), (485, 0), (490, 0), (495, 0), (500, 0), (505, 0), (510, 1), (515, 1), (520, 1), (525, 1), (530, 1), (535, 1), (540, 1), (545, 0), (550, 0), (555, 0), (560, 0), (565, 0), (570, 0), (575, 0), (580, 0), (585, 0), (590, 0), (595, 0), (600, 0), (605, 0), (610, 0), (615, 0), (620, 0), (625, 1), (630, 1), (635, 1), (640, 1), (645, 1), (650, 1), (655, 1), (660, 1), (665, 1), (670, 1), (675, 1), (680, 1), (685, 1), (690, 1), (695, 1), (700, 1), (705, 1), (710, 1), (715, 1), (720, 0), (725, 0), (730, 0), (735, 0), (740, 0), (745, 0), (750, 0), (755, 0), (760, 0), (765, 0), (770, 0), (775, 0), (780, 0), (785, 0), (790, 0), (795, 1), (800, 1), (805, 1), (810, 1), (815, 1), (820, 1), (825, 1), (830, 1), (835, 1), (840, 1), (845, 1), (850, 0), (855, 0), (860, 1), (865, 1), (870, 1), (875, 1), (880, 1), (885, 1), (890, 1), (895, 1), (900, 1), (905, 0), (910, 1), (915, 1), (920, 0), (925, 0), (930, 0), (935, 1), (940, 1), (945, 1), (950, 1), (955, 0), (960, 0), (965, 0), (970, 0), (975, 0), (980, 0), (985, 0), (990, 0), (995, 0), (1000, 0), (1005, 0), (1010, 0), (1015, 1), (1020, 1), (1025, 1)]
Vdin0_28  din0_28  0 PWL (0n 0.0v 4.745n 0.0v 4.755n 1.0v 9.745n 1.0v 9.755n 0.0v 14.745n 0.0v 14.755n 0.0v 19.745n 0.0v 19.755n 0.0v 24.745n 0.0v 24.755n 0.0v 29.745n 0.0v 29.755n 1.0v 34.745n 1.0v 34.755n 1.0v 39.745n 1.0v 39.755n 1.0v 44.745n 1.0v 44.755n 1.0v 49.745n 1.0v 49.755n 1.0v 54.745n 1.0v 54.755n 1.0v 59.745n 1.0v 59.755n 1.0v 64.745n 1.0v 64.755n 1.0v 69.745n 1.0v 69.755n 1.0v 74.745n 1.0v 74.755n 1.0v 79.745n 1.0v 79.755n 0.0v 84.745n 0.0v 84.755n 0.0v 89.745n 0.0v 89.755n 0.0v 94.745n 0.0v 94.755n 0.0v 99.745n 0.0v 99.755n 0.0v 104.745n 0.0v 104.755n 0.0v 109.745n 0.0v 109.755n 0.0v 114.745n 0.0v 114.755n 0.0v 119.745n 0.0v 119.755n 0.0v 124.745n 0.0v 124.755n 1.0v 129.745n 1.0v 129.755n 1.0v 134.745n 1.0v 134.755n 1.0v 139.745n 1.0v 139.755n 0.0v 144.745n 0.0v 144.755n 1.0v 149.745n 1.0v 149.755n 1.0v 154.745n 1.0v 154.755n 1.0v 159.745n 1.0v 159.755n 1.0v 164.745n 1.0v 164.755n 1.0v 169.745n 1.0v 169.755n 1.0v 174.745n 1.0v 174.755n 1.0v 179.745n 1.0v 179.755n 1.0v 184.745n 1.0v 184.755n 1.0v 189.745n 1.0v 189.755n 1.0v 194.745n 1.0v 194.755n 1.0v 199.745n 1.0v 199.755n 1.0v 204.745n 1.0v 204.755n 1.0v 209.745n 1.0v 209.755n 1.0v 214.745n 1.0v 214.755n 1.0v 219.745n 1.0v 219.755n 1.0v 224.745n 1.0v 224.755n 1.0v 229.745n 1.0v 229.755n 0.0v 234.745n 0.0v 234.755n 0.0v 239.745n 0.0v 239.755n 0.0v 244.745n 0.0v 244.755n 0.0v 249.745n 0.0v 249.755n 0.0v 254.745n 0.0v 254.755n 0.0v 259.745n 0.0v 259.755n 0.0v 264.745n 0.0v 264.755n 0.0v 269.745n 0.0v 269.755n 0.0v 274.745n 0.0v 274.755n 0.0v 279.745n 0.0v 279.755n 0.0v 284.745n 0.0v 284.755n 1.0v 289.745n 1.0v 289.755n 1.0v 294.745n 1.0v 294.755n 1.0v 299.745n 1.0v 299.755n 0.0v 304.745n 0.0v 304.755n 0.0v 309.745n 0.0v 309.755n 0.0v 314.745n 0.0v 314.755n 0.0v 319.745n 0.0v 319.755n 0.0v 324.745n 0.0v 324.755n 0.0v 329.745n 0.0v 329.755n 0.0v 334.745n 0.0v 334.755n 0.0v 339.745n 0.0v 339.755n 0.0v 344.745n 0.0v 344.755n 1.0v 349.745n 1.0v 349.755n 0.0v 354.745n 0.0v 354.755n 0.0v 359.745n 0.0v 359.755n 0.0v 364.745n 0.0v 364.755n 0.0v 369.745n 0.0v 369.755n 0.0v 374.745n 0.0v 374.755n 0.0v 379.745n 0.0v 379.755n 0.0v 384.745n 0.0v 384.755n 0.0v 389.745n 0.0v 389.755n 0.0v 394.745n 0.0v 394.755n 0.0v 399.745n 0.0v 399.755n 0.0v 404.745n 0.0v 404.755n 0.0v 409.745n 0.0v 409.755n 0.0v 414.745n 0.0v 414.755n 0.0v 419.745n 0.0v 419.755n 0.0v 424.745n 0.0v 424.755n 0.0v 429.745n 0.0v 429.755n 0.0v 434.745n 0.0v 434.755n 1.0v 439.745n 1.0v 439.755n 1.0v 444.745n 1.0v 444.755n 1.0v 449.745n 1.0v 449.755n 1.0v 454.745n 1.0v 454.755n 0.0v 459.745n 0.0v 459.755n 0.0v 464.745n 0.0v 464.755n 0.0v 469.745n 0.0v 469.755n 0.0v 474.745n 0.0v 474.755n 0.0v 479.745n 0.0v 479.755n 0.0v 484.745n 0.0v 484.755n 0.0v 489.745n 0.0v 489.755n 0.0v 494.745n 0.0v 494.755n 0.0v 499.745n 0.0v 499.755n 0.0v 504.745n 0.0v 504.755n 0.0v 509.745n 0.0v 509.755n 1.0v 514.745n 1.0v 514.755n 1.0v 519.745n 1.0v 519.755n 1.0v 524.745n 1.0v 524.755n 1.0v 529.745n 1.0v 529.755n 1.0v 534.745n 1.0v 534.755n 1.0v 539.745n 1.0v 539.755n 1.0v 544.745n 1.0v 544.755n 0.0v 549.745n 0.0v 549.755n 0.0v 554.745n 0.0v 554.755n 0.0v 559.745n 0.0v 559.755n 0.0v 564.745n 0.0v 564.755n 0.0v 569.745n 0.0v 569.755n 0.0v 574.745n 0.0v 574.755n 0.0v 579.745n 0.0v 579.755n 0.0v 584.745n 0.0v 584.755n 0.0v 589.745n 0.0v 589.755n 0.0v 594.745n 0.0v 594.755n 0.0v 599.745n 0.0v 599.755n 0.0v 604.745n 0.0v 604.755n 0.0v 609.745n 0.0v 609.755n 0.0v 614.745n 0.0v 614.755n 0.0v 619.745n 0.0v 619.755n 0.0v 624.745n 0.0v 624.755n 1.0v 629.745n 1.0v 629.755n 1.0v 634.745n 1.0v 634.755n 1.0v 639.745n 1.0v 639.755n 1.0v 644.745n 1.0v 644.755n 1.0v 649.745n 1.0v 649.755n 1.0v 654.745n 1.0v 654.755n 1.0v 659.745n 1.0v 659.755n 1.0v 664.745n 1.0v 664.755n 1.0v 669.745n 1.0v 669.755n 1.0v 674.745n 1.0v 674.755n 1.0v 679.745n 1.0v 679.755n 1.0v 684.745n 1.0v 684.755n 1.0v 689.745n 1.0v 689.755n 1.0v 694.745n 1.0v 694.755n 1.0v 699.745n 1.0v 699.755n 1.0v 704.745n 1.0v 704.755n 1.0v 709.745n 1.0v 709.755n 1.0v 714.745n 1.0v 714.755n 1.0v 719.745n 1.0v 719.755n 0.0v 724.745n 0.0v 724.755n 0.0v 729.745n 0.0v 729.755n 0.0v 734.745n 0.0v 734.755n 0.0v 739.745n 0.0v 739.755n 0.0v 744.745n 0.0v 744.755n 0.0v 749.745n 0.0v 749.755n 0.0v 754.745n 0.0v 754.755n 0.0v 759.745n 0.0v 759.755n 0.0v 764.745n 0.0v 764.755n 0.0v 769.745n 0.0v 769.755n 0.0v 774.745n 0.0v 774.755n 0.0v 779.745n 0.0v 779.755n 0.0v 784.745n 0.0v 784.755n 0.0v 789.745n 0.0v 789.755n 0.0v 794.745n 0.0v 794.755n 1.0v 799.745n 1.0v 799.755n 1.0v 804.745n 1.0v 804.755n 1.0v 809.745n 1.0v 809.755n 1.0v 814.745n 1.0v 814.755n 1.0v 819.745n 1.0v 819.755n 1.0v 824.745n 1.0v 824.755n 1.0v 829.745n 1.0v 829.755n 1.0v 834.745n 1.0v 834.755n 1.0v 839.745n 1.0v 839.755n 1.0v 844.745n 1.0v 844.755n 1.0v 849.745n 1.0v 849.755n 0.0v 854.745n 0.0v 854.755n 0.0v 859.745n 0.0v 859.755n 1.0v 864.745n 1.0v 864.755n 1.0v 869.745n 1.0v 869.755n 1.0v 874.745n 1.0v 874.755n 1.0v 879.745n 1.0v 879.755n 1.0v 884.745n 1.0v 884.755n 1.0v 889.745n 1.0v 889.755n 1.0v 894.745n 1.0v 894.755n 1.0v 899.745n 1.0v 899.755n 1.0v 904.745n 1.0v 904.755n 0.0v 909.745n 0.0v 909.755n 1.0v 914.745n 1.0v 914.755n 1.0v 919.745n 1.0v 919.755n 0.0v 924.745n 0.0v 924.755n 0.0v 929.745n 0.0v 929.755n 0.0v 934.745n 0.0v 934.755n 1.0v 939.745n 1.0v 939.755n 1.0v 944.745n 1.0v 944.755n 1.0v 949.745n 1.0v 949.755n 1.0v 954.745n 1.0v 954.755n 0.0v 959.745n 0.0v 959.755n 0.0v 964.745n 0.0v 964.755n 0.0v 969.745n 0.0v 969.755n 0.0v 974.745n 0.0v 974.755n 0.0v 979.745n 0.0v 979.755n 0.0v 984.745n 0.0v 984.755n 0.0v 989.745n 0.0v 989.755n 0.0v 994.745n 0.0v 994.755n 0.0v 999.745n 0.0v 999.755n 0.0v 1004.745n 0.0v 1004.755n 0.0v 1009.745n 0.0v 1009.755n 0.0v 1014.745n 0.0v 1014.755n 1.0v 1019.745n 1.0v 1019.755n 1.0v 1024.745n 1.0v 1024.755n 1.0v )
* (time, data): [(0, 0), (5, 1), (10, 1), (15, 1), (20, 1), (25, 1), (30, 1), (35, 1), (40, 0), (45, 1), (50, 1), (55, 1), (60, 1), (65, 0), (70, 0), (75, 0), (80, 1), (85, 1), (90, 1), (95, 1), (100, 1), (105, 1), (110, 0), (115, 0), (120, 0), (125, 1), (130, 1), (135, 1), (140, 0), (145, 1), (150, 1), (155, 1), (160, 1), (165, 1), (170, 1), (175, 1), (180, 1), (185, 1), (190, 1), (195, 1), (200, 1), (205, 1), (210, 1), (215, 1), (220, 1), (225, 1), (230, 1), (235, 0), (240, 1), (245, 0), (250, 1), (255, 1), (260, 1), (265, 1), (270, 1), (275, 1), (280, 1), (285, 0), (290, 0), (295, 0), (300, 1), (305, 1), (310, 1), (315, 1), (320, 1), (325, 1), (330, 1), (335, 1), (340, 1), (345, 0), (350, 1), (355, 1), (360, 1), (365, 1), (370, 1), (375, 1), (380, 1), (385, 1), (390, 1), (395, 1), (400, 1), (405, 1), (410, 1), (415, 1), (420, 1), (425, 1), (430, 1), (435, 0), (440, 0), (445, 0), (450, 0), (455, 0), (460, 0), (465, 1), (470, 1), (475, 1), (480, 1), (485, 1), (490, 1), (495, 1), (500, 1), (505, 1), (510, 1), (515, 1), (520, 1), (525, 1), (530, 1), (535, 1), (540, 1), (545, 1), (550, 1), (555, 1), (560, 1), (565, 1), (570, 1), (575, 1), (580, 1), (585, 1), (590, 1), (595, 1), (600, 1), (605, 1), (610, 1), (615, 1), (620, 1), (625, 1), (630, 1), (635, 1), (640, 1), (645, 1), (650, 1), (655, 1), (660, 1), (665, 1), (670, 1), (675, 1), (680, 1), (685, 1), (690, 1), (695, 1), (700, 1), (705, 1), (710, 1), (715, 1), (720, 1), (725, 1), (730, 1), (735, 0), (740, 0), (745, 0), (750, 0), (755, 0), (760, 0), (765, 0), (770, 1), (775, 1), (780, 0), (785, 0), (790, 0), (795, 1), (800, 1), (805, 1), (810, 1), (815, 1), (820, 0), (825, 0), (830, 0), (835, 0), (840, 0), (845, 0), (850, 0), (855, 0), (860, 1), (865, 1), (870, 1), (875, 1), (880, 1), (885, 1), (890, 1), (895, 1), (900, 1), (905, 1), (910, 0), (915, 0), (920, 0), (925, 0), (930, 0), (935, 1), (940, 1), (945, 1), (950, 1), (955, 0), (960, 1), (965, 1), (970, 1), (975, 1), (980, 1), (985, 1), (990, 1), (995, 1), (1000, 1), (1005, 1), (1010, 1), (1015, 1), (1020, 1), (1025, 1)]
Vdin0_29  din0_29  0 PWL (0n 0.0v 4.745n 0.0v 4.755n 1.0v 9.745n 1.0v 9.755n 1.0v 14.745n 1.0v 14.755n 1.0v 19.745n 1.0v 19.755n 1.0v 24.745n 1.0v 24.755n 1.0v 29.745n 1.0v 29.755n 1.0v 34.745n 1.0v 34.755n 1.0v 39.745n 1.0v 39.755n 0.0v 44.745n 0.0v 44.755n 1.0v 49.745n 1.0v 49.755n 1.0v 54.745n 1.0v 54.755n 1.0v 59.745n 1.0v 59.755n 1.0v 64.745n 1.0v 64.755n 0.0v 69.745n 0.0v 69.755n 0.0v 74.745n 0.0v 74.755n 0.0v 79.745n 0.0v 79.755n 1.0v 84.745n 1.0v 84.755n 1.0v 89.745n 1.0v 89.755n 1.0v 94.745n 1.0v 94.755n 1.0v 99.745n 1.0v 99.755n 1.0v 104.745n 1.0v 104.755n 1.0v 109.745n 1.0v 109.755n 0.0v 114.745n 0.0v 114.755n 0.0v 119.745n 0.0v 119.755n 0.0v 124.745n 0.0v 124.755n 1.0v 129.745n 1.0v 129.755n 1.0v 134.745n 1.0v 134.755n 1.0v 139.745n 1.0v 139.755n 0.0v 144.745n 0.0v 144.755n 1.0v 149.745n 1.0v 149.755n 1.0v 154.745n 1.0v 154.755n 1.0v 159.745n 1.0v 159.755n 1.0v 164.745n 1.0v 164.755n 1.0v 169.745n 1.0v 169.755n 1.0v 174.745n 1.0v 174.755n 1.0v 179.745n 1.0v 179.755n 1.0v 184.745n 1.0v 184.755n 1.0v 189.745n 1.0v 189.755n 1.0v 194.745n 1.0v 194.755n 1.0v 199.745n 1.0v 199.755n 1.0v 204.745n 1.0v 204.755n 1.0v 209.745n 1.0v 209.755n 1.0v 214.745n 1.0v 214.755n 1.0v 219.745n 1.0v 219.755n 1.0v 224.745n 1.0v 224.755n 1.0v 229.745n 1.0v 229.755n 1.0v 234.745n 1.0v 234.755n 0.0v 239.745n 0.0v 239.755n 1.0v 244.745n 1.0v 244.755n 0.0v 249.745n 0.0v 249.755n 1.0v 254.745n 1.0v 254.755n 1.0v 259.745n 1.0v 259.755n 1.0v 264.745n 1.0v 264.755n 1.0v 269.745n 1.0v 269.755n 1.0v 274.745n 1.0v 274.755n 1.0v 279.745n 1.0v 279.755n 1.0v 284.745n 1.0v 284.755n 0.0v 289.745n 0.0v 289.755n 0.0v 294.745n 0.0v 294.755n 0.0v 299.745n 0.0v 299.755n 1.0v 304.745n 1.0v 304.755n 1.0v 309.745n 1.0v 309.755n 1.0v 314.745n 1.0v 314.755n 1.0v 319.745n 1.0v 319.755n 1.0v 324.745n 1.0v 324.755n 1.0v 329.745n 1.0v 329.755n 1.0v 334.745n 1.0v 334.755n 1.0v 339.745n 1.0v 339.755n 1.0v 344.745n 1.0v 344.755n 0.0v 349.745n 0.0v 349.755n 1.0v 354.745n 1.0v 354.755n 1.0v 359.745n 1.0v 359.755n 1.0v 364.745n 1.0v 364.755n 1.0v 369.745n 1.0v 369.755n 1.0v 374.745n 1.0v 374.755n 1.0v 379.745n 1.0v 379.755n 1.0v 384.745n 1.0v 384.755n 1.0v 389.745n 1.0v 389.755n 1.0v 394.745n 1.0v 394.755n 1.0v 399.745n 1.0v 399.755n 1.0v 404.745n 1.0v 404.755n 1.0v 409.745n 1.0v 409.755n 1.0v 414.745n 1.0v 414.755n 1.0v 419.745n 1.0v 419.755n 1.0v 424.745n 1.0v 424.755n 1.0v 429.745n 1.0v 429.755n 1.0v 434.745n 1.0v 434.755n 0.0v 439.745n 0.0v 439.755n 0.0v 444.745n 0.0v 444.755n 0.0v 449.745n 0.0v 449.755n 0.0v 454.745n 0.0v 454.755n 0.0v 459.745n 0.0v 459.755n 0.0v 464.745n 0.0v 464.755n 1.0v 469.745n 1.0v 469.755n 1.0v 474.745n 1.0v 474.755n 1.0v 479.745n 1.0v 479.755n 1.0v 484.745n 1.0v 484.755n 1.0v 489.745n 1.0v 489.755n 1.0v 494.745n 1.0v 494.755n 1.0v 499.745n 1.0v 499.755n 1.0v 504.745n 1.0v 504.755n 1.0v 509.745n 1.0v 509.755n 1.0v 514.745n 1.0v 514.755n 1.0v 519.745n 1.0v 519.755n 1.0v 524.745n 1.0v 524.755n 1.0v 529.745n 1.0v 529.755n 1.0v 534.745n 1.0v 534.755n 1.0v 539.745n 1.0v 539.755n 1.0v 544.745n 1.0v 544.755n 1.0v 549.745n 1.0v 549.755n 1.0v 554.745n 1.0v 554.755n 1.0v 559.745n 1.0v 559.755n 1.0v 564.745n 1.0v 564.755n 1.0v 569.745n 1.0v 569.755n 1.0v 574.745n 1.0v 574.755n 1.0v 579.745n 1.0v 579.755n 1.0v 584.745n 1.0v 584.755n 1.0v 589.745n 1.0v 589.755n 1.0v 594.745n 1.0v 594.755n 1.0v 599.745n 1.0v 599.755n 1.0v 604.745n 1.0v 604.755n 1.0v 609.745n 1.0v 609.755n 1.0v 614.745n 1.0v 614.755n 1.0v 619.745n 1.0v 619.755n 1.0v 624.745n 1.0v 624.755n 1.0v 629.745n 1.0v 629.755n 1.0v 634.745n 1.0v 634.755n 1.0v 639.745n 1.0v 639.755n 1.0v 644.745n 1.0v 644.755n 1.0v 649.745n 1.0v 649.755n 1.0v 654.745n 1.0v 654.755n 1.0v 659.745n 1.0v 659.755n 1.0v 664.745n 1.0v 664.755n 1.0v 669.745n 1.0v 669.755n 1.0v 674.745n 1.0v 674.755n 1.0v 679.745n 1.0v 679.755n 1.0v 684.745n 1.0v 684.755n 1.0v 689.745n 1.0v 689.755n 1.0v 694.745n 1.0v 694.755n 1.0v 699.745n 1.0v 699.755n 1.0v 704.745n 1.0v 704.755n 1.0v 709.745n 1.0v 709.755n 1.0v 714.745n 1.0v 714.755n 1.0v 719.745n 1.0v 719.755n 1.0v 724.745n 1.0v 724.755n 1.0v 729.745n 1.0v 729.755n 1.0v 734.745n 1.0v 734.755n 0.0v 739.745n 0.0v 739.755n 0.0v 744.745n 0.0v 744.755n 0.0v 749.745n 0.0v 749.755n 0.0v 754.745n 0.0v 754.755n 0.0v 759.745n 0.0v 759.755n 0.0v 764.745n 0.0v 764.755n 0.0v 769.745n 0.0v 769.755n 1.0v 774.745n 1.0v 774.755n 1.0v 779.745n 1.0v 779.755n 0.0v 784.745n 0.0v 784.755n 0.0v 789.745n 0.0v 789.755n 0.0v 794.745n 0.0v 794.755n 1.0v 799.745n 1.0v 799.755n 1.0v 804.745n 1.0v 804.755n 1.0v 809.745n 1.0v 809.755n 1.0v 814.745n 1.0v 814.755n 1.0v 819.745n 1.0v 819.755n 0.0v 824.745n 0.0v 824.755n 0.0v 829.745n 0.0v 829.755n 0.0v 834.745n 0.0v 834.755n 0.0v 839.745n 0.0v 839.755n 0.0v 844.745n 0.0v 844.755n 0.0v 849.745n 0.0v 849.755n 0.0v 854.745n 0.0v 854.755n 0.0v 859.745n 0.0v 859.755n 1.0v 864.745n 1.0v 864.755n 1.0v 869.745n 1.0v 869.755n 1.0v 874.745n 1.0v 874.755n 1.0v 879.745n 1.0v 879.755n 1.0v 884.745n 1.0v 884.755n 1.0v 889.745n 1.0v 889.755n 1.0v 894.745n 1.0v 894.755n 1.0v 899.745n 1.0v 899.755n 1.0v 904.745n 1.0v 904.755n 1.0v 909.745n 1.0v 909.755n 0.0v 914.745n 0.0v 914.755n 0.0v 919.745n 0.0v 919.755n 0.0v 924.745n 0.0v 924.755n 0.0v 929.745n 0.0v 929.755n 0.0v 934.745n 0.0v 934.755n 1.0v 939.745n 1.0v 939.755n 1.0v 944.745n 1.0v 944.755n 1.0v 949.745n 1.0v 949.755n 1.0v 954.745n 1.0v 954.755n 0.0v 959.745n 0.0v 959.755n 1.0v 964.745n 1.0v 964.755n 1.0v 969.745n 1.0v 969.755n 1.0v 974.745n 1.0v 974.755n 1.0v 979.745n 1.0v 979.755n 1.0v 984.745n 1.0v 984.755n 1.0v 989.745n 1.0v 989.755n 1.0v 994.745n 1.0v 994.755n 1.0v 999.745n 1.0v 999.755n 1.0v 1004.745n 1.0v 1004.755n 1.0v 1009.745n 1.0v 1009.755n 1.0v 1014.745n 1.0v 1014.755n 1.0v 1019.745n 1.0v 1019.755n 1.0v 1024.745n 1.0v 1024.755n 1.0v )
* (time, data): [(0, 0), (5, 0), (10, 1), (15, 1), (20, 1), (25, 1), (30, 1), (35, 0), (40, 1), (45, 0), (50, 0), (55, 0), (60, 0), (65, 0), (70, 0), (75, 0), (80, 1), (85, 1), (90, 1), (95, 1), (100, 1), (105, 1), (110, 0), (115, 0), (120, 0), (125, 0), (130, 0), (135, 0), (140, 0), (145, 1), (150, 1), (155, 1), (160, 1), (165, 1), (170, 1), (175, 1), (180, 1), (185, 1), (190, 1), (195, 1), (200, 1), (205, 1), (210, 1), (215, 1), (220, 1), (225, 1), (230, 0), (235, 0), (240, 0), (245, 0), (250, 0), (255, 0), (260, 0), (265, 0), (270, 0), (275, 1), (280, 1), (285, 0), (290, 0), (295, 0), (300, 1), (305, 1), (310, 1), (315, 1), (320, 1), (325, 1), (330, 1), (335, 1), (340, 0), (345, 0), (350, 0), (355, 0), (360, 0), (365, 0), (370, 0), (375, 0), (380, 0), (385, 0), (390, 0), (395, 0), (400, 0), (405, 0), (410, 0), (415, 0), (420, 0), (425, 0), (430, 0), (435, 0), (440, 0), (445, 0), (450, 0), (455, 1), (460, 1), (465, 1), (470, 1), (475, 1), (480, 1), (485, 1), (490, 1), (495, 1), (500, 1), (505, 1), (510, 1), (515, 1), (520, 1), (525, 1), (530, 1), (535, 1), (540, 1), (545, 0), (550, 0), (555, 0), (560, 0), (565, 0), (570, 0), (575, 0), (580, 0), (585, 0), (590, 0), (595, 0), (600, 0), (605, 0), (610, 0), (615, 1), (620, 1), (625, 0), (630, 0), (635, 0), (640, 0), (645, 0), (650, 0), (655, 0), (660, 0), (665, 0), (670, 0), (675, 0), (680, 1), (685, 1), (690, 1), (695, 1), (700, 1), (705, 1), (710, 0), (715, 0), (720, 0), (725, 0), (730, 0), (735, 1), (740, 1), (745, 1), (750, 1), (755, 1), (760, 1), (765, 1), (770, 0), (775, 0), (780, 1), (785, 1), (790, 1), (795, 0), (800, 0), (805, 0), (810, 0), (815, 0), (820, 0), (825, 0), (830, 0), (835, 0), (840, 0), (845, 0), (850, 0), (855, 0), (860, 0), (865, 0), (870, 0), (875, 0), (880, 0), (885, 0), (890, 0), (895, 0), (900, 0), (905, 1), (910, 1), (915, 1), (920, 0), (925, 0), (930, 0), (935, 1), (940, 1), (945, 1), (950, 1), (955, 0), (960, 0), (965, 0), (970, 0), (975, 0), (980, 0), (985, 0), (990, 0), (995, 0), (1000, 0), (1005, 0), (1010, 0), (1015, 0), (1020, 0), (1025, 0)]
Vdin0_30  din0_30  0 PWL (0n 0.0v 4.745n 0.0v 4.755n 0.0v 9.745n 0.0v 9.755n 1.0v 14.745n 1.0v 14.755n 1.0v 19.745n 1.0v 19.755n 1.0v 24.745n 1.0v 24.755n 1.0v 29.745n 1.0v 29.755n 1.0v 34.745n 1.0v 34.755n 0.0v 39.745n 0.0v 39.755n 1.0v 44.745n 1.0v 44.755n 0.0v 49.745n 0.0v 49.755n 0.0v 54.745n 0.0v 54.755n 0.0v 59.745n 0.0v 59.755n 0.0v 64.745n 0.0v 64.755n 0.0v 69.745n 0.0v 69.755n 0.0v 74.745n 0.0v 74.755n 0.0v 79.745n 0.0v 79.755n 1.0v 84.745n 1.0v 84.755n 1.0v 89.745n 1.0v 89.755n 1.0v 94.745n 1.0v 94.755n 1.0v 99.745n 1.0v 99.755n 1.0v 104.745n 1.0v 104.755n 1.0v 109.745n 1.0v 109.755n 0.0v 114.745n 0.0v 114.755n 0.0v 119.745n 0.0v 119.755n 0.0v 124.745n 0.0v 124.755n 0.0v 129.745n 0.0v 129.755n 0.0v 134.745n 0.0v 134.755n 0.0v 139.745n 0.0v 139.755n 0.0v 144.745n 0.0v 144.755n 1.0v 149.745n 1.0v 149.755n 1.0v 154.745n 1.0v 154.755n 1.0v 159.745n 1.0v 159.755n 1.0v 164.745n 1.0v 164.755n 1.0v 169.745n 1.0v 169.755n 1.0v 174.745n 1.0v 174.755n 1.0v 179.745n 1.0v 179.755n 1.0v 184.745n 1.0v 184.755n 1.0v 189.745n 1.0v 189.755n 1.0v 194.745n 1.0v 194.755n 1.0v 199.745n 1.0v 199.755n 1.0v 204.745n 1.0v 204.755n 1.0v 209.745n 1.0v 209.755n 1.0v 214.745n 1.0v 214.755n 1.0v 219.745n 1.0v 219.755n 1.0v 224.745n 1.0v 224.755n 1.0v 229.745n 1.0v 229.755n 0.0v 234.745n 0.0v 234.755n 0.0v 239.745n 0.0v 239.755n 0.0v 244.745n 0.0v 244.755n 0.0v 249.745n 0.0v 249.755n 0.0v 254.745n 0.0v 254.755n 0.0v 259.745n 0.0v 259.755n 0.0v 264.745n 0.0v 264.755n 0.0v 269.745n 0.0v 269.755n 0.0v 274.745n 0.0v 274.755n 1.0v 279.745n 1.0v 279.755n 1.0v 284.745n 1.0v 284.755n 0.0v 289.745n 0.0v 289.755n 0.0v 294.745n 0.0v 294.755n 0.0v 299.745n 0.0v 299.755n 1.0v 304.745n 1.0v 304.755n 1.0v 309.745n 1.0v 309.755n 1.0v 314.745n 1.0v 314.755n 1.0v 319.745n 1.0v 319.755n 1.0v 324.745n 1.0v 324.755n 1.0v 329.745n 1.0v 329.755n 1.0v 334.745n 1.0v 334.755n 1.0v 339.745n 1.0v 339.755n 0.0v 344.745n 0.0v 344.755n 0.0v 349.745n 0.0v 349.755n 0.0v 354.745n 0.0v 354.755n 0.0v 359.745n 0.0v 359.755n 0.0v 364.745n 0.0v 364.755n 0.0v 369.745n 0.0v 369.755n 0.0v 374.745n 0.0v 374.755n 0.0v 379.745n 0.0v 379.755n 0.0v 384.745n 0.0v 384.755n 0.0v 389.745n 0.0v 389.755n 0.0v 394.745n 0.0v 394.755n 0.0v 399.745n 0.0v 399.755n 0.0v 404.745n 0.0v 404.755n 0.0v 409.745n 0.0v 409.755n 0.0v 414.745n 0.0v 414.755n 0.0v 419.745n 0.0v 419.755n 0.0v 424.745n 0.0v 424.755n 0.0v 429.745n 0.0v 429.755n 0.0v 434.745n 0.0v 434.755n 0.0v 439.745n 0.0v 439.755n 0.0v 444.745n 0.0v 444.755n 0.0v 449.745n 0.0v 449.755n 0.0v 454.745n 0.0v 454.755n 1.0v 459.745n 1.0v 459.755n 1.0v 464.745n 1.0v 464.755n 1.0v 469.745n 1.0v 469.755n 1.0v 474.745n 1.0v 474.755n 1.0v 479.745n 1.0v 479.755n 1.0v 484.745n 1.0v 484.755n 1.0v 489.745n 1.0v 489.755n 1.0v 494.745n 1.0v 494.755n 1.0v 499.745n 1.0v 499.755n 1.0v 504.745n 1.0v 504.755n 1.0v 509.745n 1.0v 509.755n 1.0v 514.745n 1.0v 514.755n 1.0v 519.745n 1.0v 519.755n 1.0v 524.745n 1.0v 524.755n 1.0v 529.745n 1.0v 529.755n 1.0v 534.745n 1.0v 534.755n 1.0v 539.745n 1.0v 539.755n 1.0v 544.745n 1.0v 544.755n 0.0v 549.745n 0.0v 549.755n 0.0v 554.745n 0.0v 554.755n 0.0v 559.745n 0.0v 559.755n 0.0v 564.745n 0.0v 564.755n 0.0v 569.745n 0.0v 569.755n 0.0v 574.745n 0.0v 574.755n 0.0v 579.745n 0.0v 579.755n 0.0v 584.745n 0.0v 584.755n 0.0v 589.745n 0.0v 589.755n 0.0v 594.745n 0.0v 594.755n 0.0v 599.745n 0.0v 599.755n 0.0v 604.745n 0.0v 604.755n 0.0v 609.745n 0.0v 609.755n 0.0v 614.745n 0.0v 614.755n 1.0v 619.745n 1.0v 619.755n 1.0v 624.745n 1.0v 624.755n 0.0v 629.745n 0.0v 629.755n 0.0v 634.745n 0.0v 634.755n 0.0v 639.745n 0.0v 639.755n 0.0v 644.745n 0.0v 644.755n 0.0v 649.745n 0.0v 649.755n 0.0v 654.745n 0.0v 654.755n 0.0v 659.745n 0.0v 659.755n 0.0v 664.745n 0.0v 664.755n 0.0v 669.745n 0.0v 669.755n 0.0v 674.745n 0.0v 674.755n 0.0v 679.745n 0.0v 679.755n 1.0v 684.745n 1.0v 684.755n 1.0v 689.745n 1.0v 689.755n 1.0v 694.745n 1.0v 694.755n 1.0v 699.745n 1.0v 699.755n 1.0v 704.745n 1.0v 704.755n 1.0v 709.745n 1.0v 709.755n 0.0v 714.745n 0.0v 714.755n 0.0v 719.745n 0.0v 719.755n 0.0v 724.745n 0.0v 724.755n 0.0v 729.745n 0.0v 729.755n 0.0v 734.745n 0.0v 734.755n 1.0v 739.745n 1.0v 739.755n 1.0v 744.745n 1.0v 744.755n 1.0v 749.745n 1.0v 749.755n 1.0v 754.745n 1.0v 754.755n 1.0v 759.745n 1.0v 759.755n 1.0v 764.745n 1.0v 764.755n 1.0v 769.745n 1.0v 769.755n 0.0v 774.745n 0.0v 774.755n 0.0v 779.745n 0.0v 779.755n 1.0v 784.745n 1.0v 784.755n 1.0v 789.745n 1.0v 789.755n 1.0v 794.745n 1.0v 794.755n 0.0v 799.745n 0.0v 799.755n 0.0v 804.745n 0.0v 804.755n 0.0v 809.745n 0.0v 809.755n 0.0v 814.745n 0.0v 814.755n 0.0v 819.745n 0.0v 819.755n 0.0v 824.745n 0.0v 824.755n 0.0v 829.745n 0.0v 829.755n 0.0v 834.745n 0.0v 834.755n 0.0v 839.745n 0.0v 839.755n 0.0v 844.745n 0.0v 844.755n 0.0v 849.745n 0.0v 849.755n 0.0v 854.745n 0.0v 854.755n 0.0v 859.745n 0.0v 859.755n 0.0v 864.745n 0.0v 864.755n 0.0v 869.745n 0.0v 869.755n 0.0v 874.745n 0.0v 874.755n 0.0v 879.745n 0.0v 879.755n 0.0v 884.745n 0.0v 884.755n 0.0v 889.745n 0.0v 889.755n 0.0v 894.745n 0.0v 894.755n 0.0v 899.745n 0.0v 899.755n 0.0v 904.745n 0.0v 904.755n 1.0v 909.745n 1.0v 909.755n 1.0v 914.745n 1.0v 914.755n 1.0v 919.745n 1.0v 919.755n 0.0v 924.745n 0.0v 924.755n 0.0v 929.745n 0.0v 929.755n 0.0v 934.745n 0.0v 934.755n 1.0v 939.745n 1.0v 939.755n 1.0v 944.745n 1.0v 944.755n 1.0v 949.745n 1.0v 949.755n 1.0v 954.745n 1.0v 954.755n 0.0v 959.745n 0.0v 959.755n 0.0v 964.745n 0.0v 964.755n 0.0v 969.745n 0.0v 969.755n 0.0v 974.745n 0.0v 974.755n 0.0v 979.745n 0.0v 979.755n 0.0v 984.745n 0.0v 984.755n 0.0v 989.745n 0.0v 989.755n 0.0v 994.745n 0.0v 994.755n 0.0v 999.745n 0.0v 999.755n 0.0v 1004.745n 0.0v 1004.755n 0.0v 1009.745n 0.0v 1009.755n 0.0v 1014.745n 0.0v 1014.755n 0.0v 1019.745n 0.0v 1019.755n 0.0v 1024.745n 0.0v 1024.755n 0.0v )
* (time, data): [(0, 0), (5, 0), (10, 1), (15, 1), (20, 1), (25, 1), (30, 0), (35, 1), (40, 0), (45, 0), (50, 0), (55, 0), (60, 0), (65, 1), (70, 1), (75, 1), (80, 0), (85, 0), (90, 0), (95, 0), (100, 0), (105, 0), (110, 1), (115, 1), (120, 1), (125, 1), (130, 1), (135, 1), (140, 0), (145, 0), (150, 0), (155, 0), (160, 0), (165, 0), (170, 0), (175, 0), (180, 0), (185, 0), (190, 0), (195, 0), (200, 0), (205, 0), (210, 0), (215, 0), (220, 0), (225, 0), (230, 0), (235, 0), (240, 0), (245, 0), (250, 0), (255, 0), (260, 0), (265, 0), (270, 0), (275, 1), (280, 1), (285, 0), (290, 0), (295, 0), (300, 0), (305, 0), (310, 0), (315, 0), (320, 0), (325, 0), (330, 0), (335, 0), (340, 1), (345, 0), (350, 1), (355, 1), (360, 1), (365, 1), (370, 1), (375, 1), (380, 1), (385, 1), (390, 1), (395, 1), (400, 1), (405, 1), (410, 1), (415, 1), (420, 1), (425, 1), (430, 1), (435, 0), (440, 0), (445, 0), (450, 0), (455, 1), (460, 1), (465, 1), (470, 1), (475, 1), (480, 1), (485, 1), (490, 1), (495, 1), (500, 1), (505, 1), (510, 1), (515, 1), (520, 1), (525, 1), (530, 1), (535, 1), (540, 1), (545, 1), (550, 1), (555, 1), (560, 1), (565, 1), (570, 1), (575, 1), (580, 1), (585, 1), (590, 1), (595, 1), (600, 1), (605, 1), (610, 1), (615, 1), (620, 1), (625, 0), (630, 0), (635, 0), (640, 0), (645, 0), (650, 0), (655, 0), (660, 0), (665, 0), (670, 0), (675, 0), (680, 0), (685, 0), (690, 0), (695, 0), (700, 0), (705, 0), (710, 1), (715, 1), (720, 0), (725, 0), (730, 0), (735, 0), (740, 0), (745, 0), (750, 0), (755, 0), (760, 0), (765, 0), (770, 1), (775, 1), (780, 0), (785, 0), (790, 0), (795, 0), (800, 0), (805, 0), (810, 0), (815, 0), (820, 1), (825, 1), (830, 1), (835, 1), (840, 1), (845, 1), (850, 1), (855, 1), (860, 0), (865, 0), (870, 0), (875, 0), (880, 0), (885, 0), (890, 0), (895, 0), (900, 0), (905, 1), (910, 0), (915, 0), (920, 0), (925, 0), (930, 0), (935, 0), (940, 0), (945, 0), (950, 0), (955, 1), (960, 0), (965, 0), (970, 1), (975, 1), (980, 1), (985, 1), (990, 1), (995, 1), (1000, 1), (1005, 1), (1010, 1), (1015, 1), (1020, 1), (1025, 1)]
Vdin0_31  din0_31  0 PWL (0n 0.0v 4.745n 0.0v 4.755n 0.0v 9.745n 0.0v 9.755n 1.0v 14.745n 1.0v 14.755n 1.0v 19.745n 1.0v 19.755n 1.0v 24.745n 1.0v 24.755n 1.0v 29.745n 1.0v 29.755n 0.0v 34.745n 0.0v 34.755n 1.0v 39.745n 1.0v 39.755n 0.0v 44.745n 0.0v 44.755n 0.0v 49.745n 0.0v 49.755n 0.0v 54.745n 0.0v 54.755n 0.0v 59.745n 0.0v 59.755n 0.0v 64.745n 0.0v 64.755n 1.0v 69.745n 1.0v 69.755n 1.0v 74.745n 1.0v 74.755n 1.0v 79.745n 1.0v 79.755n 0.0v 84.745n 0.0v 84.755n 0.0v 89.745n 0.0v 89.755n 0.0v 94.745n 0.0v 94.755n 0.0v 99.745n 0.0v 99.755n 0.0v 104.745n 0.0v 104.755n 0.0v 109.745n 0.0v 109.755n 1.0v 114.745n 1.0v 114.755n 1.0v 119.745n 1.0v 119.755n 1.0v 124.745n 1.0v 124.755n 1.0v 129.745n 1.0v 129.755n 1.0v 134.745n 1.0v 134.755n 1.0v 139.745n 1.0v 139.755n 0.0v 144.745n 0.0v 144.755n 0.0v 149.745n 0.0v 149.755n 0.0v 154.745n 0.0v 154.755n 0.0v 159.745n 0.0v 159.755n 0.0v 164.745n 0.0v 164.755n 0.0v 169.745n 0.0v 169.755n 0.0v 174.745n 0.0v 174.755n 0.0v 179.745n 0.0v 179.755n 0.0v 184.745n 0.0v 184.755n 0.0v 189.745n 0.0v 189.755n 0.0v 194.745n 0.0v 194.755n 0.0v 199.745n 0.0v 199.755n 0.0v 204.745n 0.0v 204.755n 0.0v 209.745n 0.0v 209.755n 0.0v 214.745n 0.0v 214.755n 0.0v 219.745n 0.0v 219.755n 0.0v 224.745n 0.0v 224.755n 0.0v 229.745n 0.0v 229.755n 0.0v 234.745n 0.0v 234.755n 0.0v 239.745n 0.0v 239.755n 0.0v 244.745n 0.0v 244.755n 0.0v 249.745n 0.0v 249.755n 0.0v 254.745n 0.0v 254.755n 0.0v 259.745n 0.0v 259.755n 0.0v 264.745n 0.0v 264.755n 0.0v 269.745n 0.0v 269.755n 0.0v 274.745n 0.0v 274.755n 1.0v 279.745n 1.0v 279.755n 1.0v 284.745n 1.0v 284.755n 0.0v 289.745n 0.0v 289.755n 0.0v 294.745n 0.0v 294.755n 0.0v 299.745n 0.0v 299.755n 0.0v 304.745n 0.0v 304.755n 0.0v 309.745n 0.0v 309.755n 0.0v 314.745n 0.0v 314.755n 0.0v 319.745n 0.0v 319.755n 0.0v 324.745n 0.0v 324.755n 0.0v 329.745n 0.0v 329.755n 0.0v 334.745n 0.0v 334.755n 0.0v 339.745n 0.0v 339.755n 1.0v 344.745n 1.0v 344.755n 0.0v 349.745n 0.0v 349.755n 1.0v 354.745n 1.0v 354.755n 1.0v 359.745n 1.0v 359.755n 1.0v 364.745n 1.0v 364.755n 1.0v 369.745n 1.0v 369.755n 1.0v 374.745n 1.0v 374.755n 1.0v 379.745n 1.0v 379.755n 1.0v 384.745n 1.0v 384.755n 1.0v 389.745n 1.0v 389.755n 1.0v 394.745n 1.0v 394.755n 1.0v 399.745n 1.0v 399.755n 1.0v 404.745n 1.0v 404.755n 1.0v 409.745n 1.0v 409.755n 1.0v 414.745n 1.0v 414.755n 1.0v 419.745n 1.0v 419.755n 1.0v 424.745n 1.0v 424.755n 1.0v 429.745n 1.0v 429.755n 1.0v 434.745n 1.0v 434.755n 0.0v 439.745n 0.0v 439.755n 0.0v 444.745n 0.0v 444.755n 0.0v 449.745n 0.0v 449.755n 0.0v 454.745n 0.0v 454.755n 1.0v 459.745n 1.0v 459.755n 1.0v 464.745n 1.0v 464.755n 1.0v 469.745n 1.0v 469.755n 1.0v 474.745n 1.0v 474.755n 1.0v 479.745n 1.0v 479.755n 1.0v 484.745n 1.0v 484.755n 1.0v 489.745n 1.0v 489.755n 1.0v 494.745n 1.0v 494.755n 1.0v 499.745n 1.0v 499.755n 1.0v 504.745n 1.0v 504.755n 1.0v 509.745n 1.0v 509.755n 1.0v 514.745n 1.0v 514.755n 1.0v 519.745n 1.0v 519.755n 1.0v 524.745n 1.0v 524.755n 1.0v 529.745n 1.0v 529.755n 1.0v 534.745n 1.0v 534.755n 1.0v 539.745n 1.0v 539.755n 1.0v 544.745n 1.0v 544.755n 1.0v 549.745n 1.0v 549.755n 1.0v 554.745n 1.0v 554.755n 1.0v 559.745n 1.0v 559.755n 1.0v 564.745n 1.0v 564.755n 1.0v 569.745n 1.0v 569.755n 1.0v 574.745n 1.0v 574.755n 1.0v 579.745n 1.0v 579.755n 1.0v 584.745n 1.0v 584.755n 1.0v 589.745n 1.0v 589.755n 1.0v 594.745n 1.0v 594.755n 1.0v 599.745n 1.0v 599.755n 1.0v 604.745n 1.0v 604.755n 1.0v 609.745n 1.0v 609.755n 1.0v 614.745n 1.0v 614.755n 1.0v 619.745n 1.0v 619.755n 1.0v 624.745n 1.0v 624.755n 0.0v 629.745n 0.0v 629.755n 0.0v 634.745n 0.0v 634.755n 0.0v 639.745n 0.0v 639.755n 0.0v 644.745n 0.0v 644.755n 0.0v 649.745n 0.0v 649.755n 0.0v 654.745n 0.0v 654.755n 0.0v 659.745n 0.0v 659.755n 0.0v 664.745n 0.0v 664.755n 0.0v 669.745n 0.0v 669.755n 0.0v 674.745n 0.0v 674.755n 0.0v 679.745n 0.0v 679.755n 0.0v 684.745n 0.0v 684.755n 0.0v 689.745n 0.0v 689.755n 0.0v 694.745n 0.0v 694.755n 0.0v 699.745n 0.0v 699.755n 0.0v 704.745n 0.0v 704.755n 0.0v 709.745n 0.0v 709.755n 1.0v 714.745n 1.0v 714.755n 1.0v 719.745n 1.0v 719.755n 0.0v 724.745n 0.0v 724.755n 0.0v 729.745n 0.0v 729.755n 0.0v 734.745n 0.0v 734.755n 0.0v 739.745n 0.0v 739.755n 0.0v 744.745n 0.0v 744.755n 0.0v 749.745n 0.0v 749.755n 0.0v 754.745n 0.0v 754.755n 0.0v 759.745n 0.0v 759.755n 0.0v 764.745n 0.0v 764.755n 0.0v 769.745n 0.0v 769.755n 1.0v 774.745n 1.0v 774.755n 1.0v 779.745n 1.0v 779.755n 0.0v 784.745n 0.0v 784.755n 0.0v 789.745n 0.0v 789.755n 0.0v 794.745n 0.0v 794.755n 0.0v 799.745n 0.0v 799.755n 0.0v 804.745n 0.0v 804.755n 0.0v 809.745n 0.0v 809.755n 0.0v 814.745n 0.0v 814.755n 0.0v 819.745n 0.0v 819.755n 1.0v 824.745n 1.0v 824.755n 1.0v 829.745n 1.0v 829.755n 1.0v 834.745n 1.0v 834.755n 1.0v 839.745n 1.0v 839.755n 1.0v 844.745n 1.0v 844.755n 1.0v 849.745n 1.0v 849.755n 1.0v 854.745n 1.0v 854.755n 1.0v 859.745n 1.0v 859.755n 0.0v 864.745n 0.0v 864.755n 0.0v 869.745n 0.0v 869.755n 0.0v 874.745n 0.0v 874.755n 0.0v 879.745n 0.0v 879.755n 0.0v 884.745n 0.0v 884.755n 0.0v 889.745n 0.0v 889.755n 0.0v 894.745n 0.0v 894.755n 0.0v 899.745n 0.0v 899.755n 0.0v 904.745n 0.0v 904.755n 1.0v 909.745n 1.0v 909.755n 0.0v 914.745n 0.0v 914.755n 0.0v 919.745n 0.0v 919.755n 0.0v 924.745n 0.0v 924.755n 0.0v 929.745n 0.0v 929.755n 0.0v 934.745n 0.0v 934.755n 0.0v 939.745n 0.0v 939.755n 0.0v 944.745n 0.0v 944.755n 0.0v 949.745n 0.0v 949.755n 0.0v 954.745n 0.0v 954.755n 1.0v 959.745n 1.0v 959.755n 0.0v 964.745n 0.0v 964.755n 0.0v 969.745n 0.0v 969.755n 1.0v 974.745n 1.0v 974.755n 1.0v 979.745n 1.0v 979.755n 1.0v 984.745n 1.0v 984.755n 1.0v 989.745n 1.0v 989.755n 1.0v 994.745n 1.0v 994.755n 1.0v 999.745n 1.0v 999.755n 1.0v 1004.745n 1.0v 1004.755n 1.0v 1009.745n 1.0v 1009.755n 1.0v 1014.745n 1.0v 1014.755n 1.0v 1019.745n 1.0v 1019.755n 1.0v 1024.745n 1.0v 1024.755n 1.0v )
* (time, data): [(0, 0), (5, 1), (10, 0), (15, 0), (20, 0), (25, 0), (30, 0), (35, 0), (40, 0), (45, 0), (50, 0), (55, 0), (60, 0), (65, 0), (70, 0), (75, 0), (80, 0), (85, 0), (90, 0), (95, 0), (100, 1), (105, 1), (110, 1), (115, 1), (120, 1), (125, 0), (130, 0), (135, 0), (140, 0), (145, 0), (150, 1), (155, 1), (160, 1), (165, 1), (170, 1), (175, 1), (180, 1), (185, 1), (190, 1), (195, 1), (200, 1), (205, 0), (210, 0), (215, 0), (220, 1), (225, 1), (230, 1), (235, 1), (240, 1), (245, 1), (250, 1), (255, 1), (260, 0), (265, 0), (270, 0), (275, 1), (280, 1), (285, 1), (290, 1), (295, 1), (300, 1), (305, 1), (310, 1), (315, 1), (320, 1), (325, 1), (330, 1), (335, 1), (340, 1), (345, 1), (350, 0), (355, 0), (360, 0), (365, 0), (370, 0), (375, 0), (380, 0), (385, 0), (390, 0), (395, 0), (400, 0), (405, 1), (410, 1), (415, 1), (420, 1), (425, 1), (430, 1), (435, 1), (440, 1), (445, 1), (450, 1), (455, 1), (460, 1), (465, 1), (470, 1), (475, 1), (480, 1), (485, 1), (490, 1), (495, 1), (500, 1), (505, 1), (510, 1), (515, 1), (520, 1), (525, 1), (530, 1), (535, 1), (540, 0), (545, 0), (550, 0), (555, 0), (560, 0), (565, 0), (570, 0), (575, 0), (580, 0), (585, 0), (590, 0), (595, 0), (600, 0), (605, 0), (610, 0), (615, 0), (620, 0), (625, 0), (630, 0), (635, 0), (640, 0), (645, 0), (650, 0), (655, 0), (660, 0), (665, 0), (670, 0), (675, 0), (680, 0), (685, 0), (690, 0), (695, 0), (700, 0), (705, 0), (710, 0), (715, 0), (720, 0), (725, 0), (730, 0), (735, 0), (740, 0), (745, 0), (750, 0), (755, 0), (760, 1), (765, 1), (770, 1), (775, 1), (780, 0), (785, 0), (790, 0), (795, 0), (800, 0), (805, 0), (810, 1), (815, 1), (820, 1), (825, 1), (830, 1), (835, 1), (840, 1), (845, 1), (850, 1), (855, 1), (860, 0), (865, 0), (870, 0), (875, 0), (880, 0), (885, 0), (890, 0), (895, 0), (900, 0), (905, 0), (910, 1), (915, 1), (920, 1), (925, 1), (930, 0), (935, 1), (940, 1), (945, 1), (950, 1), (955, 0), (960, 0), (965, 0), (970, 0), (975, 0), (980, 0), (985, 0), (990, 0), (995, 0), (1000, 0), (1005, 0), (1010, 0), (1015, 0), (1020, 0), (1025, 0)]
Vdin1_0  din1_0  0 PWL (0n 0.0v 4.745n 0.0v 4.755n 1.0v 9.745n 1.0v 9.755n 0.0v 14.745n 0.0v 14.755n 0.0v 19.745n 0.0v 19.755n 0.0v 24.745n 0.0v 24.755n 0.0v 29.745n 0.0v 29.755n 0.0v 34.745n 0.0v 34.755n 0.0v 39.745n 0.0v 39.755n 0.0v 44.745n 0.0v 44.755n 0.0v 49.745n 0.0v 49.755n 0.0v 54.745n 0.0v 54.755n 0.0v 59.745n 0.0v 59.755n 0.0v 64.745n 0.0v 64.755n 0.0v 69.745n 0.0v 69.755n 0.0v 74.745n 0.0v 74.755n 0.0v 79.745n 0.0v 79.755n 0.0v 84.745n 0.0v 84.755n 0.0v 89.745n 0.0v 89.755n 0.0v 94.745n 0.0v 94.755n 0.0v 99.745n 0.0v 99.755n 1.0v 104.745n 1.0v 104.755n 1.0v 109.745n 1.0v 109.755n 1.0v 114.745n 1.0v 114.755n 1.0v 119.745n 1.0v 119.755n 1.0v 124.745n 1.0v 124.755n 0.0v 129.745n 0.0v 129.755n 0.0v 134.745n 0.0v 134.755n 0.0v 139.745n 0.0v 139.755n 0.0v 144.745n 0.0v 144.755n 0.0v 149.745n 0.0v 149.755n 1.0v 154.745n 1.0v 154.755n 1.0v 159.745n 1.0v 159.755n 1.0v 164.745n 1.0v 164.755n 1.0v 169.745n 1.0v 169.755n 1.0v 174.745n 1.0v 174.755n 1.0v 179.745n 1.0v 179.755n 1.0v 184.745n 1.0v 184.755n 1.0v 189.745n 1.0v 189.755n 1.0v 194.745n 1.0v 194.755n 1.0v 199.745n 1.0v 199.755n 1.0v 204.745n 1.0v 204.755n 0.0v 209.745n 0.0v 209.755n 0.0v 214.745n 0.0v 214.755n 0.0v 219.745n 0.0v 219.755n 1.0v 224.745n 1.0v 224.755n 1.0v 229.745n 1.0v 229.755n 1.0v 234.745n 1.0v 234.755n 1.0v 239.745n 1.0v 239.755n 1.0v 244.745n 1.0v 244.755n 1.0v 249.745n 1.0v 249.755n 1.0v 254.745n 1.0v 254.755n 1.0v 259.745n 1.0v 259.755n 0.0v 264.745n 0.0v 264.755n 0.0v 269.745n 0.0v 269.755n 0.0v 274.745n 0.0v 274.755n 1.0v 279.745n 1.0v 279.755n 1.0v 284.745n 1.0v 284.755n 1.0v 289.745n 1.0v 289.755n 1.0v 294.745n 1.0v 294.755n 1.0v 299.745n 1.0v 299.755n 1.0v 304.745n 1.0v 304.755n 1.0v 309.745n 1.0v 309.755n 1.0v 314.745n 1.0v 314.755n 1.0v 319.745n 1.0v 319.755n 1.0v 324.745n 1.0v 324.755n 1.0v 329.745n 1.0v 329.755n 1.0v 334.745n 1.0v 334.755n 1.0v 339.745n 1.0v 339.755n 1.0v 344.745n 1.0v 344.755n 1.0v 349.745n 1.0v 349.755n 0.0v 354.745n 0.0v 354.755n 0.0v 359.745n 0.0v 359.755n 0.0v 364.745n 0.0v 364.755n 0.0v 369.745n 0.0v 369.755n 0.0v 374.745n 0.0v 374.755n 0.0v 379.745n 0.0v 379.755n 0.0v 384.745n 0.0v 384.755n 0.0v 389.745n 0.0v 389.755n 0.0v 394.745n 0.0v 394.755n 0.0v 399.745n 0.0v 399.755n 0.0v 404.745n 0.0v 404.755n 1.0v 409.745n 1.0v 409.755n 1.0v 414.745n 1.0v 414.755n 1.0v 419.745n 1.0v 419.755n 1.0v 424.745n 1.0v 424.755n 1.0v 429.745n 1.0v 429.755n 1.0v 434.745n 1.0v 434.755n 1.0v 439.745n 1.0v 439.755n 1.0v 444.745n 1.0v 444.755n 1.0v 449.745n 1.0v 449.755n 1.0v 454.745n 1.0v 454.755n 1.0v 459.745n 1.0v 459.755n 1.0v 464.745n 1.0v 464.755n 1.0v 469.745n 1.0v 469.755n 1.0v 474.745n 1.0v 474.755n 1.0v 479.745n 1.0v 479.755n 1.0v 484.745n 1.0v 484.755n 1.0v 489.745n 1.0v 489.755n 1.0v 494.745n 1.0v 494.755n 1.0v 499.745n 1.0v 499.755n 1.0v 504.745n 1.0v 504.755n 1.0v 509.745n 1.0v 509.755n 1.0v 514.745n 1.0v 514.755n 1.0v 519.745n 1.0v 519.755n 1.0v 524.745n 1.0v 524.755n 1.0v 529.745n 1.0v 529.755n 1.0v 534.745n 1.0v 534.755n 1.0v 539.745n 1.0v 539.755n 0.0v 544.745n 0.0v 544.755n 0.0v 549.745n 0.0v 549.755n 0.0v 554.745n 0.0v 554.755n 0.0v 559.745n 0.0v 559.755n 0.0v 564.745n 0.0v 564.755n 0.0v 569.745n 0.0v 569.755n 0.0v 574.745n 0.0v 574.755n 0.0v 579.745n 0.0v 579.755n 0.0v 584.745n 0.0v 584.755n 0.0v 589.745n 0.0v 589.755n 0.0v 594.745n 0.0v 594.755n 0.0v 599.745n 0.0v 599.755n 0.0v 604.745n 0.0v 604.755n 0.0v 609.745n 0.0v 609.755n 0.0v 614.745n 0.0v 614.755n 0.0v 619.745n 0.0v 619.755n 0.0v 624.745n 0.0v 624.755n 0.0v 629.745n 0.0v 629.755n 0.0v 634.745n 0.0v 634.755n 0.0v 639.745n 0.0v 639.755n 0.0v 644.745n 0.0v 644.755n 0.0v 649.745n 0.0v 649.755n 0.0v 654.745n 0.0v 654.755n 0.0v 659.745n 0.0v 659.755n 0.0v 664.745n 0.0v 664.755n 0.0v 669.745n 0.0v 669.755n 0.0v 674.745n 0.0v 674.755n 0.0v 679.745n 0.0v 679.755n 0.0v 684.745n 0.0v 684.755n 0.0v 689.745n 0.0v 689.755n 0.0v 694.745n 0.0v 694.755n 0.0v 699.745n 0.0v 699.755n 0.0v 704.745n 0.0v 704.755n 0.0v 709.745n 0.0v 709.755n 0.0v 714.745n 0.0v 714.755n 0.0v 719.745n 0.0v 719.755n 0.0v 724.745n 0.0v 724.755n 0.0v 729.745n 0.0v 729.755n 0.0v 734.745n 0.0v 734.755n 0.0v 739.745n 0.0v 739.755n 0.0v 744.745n 0.0v 744.755n 0.0v 749.745n 0.0v 749.755n 0.0v 754.745n 0.0v 754.755n 0.0v 759.745n 0.0v 759.755n 1.0v 764.745n 1.0v 764.755n 1.0v 769.745n 1.0v 769.755n 1.0v 774.745n 1.0v 774.755n 1.0v 779.745n 1.0v 779.755n 0.0v 784.745n 0.0v 784.755n 0.0v 789.745n 0.0v 789.755n 0.0v 794.745n 0.0v 794.755n 0.0v 799.745n 0.0v 799.755n 0.0v 804.745n 0.0v 804.755n 0.0v 809.745n 0.0v 809.755n 1.0v 814.745n 1.0v 814.755n 1.0v 819.745n 1.0v 819.755n 1.0v 824.745n 1.0v 824.755n 1.0v 829.745n 1.0v 829.755n 1.0v 834.745n 1.0v 834.755n 1.0v 839.745n 1.0v 839.755n 1.0v 844.745n 1.0v 844.755n 1.0v 849.745n 1.0v 849.755n 1.0v 854.745n 1.0v 854.755n 1.0v 859.745n 1.0v 859.755n 0.0v 864.745n 0.0v 864.755n 0.0v 869.745n 0.0v 869.755n 0.0v 874.745n 0.0v 874.755n 0.0v 879.745n 0.0v 879.755n 0.0v 884.745n 0.0v 884.755n 0.0v 889.745n 0.0v 889.755n 0.0v 894.745n 0.0v 894.755n 0.0v 899.745n 0.0v 899.755n 0.0v 904.745n 0.0v 904.755n 0.0v 909.745n 0.0v 909.755n 1.0v 914.745n 1.0v 914.755n 1.0v 919.745n 1.0v 919.755n 1.0v 924.745n 1.0v 924.755n 1.0v 929.745n 1.0v 929.755n 0.0v 934.745n 0.0v 934.755n 1.0v 939.745n 1.0v 939.755n 1.0v 944.745n 1.0v 944.755n 1.0v 949.745n 1.0v 949.755n 1.0v 954.745n 1.0v 954.755n 0.0v 959.745n 0.0v 959.755n 0.0v 964.745n 0.0v 964.755n 0.0v 969.745n 0.0v 969.755n 0.0v 974.745n 0.0v 974.755n 0.0v 979.745n 0.0v 979.755n 0.0v 984.745n 0.0v 984.755n 0.0v 989.745n 0.0v 989.755n 0.0v 994.745n 0.0v 994.755n 0.0v 999.745n 0.0v 999.755n 0.0v 1004.745n 0.0v 1004.755n 0.0v 1009.745n 0.0v 1009.755n 0.0v 1014.745n 0.0v 1014.755n 0.0v 1019.745n 0.0v 1019.755n 0.0v 1024.745n 0.0v 1024.755n 0.0v )
* (time, data): [(0, 0), (5, 1), (10, 1), (15, 0), (20, 0), (25, 0), (30, 0), (35, 0), (40, 0), (45, 0), (50, 0), (55, 0), (60, 0), (65, 0), (70, 0), (75, 0), (80, 0), (85, 0), (90, 0), (95, 0), (100, 1), (105, 1), (110, 1), (115, 1), (120, 1), (125, 0), (130, 0), (135, 0), (140, 0), (145, 0), (150, 1), (155, 1), (160, 1), (165, 0), (170, 0), (175, 0), (180, 0), (185, 0), (190, 0), (195, 0), (200, 0), (205, 0), (210, 0), (215, 0), (220, 1), (225, 1), (230, 1), (235, 1), (240, 1), (245, 1), (250, 0), (255, 0), (260, 0), (265, 0), (270, 0), (275, 1), (280, 1), (285, 1), (290, 1), (295, 1), (300, 1), (305, 1), (310, 1), (315, 1), (320, 1), (325, 1), (330, 1), (335, 1), (340, 1), (345, 0), (350, 1), (355, 1), (360, 1), (365, 1), (370, 1), (375, 1), (380, 1), (385, 1), (390, 1), (395, 1), (400, 0), (405, 0), (410, 0), (415, 0), (420, 0), (425, 0), (430, 0), (435, 0), (440, 1), (445, 1), (450, 1), (455, 1), (460, 1), (465, 1), (470, 1), (475, 1), (480, 1), (485, 1), (490, 1), (495, 1), (500, 0), (505, 0), (510, 0), (515, 0), (520, 0), (525, 0), (530, 0), (535, 1), (540, 0), (545, 0), (550, 0), (555, 0), (560, 0), (565, 0), (570, 0), (575, 0), (580, 0), (585, 0), (590, 0), (595, 0), (600, 0), (605, 0), (610, 0), (615, 0), (620, 0), (625, 0), (630, 0), (635, 0), (640, 0), (645, 0), (650, 0), (655, 0), (660, 0), (665, 0), (670, 0), (675, 0), (680, 0), (685, 0), (690, 0), (695, 0), (700, 0), (705, 0), (710, 0), (715, 0), (720, 0), (725, 0), (730, 0), (735, 0), (740, 0), (745, 0), (750, 0), (755, 0), (760, 1), (765, 1), (770, 1), (775, 1), (780, 1), (785, 1), (790, 1), (795, 1), (800, 1), (805, 1), (810, 1), (815, 1), (820, 1), (825, 1), (830, 1), (835, 1), (840, 1), (845, 1), (850, 1), (855, 1), (860, 1), (865, 1), (870, 1), (875, 1), (880, 0), (885, 0), (890, 0), (895, 0), (900, 0), (905, 0), (910, 1), (915, 1), (920, 1), (925, 1), (930, 1), (935, 1), (940, 1), (945, 1), (950, 0), (955, 1), (960, 1), (965, 1), (970, 1), (975, 1), (980, 1), (985, 0), (990, 0), (995, 0), (1000, 0), (1005, 1), (1010, 1), (1015, 1), (1020, 1), (1025, 1)]
Vdin1_1  din1_1  0 PWL (0n 0.0v 4.745n 0.0v 4.755n 1.0v 9.745n 1.0v 9.755n 1.0v 14.745n 1.0v 14.755n 0.0v 19.745n 0.0v 19.755n 0.0v 24.745n 0.0v 24.755n 0.0v 29.745n 0.0v 29.755n 0.0v 34.745n 0.0v 34.755n 0.0v 39.745n 0.0v 39.755n 0.0v 44.745n 0.0v 44.755n 0.0v 49.745n 0.0v 49.755n 0.0v 54.745n 0.0v 54.755n 0.0v 59.745n 0.0v 59.755n 0.0v 64.745n 0.0v 64.755n 0.0v 69.745n 0.0v 69.755n 0.0v 74.745n 0.0v 74.755n 0.0v 79.745n 0.0v 79.755n 0.0v 84.745n 0.0v 84.755n 0.0v 89.745n 0.0v 89.755n 0.0v 94.745n 0.0v 94.755n 0.0v 99.745n 0.0v 99.755n 1.0v 104.745n 1.0v 104.755n 1.0v 109.745n 1.0v 109.755n 1.0v 114.745n 1.0v 114.755n 1.0v 119.745n 1.0v 119.755n 1.0v 124.745n 1.0v 124.755n 0.0v 129.745n 0.0v 129.755n 0.0v 134.745n 0.0v 134.755n 0.0v 139.745n 0.0v 139.755n 0.0v 144.745n 0.0v 144.755n 0.0v 149.745n 0.0v 149.755n 1.0v 154.745n 1.0v 154.755n 1.0v 159.745n 1.0v 159.755n 1.0v 164.745n 1.0v 164.755n 0.0v 169.745n 0.0v 169.755n 0.0v 174.745n 0.0v 174.755n 0.0v 179.745n 0.0v 179.755n 0.0v 184.745n 0.0v 184.755n 0.0v 189.745n 0.0v 189.755n 0.0v 194.745n 0.0v 194.755n 0.0v 199.745n 0.0v 199.755n 0.0v 204.745n 0.0v 204.755n 0.0v 209.745n 0.0v 209.755n 0.0v 214.745n 0.0v 214.755n 0.0v 219.745n 0.0v 219.755n 1.0v 224.745n 1.0v 224.755n 1.0v 229.745n 1.0v 229.755n 1.0v 234.745n 1.0v 234.755n 1.0v 239.745n 1.0v 239.755n 1.0v 244.745n 1.0v 244.755n 1.0v 249.745n 1.0v 249.755n 0.0v 254.745n 0.0v 254.755n 0.0v 259.745n 0.0v 259.755n 0.0v 264.745n 0.0v 264.755n 0.0v 269.745n 0.0v 269.755n 0.0v 274.745n 0.0v 274.755n 1.0v 279.745n 1.0v 279.755n 1.0v 284.745n 1.0v 284.755n 1.0v 289.745n 1.0v 289.755n 1.0v 294.745n 1.0v 294.755n 1.0v 299.745n 1.0v 299.755n 1.0v 304.745n 1.0v 304.755n 1.0v 309.745n 1.0v 309.755n 1.0v 314.745n 1.0v 314.755n 1.0v 319.745n 1.0v 319.755n 1.0v 324.745n 1.0v 324.755n 1.0v 329.745n 1.0v 329.755n 1.0v 334.745n 1.0v 334.755n 1.0v 339.745n 1.0v 339.755n 1.0v 344.745n 1.0v 344.755n 0.0v 349.745n 0.0v 349.755n 1.0v 354.745n 1.0v 354.755n 1.0v 359.745n 1.0v 359.755n 1.0v 364.745n 1.0v 364.755n 1.0v 369.745n 1.0v 369.755n 1.0v 374.745n 1.0v 374.755n 1.0v 379.745n 1.0v 379.755n 1.0v 384.745n 1.0v 384.755n 1.0v 389.745n 1.0v 389.755n 1.0v 394.745n 1.0v 394.755n 1.0v 399.745n 1.0v 399.755n 0.0v 404.745n 0.0v 404.755n 0.0v 409.745n 0.0v 409.755n 0.0v 414.745n 0.0v 414.755n 0.0v 419.745n 0.0v 419.755n 0.0v 424.745n 0.0v 424.755n 0.0v 429.745n 0.0v 429.755n 0.0v 434.745n 0.0v 434.755n 0.0v 439.745n 0.0v 439.755n 1.0v 444.745n 1.0v 444.755n 1.0v 449.745n 1.0v 449.755n 1.0v 454.745n 1.0v 454.755n 1.0v 459.745n 1.0v 459.755n 1.0v 464.745n 1.0v 464.755n 1.0v 469.745n 1.0v 469.755n 1.0v 474.745n 1.0v 474.755n 1.0v 479.745n 1.0v 479.755n 1.0v 484.745n 1.0v 484.755n 1.0v 489.745n 1.0v 489.755n 1.0v 494.745n 1.0v 494.755n 1.0v 499.745n 1.0v 499.755n 0.0v 504.745n 0.0v 504.755n 0.0v 509.745n 0.0v 509.755n 0.0v 514.745n 0.0v 514.755n 0.0v 519.745n 0.0v 519.755n 0.0v 524.745n 0.0v 524.755n 0.0v 529.745n 0.0v 529.755n 0.0v 534.745n 0.0v 534.755n 1.0v 539.745n 1.0v 539.755n 0.0v 544.745n 0.0v 544.755n 0.0v 549.745n 0.0v 549.755n 0.0v 554.745n 0.0v 554.755n 0.0v 559.745n 0.0v 559.755n 0.0v 564.745n 0.0v 564.755n 0.0v 569.745n 0.0v 569.755n 0.0v 574.745n 0.0v 574.755n 0.0v 579.745n 0.0v 579.755n 0.0v 584.745n 0.0v 584.755n 0.0v 589.745n 0.0v 589.755n 0.0v 594.745n 0.0v 594.755n 0.0v 599.745n 0.0v 599.755n 0.0v 604.745n 0.0v 604.755n 0.0v 609.745n 0.0v 609.755n 0.0v 614.745n 0.0v 614.755n 0.0v 619.745n 0.0v 619.755n 0.0v 624.745n 0.0v 624.755n 0.0v 629.745n 0.0v 629.755n 0.0v 634.745n 0.0v 634.755n 0.0v 639.745n 0.0v 639.755n 0.0v 644.745n 0.0v 644.755n 0.0v 649.745n 0.0v 649.755n 0.0v 654.745n 0.0v 654.755n 0.0v 659.745n 0.0v 659.755n 0.0v 664.745n 0.0v 664.755n 0.0v 669.745n 0.0v 669.755n 0.0v 674.745n 0.0v 674.755n 0.0v 679.745n 0.0v 679.755n 0.0v 684.745n 0.0v 684.755n 0.0v 689.745n 0.0v 689.755n 0.0v 694.745n 0.0v 694.755n 0.0v 699.745n 0.0v 699.755n 0.0v 704.745n 0.0v 704.755n 0.0v 709.745n 0.0v 709.755n 0.0v 714.745n 0.0v 714.755n 0.0v 719.745n 0.0v 719.755n 0.0v 724.745n 0.0v 724.755n 0.0v 729.745n 0.0v 729.755n 0.0v 734.745n 0.0v 734.755n 0.0v 739.745n 0.0v 739.755n 0.0v 744.745n 0.0v 744.755n 0.0v 749.745n 0.0v 749.755n 0.0v 754.745n 0.0v 754.755n 0.0v 759.745n 0.0v 759.755n 1.0v 764.745n 1.0v 764.755n 1.0v 769.745n 1.0v 769.755n 1.0v 774.745n 1.0v 774.755n 1.0v 779.745n 1.0v 779.755n 1.0v 784.745n 1.0v 784.755n 1.0v 789.745n 1.0v 789.755n 1.0v 794.745n 1.0v 794.755n 1.0v 799.745n 1.0v 799.755n 1.0v 804.745n 1.0v 804.755n 1.0v 809.745n 1.0v 809.755n 1.0v 814.745n 1.0v 814.755n 1.0v 819.745n 1.0v 819.755n 1.0v 824.745n 1.0v 824.755n 1.0v 829.745n 1.0v 829.755n 1.0v 834.745n 1.0v 834.755n 1.0v 839.745n 1.0v 839.755n 1.0v 844.745n 1.0v 844.755n 1.0v 849.745n 1.0v 849.755n 1.0v 854.745n 1.0v 854.755n 1.0v 859.745n 1.0v 859.755n 1.0v 864.745n 1.0v 864.755n 1.0v 869.745n 1.0v 869.755n 1.0v 874.745n 1.0v 874.755n 1.0v 879.745n 1.0v 879.755n 0.0v 884.745n 0.0v 884.755n 0.0v 889.745n 0.0v 889.755n 0.0v 894.745n 0.0v 894.755n 0.0v 899.745n 0.0v 899.755n 0.0v 904.745n 0.0v 904.755n 0.0v 909.745n 0.0v 909.755n 1.0v 914.745n 1.0v 914.755n 1.0v 919.745n 1.0v 919.755n 1.0v 924.745n 1.0v 924.755n 1.0v 929.745n 1.0v 929.755n 1.0v 934.745n 1.0v 934.755n 1.0v 939.745n 1.0v 939.755n 1.0v 944.745n 1.0v 944.755n 1.0v 949.745n 1.0v 949.755n 0.0v 954.745n 0.0v 954.755n 1.0v 959.745n 1.0v 959.755n 1.0v 964.745n 1.0v 964.755n 1.0v 969.745n 1.0v 969.755n 1.0v 974.745n 1.0v 974.755n 1.0v 979.745n 1.0v 979.755n 1.0v 984.745n 1.0v 984.755n 0.0v 989.745n 0.0v 989.755n 0.0v 994.745n 0.0v 994.755n 0.0v 999.745n 0.0v 999.755n 0.0v 1004.745n 0.0v 1004.755n 1.0v 1009.745n 1.0v 1009.755n 1.0v 1014.745n 1.0v 1014.755n 1.0v 1019.745n 1.0v 1019.755n 1.0v 1024.745n 1.0v 1024.755n 1.0v )
* (time, data): [(0, 0), (5, 1), (10, 0), (15, 1), (20, 1), (25, 1), (30, 1), (35, 1), (40, 1), (45, 1), (50, 0), (55, 0), (60, 0), (65, 0), (70, 0), (75, 0), (80, 0), (85, 1), (90, 1), (95, 1), (100, 0), (105, 0), (110, 0), (115, 1), (120, 1), (125, 0), (130, 0), (135, 0), (140, 0), (145, 0), (150, 0), (155, 0), (160, 0), (165, 0), (170, 0), (175, 0), (180, 0), (185, 0), (190, 0), (195, 0), (200, 0), (205, 0), (210, 0), (215, 0), (220, 0), (225, 0), (230, 0), (235, 0), (240, 1), (245, 1), (250, 1), (255, 1), (260, 0), (265, 0), (270, 0), (275, 1), (280, 1), (285, 1), (290, 1), (295, 1), (300, 1), (305, 1), (310, 0), (315, 0), (320, 0), (325, 0), (330, 0), (335, 0), (340, 0), (345, 0), (350, 0), (355, 0), (360, 1), (365, 1), (370, 1), (375, 1), (380, 1), (385, 1), (390, 1), (395, 1), (400, 1), (405, 0), (410, 0), (415, 0), (420, 0), (425, 0), (430, 0), (435, 0), (440, 1), (445, 1), (450, 1), (455, 1), (460, 1), (465, 1), (470, 1), (475, 1), (480, 1), (485, 1), (490, 1), (495, 1), (500, 1), (505, 1), (510, 1), (515, 1), (520, 1), (525, 1), (530, 1), (535, 0), (540, 0), (545, 0), (550, 0), (555, 0), (560, 0), (565, 0), (570, 0), (575, 0), (580, 0), (585, 0), (590, 0), (595, 0), (600, 0), (605, 0), (610, 0), (615, 0), (620, 0), (625, 0), (630, 0), (635, 0), (640, 0), (645, 0), (650, 0), (655, 0), (660, 0), (665, 0), (670, 0), (675, 0), (680, 0), (685, 0), (690, 0), (695, 0), (700, 0), (705, 0), (710, 1), (715, 1), (720, 1), (725, 1), (730, 1), (735, 1), (740, 1), (745, 1), (750, 1), (755, 1), (760, 0), (765, 0), (770, 0), (775, 0), (780, 0), (785, 0), (790, 0), (795, 0), (800, 0), (805, 0), (810, 0), (815, 0), (820, 0), (825, 0), (830, 0), (835, 0), (840, 0), (845, 0), (850, 0), (855, 0), (860, 0), (865, 0), (870, 0), (875, 0), (880, 0), (885, 0), (890, 0), (895, 0), (900, 0), (905, 0), (910, 0), (915, 0), (920, 0), (925, 0), (930, 0), (935, 1), (940, 1), (945, 1), (950, 1), (955, 1), (960, 1), (965, 1), (970, 1), (975, 1), (980, 1), (985, 1), (990, 1), (995, 1), (1000, 1), (1005, 1), (1010, 1), (1015, 1), (1020, 1), (1025, 1)]
Vdin1_2  din1_2  0 PWL (0n 0.0v 4.745n 0.0v 4.755n 1.0v 9.745n 1.0v 9.755n 0.0v 14.745n 0.0v 14.755n 1.0v 19.745n 1.0v 19.755n 1.0v 24.745n 1.0v 24.755n 1.0v 29.745n 1.0v 29.755n 1.0v 34.745n 1.0v 34.755n 1.0v 39.745n 1.0v 39.755n 1.0v 44.745n 1.0v 44.755n 1.0v 49.745n 1.0v 49.755n 0.0v 54.745n 0.0v 54.755n 0.0v 59.745n 0.0v 59.755n 0.0v 64.745n 0.0v 64.755n 0.0v 69.745n 0.0v 69.755n 0.0v 74.745n 0.0v 74.755n 0.0v 79.745n 0.0v 79.755n 0.0v 84.745n 0.0v 84.755n 1.0v 89.745n 1.0v 89.755n 1.0v 94.745n 1.0v 94.755n 1.0v 99.745n 1.0v 99.755n 0.0v 104.745n 0.0v 104.755n 0.0v 109.745n 0.0v 109.755n 0.0v 114.745n 0.0v 114.755n 1.0v 119.745n 1.0v 119.755n 1.0v 124.745n 1.0v 124.755n 0.0v 129.745n 0.0v 129.755n 0.0v 134.745n 0.0v 134.755n 0.0v 139.745n 0.0v 139.755n 0.0v 144.745n 0.0v 144.755n 0.0v 149.745n 0.0v 149.755n 0.0v 154.745n 0.0v 154.755n 0.0v 159.745n 0.0v 159.755n 0.0v 164.745n 0.0v 164.755n 0.0v 169.745n 0.0v 169.755n 0.0v 174.745n 0.0v 174.755n 0.0v 179.745n 0.0v 179.755n 0.0v 184.745n 0.0v 184.755n 0.0v 189.745n 0.0v 189.755n 0.0v 194.745n 0.0v 194.755n 0.0v 199.745n 0.0v 199.755n 0.0v 204.745n 0.0v 204.755n 0.0v 209.745n 0.0v 209.755n 0.0v 214.745n 0.0v 214.755n 0.0v 219.745n 0.0v 219.755n 0.0v 224.745n 0.0v 224.755n 0.0v 229.745n 0.0v 229.755n 0.0v 234.745n 0.0v 234.755n 0.0v 239.745n 0.0v 239.755n 1.0v 244.745n 1.0v 244.755n 1.0v 249.745n 1.0v 249.755n 1.0v 254.745n 1.0v 254.755n 1.0v 259.745n 1.0v 259.755n 0.0v 264.745n 0.0v 264.755n 0.0v 269.745n 0.0v 269.755n 0.0v 274.745n 0.0v 274.755n 1.0v 279.745n 1.0v 279.755n 1.0v 284.745n 1.0v 284.755n 1.0v 289.745n 1.0v 289.755n 1.0v 294.745n 1.0v 294.755n 1.0v 299.745n 1.0v 299.755n 1.0v 304.745n 1.0v 304.755n 1.0v 309.745n 1.0v 309.755n 0.0v 314.745n 0.0v 314.755n 0.0v 319.745n 0.0v 319.755n 0.0v 324.745n 0.0v 324.755n 0.0v 329.745n 0.0v 329.755n 0.0v 334.745n 0.0v 334.755n 0.0v 339.745n 0.0v 339.755n 0.0v 344.745n 0.0v 344.755n 0.0v 349.745n 0.0v 349.755n 0.0v 354.745n 0.0v 354.755n 0.0v 359.745n 0.0v 359.755n 1.0v 364.745n 1.0v 364.755n 1.0v 369.745n 1.0v 369.755n 1.0v 374.745n 1.0v 374.755n 1.0v 379.745n 1.0v 379.755n 1.0v 384.745n 1.0v 384.755n 1.0v 389.745n 1.0v 389.755n 1.0v 394.745n 1.0v 394.755n 1.0v 399.745n 1.0v 399.755n 1.0v 404.745n 1.0v 404.755n 0.0v 409.745n 0.0v 409.755n 0.0v 414.745n 0.0v 414.755n 0.0v 419.745n 0.0v 419.755n 0.0v 424.745n 0.0v 424.755n 0.0v 429.745n 0.0v 429.755n 0.0v 434.745n 0.0v 434.755n 0.0v 439.745n 0.0v 439.755n 1.0v 444.745n 1.0v 444.755n 1.0v 449.745n 1.0v 449.755n 1.0v 454.745n 1.0v 454.755n 1.0v 459.745n 1.0v 459.755n 1.0v 464.745n 1.0v 464.755n 1.0v 469.745n 1.0v 469.755n 1.0v 474.745n 1.0v 474.755n 1.0v 479.745n 1.0v 479.755n 1.0v 484.745n 1.0v 484.755n 1.0v 489.745n 1.0v 489.755n 1.0v 494.745n 1.0v 494.755n 1.0v 499.745n 1.0v 499.755n 1.0v 504.745n 1.0v 504.755n 1.0v 509.745n 1.0v 509.755n 1.0v 514.745n 1.0v 514.755n 1.0v 519.745n 1.0v 519.755n 1.0v 524.745n 1.0v 524.755n 1.0v 529.745n 1.0v 529.755n 1.0v 534.745n 1.0v 534.755n 0.0v 539.745n 0.0v 539.755n 0.0v 544.745n 0.0v 544.755n 0.0v 549.745n 0.0v 549.755n 0.0v 554.745n 0.0v 554.755n 0.0v 559.745n 0.0v 559.755n 0.0v 564.745n 0.0v 564.755n 0.0v 569.745n 0.0v 569.755n 0.0v 574.745n 0.0v 574.755n 0.0v 579.745n 0.0v 579.755n 0.0v 584.745n 0.0v 584.755n 0.0v 589.745n 0.0v 589.755n 0.0v 594.745n 0.0v 594.755n 0.0v 599.745n 0.0v 599.755n 0.0v 604.745n 0.0v 604.755n 0.0v 609.745n 0.0v 609.755n 0.0v 614.745n 0.0v 614.755n 0.0v 619.745n 0.0v 619.755n 0.0v 624.745n 0.0v 624.755n 0.0v 629.745n 0.0v 629.755n 0.0v 634.745n 0.0v 634.755n 0.0v 639.745n 0.0v 639.755n 0.0v 644.745n 0.0v 644.755n 0.0v 649.745n 0.0v 649.755n 0.0v 654.745n 0.0v 654.755n 0.0v 659.745n 0.0v 659.755n 0.0v 664.745n 0.0v 664.755n 0.0v 669.745n 0.0v 669.755n 0.0v 674.745n 0.0v 674.755n 0.0v 679.745n 0.0v 679.755n 0.0v 684.745n 0.0v 684.755n 0.0v 689.745n 0.0v 689.755n 0.0v 694.745n 0.0v 694.755n 0.0v 699.745n 0.0v 699.755n 0.0v 704.745n 0.0v 704.755n 0.0v 709.745n 0.0v 709.755n 1.0v 714.745n 1.0v 714.755n 1.0v 719.745n 1.0v 719.755n 1.0v 724.745n 1.0v 724.755n 1.0v 729.745n 1.0v 729.755n 1.0v 734.745n 1.0v 734.755n 1.0v 739.745n 1.0v 739.755n 1.0v 744.745n 1.0v 744.755n 1.0v 749.745n 1.0v 749.755n 1.0v 754.745n 1.0v 754.755n 1.0v 759.745n 1.0v 759.755n 0.0v 764.745n 0.0v 764.755n 0.0v 769.745n 0.0v 769.755n 0.0v 774.745n 0.0v 774.755n 0.0v 779.745n 0.0v 779.755n 0.0v 784.745n 0.0v 784.755n 0.0v 789.745n 0.0v 789.755n 0.0v 794.745n 0.0v 794.755n 0.0v 799.745n 0.0v 799.755n 0.0v 804.745n 0.0v 804.755n 0.0v 809.745n 0.0v 809.755n 0.0v 814.745n 0.0v 814.755n 0.0v 819.745n 0.0v 819.755n 0.0v 824.745n 0.0v 824.755n 0.0v 829.745n 0.0v 829.755n 0.0v 834.745n 0.0v 834.755n 0.0v 839.745n 0.0v 839.755n 0.0v 844.745n 0.0v 844.755n 0.0v 849.745n 0.0v 849.755n 0.0v 854.745n 0.0v 854.755n 0.0v 859.745n 0.0v 859.755n 0.0v 864.745n 0.0v 864.755n 0.0v 869.745n 0.0v 869.755n 0.0v 874.745n 0.0v 874.755n 0.0v 879.745n 0.0v 879.755n 0.0v 884.745n 0.0v 884.755n 0.0v 889.745n 0.0v 889.755n 0.0v 894.745n 0.0v 894.755n 0.0v 899.745n 0.0v 899.755n 0.0v 904.745n 0.0v 904.755n 0.0v 909.745n 0.0v 909.755n 0.0v 914.745n 0.0v 914.755n 0.0v 919.745n 0.0v 919.755n 0.0v 924.745n 0.0v 924.755n 0.0v 929.745n 0.0v 929.755n 0.0v 934.745n 0.0v 934.755n 1.0v 939.745n 1.0v 939.755n 1.0v 944.745n 1.0v 944.755n 1.0v 949.745n 1.0v 949.755n 1.0v 954.745n 1.0v 954.755n 1.0v 959.745n 1.0v 959.755n 1.0v 964.745n 1.0v 964.755n 1.0v 969.745n 1.0v 969.755n 1.0v 974.745n 1.0v 974.755n 1.0v 979.745n 1.0v 979.755n 1.0v 984.745n 1.0v 984.755n 1.0v 989.745n 1.0v 989.755n 1.0v 994.745n 1.0v 994.755n 1.0v 999.745n 1.0v 999.755n 1.0v 1004.745n 1.0v 1004.755n 1.0v 1009.745n 1.0v 1009.755n 1.0v 1014.745n 1.0v 1014.755n 1.0v 1019.745n 1.0v 1019.755n 1.0v 1024.745n 1.0v 1024.755n 1.0v )
* (time, data): [(0, 0), (5, 0), (10, 1), (15, 1), (20, 1), (25, 1), (30, 1), (35, 1), (40, 1), (45, 1), (50, 0), (55, 0), (60, 0), (65, 0), (70, 0), (75, 0), (80, 0), (85, 1), (90, 1), (95, 1), (100, 1), (105, 1), (110, 1), (115, 1), (120, 1), (125, 0), (130, 0), (135, 0), (140, 0), (145, 0), (150, 0), (155, 0), (160, 0), (165, 1), (170, 1), (175, 1), (180, 1), (185, 1), (190, 1), (195, 1), (200, 1), (205, 0), (210, 0), (215, 0), (220, 0), (225, 0), (230, 0), (235, 0), (240, 1), (245, 1), (250, 0), (255, 0), (260, 0), (265, 0), (270, 0), (275, 1), (280, 1), (285, 1), (290, 1), (295, 1), (300, 1), (305, 1), (310, 0), (315, 0), (320, 0), (325, 0), (330, 0), (335, 0), (340, 0), (345, 1), (350, 0), (355, 0), (360, 0), (365, 0), (370, 0), (375, 0), (380, 0), (385, 0), (390, 0), (395, 0), (400, 1), (405, 1), (410, 1), (415, 1), (420, 1), (425, 1), (430, 1), (435, 1), (440, 1), (445, 1), (450, 1), (455, 1), (460, 1), (465, 1), (470, 1), (475, 1), (480, 1), (485, 1), (490, 1), (495, 1), (500, 0), (505, 0), (510, 0), (515, 0), (520, 0), (525, 0), (530, 0), (535, 1), (540, 1), (545, 1), (550, 1), (555, 1), (560, 1), (565, 1), (570, 1), (575, 1), (580, 1), (585, 1), (590, 1), (595, 1), (600, 1), (605, 1), (610, 1), (615, 1), (620, 1), (625, 1), (630, 1), (635, 1), (640, 1), (645, 1), (650, 1), (655, 0), (660, 0), (665, 0), (670, 0), (675, 0), (680, 0), (685, 0), (690, 0), (695, 0), (700, 0), (705, 0), (710, 0), (715, 0), (720, 0), (725, 0), (730, 0), (735, 0), (740, 0), (745, 0), (750, 0), (755, 0), (760, 1), (765, 1), (770, 1), (775, 1), (780, 0), (785, 0), (790, 0), (795, 0), (800, 0), (805, 0), (810, 0), (815, 0), (820, 0), (825, 0), (830, 0), (835, 0), (840, 0), (845, 0), (850, 0), (855, 0), (860, 1), (865, 1), (870, 1), (875, 1), (880, 1), (885, 1), (890, 1), (895, 1), (900, 1), (905, 1), (910, 0), (915, 0), (920, 0), (925, 0), (930, 1), (935, 0), (940, 0), (945, 0), (950, 0), (955, 0), (960, 0), (965, 0), (970, 0), (975, 0), (980, 0), (985, 1), (990, 1), (995, 1), (1000, 1), (1005, 1), (1010, 1), (1015, 1), (1020, 1), (1025, 1)]
Vdin1_3  din1_3  0 PWL (0n 0.0v 4.745n 0.0v 4.755n 0.0v 9.745n 0.0v 9.755n 1.0v 14.745n 1.0v 14.755n 1.0v 19.745n 1.0v 19.755n 1.0v 24.745n 1.0v 24.755n 1.0v 29.745n 1.0v 29.755n 1.0v 34.745n 1.0v 34.755n 1.0v 39.745n 1.0v 39.755n 1.0v 44.745n 1.0v 44.755n 1.0v 49.745n 1.0v 49.755n 0.0v 54.745n 0.0v 54.755n 0.0v 59.745n 0.0v 59.755n 0.0v 64.745n 0.0v 64.755n 0.0v 69.745n 0.0v 69.755n 0.0v 74.745n 0.0v 74.755n 0.0v 79.745n 0.0v 79.755n 0.0v 84.745n 0.0v 84.755n 1.0v 89.745n 1.0v 89.755n 1.0v 94.745n 1.0v 94.755n 1.0v 99.745n 1.0v 99.755n 1.0v 104.745n 1.0v 104.755n 1.0v 109.745n 1.0v 109.755n 1.0v 114.745n 1.0v 114.755n 1.0v 119.745n 1.0v 119.755n 1.0v 124.745n 1.0v 124.755n 0.0v 129.745n 0.0v 129.755n 0.0v 134.745n 0.0v 134.755n 0.0v 139.745n 0.0v 139.755n 0.0v 144.745n 0.0v 144.755n 0.0v 149.745n 0.0v 149.755n 0.0v 154.745n 0.0v 154.755n 0.0v 159.745n 0.0v 159.755n 0.0v 164.745n 0.0v 164.755n 1.0v 169.745n 1.0v 169.755n 1.0v 174.745n 1.0v 174.755n 1.0v 179.745n 1.0v 179.755n 1.0v 184.745n 1.0v 184.755n 1.0v 189.745n 1.0v 189.755n 1.0v 194.745n 1.0v 194.755n 1.0v 199.745n 1.0v 199.755n 1.0v 204.745n 1.0v 204.755n 0.0v 209.745n 0.0v 209.755n 0.0v 214.745n 0.0v 214.755n 0.0v 219.745n 0.0v 219.755n 0.0v 224.745n 0.0v 224.755n 0.0v 229.745n 0.0v 229.755n 0.0v 234.745n 0.0v 234.755n 0.0v 239.745n 0.0v 239.755n 1.0v 244.745n 1.0v 244.755n 1.0v 249.745n 1.0v 249.755n 0.0v 254.745n 0.0v 254.755n 0.0v 259.745n 0.0v 259.755n 0.0v 264.745n 0.0v 264.755n 0.0v 269.745n 0.0v 269.755n 0.0v 274.745n 0.0v 274.755n 1.0v 279.745n 1.0v 279.755n 1.0v 284.745n 1.0v 284.755n 1.0v 289.745n 1.0v 289.755n 1.0v 294.745n 1.0v 294.755n 1.0v 299.745n 1.0v 299.755n 1.0v 304.745n 1.0v 304.755n 1.0v 309.745n 1.0v 309.755n 0.0v 314.745n 0.0v 314.755n 0.0v 319.745n 0.0v 319.755n 0.0v 324.745n 0.0v 324.755n 0.0v 329.745n 0.0v 329.755n 0.0v 334.745n 0.0v 334.755n 0.0v 339.745n 0.0v 339.755n 0.0v 344.745n 0.0v 344.755n 1.0v 349.745n 1.0v 349.755n 0.0v 354.745n 0.0v 354.755n 0.0v 359.745n 0.0v 359.755n 0.0v 364.745n 0.0v 364.755n 0.0v 369.745n 0.0v 369.755n 0.0v 374.745n 0.0v 374.755n 0.0v 379.745n 0.0v 379.755n 0.0v 384.745n 0.0v 384.755n 0.0v 389.745n 0.0v 389.755n 0.0v 394.745n 0.0v 394.755n 0.0v 399.745n 0.0v 399.755n 1.0v 404.745n 1.0v 404.755n 1.0v 409.745n 1.0v 409.755n 1.0v 414.745n 1.0v 414.755n 1.0v 419.745n 1.0v 419.755n 1.0v 424.745n 1.0v 424.755n 1.0v 429.745n 1.0v 429.755n 1.0v 434.745n 1.0v 434.755n 1.0v 439.745n 1.0v 439.755n 1.0v 444.745n 1.0v 444.755n 1.0v 449.745n 1.0v 449.755n 1.0v 454.745n 1.0v 454.755n 1.0v 459.745n 1.0v 459.755n 1.0v 464.745n 1.0v 464.755n 1.0v 469.745n 1.0v 469.755n 1.0v 474.745n 1.0v 474.755n 1.0v 479.745n 1.0v 479.755n 1.0v 484.745n 1.0v 484.755n 1.0v 489.745n 1.0v 489.755n 1.0v 494.745n 1.0v 494.755n 1.0v 499.745n 1.0v 499.755n 0.0v 504.745n 0.0v 504.755n 0.0v 509.745n 0.0v 509.755n 0.0v 514.745n 0.0v 514.755n 0.0v 519.745n 0.0v 519.755n 0.0v 524.745n 0.0v 524.755n 0.0v 529.745n 0.0v 529.755n 0.0v 534.745n 0.0v 534.755n 1.0v 539.745n 1.0v 539.755n 1.0v 544.745n 1.0v 544.755n 1.0v 549.745n 1.0v 549.755n 1.0v 554.745n 1.0v 554.755n 1.0v 559.745n 1.0v 559.755n 1.0v 564.745n 1.0v 564.755n 1.0v 569.745n 1.0v 569.755n 1.0v 574.745n 1.0v 574.755n 1.0v 579.745n 1.0v 579.755n 1.0v 584.745n 1.0v 584.755n 1.0v 589.745n 1.0v 589.755n 1.0v 594.745n 1.0v 594.755n 1.0v 599.745n 1.0v 599.755n 1.0v 604.745n 1.0v 604.755n 1.0v 609.745n 1.0v 609.755n 1.0v 614.745n 1.0v 614.755n 1.0v 619.745n 1.0v 619.755n 1.0v 624.745n 1.0v 624.755n 1.0v 629.745n 1.0v 629.755n 1.0v 634.745n 1.0v 634.755n 1.0v 639.745n 1.0v 639.755n 1.0v 644.745n 1.0v 644.755n 1.0v 649.745n 1.0v 649.755n 1.0v 654.745n 1.0v 654.755n 0.0v 659.745n 0.0v 659.755n 0.0v 664.745n 0.0v 664.755n 0.0v 669.745n 0.0v 669.755n 0.0v 674.745n 0.0v 674.755n 0.0v 679.745n 0.0v 679.755n 0.0v 684.745n 0.0v 684.755n 0.0v 689.745n 0.0v 689.755n 0.0v 694.745n 0.0v 694.755n 0.0v 699.745n 0.0v 699.755n 0.0v 704.745n 0.0v 704.755n 0.0v 709.745n 0.0v 709.755n 0.0v 714.745n 0.0v 714.755n 0.0v 719.745n 0.0v 719.755n 0.0v 724.745n 0.0v 724.755n 0.0v 729.745n 0.0v 729.755n 0.0v 734.745n 0.0v 734.755n 0.0v 739.745n 0.0v 739.755n 0.0v 744.745n 0.0v 744.755n 0.0v 749.745n 0.0v 749.755n 0.0v 754.745n 0.0v 754.755n 0.0v 759.745n 0.0v 759.755n 1.0v 764.745n 1.0v 764.755n 1.0v 769.745n 1.0v 769.755n 1.0v 774.745n 1.0v 774.755n 1.0v 779.745n 1.0v 779.755n 0.0v 784.745n 0.0v 784.755n 0.0v 789.745n 0.0v 789.755n 0.0v 794.745n 0.0v 794.755n 0.0v 799.745n 0.0v 799.755n 0.0v 804.745n 0.0v 804.755n 0.0v 809.745n 0.0v 809.755n 0.0v 814.745n 0.0v 814.755n 0.0v 819.745n 0.0v 819.755n 0.0v 824.745n 0.0v 824.755n 0.0v 829.745n 0.0v 829.755n 0.0v 834.745n 0.0v 834.755n 0.0v 839.745n 0.0v 839.755n 0.0v 844.745n 0.0v 844.755n 0.0v 849.745n 0.0v 849.755n 0.0v 854.745n 0.0v 854.755n 0.0v 859.745n 0.0v 859.755n 1.0v 864.745n 1.0v 864.755n 1.0v 869.745n 1.0v 869.755n 1.0v 874.745n 1.0v 874.755n 1.0v 879.745n 1.0v 879.755n 1.0v 884.745n 1.0v 884.755n 1.0v 889.745n 1.0v 889.755n 1.0v 894.745n 1.0v 894.755n 1.0v 899.745n 1.0v 899.755n 1.0v 904.745n 1.0v 904.755n 1.0v 909.745n 1.0v 909.755n 0.0v 914.745n 0.0v 914.755n 0.0v 919.745n 0.0v 919.755n 0.0v 924.745n 0.0v 924.755n 0.0v 929.745n 0.0v 929.755n 1.0v 934.745n 1.0v 934.755n 0.0v 939.745n 0.0v 939.755n 0.0v 944.745n 0.0v 944.755n 0.0v 949.745n 0.0v 949.755n 0.0v 954.745n 0.0v 954.755n 0.0v 959.745n 0.0v 959.755n 0.0v 964.745n 0.0v 964.755n 0.0v 969.745n 0.0v 969.755n 0.0v 974.745n 0.0v 974.755n 0.0v 979.745n 0.0v 979.755n 0.0v 984.745n 0.0v 984.755n 1.0v 989.745n 1.0v 989.755n 1.0v 994.745n 1.0v 994.755n 1.0v 999.745n 1.0v 999.755n 1.0v 1004.745n 1.0v 1004.755n 1.0v 1009.745n 1.0v 1009.755n 1.0v 1014.745n 1.0v 1014.755n 1.0v 1019.745n 1.0v 1019.755n 1.0v 1024.745n 1.0v 1024.755n 1.0v )
* (time, data): [(0, 0), (5, 0), (10, 1), (15, 0), (20, 0), (25, 0), (30, 0), (35, 0), (40, 0), (45, 0), (50, 0), (55, 0), (60, 0), (65, 0), (70, 0), (75, 0), (80, 0), (85, 1), (90, 1), (95, 1), (100, 1), (105, 1), (110, 1), (115, 0), (120, 0), (125, 0), (130, 0), (135, 0), (140, 0), (145, 0), (150, 1), (155, 1), (160, 1), (165, 1), (170, 1), (175, 1), (180, 1), (185, 1), (190, 1), (195, 1), (200, 1), (205, 1), (210, 1), (215, 1), (220, 0), (225, 0), (230, 0), (235, 0), (240, 0), (245, 0), (250, 0), (255, 0), (260, 0), (265, 0), (270, 0), (275, 0), (280, 0), (285, 0), (290, 0), (295, 0), (300, 0), (305, 0), (310, 0), (315, 0), (320, 0), (325, 0), (330, 0), (335, 0), (340, 0), (345, 0), (350, 1), (355, 1), (360, 1), (365, 1), (370, 1), (375, 1), (380, 1), (385, 1), (390, 1), (395, 1), (400, 1), (405, 1), (410, 1), (415, 1), (420, 1), (425, 1), (430, 1), (435, 1), (440, 0), (445, 0), (450, 0), (455, 0), (460, 0), (465, 0), (470, 0), (475, 0), (480, 0), (485, 0), (490, 0), (495, 0), (500, 0), (505, 0), (510, 0), (515, 0), (520, 0), (525, 0), (530, 0), (535, 1), (540, 1), (545, 1), (550, 1), (555, 1), (560, 1), (565, 1), (570, 1), (575, 1), (580, 1), (585, 1), (590, 1), (595, 1), (600, 1), (605, 1), (610, 1), (615, 1), (620, 1), (625, 1), (630, 1), (635, 1), (640, 1), (645, 1), (650, 1), (655, 0), (660, 0), (665, 0), (670, 0), (675, 0), (680, 0), (685, 0), (690, 0), (695, 0), (700, 0), (705, 0), (710, 1), (715, 1), (720, 1), (725, 1), (730, 1), (735, 1), (740, 1), (745, 1), (750, 1), (755, 1), (760, 1), (765, 1), (770, 1), (775, 1), (780, 1), (785, 1), (790, 1), (795, 1), (800, 1), (805, 1), (810, 0), (815, 0), (820, 0), (825, 0), (830, 0), (835, 0), (840, 0), (845, 0), (850, 0), (855, 0), (860, 1), (865, 1), (870, 1), (875, 1), (880, 0), (885, 0), (890, 0), (895, 0), (900, 0), (905, 0), (910, 1), (915, 1), (920, 0), (925, 0), (930, 1), (935, 0), (940, 0), (945, 0), (950, 0), (955, 1), (960, 1), (965, 1), (970, 1), (975, 1), (980, 1), (985, 1), (990, 1), (995, 1), (1000, 1), (1005, 0), (1010, 0), (1015, 0), (1020, 0), (1025, 0)]
Vdin1_4  din1_4  0 PWL (0n 0.0v 4.745n 0.0v 4.755n 0.0v 9.745n 0.0v 9.755n 1.0v 14.745n 1.0v 14.755n 0.0v 19.745n 0.0v 19.755n 0.0v 24.745n 0.0v 24.755n 0.0v 29.745n 0.0v 29.755n 0.0v 34.745n 0.0v 34.755n 0.0v 39.745n 0.0v 39.755n 0.0v 44.745n 0.0v 44.755n 0.0v 49.745n 0.0v 49.755n 0.0v 54.745n 0.0v 54.755n 0.0v 59.745n 0.0v 59.755n 0.0v 64.745n 0.0v 64.755n 0.0v 69.745n 0.0v 69.755n 0.0v 74.745n 0.0v 74.755n 0.0v 79.745n 0.0v 79.755n 0.0v 84.745n 0.0v 84.755n 1.0v 89.745n 1.0v 89.755n 1.0v 94.745n 1.0v 94.755n 1.0v 99.745n 1.0v 99.755n 1.0v 104.745n 1.0v 104.755n 1.0v 109.745n 1.0v 109.755n 1.0v 114.745n 1.0v 114.755n 0.0v 119.745n 0.0v 119.755n 0.0v 124.745n 0.0v 124.755n 0.0v 129.745n 0.0v 129.755n 0.0v 134.745n 0.0v 134.755n 0.0v 139.745n 0.0v 139.755n 0.0v 144.745n 0.0v 144.755n 0.0v 149.745n 0.0v 149.755n 1.0v 154.745n 1.0v 154.755n 1.0v 159.745n 1.0v 159.755n 1.0v 164.745n 1.0v 164.755n 1.0v 169.745n 1.0v 169.755n 1.0v 174.745n 1.0v 174.755n 1.0v 179.745n 1.0v 179.755n 1.0v 184.745n 1.0v 184.755n 1.0v 189.745n 1.0v 189.755n 1.0v 194.745n 1.0v 194.755n 1.0v 199.745n 1.0v 199.755n 1.0v 204.745n 1.0v 204.755n 1.0v 209.745n 1.0v 209.755n 1.0v 214.745n 1.0v 214.755n 1.0v 219.745n 1.0v 219.755n 0.0v 224.745n 0.0v 224.755n 0.0v 229.745n 0.0v 229.755n 0.0v 234.745n 0.0v 234.755n 0.0v 239.745n 0.0v 239.755n 0.0v 244.745n 0.0v 244.755n 0.0v 249.745n 0.0v 249.755n 0.0v 254.745n 0.0v 254.755n 0.0v 259.745n 0.0v 259.755n 0.0v 264.745n 0.0v 264.755n 0.0v 269.745n 0.0v 269.755n 0.0v 274.745n 0.0v 274.755n 0.0v 279.745n 0.0v 279.755n 0.0v 284.745n 0.0v 284.755n 0.0v 289.745n 0.0v 289.755n 0.0v 294.745n 0.0v 294.755n 0.0v 299.745n 0.0v 299.755n 0.0v 304.745n 0.0v 304.755n 0.0v 309.745n 0.0v 309.755n 0.0v 314.745n 0.0v 314.755n 0.0v 319.745n 0.0v 319.755n 0.0v 324.745n 0.0v 324.755n 0.0v 329.745n 0.0v 329.755n 0.0v 334.745n 0.0v 334.755n 0.0v 339.745n 0.0v 339.755n 0.0v 344.745n 0.0v 344.755n 0.0v 349.745n 0.0v 349.755n 1.0v 354.745n 1.0v 354.755n 1.0v 359.745n 1.0v 359.755n 1.0v 364.745n 1.0v 364.755n 1.0v 369.745n 1.0v 369.755n 1.0v 374.745n 1.0v 374.755n 1.0v 379.745n 1.0v 379.755n 1.0v 384.745n 1.0v 384.755n 1.0v 389.745n 1.0v 389.755n 1.0v 394.745n 1.0v 394.755n 1.0v 399.745n 1.0v 399.755n 1.0v 404.745n 1.0v 404.755n 1.0v 409.745n 1.0v 409.755n 1.0v 414.745n 1.0v 414.755n 1.0v 419.745n 1.0v 419.755n 1.0v 424.745n 1.0v 424.755n 1.0v 429.745n 1.0v 429.755n 1.0v 434.745n 1.0v 434.755n 1.0v 439.745n 1.0v 439.755n 0.0v 444.745n 0.0v 444.755n 0.0v 449.745n 0.0v 449.755n 0.0v 454.745n 0.0v 454.755n 0.0v 459.745n 0.0v 459.755n 0.0v 464.745n 0.0v 464.755n 0.0v 469.745n 0.0v 469.755n 0.0v 474.745n 0.0v 474.755n 0.0v 479.745n 0.0v 479.755n 0.0v 484.745n 0.0v 484.755n 0.0v 489.745n 0.0v 489.755n 0.0v 494.745n 0.0v 494.755n 0.0v 499.745n 0.0v 499.755n 0.0v 504.745n 0.0v 504.755n 0.0v 509.745n 0.0v 509.755n 0.0v 514.745n 0.0v 514.755n 0.0v 519.745n 0.0v 519.755n 0.0v 524.745n 0.0v 524.755n 0.0v 529.745n 0.0v 529.755n 0.0v 534.745n 0.0v 534.755n 1.0v 539.745n 1.0v 539.755n 1.0v 544.745n 1.0v 544.755n 1.0v 549.745n 1.0v 549.755n 1.0v 554.745n 1.0v 554.755n 1.0v 559.745n 1.0v 559.755n 1.0v 564.745n 1.0v 564.755n 1.0v 569.745n 1.0v 569.755n 1.0v 574.745n 1.0v 574.755n 1.0v 579.745n 1.0v 579.755n 1.0v 584.745n 1.0v 584.755n 1.0v 589.745n 1.0v 589.755n 1.0v 594.745n 1.0v 594.755n 1.0v 599.745n 1.0v 599.755n 1.0v 604.745n 1.0v 604.755n 1.0v 609.745n 1.0v 609.755n 1.0v 614.745n 1.0v 614.755n 1.0v 619.745n 1.0v 619.755n 1.0v 624.745n 1.0v 624.755n 1.0v 629.745n 1.0v 629.755n 1.0v 634.745n 1.0v 634.755n 1.0v 639.745n 1.0v 639.755n 1.0v 644.745n 1.0v 644.755n 1.0v 649.745n 1.0v 649.755n 1.0v 654.745n 1.0v 654.755n 0.0v 659.745n 0.0v 659.755n 0.0v 664.745n 0.0v 664.755n 0.0v 669.745n 0.0v 669.755n 0.0v 674.745n 0.0v 674.755n 0.0v 679.745n 0.0v 679.755n 0.0v 684.745n 0.0v 684.755n 0.0v 689.745n 0.0v 689.755n 0.0v 694.745n 0.0v 694.755n 0.0v 699.745n 0.0v 699.755n 0.0v 704.745n 0.0v 704.755n 0.0v 709.745n 0.0v 709.755n 1.0v 714.745n 1.0v 714.755n 1.0v 719.745n 1.0v 719.755n 1.0v 724.745n 1.0v 724.755n 1.0v 729.745n 1.0v 729.755n 1.0v 734.745n 1.0v 734.755n 1.0v 739.745n 1.0v 739.755n 1.0v 744.745n 1.0v 744.755n 1.0v 749.745n 1.0v 749.755n 1.0v 754.745n 1.0v 754.755n 1.0v 759.745n 1.0v 759.755n 1.0v 764.745n 1.0v 764.755n 1.0v 769.745n 1.0v 769.755n 1.0v 774.745n 1.0v 774.755n 1.0v 779.745n 1.0v 779.755n 1.0v 784.745n 1.0v 784.755n 1.0v 789.745n 1.0v 789.755n 1.0v 794.745n 1.0v 794.755n 1.0v 799.745n 1.0v 799.755n 1.0v 804.745n 1.0v 804.755n 1.0v 809.745n 1.0v 809.755n 0.0v 814.745n 0.0v 814.755n 0.0v 819.745n 0.0v 819.755n 0.0v 824.745n 0.0v 824.755n 0.0v 829.745n 0.0v 829.755n 0.0v 834.745n 0.0v 834.755n 0.0v 839.745n 0.0v 839.755n 0.0v 844.745n 0.0v 844.755n 0.0v 849.745n 0.0v 849.755n 0.0v 854.745n 0.0v 854.755n 0.0v 859.745n 0.0v 859.755n 1.0v 864.745n 1.0v 864.755n 1.0v 869.745n 1.0v 869.755n 1.0v 874.745n 1.0v 874.755n 1.0v 879.745n 1.0v 879.755n 0.0v 884.745n 0.0v 884.755n 0.0v 889.745n 0.0v 889.755n 0.0v 894.745n 0.0v 894.755n 0.0v 899.745n 0.0v 899.755n 0.0v 904.745n 0.0v 904.755n 0.0v 909.745n 0.0v 909.755n 1.0v 914.745n 1.0v 914.755n 1.0v 919.745n 1.0v 919.755n 0.0v 924.745n 0.0v 924.755n 0.0v 929.745n 0.0v 929.755n 1.0v 934.745n 1.0v 934.755n 0.0v 939.745n 0.0v 939.755n 0.0v 944.745n 0.0v 944.755n 0.0v 949.745n 0.0v 949.755n 0.0v 954.745n 0.0v 954.755n 1.0v 959.745n 1.0v 959.755n 1.0v 964.745n 1.0v 964.755n 1.0v 969.745n 1.0v 969.755n 1.0v 974.745n 1.0v 974.755n 1.0v 979.745n 1.0v 979.755n 1.0v 984.745n 1.0v 984.755n 1.0v 989.745n 1.0v 989.755n 1.0v 994.745n 1.0v 994.755n 1.0v 999.745n 1.0v 999.755n 1.0v 1004.745n 1.0v 1004.755n 0.0v 1009.745n 0.0v 1009.755n 0.0v 1014.745n 0.0v 1014.755n 0.0v 1019.745n 0.0v 1019.755n 0.0v 1024.745n 0.0v 1024.755n 0.0v )
* (time, data): [(0, 0), (5, 1), (10, 1), (15, 1), (20, 1), (25, 1), (30, 1), (35, 0), (40, 0), (45, 0), (50, 1), (55, 1), (60, 1), (65, 1), (70, 1), (75, 1), (80, 1), (85, 0), (90, 0), (95, 0), (100, 1), (105, 1), (110, 1), (115, 1), (120, 1), (125, 0), (130, 0), (135, 0), (140, 0), (145, 0), (150, 0), (155, 0), (160, 0), (165, 1), (170, 1), (175, 1), (180, 1), (185, 1), (190, 1), (195, 1), (200, 1), (205, 0), (210, 0), (215, 0), (220, 1), (225, 1), (230, 1), (235, 1), (240, 0), (245, 0), (250, 0), (255, 0), (260, 1), (265, 1), (270, 1), (275, 0), (280, 0), (285, 0), (290, 0), (295, 0), (300, 0), (305, 0), (310, 1), (315, 1), (320, 1), (325, 1), (330, 1), (335, 1), (340, 1), (345, 0), (350, 0), (355, 0), (360, 1), (365, 1), (370, 1), (375, 1), (380, 1), (385, 1), (390, 1), (395, 1), (400, 0), (405, 1), (410, 1), (415, 1), (420, 1), (425, 1), (430, 1), (435, 1), (440, 0), (445, 0), (450, 0), (455, 0), (460, 0), (465, 0), (470, 0), (475, 0), (480, 0), (485, 0), (490, 0), (495, 0), (500, 1), (505, 1), (510, 1), (515, 1), (520, 1), (525, 1), (530, 1), (535, 0), (540, 1), (545, 1), (550, 1), (555, 1), (560, 1), (565, 1), (570, 1), (575, 1), (580, 1), (585, 1), (590, 1), (595, 1), (600, 1), (605, 1), (610, 1), (615, 1), (620, 1), (625, 1), (630, 1), (635, 1), (640, 1), (645, 1), (650, 1), (655, 0), (660, 0), (665, 0), (670, 0), (675, 0), (680, 0), (685, 0), (690, 0), (695, 0), (700, 0), (705, 0), (710, 1), (715, 1), (720, 1), (725, 1), (730, 1), (735, 1), (740, 1), (745, 1), (750, 1), (755, 1), (760, 1), (765, 1), (770, 1), (775, 1), (780, 1), (785, 1), (790, 1), (795, 1), (800, 1), (805, 1), (810, 1), (815, 1), (820, 1), (825, 1), (830, 1), (835, 1), (840, 1), (845, 1), (850, 1), (855, 1), (860, 1), (865, 1), (870, 1), (875, 1), (880, 1), (885, 1), (890, 1), (895, 1), (900, 1), (905, 1), (910, 0), (915, 0), (920, 1), (925, 1), (930, 1), (935, 0), (940, 0), (945, 0), (950, 0), (955, 0), (960, 0), (965, 0), (970, 0), (975, 0), (980, 0), (985, 0), (990, 0), (995, 0), (1000, 0), (1005, 1), (1010, 1), (1015, 1), (1020, 1), (1025, 1)]
Vdin1_5  din1_5  0 PWL (0n 0.0v 4.745n 0.0v 4.755n 1.0v 9.745n 1.0v 9.755n 1.0v 14.745n 1.0v 14.755n 1.0v 19.745n 1.0v 19.755n 1.0v 24.745n 1.0v 24.755n 1.0v 29.745n 1.0v 29.755n 1.0v 34.745n 1.0v 34.755n 0.0v 39.745n 0.0v 39.755n 0.0v 44.745n 0.0v 44.755n 0.0v 49.745n 0.0v 49.755n 1.0v 54.745n 1.0v 54.755n 1.0v 59.745n 1.0v 59.755n 1.0v 64.745n 1.0v 64.755n 1.0v 69.745n 1.0v 69.755n 1.0v 74.745n 1.0v 74.755n 1.0v 79.745n 1.0v 79.755n 1.0v 84.745n 1.0v 84.755n 0.0v 89.745n 0.0v 89.755n 0.0v 94.745n 0.0v 94.755n 0.0v 99.745n 0.0v 99.755n 1.0v 104.745n 1.0v 104.755n 1.0v 109.745n 1.0v 109.755n 1.0v 114.745n 1.0v 114.755n 1.0v 119.745n 1.0v 119.755n 1.0v 124.745n 1.0v 124.755n 0.0v 129.745n 0.0v 129.755n 0.0v 134.745n 0.0v 134.755n 0.0v 139.745n 0.0v 139.755n 0.0v 144.745n 0.0v 144.755n 0.0v 149.745n 0.0v 149.755n 0.0v 154.745n 0.0v 154.755n 0.0v 159.745n 0.0v 159.755n 0.0v 164.745n 0.0v 164.755n 1.0v 169.745n 1.0v 169.755n 1.0v 174.745n 1.0v 174.755n 1.0v 179.745n 1.0v 179.755n 1.0v 184.745n 1.0v 184.755n 1.0v 189.745n 1.0v 189.755n 1.0v 194.745n 1.0v 194.755n 1.0v 199.745n 1.0v 199.755n 1.0v 204.745n 1.0v 204.755n 0.0v 209.745n 0.0v 209.755n 0.0v 214.745n 0.0v 214.755n 0.0v 219.745n 0.0v 219.755n 1.0v 224.745n 1.0v 224.755n 1.0v 229.745n 1.0v 229.755n 1.0v 234.745n 1.0v 234.755n 1.0v 239.745n 1.0v 239.755n 0.0v 244.745n 0.0v 244.755n 0.0v 249.745n 0.0v 249.755n 0.0v 254.745n 0.0v 254.755n 0.0v 259.745n 0.0v 259.755n 1.0v 264.745n 1.0v 264.755n 1.0v 269.745n 1.0v 269.755n 1.0v 274.745n 1.0v 274.755n 0.0v 279.745n 0.0v 279.755n 0.0v 284.745n 0.0v 284.755n 0.0v 289.745n 0.0v 289.755n 0.0v 294.745n 0.0v 294.755n 0.0v 299.745n 0.0v 299.755n 0.0v 304.745n 0.0v 304.755n 0.0v 309.745n 0.0v 309.755n 1.0v 314.745n 1.0v 314.755n 1.0v 319.745n 1.0v 319.755n 1.0v 324.745n 1.0v 324.755n 1.0v 329.745n 1.0v 329.755n 1.0v 334.745n 1.0v 334.755n 1.0v 339.745n 1.0v 339.755n 1.0v 344.745n 1.0v 344.755n 0.0v 349.745n 0.0v 349.755n 0.0v 354.745n 0.0v 354.755n 0.0v 359.745n 0.0v 359.755n 1.0v 364.745n 1.0v 364.755n 1.0v 369.745n 1.0v 369.755n 1.0v 374.745n 1.0v 374.755n 1.0v 379.745n 1.0v 379.755n 1.0v 384.745n 1.0v 384.755n 1.0v 389.745n 1.0v 389.755n 1.0v 394.745n 1.0v 394.755n 1.0v 399.745n 1.0v 399.755n 0.0v 404.745n 0.0v 404.755n 1.0v 409.745n 1.0v 409.755n 1.0v 414.745n 1.0v 414.755n 1.0v 419.745n 1.0v 419.755n 1.0v 424.745n 1.0v 424.755n 1.0v 429.745n 1.0v 429.755n 1.0v 434.745n 1.0v 434.755n 1.0v 439.745n 1.0v 439.755n 0.0v 444.745n 0.0v 444.755n 0.0v 449.745n 0.0v 449.755n 0.0v 454.745n 0.0v 454.755n 0.0v 459.745n 0.0v 459.755n 0.0v 464.745n 0.0v 464.755n 0.0v 469.745n 0.0v 469.755n 0.0v 474.745n 0.0v 474.755n 0.0v 479.745n 0.0v 479.755n 0.0v 484.745n 0.0v 484.755n 0.0v 489.745n 0.0v 489.755n 0.0v 494.745n 0.0v 494.755n 0.0v 499.745n 0.0v 499.755n 1.0v 504.745n 1.0v 504.755n 1.0v 509.745n 1.0v 509.755n 1.0v 514.745n 1.0v 514.755n 1.0v 519.745n 1.0v 519.755n 1.0v 524.745n 1.0v 524.755n 1.0v 529.745n 1.0v 529.755n 1.0v 534.745n 1.0v 534.755n 0.0v 539.745n 0.0v 539.755n 1.0v 544.745n 1.0v 544.755n 1.0v 549.745n 1.0v 549.755n 1.0v 554.745n 1.0v 554.755n 1.0v 559.745n 1.0v 559.755n 1.0v 564.745n 1.0v 564.755n 1.0v 569.745n 1.0v 569.755n 1.0v 574.745n 1.0v 574.755n 1.0v 579.745n 1.0v 579.755n 1.0v 584.745n 1.0v 584.755n 1.0v 589.745n 1.0v 589.755n 1.0v 594.745n 1.0v 594.755n 1.0v 599.745n 1.0v 599.755n 1.0v 604.745n 1.0v 604.755n 1.0v 609.745n 1.0v 609.755n 1.0v 614.745n 1.0v 614.755n 1.0v 619.745n 1.0v 619.755n 1.0v 624.745n 1.0v 624.755n 1.0v 629.745n 1.0v 629.755n 1.0v 634.745n 1.0v 634.755n 1.0v 639.745n 1.0v 639.755n 1.0v 644.745n 1.0v 644.755n 1.0v 649.745n 1.0v 649.755n 1.0v 654.745n 1.0v 654.755n 0.0v 659.745n 0.0v 659.755n 0.0v 664.745n 0.0v 664.755n 0.0v 669.745n 0.0v 669.755n 0.0v 674.745n 0.0v 674.755n 0.0v 679.745n 0.0v 679.755n 0.0v 684.745n 0.0v 684.755n 0.0v 689.745n 0.0v 689.755n 0.0v 694.745n 0.0v 694.755n 0.0v 699.745n 0.0v 699.755n 0.0v 704.745n 0.0v 704.755n 0.0v 709.745n 0.0v 709.755n 1.0v 714.745n 1.0v 714.755n 1.0v 719.745n 1.0v 719.755n 1.0v 724.745n 1.0v 724.755n 1.0v 729.745n 1.0v 729.755n 1.0v 734.745n 1.0v 734.755n 1.0v 739.745n 1.0v 739.755n 1.0v 744.745n 1.0v 744.755n 1.0v 749.745n 1.0v 749.755n 1.0v 754.745n 1.0v 754.755n 1.0v 759.745n 1.0v 759.755n 1.0v 764.745n 1.0v 764.755n 1.0v 769.745n 1.0v 769.755n 1.0v 774.745n 1.0v 774.755n 1.0v 779.745n 1.0v 779.755n 1.0v 784.745n 1.0v 784.755n 1.0v 789.745n 1.0v 789.755n 1.0v 794.745n 1.0v 794.755n 1.0v 799.745n 1.0v 799.755n 1.0v 804.745n 1.0v 804.755n 1.0v 809.745n 1.0v 809.755n 1.0v 814.745n 1.0v 814.755n 1.0v 819.745n 1.0v 819.755n 1.0v 824.745n 1.0v 824.755n 1.0v 829.745n 1.0v 829.755n 1.0v 834.745n 1.0v 834.755n 1.0v 839.745n 1.0v 839.755n 1.0v 844.745n 1.0v 844.755n 1.0v 849.745n 1.0v 849.755n 1.0v 854.745n 1.0v 854.755n 1.0v 859.745n 1.0v 859.755n 1.0v 864.745n 1.0v 864.755n 1.0v 869.745n 1.0v 869.755n 1.0v 874.745n 1.0v 874.755n 1.0v 879.745n 1.0v 879.755n 1.0v 884.745n 1.0v 884.755n 1.0v 889.745n 1.0v 889.755n 1.0v 894.745n 1.0v 894.755n 1.0v 899.745n 1.0v 899.755n 1.0v 904.745n 1.0v 904.755n 1.0v 909.745n 1.0v 909.755n 0.0v 914.745n 0.0v 914.755n 0.0v 919.745n 0.0v 919.755n 1.0v 924.745n 1.0v 924.755n 1.0v 929.745n 1.0v 929.755n 1.0v 934.745n 1.0v 934.755n 0.0v 939.745n 0.0v 939.755n 0.0v 944.745n 0.0v 944.755n 0.0v 949.745n 0.0v 949.755n 0.0v 954.745n 0.0v 954.755n 0.0v 959.745n 0.0v 959.755n 0.0v 964.745n 0.0v 964.755n 0.0v 969.745n 0.0v 969.755n 0.0v 974.745n 0.0v 974.755n 0.0v 979.745n 0.0v 979.755n 0.0v 984.745n 0.0v 984.755n 0.0v 989.745n 0.0v 989.755n 0.0v 994.745n 0.0v 994.755n 0.0v 999.745n 0.0v 999.755n 0.0v 1004.745n 0.0v 1004.755n 1.0v 1009.745n 1.0v 1009.755n 1.0v 1014.745n 1.0v 1014.755n 1.0v 1019.745n 1.0v 1019.755n 1.0v 1024.745n 1.0v 1024.755n 1.0v )
* (time, data): [(0, 0), (5, 0), (10, 0), (15, 0), (20, 0), (25, 0), (30, 0), (35, 0), (40, 0), (45, 0), (50, 1), (55, 1), (60, 1), (65, 1), (70, 1), (75, 1), (80, 1), (85, 1), (90, 1), (95, 1), (100, 0), (105, 0), (110, 0), (115, 0), (120, 0), (125, 1), (130, 1), (135, 1), (140, 1), (145, 1), (150, 0), (155, 0), (160, 0), (165, 1), (170, 1), (175, 1), (180, 1), (185, 1), (190, 1), (195, 1), (200, 1), (205, 1), (210, 1), (215, 1), (220, 0), (225, 0), (230, 0), (235, 0), (240, 1), (245, 1), (250, 0), (255, 0), (260, 1), (265, 1), (270, 1), (275, 0), (280, 0), (285, 0), (290, 0), (295, 0), (300, 0), (305, 0), (310, 0), (315, 0), (320, 0), (325, 0), (330, 0), (335, 0), (340, 0), (345, 1), (350, 1), (355, 1), (360, 1), (365, 1), (370, 1), (375, 1), (380, 1), (385, 1), (390, 1), (395, 1), (400, 0), (405, 0), (410, 0), (415, 0), (420, 0), (425, 0), (430, 0), (435, 0), (440, 0), (445, 0), (450, 0), (455, 0), (460, 0), (465, 0), (470, 0), (475, 0), (480, 0), (485, 0), (490, 0), (495, 0), (500, 0), (505, 0), (510, 0), (515, 0), (520, 0), (525, 0), (530, 0), (535, 1), (540, 0), (545, 0), (550, 0), (555, 0), (560, 0), (565, 0), (570, 0), (575, 0), (580, 0), (585, 0), (590, 0), (595, 0), (600, 0), (605, 0), (610, 0), (615, 0), (620, 0), (625, 0), (630, 0), (635, 0), (640, 0), (645, 0), (650, 0), (655, 1), (660, 1), (665, 1), (670, 1), (675, 1), (680, 1), (685, 1), (690, 1), (695, 1), (700, 1), (705, 1), (710, 0), (715, 0), (720, 0), (725, 0), (730, 0), (735, 0), (740, 0), (745, 0), (750, 0), (755, 0), (760, 0), (765, 0), (770, 0), (775, 0), (780, 1), (785, 1), (790, 1), (795, 1), (800, 1), (805, 1), (810, 0), (815, 0), (820, 0), (825, 0), (830, 0), (835, 0), (840, 0), (845, 0), (850, 0), (855, 0), (860, 0), (865, 0), (870, 0), (875, 0), (880, 1), (885, 1), (890, 1), (895, 1), (900, 1), (905, 1), (910, 1), (915, 1), (920, 1), (925, 1), (930, 0), (935, 1), (940, 1), (945, 1), (950, 1), (955, 1), (960, 1), (965, 1), (970, 1), (975, 1), (980, 1), (985, 1), (990, 1), (995, 1), (1000, 1), (1005, 1), (1010, 1), (1015, 1), (1020, 1), (1025, 1)]
Vdin1_6  din1_6  0 PWL (0n 0.0v 4.745n 0.0v 4.755n 0.0v 9.745n 0.0v 9.755n 0.0v 14.745n 0.0v 14.755n 0.0v 19.745n 0.0v 19.755n 0.0v 24.745n 0.0v 24.755n 0.0v 29.745n 0.0v 29.755n 0.0v 34.745n 0.0v 34.755n 0.0v 39.745n 0.0v 39.755n 0.0v 44.745n 0.0v 44.755n 0.0v 49.745n 0.0v 49.755n 1.0v 54.745n 1.0v 54.755n 1.0v 59.745n 1.0v 59.755n 1.0v 64.745n 1.0v 64.755n 1.0v 69.745n 1.0v 69.755n 1.0v 74.745n 1.0v 74.755n 1.0v 79.745n 1.0v 79.755n 1.0v 84.745n 1.0v 84.755n 1.0v 89.745n 1.0v 89.755n 1.0v 94.745n 1.0v 94.755n 1.0v 99.745n 1.0v 99.755n 0.0v 104.745n 0.0v 104.755n 0.0v 109.745n 0.0v 109.755n 0.0v 114.745n 0.0v 114.755n 0.0v 119.745n 0.0v 119.755n 0.0v 124.745n 0.0v 124.755n 1.0v 129.745n 1.0v 129.755n 1.0v 134.745n 1.0v 134.755n 1.0v 139.745n 1.0v 139.755n 1.0v 144.745n 1.0v 144.755n 1.0v 149.745n 1.0v 149.755n 0.0v 154.745n 0.0v 154.755n 0.0v 159.745n 0.0v 159.755n 0.0v 164.745n 0.0v 164.755n 1.0v 169.745n 1.0v 169.755n 1.0v 174.745n 1.0v 174.755n 1.0v 179.745n 1.0v 179.755n 1.0v 184.745n 1.0v 184.755n 1.0v 189.745n 1.0v 189.755n 1.0v 194.745n 1.0v 194.755n 1.0v 199.745n 1.0v 199.755n 1.0v 204.745n 1.0v 204.755n 1.0v 209.745n 1.0v 209.755n 1.0v 214.745n 1.0v 214.755n 1.0v 219.745n 1.0v 219.755n 0.0v 224.745n 0.0v 224.755n 0.0v 229.745n 0.0v 229.755n 0.0v 234.745n 0.0v 234.755n 0.0v 239.745n 0.0v 239.755n 1.0v 244.745n 1.0v 244.755n 1.0v 249.745n 1.0v 249.755n 0.0v 254.745n 0.0v 254.755n 0.0v 259.745n 0.0v 259.755n 1.0v 264.745n 1.0v 264.755n 1.0v 269.745n 1.0v 269.755n 1.0v 274.745n 1.0v 274.755n 0.0v 279.745n 0.0v 279.755n 0.0v 284.745n 0.0v 284.755n 0.0v 289.745n 0.0v 289.755n 0.0v 294.745n 0.0v 294.755n 0.0v 299.745n 0.0v 299.755n 0.0v 304.745n 0.0v 304.755n 0.0v 309.745n 0.0v 309.755n 0.0v 314.745n 0.0v 314.755n 0.0v 319.745n 0.0v 319.755n 0.0v 324.745n 0.0v 324.755n 0.0v 329.745n 0.0v 329.755n 0.0v 334.745n 0.0v 334.755n 0.0v 339.745n 0.0v 339.755n 0.0v 344.745n 0.0v 344.755n 1.0v 349.745n 1.0v 349.755n 1.0v 354.745n 1.0v 354.755n 1.0v 359.745n 1.0v 359.755n 1.0v 364.745n 1.0v 364.755n 1.0v 369.745n 1.0v 369.755n 1.0v 374.745n 1.0v 374.755n 1.0v 379.745n 1.0v 379.755n 1.0v 384.745n 1.0v 384.755n 1.0v 389.745n 1.0v 389.755n 1.0v 394.745n 1.0v 394.755n 1.0v 399.745n 1.0v 399.755n 0.0v 404.745n 0.0v 404.755n 0.0v 409.745n 0.0v 409.755n 0.0v 414.745n 0.0v 414.755n 0.0v 419.745n 0.0v 419.755n 0.0v 424.745n 0.0v 424.755n 0.0v 429.745n 0.0v 429.755n 0.0v 434.745n 0.0v 434.755n 0.0v 439.745n 0.0v 439.755n 0.0v 444.745n 0.0v 444.755n 0.0v 449.745n 0.0v 449.755n 0.0v 454.745n 0.0v 454.755n 0.0v 459.745n 0.0v 459.755n 0.0v 464.745n 0.0v 464.755n 0.0v 469.745n 0.0v 469.755n 0.0v 474.745n 0.0v 474.755n 0.0v 479.745n 0.0v 479.755n 0.0v 484.745n 0.0v 484.755n 0.0v 489.745n 0.0v 489.755n 0.0v 494.745n 0.0v 494.755n 0.0v 499.745n 0.0v 499.755n 0.0v 504.745n 0.0v 504.755n 0.0v 509.745n 0.0v 509.755n 0.0v 514.745n 0.0v 514.755n 0.0v 519.745n 0.0v 519.755n 0.0v 524.745n 0.0v 524.755n 0.0v 529.745n 0.0v 529.755n 0.0v 534.745n 0.0v 534.755n 1.0v 539.745n 1.0v 539.755n 0.0v 544.745n 0.0v 544.755n 0.0v 549.745n 0.0v 549.755n 0.0v 554.745n 0.0v 554.755n 0.0v 559.745n 0.0v 559.755n 0.0v 564.745n 0.0v 564.755n 0.0v 569.745n 0.0v 569.755n 0.0v 574.745n 0.0v 574.755n 0.0v 579.745n 0.0v 579.755n 0.0v 584.745n 0.0v 584.755n 0.0v 589.745n 0.0v 589.755n 0.0v 594.745n 0.0v 594.755n 0.0v 599.745n 0.0v 599.755n 0.0v 604.745n 0.0v 604.755n 0.0v 609.745n 0.0v 609.755n 0.0v 614.745n 0.0v 614.755n 0.0v 619.745n 0.0v 619.755n 0.0v 624.745n 0.0v 624.755n 0.0v 629.745n 0.0v 629.755n 0.0v 634.745n 0.0v 634.755n 0.0v 639.745n 0.0v 639.755n 0.0v 644.745n 0.0v 644.755n 0.0v 649.745n 0.0v 649.755n 0.0v 654.745n 0.0v 654.755n 1.0v 659.745n 1.0v 659.755n 1.0v 664.745n 1.0v 664.755n 1.0v 669.745n 1.0v 669.755n 1.0v 674.745n 1.0v 674.755n 1.0v 679.745n 1.0v 679.755n 1.0v 684.745n 1.0v 684.755n 1.0v 689.745n 1.0v 689.755n 1.0v 694.745n 1.0v 694.755n 1.0v 699.745n 1.0v 699.755n 1.0v 704.745n 1.0v 704.755n 1.0v 709.745n 1.0v 709.755n 0.0v 714.745n 0.0v 714.755n 0.0v 719.745n 0.0v 719.755n 0.0v 724.745n 0.0v 724.755n 0.0v 729.745n 0.0v 729.755n 0.0v 734.745n 0.0v 734.755n 0.0v 739.745n 0.0v 739.755n 0.0v 744.745n 0.0v 744.755n 0.0v 749.745n 0.0v 749.755n 0.0v 754.745n 0.0v 754.755n 0.0v 759.745n 0.0v 759.755n 0.0v 764.745n 0.0v 764.755n 0.0v 769.745n 0.0v 769.755n 0.0v 774.745n 0.0v 774.755n 0.0v 779.745n 0.0v 779.755n 1.0v 784.745n 1.0v 784.755n 1.0v 789.745n 1.0v 789.755n 1.0v 794.745n 1.0v 794.755n 1.0v 799.745n 1.0v 799.755n 1.0v 804.745n 1.0v 804.755n 1.0v 809.745n 1.0v 809.755n 0.0v 814.745n 0.0v 814.755n 0.0v 819.745n 0.0v 819.755n 0.0v 824.745n 0.0v 824.755n 0.0v 829.745n 0.0v 829.755n 0.0v 834.745n 0.0v 834.755n 0.0v 839.745n 0.0v 839.755n 0.0v 844.745n 0.0v 844.755n 0.0v 849.745n 0.0v 849.755n 0.0v 854.745n 0.0v 854.755n 0.0v 859.745n 0.0v 859.755n 0.0v 864.745n 0.0v 864.755n 0.0v 869.745n 0.0v 869.755n 0.0v 874.745n 0.0v 874.755n 0.0v 879.745n 0.0v 879.755n 1.0v 884.745n 1.0v 884.755n 1.0v 889.745n 1.0v 889.755n 1.0v 894.745n 1.0v 894.755n 1.0v 899.745n 1.0v 899.755n 1.0v 904.745n 1.0v 904.755n 1.0v 909.745n 1.0v 909.755n 1.0v 914.745n 1.0v 914.755n 1.0v 919.745n 1.0v 919.755n 1.0v 924.745n 1.0v 924.755n 1.0v 929.745n 1.0v 929.755n 0.0v 934.745n 0.0v 934.755n 1.0v 939.745n 1.0v 939.755n 1.0v 944.745n 1.0v 944.755n 1.0v 949.745n 1.0v 949.755n 1.0v 954.745n 1.0v 954.755n 1.0v 959.745n 1.0v 959.755n 1.0v 964.745n 1.0v 964.755n 1.0v 969.745n 1.0v 969.755n 1.0v 974.745n 1.0v 974.755n 1.0v 979.745n 1.0v 979.755n 1.0v 984.745n 1.0v 984.755n 1.0v 989.745n 1.0v 989.755n 1.0v 994.745n 1.0v 994.755n 1.0v 999.745n 1.0v 999.755n 1.0v 1004.745n 1.0v 1004.755n 1.0v 1009.745n 1.0v 1009.755n 1.0v 1014.745n 1.0v 1014.755n 1.0v 1019.745n 1.0v 1019.755n 1.0v 1024.745n 1.0v 1024.755n 1.0v )
* (time, data): [(0, 0), (5, 1), (10, 1), (15, 1), (20, 1), (25, 1), (30, 1), (35, 1), (40, 1), (45, 1), (50, 0), (55, 0), (60, 0), (65, 0), (70, 0), (75, 0), (80, 0), (85, 1), (90, 1), (95, 1), (100, 1), (105, 1), (110, 1), (115, 0), (120, 0), (125, 1), (130, 1), (135, 1), (140, 1), (145, 1), (150, 1), (155, 1), (160, 1), (165, 1), (170, 1), (175, 1), (180, 1), (185, 1), (190, 1), (195, 1), (200, 1), (205, 0), (210, 0), (215, 0), (220, 1), (225, 1), (230, 1), (235, 1), (240, 1), (245, 1), (250, 0), (255, 0), (260, 0), (265, 0), (270, 0), (275, 0), (280, 0), (285, 0), (290, 0), (295, 0), (300, 0), (305, 0), (310, 0), (315, 0), (320, 0), (325, 0), (330, 0), (335, 0), (340, 0), (345, 0), (350, 0), (355, 0), (360, 1), (365, 1), (370, 1), (375, 1), (380, 1), (385, 1), (390, 1), (395, 1), (400, 1), (405, 1), (410, 1), (415, 1), (420, 1), (425, 1), (430, 1), (435, 1), (440, 0), (445, 0), (450, 0), (455, 0), (460, 0), (465, 0), (470, 0), (475, 0), (480, 0), (485, 0), (490, 0), (495, 0), (500, 0), (505, 0), (510, 0), (515, 0), (520, 0), (525, 0), (530, 0), (535, 0), (540, 1), (545, 1), (550, 1), (555, 1), (560, 1), (565, 1), (570, 1), (575, 1), (580, 1), (585, 1), (590, 1), (595, 1), (600, 1), (605, 1), (610, 1), (615, 1), (620, 1), (625, 1), (630, 1), (635, 1), (640, 1), (645, 1), (650, 1), (655, 1), (660, 1), (665, 1), (670, 1), (675, 1), (680, 1), (685, 1), (690, 1), (695, 1), (700, 1), (705, 1), (710, 1), (715, 1), (720, 1), (725, 1), (730, 1), (735, 1), (740, 1), (745, 1), (750, 1), (755, 1), (760, 1), (765, 1), (770, 1), (775, 1), (780, 1), (785, 1), (790, 1), (795, 1), (800, 1), (805, 1), (810, 1), (815, 1), (820, 1), (825, 1), (830, 1), (835, 1), (840, 1), (845, 1), (850, 1), (855, 1), (860, 1), (865, 1), (870, 1), (875, 1), (880, 1), (885, 1), (890, 1), (895, 1), (900, 1), (905, 1), (910, 0), (915, 0), (920, 0), (925, 0), (930, 1), (935, 1), (940, 1), (945, 1), (950, 0), (955, 0), (960, 0), (965, 0), (970, 0), (975, 0), (980, 0), (985, 0), (990, 0), (995, 0), (1000, 0), (1005, 1), (1010, 1), (1015, 1), (1020, 1), (1025, 1)]
Vdin1_7  din1_7  0 PWL (0n 0.0v 4.745n 0.0v 4.755n 1.0v 9.745n 1.0v 9.755n 1.0v 14.745n 1.0v 14.755n 1.0v 19.745n 1.0v 19.755n 1.0v 24.745n 1.0v 24.755n 1.0v 29.745n 1.0v 29.755n 1.0v 34.745n 1.0v 34.755n 1.0v 39.745n 1.0v 39.755n 1.0v 44.745n 1.0v 44.755n 1.0v 49.745n 1.0v 49.755n 0.0v 54.745n 0.0v 54.755n 0.0v 59.745n 0.0v 59.755n 0.0v 64.745n 0.0v 64.755n 0.0v 69.745n 0.0v 69.755n 0.0v 74.745n 0.0v 74.755n 0.0v 79.745n 0.0v 79.755n 0.0v 84.745n 0.0v 84.755n 1.0v 89.745n 1.0v 89.755n 1.0v 94.745n 1.0v 94.755n 1.0v 99.745n 1.0v 99.755n 1.0v 104.745n 1.0v 104.755n 1.0v 109.745n 1.0v 109.755n 1.0v 114.745n 1.0v 114.755n 0.0v 119.745n 0.0v 119.755n 0.0v 124.745n 0.0v 124.755n 1.0v 129.745n 1.0v 129.755n 1.0v 134.745n 1.0v 134.755n 1.0v 139.745n 1.0v 139.755n 1.0v 144.745n 1.0v 144.755n 1.0v 149.745n 1.0v 149.755n 1.0v 154.745n 1.0v 154.755n 1.0v 159.745n 1.0v 159.755n 1.0v 164.745n 1.0v 164.755n 1.0v 169.745n 1.0v 169.755n 1.0v 174.745n 1.0v 174.755n 1.0v 179.745n 1.0v 179.755n 1.0v 184.745n 1.0v 184.755n 1.0v 189.745n 1.0v 189.755n 1.0v 194.745n 1.0v 194.755n 1.0v 199.745n 1.0v 199.755n 1.0v 204.745n 1.0v 204.755n 0.0v 209.745n 0.0v 209.755n 0.0v 214.745n 0.0v 214.755n 0.0v 219.745n 0.0v 219.755n 1.0v 224.745n 1.0v 224.755n 1.0v 229.745n 1.0v 229.755n 1.0v 234.745n 1.0v 234.755n 1.0v 239.745n 1.0v 239.755n 1.0v 244.745n 1.0v 244.755n 1.0v 249.745n 1.0v 249.755n 0.0v 254.745n 0.0v 254.755n 0.0v 259.745n 0.0v 259.755n 0.0v 264.745n 0.0v 264.755n 0.0v 269.745n 0.0v 269.755n 0.0v 274.745n 0.0v 274.755n 0.0v 279.745n 0.0v 279.755n 0.0v 284.745n 0.0v 284.755n 0.0v 289.745n 0.0v 289.755n 0.0v 294.745n 0.0v 294.755n 0.0v 299.745n 0.0v 299.755n 0.0v 304.745n 0.0v 304.755n 0.0v 309.745n 0.0v 309.755n 0.0v 314.745n 0.0v 314.755n 0.0v 319.745n 0.0v 319.755n 0.0v 324.745n 0.0v 324.755n 0.0v 329.745n 0.0v 329.755n 0.0v 334.745n 0.0v 334.755n 0.0v 339.745n 0.0v 339.755n 0.0v 344.745n 0.0v 344.755n 0.0v 349.745n 0.0v 349.755n 0.0v 354.745n 0.0v 354.755n 0.0v 359.745n 0.0v 359.755n 1.0v 364.745n 1.0v 364.755n 1.0v 369.745n 1.0v 369.755n 1.0v 374.745n 1.0v 374.755n 1.0v 379.745n 1.0v 379.755n 1.0v 384.745n 1.0v 384.755n 1.0v 389.745n 1.0v 389.755n 1.0v 394.745n 1.0v 394.755n 1.0v 399.745n 1.0v 399.755n 1.0v 404.745n 1.0v 404.755n 1.0v 409.745n 1.0v 409.755n 1.0v 414.745n 1.0v 414.755n 1.0v 419.745n 1.0v 419.755n 1.0v 424.745n 1.0v 424.755n 1.0v 429.745n 1.0v 429.755n 1.0v 434.745n 1.0v 434.755n 1.0v 439.745n 1.0v 439.755n 0.0v 444.745n 0.0v 444.755n 0.0v 449.745n 0.0v 449.755n 0.0v 454.745n 0.0v 454.755n 0.0v 459.745n 0.0v 459.755n 0.0v 464.745n 0.0v 464.755n 0.0v 469.745n 0.0v 469.755n 0.0v 474.745n 0.0v 474.755n 0.0v 479.745n 0.0v 479.755n 0.0v 484.745n 0.0v 484.755n 0.0v 489.745n 0.0v 489.755n 0.0v 494.745n 0.0v 494.755n 0.0v 499.745n 0.0v 499.755n 0.0v 504.745n 0.0v 504.755n 0.0v 509.745n 0.0v 509.755n 0.0v 514.745n 0.0v 514.755n 0.0v 519.745n 0.0v 519.755n 0.0v 524.745n 0.0v 524.755n 0.0v 529.745n 0.0v 529.755n 0.0v 534.745n 0.0v 534.755n 0.0v 539.745n 0.0v 539.755n 1.0v 544.745n 1.0v 544.755n 1.0v 549.745n 1.0v 549.755n 1.0v 554.745n 1.0v 554.755n 1.0v 559.745n 1.0v 559.755n 1.0v 564.745n 1.0v 564.755n 1.0v 569.745n 1.0v 569.755n 1.0v 574.745n 1.0v 574.755n 1.0v 579.745n 1.0v 579.755n 1.0v 584.745n 1.0v 584.755n 1.0v 589.745n 1.0v 589.755n 1.0v 594.745n 1.0v 594.755n 1.0v 599.745n 1.0v 599.755n 1.0v 604.745n 1.0v 604.755n 1.0v 609.745n 1.0v 609.755n 1.0v 614.745n 1.0v 614.755n 1.0v 619.745n 1.0v 619.755n 1.0v 624.745n 1.0v 624.755n 1.0v 629.745n 1.0v 629.755n 1.0v 634.745n 1.0v 634.755n 1.0v 639.745n 1.0v 639.755n 1.0v 644.745n 1.0v 644.755n 1.0v 649.745n 1.0v 649.755n 1.0v 654.745n 1.0v 654.755n 1.0v 659.745n 1.0v 659.755n 1.0v 664.745n 1.0v 664.755n 1.0v 669.745n 1.0v 669.755n 1.0v 674.745n 1.0v 674.755n 1.0v 679.745n 1.0v 679.755n 1.0v 684.745n 1.0v 684.755n 1.0v 689.745n 1.0v 689.755n 1.0v 694.745n 1.0v 694.755n 1.0v 699.745n 1.0v 699.755n 1.0v 704.745n 1.0v 704.755n 1.0v 709.745n 1.0v 709.755n 1.0v 714.745n 1.0v 714.755n 1.0v 719.745n 1.0v 719.755n 1.0v 724.745n 1.0v 724.755n 1.0v 729.745n 1.0v 729.755n 1.0v 734.745n 1.0v 734.755n 1.0v 739.745n 1.0v 739.755n 1.0v 744.745n 1.0v 744.755n 1.0v 749.745n 1.0v 749.755n 1.0v 754.745n 1.0v 754.755n 1.0v 759.745n 1.0v 759.755n 1.0v 764.745n 1.0v 764.755n 1.0v 769.745n 1.0v 769.755n 1.0v 774.745n 1.0v 774.755n 1.0v 779.745n 1.0v 779.755n 1.0v 784.745n 1.0v 784.755n 1.0v 789.745n 1.0v 789.755n 1.0v 794.745n 1.0v 794.755n 1.0v 799.745n 1.0v 799.755n 1.0v 804.745n 1.0v 804.755n 1.0v 809.745n 1.0v 809.755n 1.0v 814.745n 1.0v 814.755n 1.0v 819.745n 1.0v 819.755n 1.0v 824.745n 1.0v 824.755n 1.0v 829.745n 1.0v 829.755n 1.0v 834.745n 1.0v 834.755n 1.0v 839.745n 1.0v 839.755n 1.0v 844.745n 1.0v 844.755n 1.0v 849.745n 1.0v 849.755n 1.0v 854.745n 1.0v 854.755n 1.0v 859.745n 1.0v 859.755n 1.0v 864.745n 1.0v 864.755n 1.0v 869.745n 1.0v 869.755n 1.0v 874.745n 1.0v 874.755n 1.0v 879.745n 1.0v 879.755n 1.0v 884.745n 1.0v 884.755n 1.0v 889.745n 1.0v 889.755n 1.0v 894.745n 1.0v 894.755n 1.0v 899.745n 1.0v 899.755n 1.0v 904.745n 1.0v 904.755n 1.0v 909.745n 1.0v 909.755n 0.0v 914.745n 0.0v 914.755n 0.0v 919.745n 0.0v 919.755n 0.0v 924.745n 0.0v 924.755n 0.0v 929.745n 0.0v 929.755n 1.0v 934.745n 1.0v 934.755n 1.0v 939.745n 1.0v 939.755n 1.0v 944.745n 1.0v 944.755n 1.0v 949.745n 1.0v 949.755n 0.0v 954.745n 0.0v 954.755n 0.0v 959.745n 0.0v 959.755n 0.0v 964.745n 0.0v 964.755n 0.0v 969.745n 0.0v 969.755n 0.0v 974.745n 0.0v 974.755n 0.0v 979.745n 0.0v 979.755n 0.0v 984.745n 0.0v 984.755n 0.0v 989.745n 0.0v 989.755n 0.0v 994.745n 0.0v 994.755n 0.0v 999.745n 0.0v 999.755n 0.0v 1004.745n 0.0v 1004.755n 1.0v 1009.745n 1.0v 1009.755n 1.0v 1014.745n 1.0v 1014.755n 1.0v 1019.745n 1.0v 1019.755n 1.0v 1024.745n 1.0v 1024.755n 1.0v )
* (time, data): [(0, 0), (5, 0), (10, 0), (15, 1), (20, 1), (25, 1), (30, 1), (35, 0), (40, 0), (45, 0), (50, 0), (55, 0), (60, 0), (65, 0), (70, 0), (75, 0), (80, 0), (85, 1), (90, 1), (95, 1), (100, 1), (105, 1), (110, 1), (115, 1), (120, 1), (125, 0), (130, 0), (135, 0), (140, 0), (145, 0), (150, 1), (155, 1), (160, 1), (165, 0), (170, 0), (175, 0), (180, 0), (185, 0), (190, 0), (195, 0), (200, 0), (205, 0), (210, 0), (215, 0), (220, 1), (225, 1), (230, 1), (235, 1), (240, 0), (245, 0), (250, 1), (255, 1), (260, 0), (265, 0), (270, 0), (275, 1), (280, 1), (285, 1), (290, 1), (295, 1), (300, 1), (305, 1), (310, 1), (315, 1), (320, 1), (325, 1), (330, 1), (335, 1), (340, 1), (345, 1), (350, 0), (355, 0), (360, 0), (365, 0), (370, 0), (375, 0), (380, 0), (385, 0), (390, 0), (395, 0), (400, 0), (405, 1), (410, 1), (415, 1), (420, 1), (425, 1), (430, 1), (435, 1), (440, 1), (445, 1), (450, 1), (455, 1), (460, 1), (465, 1), (470, 1), (475, 1), (480, 1), (485, 1), (490, 1), (495, 1), (500, 0), (505, 0), (510, 0), (515, 0), (520, 0), (525, 0), (530, 0), (535, 0), (540, 0), (545, 0), (550, 0), (555, 0), (560, 0), (565, 0), (570, 0), (575, 0), (580, 0), (585, 0), (590, 0), (595, 0), (600, 0), (605, 0), (610, 0), (615, 0), (620, 0), (625, 0), (630, 0), (635, 0), (640, 0), (645, 0), (650, 0), (655, 0), (660, 0), (665, 0), (670, 0), (675, 0), (680, 0), (685, 0), (690, 0), (695, 0), (700, 0), (705, 0), (710, 1), (715, 1), (720, 1), (725, 1), (730, 1), (735, 1), (740, 1), (745, 1), (750, 1), (755, 1), (760, 0), (765, 0), (770, 0), (775, 0), (780, 1), (785, 1), (790, 1), (795, 1), (800, 1), (805, 1), (810, 0), (815, 0), (820, 0), (825, 0), (830, 0), (835, 0), (840, 0), (845, 0), (850, 0), (855, 0), (860, 0), (865, 0), (870, 0), (875, 0), (880, 1), (885, 1), (890, 1), (895, 1), (900, 1), (905, 1), (910, 0), (915, 0), (920, 1), (925, 1), (930, 0), (935, 1), (940, 1), (945, 1), (950, 0), (955, 0), (960, 0), (965, 0), (970, 0), (975, 0), (980, 0), (985, 1), (990, 1), (995, 1), (1000, 1), (1005, 0), (1010, 0), (1015, 0), (1020, 0), (1025, 0)]
Vdin1_8  din1_8  0 PWL (0n 0.0v 4.745n 0.0v 4.755n 0.0v 9.745n 0.0v 9.755n 0.0v 14.745n 0.0v 14.755n 1.0v 19.745n 1.0v 19.755n 1.0v 24.745n 1.0v 24.755n 1.0v 29.745n 1.0v 29.755n 1.0v 34.745n 1.0v 34.755n 0.0v 39.745n 0.0v 39.755n 0.0v 44.745n 0.0v 44.755n 0.0v 49.745n 0.0v 49.755n 0.0v 54.745n 0.0v 54.755n 0.0v 59.745n 0.0v 59.755n 0.0v 64.745n 0.0v 64.755n 0.0v 69.745n 0.0v 69.755n 0.0v 74.745n 0.0v 74.755n 0.0v 79.745n 0.0v 79.755n 0.0v 84.745n 0.0v 84.755n 1.0v 89.745n 1.0v 89.755n 1.0v 94.745n 1.0v 94.755n 1.0v 99.745n 1.0v 99.755n 1.0v 104.745n 1.0v 104.755n 1.0v 109.745n 1.0v 109.755n 1.0v 114.745n 1.0v 114.755n 1.0v 119.745n 1.0v 119.755n 1.0v 124.745n 1.0v 124.755n 0.0v 129.745n 0.0v 129.755n 0.0v 134.745n 0.0v 134.755n 0.0v 139.745n 0.0v 139.755n 0.0v 144.745n 0.0v 144.755n 0.0v 149.745n 0.0v 149.755n 1.0v 154.745n 1.0v 154.755n 1.0v 159.745n 1.0v 159.755n 1.0v 164.745n 1.0v 164.755n 0.0v 169.745n 0.0v 169.755n 0.0v 174.745n 0.0v 174.755n 0.0v 179.745n 0.0v 179.755n 0.0v 184.745n 0.0v 184.755n 0.0v 189.745n 0.0v 189.755n 0.0v 194.745n 0.0v 194.755n 0.0v 199.745n 0.0v 199.755n 0.0v 204.745n 0.0v 204.755n 0.0v 209.745n 0.0v 209.755n 0.0v 214.745n 0.0v 214.755n 0.0v 219.745n 0.0v 219.755n 1.0v 224.745n 1.0v 224.755n 1.0v 229.745n 1.0v 229.755n 1.0v 234.745n 1.0v 234.755n 1.0v 239.745n 1.0v 239.755n 0.0v 244.745n 0.0v 244.755n 0.0v 249.745n 0.0v 249.755n 1.0v 254.745n 1.0v 254.755n 1.0v 259.745n 1.0v 259.755n 0.0v 264.745n 0.0v 264.755n 0.0v 269.745n 0.0v 269.755n 0.0v 274.745n 0.0v 274.755n 1.0v 279.745n 1.0v 279.755n 1.0v 284.745n 1.0v 284.755n 1.0v 289.745n 1.0v 289.755n 1.0v 294.745n 1.0v 294.755n 1.0v 299.745n 1.0v 299.755n 1.0v 304.745n 1.0v 304.755n 1.0v 309.745n 1.0v 309.755n 1.0v 314.745n 1.0v 314.755n 1.0v 319.745n 1.0v 319.755n 1.0v 324.745n 1.0v 324.755n 1.0v 329.745n 1.0v 329.755n 1.0v 334.745n 1.0v 334.755n 1.0v 339.745n 1.0v 339.755n 1.0v 344.745n 1.0v 344.755n 1.0v 349.745n 1.0v 349.755n 0.0v 354.745n 0.0v 354.755n 0.0v 359.745n 0.0v 359.755n 0.0v 364.745n 0.0v 364.755n 0.0v 369.745n 0.0v 369.755n 0.0v 374.745n 0.0v 374.755n 0.0v 379.745n 0.0v 379.755n 0.0v 384.745n 0.0v 384.755n 0.0v 389.745n 0.0v 389.755n 0.0v 394.745n 0.0v 394.755n 0.0v 399.745n 0.0v 399.755n 0.0v 404.745n 0.0v 404.755n 1.0v 409.745n 1.0v 409.755n 1.0v 414.745n 1.0v 414.755n 1.0v 419.745n 1.0v 419.755n 1.0v 424.745n 1.0v 424.755n 1.0v 429.745n 1.0v 429.755n 1.0v 434.745n 1.0v 434.755n 1.0v 439.745n 1.0v 439.755n 1.0v 444.745n 1.0v 444.755n 1.0v 449.745n 1.0v 449.755n 1.0v 454.745n 1.0v 454.755n 1.0v 459.745n 1.0v 459.755n 1.0v 464.745n 1.0v 464.755n 1.0v 469.745n 1.0v 469.755n 1.0v 474.745n 1.0v 474.755n 1.0v 479.745n 1.0v 479.755n 1.0v 484.745n 1.0v 484.755n 1.0v 489.745n 1.0v 489.755n 1.0v 494.745n 1.0v 494.755n 1.0v 499.745n 1.0v 499.755n 0.0v 504.745n 0.0v 504.755n 0.0v 509.745n 0.0v 509.755n 0.0v 514.745n 0.0v 514.755n 0.0v 519.745n 0.0v 519.755n 0.0v 524.745n 0.0v 524.755n 0.0v 529.745n 0.0v 529.755n 0.0v 534.745n 0.0v 534.755n 0.0v 539.745n 0.0v 539.755n 0.0v 544.745n 0.0v 544.755n 0.0v 549.745n 0.0v 549.755n 0.0v 554.745n 0.0v 554.755n 0.0v 559.745n 0.0v 559.755n 0.0v 564.745n 0.0v 564.755n 0.0v 569.745n 0.0v 569.755n 0.0v 574.745n 0.0v 574.755n 0.0v 579.745n 0.0v 579.755n 0.0v 584.745n 0.0v 584.755n 0.0v 589.745n 0.0v 589.755n 0.0v 594.745n 0.0v 594.755n 0.0v 599.745n 0.0v 599.755n 0.0v 604.745n 0.0v 604.755n 0.0v 609.745n 0.0v 609.755n 0.0v 614.745n 0.0v 614.755n 0.0v 619.745n 0.0v 619.755n 0.0v 624.745n 0.0v 624.755n 0.0v 629.745n 0.0v 629.755n 0.0v 634.745n 0.0v 634.755n 0.0v 639.745n 0.0v 639.755n 0.0v 644.745n 0.0v 644.755n 0.0v 649.745n 0.0v 649.755n 0.0v 654.745n 0.0v 654.755n 0.0v 659.745n 0.0v 659.755n 0.0v 664.745n 0.0v 664.755n 0.0v 669.745n 0.0v 669.755n 0.0v 674.745n 0.0v 674.755n 0.0v 679.745n 0.0v 679.755n 0.0v 684.745n 0.0v 684.755n 0.0v 689.745n 0.0v 689.755n 0.0v 694.745n 0.0v 694.755n 0.0v 699.745n 0.0v 699.755n 0.0v 704.745n 0.0v 704.755n 0.0v 709.745n 0.0v 709.755n 1.0v 714.745n 1.0v 714.755n 1.0v 719.745n 1.0v 719.755n 1.0v 724.745n 1.0v 724.755n 1.0v 729.745n 1.0v 729.755n 1.0v 734.745n 1.0v 734.755n 1.0v 739.745n 1.0v 739.755n 1.0v 744.745n 1.0v 744.755n 1.0v 749.745n 1.0v 749.755n 1.0v 754.745n 1.0v 754.755n 1.0v 759.745n 1.0v 759.755n 0.0v 764.745n 0.0v 764.755n 0.0v 769.745n 0.0v 769.755n 0.0v 774.745n 0.0v 774.755n 0.0v 779.745n 0.0v 779.755n 1.0v 784.745n 1.0v 784.755n 1.0v 789.745n 1.0v 789.755n 1.0v 794.745n 1.0v 794.755n 1.0v 799.745n 1.0v 799.755n 1.0v 804.745n 1.0v 804.755n 1.0v 809.745n 1.0v 809.755n 0.0v 814.745n 0.0v 814.755n 0.0v 819.745n 0.0v 819.755n 0.0v 824.745n 0.0v 824.755n 0.0v 829.745n 0.0v 829.755n 0.0v 834.745n 0.0v 834.755n 0.0v 839.745n 0.0v 839.755n 0.0v 844.745n 0.0v 844.755n 0.0v 849.745n 0.0v 849.755n 0.0v 854.745n 0.0v 854.755n 0.0v 859.745n 0.0v 859.755n 0.0v 864.745n 0.0v 864.755n 0.0v 869.745n 0.0v 869.755n 0.0v 874.745n 0.0v 874.755n 0.0v 879.745n 0.0v 879.755n 1.0v 884.745n 1.0v 884.755n 1.0v 889.745n 1.0v 889.755n 1.0v 894.745n 1.0v 894.755n 1.0v 899.745n 1.0v 899.755n 1.0v 904.745n 1.0v 904.755n 1.0v 909.745n 1.0v 909.755n 0.0v 914.745n 0.0v 914.755n 0.0v 919.745n 0.0v 919.755n 1.0v 924.745n 1.0v 924.755n 1.0v 929.745n 1.0v 929.755n 0.0v 934.745n 0.0v 934.755n 1.0v 939.745n 1.0v 939.755n 1.0v 944.745n 1.0v 944.755n 1.0v 949.745n 1.0v 949.755n 0.0v 954.745n 0.0v 954.755n 0.0v 959.745n 0.0v 959.755n 0.0v 964.745n 0.0v 964.755n 0.0v 969.745n 0.0v 969.755n 0.0v 974.745n 0.0v 974.755n 0.0v 979.745n 0.0v 979.755n 0.0v 984.745n 0.0v 984.755n 1.0v 989.745n 1.0v 989.755n 1.0v 994.745n 1.0v 994.755n 1.0v 999.745n 1.0v 999.755n 1.0v 1004.745n 1.0v 1004.755n 0.0v 1009.745n 0.0v 1009.755n 0.0v 1014.745n 0.0v 1014.755n 0.0v 1019.745n 0.0v 1019.755n 0.0v 1024.745n 0.0v 1024.755n 0.0v )
* (time, data): [(0, 0), (5, 1), (10, 0), (15, 0), (20, 0), (25, 0), (30, 0), (35, 1), (40, 1), (45, 1), (50, 0), (55, 0), (60, 0), (65, 0), (70, 0), (75, 0), (80, 0), (85, 1), (90, 1), (95, 1), (100, 0), (105, 0), (110, 0), (115, 1), (120, 1), (125, 1), (130, 1), (135, 1), (140, 1), (145, 1), (150, 1), (155, 1), (160, 1), (165, 1), (170, 1), (175, 1), (180, 1), (185, 1), (190, 1), (195, 1), (200, 1), (205, 1), (210, 1), (215, 1), (220, 0), (225, 0), (230, 0), (235, 0), (240, 0), (245, 0), (250, 1), (255, 1), (260, 1), (265, 1), (270, 1), (275, 1), (280, 1), (285, 1), (290, 1), (295, 1), (300, 1), (305, 1), (310, 0), (315, 0), (320, 0), (325, 0), (330, 0), (335, 0), (340, 0), (345, 0), (350, 1), (355, 1), (360, 1), (365, 1), (370, 1), (375, 1), (380, 1), (385, 1), (390, 1), (395, 1), (400, 0), (405, 1), (410, 1), (415, 1), (420, 1), (425, 1), (430, 1), (435, 1), (440, 1), (445, 1), (450, 1), (455, 1), (460, 1), (465, 1), (470, 1), (475, 1), (480, 1), (485, 1), (490, 1), (495, 1), (500, 1), (505, 1), (510, 1), (515, 1), (520, 1), (525, 1), (530, 1), (535, 0), (540, 1), (545, 1), (550, 1), (555, 1), (560, 1), (565, 1), (570, 1), (575, 1), (580, 1), (585, 1), (590, 1), (595, 1), (600, 1), (605, 1), (610, 1), (615, 1), (620, 1), (625, 1), (630, 1), (635, 1), (640, 1), (645, 1), (650, 1), (655, 1), (660, 1), (665, 1), (670, 1), (675, 1), (680, 1), (685, 1), (690, 1), (695, 1), (700, 1), (705, 1), (710, 0), (715, 0), (720, 0), (725, 0), (730, 0), (735, 0), (740, 0), (745, 0), (750, 0), (755, 0), (760, 0), (765, 0), (770, 0), (775, 0), (780, 0), (785, 0), (790, 0), (795, 0), (800, 0), (805, 0), (810, 1), (815, 1), (820, 1), (825, 1), (830, 1), (835, 1), (840, 1), (845, 1), (850, 1), (855, 1), (860, 1), (865, 1), (870, 1), (875, 1), (880, 0), (885, 0), (890, 0), (895, 0), (900, 0), (905, 0), (910, 1), (915, 1), (920, 1), (925, 1), (930, 0), (935, 0), (940, 0), (945, 0), (950, 0), (955, 0), (960, 0), (965, 0), (970, 0), (975, 0), (980, 0), (985, 0), (990, 0), (995, 0), (1000, 0), (1005, 1), (1010, 1), (1015, 1), (1020, 1), (1025, 1)]
Vdin1_9  din1_9  0 PWL (0n 0.0v 4.745n 0.0v 4.755n 1.0v 9.745n 1.0v 9.755n 0.0v 14.745n 0.0v 14.755n 0.0v 19.745n 0.0v 19.755n 0.0v 24.745n 0.0v 24.755n 0.0v 29.745n 0.0v 29.755n 0.0v 34.745n 0.0v 34.755n 1.0v 39.745n 1.0v 39.755n 1.0v 44.745n 1.0v 44.755n 1.0v 49.745n 1.0v 49.755n 0.0v 54.745n 0.0v 54.755n 0.0v 59.745n 0.0v 59.755n 0.0v 64.745n 0.0v 64.755n 0.0v 69.745n 0.0v 69.755n 0.0v 74.745n 0.0v 74.755n 0.0v 79.745n 0.0v 79.755n 0.0v 84.745n 0.0v 84.755n 1.0v 89.745n 1.0v 89.755n 1.0v 94.745n 1.0v 94.755n 1.0v 99.745n 1.0v 99.755n 0.0v 104.745n 0.0v 104.755n 0.0v 109.745n 0.0v 109.755n 0.0v 114.745n 0.0v 114.755n 1.0v 119.745n 1.0v 119.755n 1.0v 124.745n 1.0v 124.755n 1.0v 129.745n 1.0v 129.755n 1.0v 134.745n 1.0v 134.755n 1.0v 139.745n 1.0v 139.755n 1.0v 144.745n 1.0v 144.755n 1.0v 149.745n 1.0v 149.755n 1.0v 154.745n 1.0v 154.755n 1.0v 159.745n 1.0v 159.755n 1.0v 164.745n 1.0v 164.755n 1.0v 169.745n 1.0v 169.755n 1.0v 174.745n 1.0v 174.755n 1.0v 179.745n 1.0v 179.755n 1.0v 184.745n 1.0v 184.755n 1.0v 189.745n 1.0v 189.755n 1.0v 194.745n 1.0v 194.755n 1.0v 199.745n 1.0v 199.755n 1.0v 204.745n 1.0v 204.755n 1.0v 209.745n 1.0v 209.755n 1.0v 214.745n 1.0v 214.755n 1.0v 219.745n 1.0v 219.755n 0.0v 224.745n 0.0v 224.755n 0.0v 229.745n 0.0v 229.755n 0.0v 234.745n 0.0v 234.755n 0.0v 239.745n 0.0v 239.755n 0.0v 244.745n 0.0v 244.755n 0.0v 249.745n 0.0v 249.755n 1.0v 254.745n 1.0v 254.755n 1.0v 259.745n 1.0v 259.755n 1.0v 264.745n 1.0v 264.755n 1.0v 269.745n 1.0v 269.755n 1.0v 274.745n 1.0v 274.755n 1.0v 279.745n 1.0v 279.755n 1.0v 284.745n 1.0v 284.755n 1.0v 289.745n 1.0v 289.755n 1.0v 294.745n 1.0v 294.755n 1.0v 299.745n 1.0v 299.755n 1.0v 304.745n 1.0v 304.755n 1.0v 309.745n 1.0v 309.755n 0.0v 314.745n 0.0v 314.755n 0.0v 319.745n 0.0v 319.755n 0.0v 324.745n 0.0v 324.755n 0.0v 329.745n 0.0v 329.755n 0.0v 334.745n 0.0v 334.755n 0.0v 339.745n 0.0v 339.755n 0.0v 344.745n 0.0v 344.755n 0.0v 349.745n 0.0v 349.755n 1.0v 354.745n 1.0v 354.755n 1.0v 359.745n 1.0v 359.755n 1.0v 364.745n 1.0v 364.755n 1.0v 369.745n 1.0v 369.755n 1.0v 374.745n 1.0v 374.755n 1.0v 379.745n 1.0v 379.755n 1.0v 384.745n 1.0v 384.755n 1.0v 389.745n 1.0v 389.755n 1.0v 394.745n 1.0v 394.755n 1.0v 399.745n 1.0v 399.755n 0.0v 404.745n 0.0v 404.755n 1.0v 409.745n 1.0v 409.755n 1.0v 414.745n 1.0v 414.755n 1.0v 419.745n 1.0v 419.755n 1.0v 424.745n 1.0v 424.755n 1.0v 429.745n 1.0v 429.755n 1.0v 434.745n 1.0v 434.755n 1.0v 439.745n 1.0v 439.755n 1.0v 444.745n 1.0v 444.755n 1.0v 449.745n 1.0v 449.755n 1.0v 454.745n 1.0v 454.755n 1.0v 459.745n 1.0v 459.755n 1.0v 464.745n 1.0v 464.755n 1.0v 469.745n 1.0v 469.755n 1.0v 474.745n 1.0v 474.755n 1.0v 479.745n 1.0v 479.755n 1.0v 484.745n 1.0v 484.755n 1.0v 489.745n 1.0v 489.755n 1.0v 494.745n 1.0v 494.755n 1.0v 499.745n 1.0v 499.755n 1.0v 504.745n 1.0v 504.755n 1.0v 509.745n 1.0v 509.755n 1.0v 514.745n 1.0v 514.755n 1.0v 519.745n 1.0v 519.755n 1.0v 524.745n 1.0v 524.755n 1.0v 529.745n 1.0v 529.755n 1.0v 534.745n 1.0v 534.755n 0.0v 539.745n 0.0v 539.755n 1.0v 544.745n 1.0v 544.755n 1.0v 549.745n 1.0v 549.755n 1.0v 554.745n 1.0v 554.755n 1.0v 559.745n 1.0v 559.755n 1.0v 564.745n 1.0v 564.755n 1.0v 569.745n 1.0v 569.755n 1.0v 574.745n 1.0v 574.755n 1.0v 579.745n 1.0v 579.755n 1.0v 584.745n 1.0v 584.755n 1.0v 589.745n 1.0v 589.755n 1.0v 594.745n 1.0v 594.755n 1.0v 599.745n 1.0v 599.755n 1.0v 604.745n 1.0v 604.755n 1.0v 609.745n 1.0v 609.755n 1.0v 614.745n 1.0v 614.755n 1.0v 619.745n 1.0v 619.755n 1.0v 624.745n 1.0v 624.755n 1.0v 629.745n 1.0v 629.755n 1.0v 634.745n 1.0v 634.755n 1.0v 639.745n 1.0v 639.755n 1.0v 644.745n 1.0v 644.755n 1.0v 649.745n 1.0v 649.755n 1.0v 654.745n 1.0v 654.755n 1.0v 659.745n 1.0v 659.755n 1.0v 664.745n 1.0v 664.755n 1.0v 669.745n 1.0v 669.755n 1.0v 674.745n 1.0v 674.755n 1.0v 679.745n 1.0v 679.755n 1.0v 684.745n 1.0v 684.755n 1.0v 689.745n 1.0v 689.755n 1.0v 694.745n 1.0v 694.755n 1.0v 699.745n 1.0v 699.755n 1.0v 704.745n 1.0v 704.755n 1.0v 709.745n 1.0v 709.755n 0.0v 714.745n 0.0v 714.755n 0.0v 719.745n 0.0v 719.755n 0.0v 724.745n 0.0v 724.755n 0.0v 729.745n 0.0v 729.755n 0.0v 734.745n 0.0v 734.755n 0.0v 739.745n 0.0v 739.755n 0.0v 744.745n 0.0v 744.755n 0.0v 749.745n 0.0v 749.755n 0.0v 754.745n 0.0v 754.755n 0.0v 759.745n 0.0v 759.755n 0.0v 764.745n 0.0v 764.755n 0.0v 769.745n 0.0v 769.755n 0.0v 774.745n 0.0v 774.755n 0.0v 779.745n 0.0v 779.755n 0.0v 784.745n 0.0v 784.755n 0.0v 789.745n 0.0v 789.755n 0.0v 794.745n 0.0v 794.755n 0.0v 799.745n 0.0v 799.755n 0.0v 804.745n 0.0v 804.755n 0.0v 809.745n 0.0v 809.755n 1.0v 814.745n 1.0v 814.755n 1.0v 819.745n 1.0v 819.755n 1.0v 824.745n 1.0v 824.755n 1.0v 829.745n 1.0v 829.755n 1.0v 834.745n 1.0v 834.755n 1.0v 839.745n 1.0v 839.755n 1.0v 844.745n 1.0v 844.755n 1.0v 849.745n 1.0v 849.755n 1.0v 854.745n 1.0v 854.755n 1.0v 859.745n 1.0v 859.755n 1.0v 864.745n 1.0v 864.755n 1.0v 869.745n 1.0v 869.755n 1.0v 874.745n 1.0v 874.755n 1.0v 879.745n 1.0v 879.755n 0.0v 884.745n 0.0v 884.755n 0.0v 889.745n 0.0v 889.755n 0.0v 894.745n 0.0v 894.755n 0.0v 899.745n 0.0v 899.755n 0.0v 904.745n 0.0v 904.755n 0.0v 909.745n 0.0v 909.755n 1.0v 914.745n 1.0v 914.755n 1.0v 919.745n 1.0v 919.755n 1.0v 924.745n 1.0v 924.755n 1.0v 929.745n 1.0v 929.755n 0.0v 934.745n 0.0v 934.755n 0.0v 939.745n 0.0v 939.755n 0.0v 944.745n 0.0v 944.755n 0.0v 949.745n 0.0v 949.755n 0.0v 954.745n 0.0v 954.755n 0.0v 959.745n 0.0v 959.755n 0.0v 964.745n 0.0v 964.755n 0.0v 969.745n 0.0v 969.755n 0.0v 974.745n 0.0v 974.755n 0.0v 979.745n 0.0v 979.755n 0.0v 984.745n 0.0v 984.755n 0.0v 989.745n 0.0v 989.755n 0.0v 994.745n 0.0v 994.755n 0.0v 999.745n 0.0v 999.755n 0.0v 1004.745n 0.0v 1004.755n 1.0v 1009.745n 1.0v 1009.755n 1.0v 1014.745n 1.0v 1014.755n 1.0v 1019.745n 1.0v 1019.755n 1.0v 1024.745n 1.0v 1024.755n 1.0v )
* (time, data): [(0, 0), (5, 0), (10, 1), (15, 1), (20, 1), (25, 1), (30, 1), (35, 0), (40, 0), (45, 0), (50, 0), (55, 0), (60, 0), (65, 0), (70, 0), (75, 0), (80, 0), (85, 1), (90, 1), (95, 1), (100, 1), (105, 1), (110, 1), (115, 0), (120, 0), (125, 0), (130, 0), (135, 0), (140, 0), (145, 0), (150, 1), (155, 1), (160, 1), (165, 0), (170, 0), (175, 0), (180, 0), (185, 0), (190, 0), (195, 0), (200, 0), (205, 1), (210, 1), (215, 1), (220, 1), (225, 1), (230, 1), (235, 1), (240, 1), (245, 1), (250, 1), (255, 1), (260, 0), (265, 0), (270, 0), (275, 1), (280, 1), (285, 1), (290, 1), (295, 1), (300, 1), (305, 1), (310, 0), (315, 0), (320, 0), (325, 0), (330, 0), (335, 0), (340, 0), (345, 0), (350, 0), (355, 0), (360, 0), (365, 0), (370, 0), (375, 0), (380, 0), (385, 0), (390, 0), (395, 0), (400, 0), (405, 0), (410, 0), (415, 0), (420, 0), (425, 0), (430, 0), (435, 0), (440, 1), (445, 1), (450, 1), (455, 1), (460, 1), (465, 1), (470, 1), (475, 1), (480, 1), (485, 1), (490, 1), (495, 1), (500, 0), (505, 0), (510, 0), (515, 0), (520, 0), (525, 0), (530, 0), (535, 1), (540, 0), (545, 0), (550, 0), (555, 0), (560, 0), (565, 0), (570, 0), (575, 0), (580, 0), (585, 0), (590, 0), (595, 0), (600, 0), (605, 0), (610, 0), (615, 0), (620, 0), (625, 0), (630, 0), (635, 0), (640, 0), (645, 0), (650, 0), (655, 0), (660, 0), (665, 0), (670, 0), (675, 0), (680, 0), (685, 0), (690, 0), (695, 0), (700, 0), (705, 0), (710, 0), (715, 0), (720, 0), (725, 0), (730, 0), (735, 0), (740, 0), (745, 0), (750, 0), (755, 0), (760, 1), (765, 1), (770, 1), (775, 1), (780, 0), (785, 0), (790, 0), (795, 0), (800, 0), (805, 0), (810, 0), (815, 0), (820, 0), (825, 0), (830, 0), (835, 0), (840, 0), (845, 0), (850, 0), (855, 0), (860, 1), (865, 1), (870, 1), (875, 1), (880, 1), (885, 1), (890, 1), (895, 1), (900, 1), (905, 1), (910, 1), (915, 1), (920, 1), (925, 1), (930, 1), (935, 0), (940, 0), (945, 0), (950, 1), (955, 1), (960, 1), (965, 1), (970, 1), (975, 1), (980, 1), (985, 1), (990, 1), (995, 1), (1000, 1), (1005, 0), (1010, 0), (1015, 0), (1020, 0), (1025, 0)]
Vdin1_10  din1_10  0 PWL (0n 0.0v 4.745n 0.0v 4.755n 0.0v 9.745n 0.0v 9.755n 1.0v 14.745n 1.0v 14.755n 1.0v 19.745n 1.0v 19.755n 1.0v 24.745n 1.0v 24.755n 1.0v 29.745n 1.0v 29.755n 1.0v 34.745n 1.0v 34.755n 0.0v 39.745n 0.0v 39.755n 0.0v 44.745n 0.0v 44.755n 0.0v 49.745n 0.0v 49.755n 0.0v 54.745n 0.0v 54.755n 0.0v 59.745n 0.0v 59.755n 0.0v 64.745n 0.0v 64.755n 0.0v 69.745n 0.0v 69.755n 0.0v 74.745n 0.0v 74.755n 0.0v 79.745n 0.0v 79.755n 0.0v 84.745n 0.0v 84.755n 1.0v 89.745n 1.0v 89.755n 1.0v 94.745n 1.0v 94.755n 1.0v 99.745n 1.0v 99.755n 1.0v 104.745n 1.0v 104.755n 1.0v 109.745n 1.0v 109.755n 1.0v 114.745n 1.0v 114.755n 0.0v 119.745n 0.0v 119.755n 0.0v 124.745n 0.0v 124.755n 0.0v 129.745n 0.0v 129.755n 0.0v 134.745n 0.0v 134.755n 0.0v 139.745n 0.0v 139.755n 0.0v 144.745n 0.0v 144.755n 0.0v 149.745n 0.0v 149.755n 1.0v 154.745n 1.0v 154.755n 1.0v 159.745n 1.0v 159.755n 1.0v 164.745n 1.0v 164.755n 0.0v 169.745n 0.0v 169.755n 0.0v 174.745n 0.0v 174.755n 0.0v 179.745n 0.0v 179.755n 0.0v 184.745n 0.0v 184.755n 0.0v 189.745n 0.0v 189.755n 0.0v 194.745n 0.0v 194.755n 0.0v 199.745n 0.0v 199.755n 0.0v 204.745n 0.0v 204.755n 1.0v 209.745n 1.0v 209.755n 1.0v 214.745n 1.0v 214.755n 1.0v 219.745n 1.0v 219.755n 1.0v 224.745n 1.0v 224.755n 1.0v 229.745n 1.0v 229.755n 1.0v 234.745n 1.0v 234.755n 1.0v 239.745n 1.0v 239.755n 1.0v 244.745n 1.0v 244.755n 1.0v 249.745n 1.0v 249.755n 1.0v 254.745n 1.0v 254.755n 1.0v 259.745n 1.0v 259.755n 0.0v 264.745n 0.0v 264.755n 0.0v 269.745n 0.0v 269.755n 0.0v 274.745n 0.0v 274.755n 1.0v 279.745n 1.0v 279.755n 1.0v 284.745n 1.0v 284.755n 1.0v 289.745n 1.0v 289.755n 1.0v 294.745n 1.0v 294.755n 1.0v 299.745n 1.0v 299.755n 1.0v 304.745n 1.0v 304.755n 1.0v 309.745n 1.0v 309.755n 0.0v 314.745n 0.0v 314.755n 0.0v 319.745n 0.0v 319.755n 0.0v 324.745n 0.0v 324.755n 0.0v 329.745n 0.0v 329.755n 0.0v 334.745n 0.0v 334.755n 0.0v 339.745n 0.0v 339.755n 0.0v 344.745n 0.0v 344.755n 0.0v 349.745n 0.0v 349.755n 0.0v 354.745n 0.0v 354.755n 0.0v 359.745n 0.0v 359.755n 0.0v 364.745n 0.0v 364.755n 0.0v 369.745n 0.0v 369.755n 0.0v 374.745n 0.0v 374.755n 0.0v 379.745n 0.0v 379.755n 0.0v 384.745n 0.0v 384.755n 0.0v 389.745n 0.0v 389.755n 0.0v 394.745n 0.0v 394.755n 0.0v 399.745n 0.0v 399.755n 0.0v 404.745n 0.0v 404.755n 0.0v 409.745n 0.0v 409.755n 0.0v 414.745n 0.0v 414.755n 0.0v 419.745n 0.0v 419.755n 0.0v 424.745n 0.0v 424.755n 0.0v 429.745n 0.0v 429.755n 0.0v 434.745n 0.0v 434.755n 0.0v 439.745n 0.0v 439.755n 1.0v 444.745n 1.0v 444.755n 1.0v 449.745n 1.0v 449.755n 1.0v 454.745n 1.0v 454.755n 1.0v 459.745n 1.0v 459.755n 1.0v 464.745n 1.0v 464.755n 1.0v 469.745n 1.0v 469.755n 1.0v 474.745n 1.0v 474.755n 1.0v 479.745n 1.0v 479.755n 1.0v 484.745n 1.0v 484.755n 1.0v 489.745n 1.0v 489.755n 1.0v 494.745n 1.0v 494.755n 1.0v 499.745n 1.0v 499.755n 0.0v 504.745n 0.0v 504.755n 0.0v 509.745n 0.0v 509.755n 0.0v 514.745n 0.0v 514.755n 0.0v 519.745n 0.0v 519.755n 0.0v 524.745n 0.0v 524.755n 0.0v 529.745n 0.0v 529.755n 0.0v 534.745n 0.0v 534.755n 1.0v 539.745n 1.0v 539.755n 0.0v 544.745n 0.0v 544.755n 0.0v 549.745n 0.0v 549.755n 0.0v 554.745n 0.0v 554.755n 0.0v 559.745n 0.0v 559.755n 0.0v 564.745n 0.0v 564.755n 0.0v 569.745n 0.0v 569.755n 0.0v 574.745n 0.0v 574.755n 0.0v 579.745n 0.0v 579.755n 0.0v 584.745n 0.0v 584.755n 0.0v 589.745n 0.0v 589.755n 0.0v 594.745n 0.0v 594.755n 0.0v 599.745n 0.0v 599.755n 0.0v 604.745n 0.0v 604.755n 0.0v 609.745n 0.0v 609.755n 0.0v 614.745n 0.0v 614.755n 0.0v 619.745n 0.0v 619.755n 0.0v 624.745n 0.0v 624.755n 0.0v 629.745n 0.0v 629.755n 0.0v 634.745n 0.0v 634.755n 0.0v 639.745n 0.0v 639.755n 0.0v 644.745n 0.0v 644.755n 0.0v 649.745n 0.0v 649.755n 0.0v 654.745n 0.0v 654.755n 0.0v 659.745n 0.0v 659.755n 0.0v 664.745n 0.0v 664.755n 0.0v 669.745n 0.0v 669.755n 0.0v 674.745n 0.0v 674.755n 0.0v 679.745n 0.0v 679.755n 0.0v 684.745n 0.0v 684.755n 0.0v 689.745n 0.0v 689.755n 0.0v 694.745n 0.0v 694.755n 0.0v 699.745n 0.0v 699.755n 0.0v 704.745n 0.0v 704.755n 0.0v 709.745n 0.0v 709.755n 0.0v 714.745n 0.0v 714.755n 0.0v 719.745n 0.0v 719.755n 0.0v 724.745n 0.0v 724.755n 0.0v 729.745n 0.0v 729.755n 0.0v 734.745n 0.0v 734.755n 0.0v 739.745n 0.0v 739.755n 0.0v 744.745n 0.0v 744.755n 0.0v 749.745n 0.0v 749.755n 0.0v 754.745n 0.0v 754.755n 0.0v 759.745n 0.0v 759.755n 1.0v 764.745n 1.0v 764.755n 1.0v 769.745n 1.0v 769.755n 1.0v 774.745n 1.0v 774.755n 1.0v 779.745n 1.0v 779.755n 0.0v 784.745n 0.0v 784.755n 0.0v 789.745n 0.0v 789.755n 0.0v 794.745n 0.0v 794.755n 0.0v 799.745n 0.0v 799.755n 0.0v 804.745n 0.0v 804.755n 0.0v 809.745n 0.0v 809.755n 0.0v 814.745n 0.0v 814.755n 0.0v 819.745n 0.0v 819.755n 0.0v 824.745n 0.0v 824.755n 0.0v 829.745n 0.0v 829.755n 0.0v 834.745n 0.0v 834.755n 0.0v 839.745n 0.0v 839.755n 0.0v 844.745n 0.0v 844.755n 0.0v 849.745n 0.0v 849.755n 0.0v 854.745n 0.0v 854.755n 0.0v 859.745n 0.0v 859.755n 1.0v 864.745n 1.0v 864.755n 1.0v 869.745n 1.0v 869.755n 1.0v 874.745n 1.0v 874.755n 1.0v 879.745n 1.0v 879.755n 1.0v 884.745n 1.0v 884.755n 1.0v 889.745n 1.0v 889.755n 1.0v 894.745n 1.0v 894.755n 1.0v 899.745n 1.0v 899.755n 1.0v 904.745n 1.0v 904.755n 1.0v 909.745n 1.0v 909.755n 1.0v 914.745n 1.0v 914.755n 1.0v 919.745n 1.0v 919.755n 1.0v 924.745n 1.0v 924.755n 1.0v 929.745n 1.0v 929.755n 1.0v 934.745n 1.0v 934.755n 0.0v 939.745n 0.0v 939.755n 0.0v 944.745n 0.0v 944.755n 0.0v 949.745n 0.0v 949.755n 1.0v 954.745n 1.0v 954.755n 1.0v 959.745n 1.0v 959.755n 1.0v 964.745n 1.0v 964.755n 1.0v 969.745n 1.0v 969.755n 1.0v 974.745n 1.0v 974.755n 1.0v 979.745n 1.0v 979.755n 1.0v 984.745n 1.0v 984.755n 1.0v 989.745n 1.0v 989.755n 1.0v 994.745n 1.0v 994.755n 1.0v 999.745n 1.0v 999.755n 1.0v 1004.745n 1.0v 1004.755n 0.0v 1009.745n 0.0v 1009.755n 0.0v 1014.745n 0.0v 1014.755n 0.0v 1019.745n 0.0v 1019.755n 0.0v 1024.745n 0.0v 1024.755n 0.0v )
* (time, data): [(0, 0), (5, 1), (10, 1), (15, 0), (20, 0), (25, 0), (30, 0), (35, 0), (40, 0), (45, 0), (50, 1), (55, 1), (60, 1), (65, 1), (70, 1), (75, 1), (80, 1), (85, 0), (90, 0), (95, 0), (100, 0), (105, 0), (110, 0), (115, 1), (120, 1), (125, 0), (130, 0), (135, 0), (140, 0), (145, 0), (150, 0), (155, 0), (160, 0), (165, 0), (170, 0), (175, 0), (180, 0), (185, 0), (190, 0), (195, 0), (200, 0), (205, 1), (210, 1), (215, 1), (220, 1), (225, 1), (230, 1), (235, 1), (240, 0), (245, 0), (250, 1), (255, 1), (260, 1), (265, 1), (270, 1), (275, 1), (280, 1), (285, 1), (290, 1), (295, 1), (300, 1), (305, 1), (310, 0), (315, 0), (320, 0), (325, 0), (330, 0), (335, 0), (340, 0), (345, 1), (350, 0), (355, 0), (360, 0), (365, 0), (370, 0), (375, 0), (380, 0), (385, 0), (390, 0), (395, 0), (400, 1), (405, 1), (410, 1), (415, 1), (420, 1), (425, 1), (430, 1), (435, 1), (440, 1), (445, 1), (450, 1), (455, 1), (460, 1), (465, 1), (470, 1), (475, 1), (480, 1), (485, 1), (490, 1), (495, 1), (500, 1), (505, 1), (510, 1), (515, 1), (520, 1), (525, 1), (530, 1), (535, 1), (540, 0), (545, 0), (550, 0), (555, 0), (560, 0), (565, 0), (570, 0), (575, 0), (580, 0), (585, 0), (590, 0), (595, 0), (600, 0), (605, 0), (610, 0), (615, 0), (620, 0), (625, 0), (630, 0), (635, 0), (640, 0), (645, 0), (650, 0), (655, 1), (660, 1), (665, 1), (670, 1), (675, 1), (680, 1), (685, 1), (690, 1), (695, 1), (700, 1), (705, 1), (710, 0), (715, 0), (720, 0), (725, 0), (730, 0), (735, 0), (740, 0), (745, 0), (750, 0), (755, 0), (760, 0), (765, 0), (770, 0), (775, 0), (780, 1), (785, 1), (790, 1), (795, 1), (800, 1), (805, 1), (810, 1), (815, 1), (820, 1), (825, 1), (830, 1), (835, 1), (840, 1), (845, 1), (850, 1), (855, 1), (860, 0), (865, 0), (870, 0), (875, 0), (880, 1), (885, 1), (890, 1), (895, 1), (900, 1), (905, 1), (910, 1), (915, 1), (920, 0), (925, 0), (930, 0), (935, 0), (940, 0), (945, 0), (950, 0), (955, 0), (960, 0), (965, 0), (970, 0), (975, 0), (980, 0), (985, 0), (990, 0), (995, 0), (1000, 0), (1005, 1), (1010, 1), (1015, 1), (1020, 1), (1025, 1)]
Vdin1_11  din1_11  0 PWL (0n 0.0v 4.745n 0.0v 4.755n 1.0v 9.745n 1.0v 9.755n 1.0v 14.745n 1.0v 14.755n 0.0v 19.745n 0.0v 19.755n 0.0v 24.745n 0.0v 24.755n 0.0v 29.745n 0.0v 29.755n 0.0v 34.745n 0.0v 34.755n 0.0v 39.745n 0.0v 39.755n 0.0v 44.745n 0.0v 44.755n 0.0v 49.745n 0.0v 49.755n 1.0v 54.745n 1.0v 54.755n 1.0v 59.745n 1.0v 59.755n 1.0v 64.745n 1.0v 64.755n 1.0v 69.745n 1.0v 69.755n 1.0v 74.745n 1.0v 74.755n 1.0v 79.745n 1.0v 79.755n 1.0v 84.745n 1.0v 84.755n 0.0v 89.745n 0.0v 89.755n 0.0v 94.745n 0.0v 94.755n 0.0v 99.745n 0.0v 99.755n 0.0v 104.745n 0.0v 104.755n 0.0v 109.745n 0.0v 109.755n 0.0v 114.745n 0.0v 114.755n 1.0v 119.745n 1.0v 119.755n 1.0v 124.745n 1.0v 124.755n 0.0v 129.745n 0.0v 129.755n 0.0v 134.745n 0.0v 134.755n 0.0v 139.745n 0.0v 139.755n 0.0v 144.745n 0.0v 144.755n 0.0v 149.745n 0.0v 149.755n 0.0v 154.745n 0.0v 154.755n 0.0v 159.745n 0.0v 159.755n 0.0v 164.745n 0.0v 164.755n 0.0v 169.745n 0.0v 169.755n 0.0v 174.745n 0.0v 174.755n 0.0v 179.745n 0.0v 179.755n 0.0v 184.745n 0.0v 184.755n 0.0v 189.745n 0.0v 189.755n 0.0v 194.745n 0.0v 194.755n 0.0v 199.745n 0.0v 199.755n 0.0v 204.745n 0.0v 204.755n 1.0v 209.745n 1.0v 209.755n 1.0v 214.745n 1.0v 214.755n 1.0v 219.745n 1.0v 219.755n 1.0v 224.745n 1.0v 224.755n 1.0v 229.745n 1.0v 229.755n 1.0v 234.745n 1.0v 234.755n 1.0v 239.745n 1.0v 239.755n 0.0v 244.745n 0.0v 244.755n 0.0v 249.745n 0.0v 249.755n 1.0v 254.745n 1.0v 254.755n 1.0v 259.745n 1.0v 259.755n 1.0v 264.745n 1.0v 264.755n 1.0v 269.745n 1.0v 269.755n 1.0v 274.745n 1.0v 274.755n 1.0v 279.745n 1.0v 279.755n 1.0v 284.745n 1.0v 284.755n 1.0v 289.745n 1.0v 289.755n 1.0v 294.745n 1.0v 294.755n 1.0v 299.745n 1.0v 299.755n 1.0v 304.745n 1.0v 304.755n 1.0v 309.745n 1.0v 309.755n 0.0v 314.745n 0.0v 314.755n 0.0v 319.745n 0.0v 319.755n 0.0v 324.745n 0.0v 324.755n 0.0v 329.745n 0.0v 329.755n 0.0v 334.745n 0.0v 334.755n 0.0v 339.745n 0.0v 339.755n 0.0v 344.745n 0.0v 344.755n 1.0v 349.745n 1.0v 349.755n 0.0v 354.745n 0.0v 354.755n 0.0v 359.745n 0.0v 359.755n 0.0v 364.745n 0.0v 364.755n 0.0v 369.745n 0.0v 369.755n 0.0v 374.745n 0.0v 374.755n 0.0v 379.745n 0.0v 379.755n 0.0v 384.745n 0.0v 384.755n 0.0v 389.745n 0.0v 389.755n 0.0v 394.745n 0.0v 394.755n 0.0v 399.745n 0.0v 399.755n 1.0v 404.745n 1.0v 404.755n 1.0v 409.745n 1.0v 409.755n 1.0v 414.745n 1.0v 414.755n 1.0v 419.745n 1.0v 419.755n 1.0v 424.745n 1.0v 424.755n 1.0v 429.745n 1.0v 429.755n 1.0v 434.745n 1.0v 434.755n 1.0v 439.745n 1.0v 439.755n 1.0v 444.745n 1.0v 444.755n 1.0v 449.745n 1.0v 449.755n 1.0v 454.745n 1.0v 454.755n 1.0v 459.745n 1.0v 459.755n 1.0v 464.745n 1.0v 464.755n 1.0v 469.745n 1.0v 469.755n 1.0v 474.745n 1.0v 474.755n 1.0v 479.745n 1.0v 479.755n 1.0v 484.745n 1.0v 484.755n 1.0v 489.745n 1.0v 489.755n 1.0v 494.745n 1.0v 494.755n 1.0v 499.745n 1.0v 499.755n 1.0v 504.745n 1.0v 504.755n 1.0v 509.745n 1.0v 509.755n 1.0v 514.745n 1.0v 514.755n 1.0v 519.745n 1.0v 519.755n 1.0v 524.745n 1.0v 524.755n 1.0v 529.745n 1.0v 529.755n 1.0v 534.745n 1.0v 534.755n 1.0v 539.745n 1.0v 539.755n 0.0v 544.745n 0.0v 544.755n 0.0v 549.745n 0.0v 549.755n 0.0v 554.745n 0.0v 554.755n 0.0v 559.745n 0.0v 559.755n 0.0v 564.745n 0.0v 564.755n 0.0v 569.745n 0.0v 569.755n 0.0v 574.745n 0.0v 574.755n 0.0v 579.745n 0.0v 579.755n 0.0v 584.745n 0.0v 584.755n 0.0v 589.745n 0.0v 589.755n 0.0v 594.745n 0.0v 594.755n 0.0v 599.745n 0.0v 599.755n 0.0v 604.745n 0.0v 604.755n 0.0v 609.745n 0.0v 609.755n 0.0v 614.745n 0.0v 614.755n 0.0v 619.745n 0.0v 619.755n 0.0v 624.745n 0.0v 624.755n 0.0v 629.745n 0.0v 629.755n 0.0v 634.745n 0.0v 634.755n 0.0v 639.745n 0.0v 639.755n 0.0v 644.745n 0.0v 644.755n 0.0v 649.745n 0.0v 649.755n 0.0v 654.745n 0.0v 654.755n 1.0v 659.745n 1.0v 659.755n 1.0v 664.745n 1.0v 664.755n 1.0v 669.745n 1.0v 669.755n 1.0v 674.745n 1.0v 674.755n 1.0v 679.745n 1.0v 679.755n 1.0v 684.745n 1.0v 684.755n 1.0v 689.745n 1.0v 689.755n 1.0v 694.745n 1.0v 694.755n 1.0v 699.745n 1.0v 699.755n 1.0v 704.745n 1.0v 704.755n 1.0v 709.745n 1.0v 709.755n 0.0v 714.745n 0.0v 714.755n 0.0v 719.745n 0.0v 719.755n 0.0v 724.745n 0.0v 724.755n 0.0v 729.745n 0.0v 729.755n 0.0v 734.745n 0.0v 734.755n 0.0v 739.745n 0.0v 739.755n 0.0v 744.745n 0.0v 744.755n 0.0v 749.745n 0.0v 749.755n 0.0v 754.745n 0.0v 754.755n 0.0v 759.745n 0.0v 759.755n 0.0v 764.745n 0.0v 764.755n 0.0v 769.745n 0.0v 769.755n 0.0v 774.745n 0.0v 774.755n 0.0v 779.745n 0.0v 779.755n 1.0v 784.745n 1.0v 784.755n 1.0v 789.745n 1.0v 789.755n 1.0v 794.745n 1.0v 794.755n 1.0v 799.745n 1.0v 799.755n 1.0v 804.745n 1.0v 804.755n 1.0v 809.745n 1.0v 809.755n 1.0v 814.745n 1.0v 814.755n 1.0v 819.745n 1.0v 819.755n 1.0v 824.745n 1.0v 824.755n 1.0v 829.745n 1.0v 829.755n 1.0v 834.745n 1.0v 834.755n 1.0v 839.745n 1.0v 839.755n 1.0v 844.745n 1.0v 844.755n 1.0v 849.745n 1.0v 849.755n 1.0v 854.745n 1.0v 854.755n 1.0v 859.745n 1.0v 859.755n 0.0v 864.745n 0.0v 864.755n 0.0v 869.745n 0.0v 869.755n 0.0v 874.745n 0.0v 874.755n 0.0v 879.745n 0.0v 879.755n 1.0v 884.745n 1.0v 884.755n 1.0v 889.745n 1.0v 889.755n 1.0v 894.745n 1.0v 894.755n 1.0v 899.745n 1.0v 899.755n 1.0v 904.745n 1.0v 904.755n 1.0v 909.745n 1.0v 909.755n 1.0v 914.745n 1.0v 914.755n 1.0v 919.745n 1.0v 919.755n 0.0v 924.745n 0.0v 924.755n 0.0v 929.745n 0.0v 929.755n 0.0v 934.745n 0.0v 934.755n 0.0v 939.745n 0.0v 939.755n 0.0v 944.745n 0.0v 944.755n 0.0v 949.745n 0.0v 949.755n 0.0v 954.745n 0.0v 954.755n 0.0v 959.745n 0.0v 959.755n 0.0v 964.745n 0.0v 964.755n 0.0v 969.745n 0.0v 969.755n 0.0v 974.745n 0.0v 974.755n 0.0v 979.745n 0.0v 979.755n 0.0v 984.745n 0.0v 984.755n 0.0v 989.745n 0.0v 989.755n 0.0v 994.745n 0.0v 994.755n 0.0v 999.745n 0.0v 999.755n 0.0v 1004.745n 0.0v 1004.755n 1.0v 1009.745n 1.0v 1009.755n 1.0v 1014.745n 1.0v 1014.755n 1.0v 1019.745n 1.0v 1019.755n 1.0v 1024.745n 1.0v 1024.755n 1.0v )
* (time, data): [(0, 0), (5, 0), (10, 0), (15, 0), (20, 0), (25, 0), (30, 0), (35, 1), (40, 1), (45, 1), (50, 1), (55, 1), (60, 1), (65, 1), (70, 1), (75, 1), (80, 1), (85, 0), (90, 0), (95, 0), (100, 0), (105, 0), (110, 0), (115, 0), (120, 0), (125, 0), (130, 0), (135, 0), (140, 0), (145, 0), (150, 1), (155, 1), (160, 1), (165, 0), (170, 0), (175, 0), (180, 0), (185, 0), (190, 0), (195, 0), (200, 0), (205, 0), (210, 0), (215, 0), (220, 0), (225, 0), (230, 0), (235, 0), (240, 1), (245, 1), (250, 1), (255, 1), (260, 0), (265, 0), (270, 0), (275, 1), (280, 1), (285, 1), (290, 1), (295, 1), (300, 1), (305, 1), (310, 1), (315, 1), (320, 1), (325, 1), (330, 1), (335, 1), (340, 1), (345, 0), (350, 0), (355, 0), (360, 0), (365, 0), (370, 0), (375, 0), (380, 0), (385, 0), (390, 0), (395, 0), (400, 0), (405, 1), (410, 1), (415, 1), (420, 1), (425, 1), (430, 1), (435, 1), (440, 1), (445, 1), (450, 1), (455, 1), (460, 1), (465, 1), (470, 1), (475, 1), (480, 1), (485, 1), (490, 1), (495, 1), (500, 1), (505, 1), (510, 1), (515, 1), (520, 1), (525, 1), (530, 1), (535, 1), (540, 0), (545, 0), (550, 0), (555, 0), (560, 0), (565, 0), (570, 0), (575, 0), (580, 0), (585, 0), (590, 0), (595, 0), (600, 0), (605, 0), (610, 0), (615, 0), (620, 0), (625, 0), (630, 0), (635, 0), (640, 0), (645, 0), (650, 0), (655, 1), (660, 1), (665, 1), (670, 1), (675, 1), (680, 1), (685, 1), (690, 1), (695, 1), (700, 1), (705, 1), (710, 0), (715, 0), (720, 0), (725, 0), (730, 0), (735, 0), (740, 0), (745, 0), (750, 0), (755, 0), (760, 1), (765, 1), (770, 1), (775, 1), (780, 1), (785, 1), (790, 1), (795, 1), (800, 1), (805, 1), (810, 0), (815, 0), (820, 0), (825, 0), (830, 0), (835, 0), (840, 0), (845, 0), (850, 0), (855, 0), (860, 1), (865, 1), (870, 1), (875, 1), (880, 1), (885, 1), (890, 1), (895, 1), (900, 1), (905, 1), (910, 0), (915, 0), (920, 1), (925, 1), (930, 0), (935, 0), (940, 0), (945, 0), (950, 1), (955, 1), (960, 1), (965, 1), (970, 1), (975, 1), (980, 1), (985, 0), (990, 0), (995, 0), (1000, 0), (1005, 1), (1010, 1), (1015, 1), (1020, 1), (1025, 1)]
Vdin1_12  din1_12  0 PWL (0n 0.0v 4.745n 0.0v 4.755n 0.0v 9.745n 0.0v 9.755n 0.0v 14.745n 0.0v 14.755n 0.0v 19.745n 0.0v 19.755n 0.0v 24.745n 0.0v 24.755n 0.0v 29.745n 0.0v 29.755n 0.0v 34.745n 0.0v 34.755n 1.0v 39.745n 1.0v 39.755n 1.0v 44.745n 1.0v 44.755n 1.0v 49.745n 1.0v 49.755n 1.0v 54.745n 1.0v 54.755n 1.0v 59.745n 1.0v 59.755n 1.0v 64.745n 1.0v 64.755n 1.0v 69.745n 1.0v 69.755n 1.0v 74.745n 1.0v 74.755n 1.0v 79.745n 1.0v 79.755n 1.0v 84.745n 1.0v 84.755n 0.0v 89.745n 0.0v 89.755n 0.0v 94.745n 0.0v 94.755n 0.0v 99.745n 0.0v 99.755n 0.0v 104.745n 0.0v 104.755n 0.0v 109.745n 0.0v 109.755n 0.0v 114.745n 0.0v 114.755n 0.0v 119.745n 0.0v 119.755n 0.0v 124.745n 0.0v 124.755n 0.0v 129.745n 0.0v 129.755n 0.0v 134.745n 0.0v 134.755n 0.0v 139.745n 0.0v 139.755n 0.0v 144.745n 0.0v 144.755n 0.0v 149.745n 0.0v 149.755n 1.0v 154.745n 1.0v 154.755n 1.0v 159.745n 1.0v 159.755n 1.0v 164.745n 1.0v 164.755n 0.0v 169.745n 0.0v 169.755n 0.0v 174.745n 0.0v 174.755n 0.0v 179.745n 0.0v 179.755n 0.0v 184.745n 0.0v 184.755n 0.0v 189.745n 0.0v 189.755n 0.0v 194.745n 0.0v 194.755n 0.0v 199.745n 0.0v 199.755n 0.0v 204.745n 0.0v 204.755n 0.0v 209.745n 0.0v 209.755n 0.0v 214.745n 0.0v 214.755n 0.0v 219.745n 0.0v 219.755n 0.0v 224.745n 0.0v 224.755n 0.0v 229.745n 0.0v 229.755n 0.0v 234.745n 0.0v 234.755n 0.0v 239.745n 0.0v 239.755n 1.0v 244.745n 1.0v 244.755n 1.0v 249.745n 1.0v 249.755n 1.0v 254.745n 1.0v 254.755n 1.0v 259.745n 1.0v 259.755n 0.0v 264.745n 0.0v 264.755n 0.0v 269.745n 0.0v 269.755n 0.0v 274.745n 0.0v 274.755n 1.0v 279.745n 1.0v 279.755n 1.0v 284.745n 1.0v 284.755n 1.0v 289.745n 1.0v 289.755n 1.0v 294.745n 1.0v 294.755n 1.0v 299.745n 1.0v 299.755n 1.0v 304.745n 1.0v 304.755n 1.0v 309.745n 1.0v 309.755n 1.0v 314.745n 1.0v 314.755n 1.0v 319.745n 1.0v 319.755n 1.0v 324.745n 1.0v 324.755n 1.0v 329.745n 1.0v 329.755n 1.0v 334.745n 1.0v 334.755n 1.0v 339.745n 1.0v 339.755n 1.0v 344.745n 1.0v 344.755n 0.0v 349.745n 0.0v 349.755n 0.0v 354.745n 0.0v 354.755n 0.0v 359.745n 0.0v 359.755n 0.0v 364.745n 0.0v 364.755n 0.0v 369.745n 0.0v 369.755n 0.0v 374.745n 0.0v 374.755n 0.0v 379.745n 0.0v 379.755n 0.0v 384.745n 0.0v 384.755n 0.0v 389.745n 0.0v 389.755n 0.0v 394.745n 0.0v 394.755n 0.0v 399.745n 0.0v 399.755n 0.0v 404.745n 0.0v 404.755n 1.0v 409.745n 1.0v 409.755n 1.0v 414.745n 1.0v 414.755n 1.0v 419.745n 1.0v 419.755n 1.0v 424.745n 1.0v 424.755n 1.0v 429.745n 1.0v 429.755n 1.0v 434.745n 1.0v 434.755n 1.0v 439.745n 1.0v 439.755n 1.0v 444.745n 1.0v 444.755n 1.0v 449.745n 1.0v 449.755n 1.0v 454.745n 1.0v 454.755n 1.0v 459.745n 1.0v 459.755n 1.0v 464.745n 1.0v 464.755n 1.0v 469.745n 1.0v 469.755n 1.0v 474.745n 1.0v 474.755n 1.0v 479.745n 1.0v 479.755n 1.0v 484.745n 1.0v 484.755n 1.0v 489.745n 1.0v 489.755n 1.0v 494.745n 1.0v 494.755n 1.0v 499.745n 1.0v 499.755n 1.0v 504.745n 1.0v 504.755n 1.0v 509.745n 1.0v 509.755n 1.0v 514.745n 1.0v 514.755n 1.0v 519.745n 1.0v 519.755n 1.0v 524.745n 1.0v 524.755n 1.0v 529.745n 1.0v 529.755n 1.0v 534.745n 1.0v 534.755n 1.0v 539.745n 1.0v 539.755n 0.0v 544.745n 0.0v 544.755n 0.0v 549.745n 0.0v 549.755n 0.0v 554.745n 0.0v 554.755n 0.0v 559.745n 0.0v 559.755n 0.0v 564.745n 0.0v 564.755n 0.0v 569.745n 0.0v 569.755n 0.0v 574.745n 0.0v 574.755n 0.0v 579.745n 0.0v 579.755n 0.0v 584.745n 0.0v 584.755n 0.0v 589.745n 0.0v 589.755n 0.0v 594.745n 0.0v 594.755n 0.0v 599.745n 0.0v 599.755n 0.0v 604.745n 0.0v 604.755n 0.0v 609.745n 0.0v 609.755n 0.0v 614.745n 0.0v 614.755n 0.0v 619.745n 0.0v 619.755n 0.0v 624.745n 0.0v 624.755n 0.0v 629.745n 0.0v 629.755n 0.0v 634.745n 0.0v 634.755n 0.0v 639.745n 0.0v 639.755n 0.0v 644.745n 0.0v 644.755n 0.0v 649.745n 0.0v 649.755n 0.0v 654.745n 0.0v 654.755n 1.0v 659.745n 1.0v 659.755n 1.0v 664.745n 1.0v 664.755n 1.0v 669.745n 1.0v 669.755n 1.0v 674.745n 1.0v 674.755n 1.0v 679.745n 1.0v 679.755n 1.0v 684.745n 1.0v 684.755n 1.0v 689.745n 1.0v 689.755n 1.0v 694.745n 1.0v 694.755n 1.0v 699.745n 1.0v 699.755n 1.0v 704.745n 1.0v 704.755n 1.0v 709.745n 1.0v 709.755n 0.0v 714.745n 0.0v 714.755n 0.0v 719.745n 0.0v 719.755n 0.0v 724.745n 0.0v 724.755n 0.0v 729.745n 0.0v 729.755n 0.0v 734.745n 0.0v 734.755n 0.0v 739.745n 0.0v 739.755n 0.0v 744.745n 0.0v 744.755n 0.0v 749.745n 0.0v 749.755n 0.0v 754.745n 0.0v 754.755n 0.0v 759.745n 0.0v 759.755n 1.0v 764.745n 1.0v 764.755n 1.0v 769.745n 1.0v 769.755n 1.0v 774.745n 1.0v 774.755n 1.0v 779.745n 1.0v 779.755n 1.0v 784.745n 1.0v 784.755n 1.0v 789.745n 1.0v 789.755n 1.0v 794.745n 1.0v 794.755n 1.0v 799.745n 1.0v 799.755n 1.0v 804.745n 1.0v 804.755n 1.0v 809.745n 1.0v 809.755n 0.0v 814.745n 0.0v 814.755n 0.0v 819.745n 0.0v 819.755n 0.0v 824.745n 0.0v 824.755n 0.0v 829.745n 0.0v 829.755n 0.0v 834.745n 0.0v 834.755n 0.0v 839.745n 0.0v 839.755n 0.0v 844.745n 0.0v 844.755n 0.0v 849.745n 0.0v 849.755n 0.0v 854.745n 0.0v 854.755n 0.0v 859.745n 0.0v 859.755n 1.0v 864.745n 1.0v 864.755n 1.0v 869.745n 1.0v 869.755n 1.0v 874.745n 1.0v 874.755n 1.0v 879.745n 1.0v 879.755n 1.0v 884.745n 1.0v 884.755n 1.0v 889.745n 1.0v 889.755n 1.0v 894.745n 1.0v 894.755n 1.0v 899.745n 1.0v 899.755n 1.0v 904.745n 1.0v 904.755n 1.0v 909.745n 1.0v 909.755n 0.0v 914.745n 0.0v 914.755n 0.0v 919.745n 0.0v 919.755n 1.0v 924.745n 1.0v 924.755n 1.0v 929.745n 1.0v 929.755n 0.0v 934.745n 0.0v 934.755n 0.0v 939.745n 0.0v 939.755n 0.0v 944.745n 0.0v 944.755n 0.0v 949.745n 0.0v 949.755n 1.0v 954.745n 1.0v 954.755n 1.0v 959.745n 1.0v 959.755n 1.0v 964.745n 1.0v 964.755n 1.0v 969.745n 1.0v 969.755n 1.0v 974.745n 1.0v 974.755n 1.0v 979.745n 1.0v 979.755n 1.0v 984.745n 1.0v 984.755n 0.0v 989.745n 0.0v 989.755n 0.0v 994.745n 0.0v 994.755n 0.0v 999.745n 0.0v 999.755n 0.0v 1004.745n 0.0v 1004.755n 1.0v 1009.745n 1.0v 1009.755n 1.0v 1014.745n 1.0v 1014.755n 1.0v 1019.745n 1.0v 1019.755n 1.0v 1024.745n 1.0v 1024.755n 1.0v )
* (time, data): [(0, 0), (5, 1), (10, 0), (15, 0), (20, 0), (25, 0), (30, 0), (35, 0), (40, 0), (45, 0), (50, 1), (55, 1), (60, 1), (65, 1), (70, 1), (75, 1), (80, 1), (85, 1), (90, 1), (95, 1), (100, 1), (105, 1), (110, 1), (115, 1), (120, 1), (125, 1), (130, 1), (135, 1), (140, 1), (145, 1), (150, 0), (155, 0), (160, 0), (165, 1), (170, 1), (175, 1), (180, 1), (185, 1), (190, 1), (195, 1), (200, 1), (205, 0), (210, 0), (215, 0), (220, 1), (225, 1), (230, 1), (235, 1), (240, 0), (245, 0), (250, 1), (255, 1), (260, 0), (265, 0), (270, 0), (275, 0), (280, 0), (285, 0), (290, 0), (295, 0), (300, 0), (305, 0), (310, 0), (315, 0), (320, 0), (325, 0), (330, 0), (335, 0), (340, 0), (345, 1), (350, 1), (355, 1), (360, 0), (365, 0), (370, 0), (375, 0), (380, 0), (385, 0), (390, 0), (395, 0), (400, 0), (405, 1), (410, 1), (415, 1), (420, 1), (425, 1), (430, 1), (435, 1), (440, 1), (445, 1), (450, 1), (455, 1), (460, 1), (465, 1), (470, 1), (475, 1), (480, 1), (485, 1), (490, 1), (495, 1), (500, 1), (505, 1), (510, 1), (515, 1), (520, 1), (525, 1), (530, 1), (535, 0), (540, 0), (545, 0), (550, 0), (555, 0), (560, 0), (565, 0), (570, 0), (575, 0), (580, 0), (585, 0), (590, 0), (595, 0), (600, 0), (605, 0), (610, 0), (615, 0), (620, 0), (625, 0), (630, 0), (635, 0), (640, 0), (645, 0), (650, 0), (655, 0), (660, 0), (665, 0), (670, 0), (675, 0), (680, 0), (685, 0), (690, 0), (695, 0), (700, 0), (705, 0), (710, 1), (715, 1), (720, 1), (725, 1), (730, 1), (735, 1), (740, 1), (745, 1), (750, 1), (755, 1), (760, 0), (765, 0), (770, 0), (775, 0), (780, 0), (785, 0), (790, 0), (795, 0), (800, 0), (805, 0), (810, 1), (815, 1), (820, 1), (825, 1), (830, 1), (835, 1), (840, 1), (845, 1), (850, 1), (855, 1), (860, 1), (865, 1), (870, 1), (875, 1), (880, 1), (885, 1), (890, 1), (895, 1), (900, 1), (905, 1), (910, 1), (915, 1), (920, 0), (925, 0), (930, 1), (935, 1), (940, 1), (945, 1), (950, 1), (955, 0), (960, 0), (965, 0), (970, 0), (975, 0), (980, 0), (985, 1), (990, 1), (995, 1), (1000, 1), (1005, 1), (1010, 1), (1015, 1), (1020, 1), (1025, 1)]
Vdin1_13  din1_13  0 PWL (0n 0.0v 4.745n 0.0v 4.755n 1.0v 9.745n 1.0v 9.755n 0.0v 14.745n 0.0v 14.755n 0.0v 19.745n 0.0v 19.755n 0.0v 24.745n 0.0v 24.755n 0.0v 29.745n 0.0v 29.755n 0.0v 34.745n 0.0v 34.755n 0.0v 39.745n 0.0v 39.755n 0.0v 44.745n 0.0v 44.755n 0.0v 49.745n 0.0v 49.755n 1.0v 54.745n 1.0v 54.755n 1.0v 59.745n 1.0v 59.755n 1.0v 64.745n 1.0v 64.755n 1.0v 69.745n 1.0v 69.755n 1.0v 74.745n 1.0v 74.755n 1.0v 79.745n 1.0v 79.755n 1.0v 84.745n 1.0v 84.755n 1.0v 89.745n 1.0v 89.755n 1.0v 94.745n 1.0v 94.755n 1.0v 99.745n 1.0v 99.755n 1.0v 104.745n 1.0v 104.755n 1.0v 109.745n 1.0v 109.755n 1.0v 114.745n 1.0v 114.755n 1.0v 119.745n 1.0v 119.755n 1.0v 124.745n 1.0v 124.755n 1.0v 129.745n 1.0v 129.755n 1.0v 134.745n 1.0v 134.755n 1.0v 139.745n 1.0v 139.755n 1.0v 144.745n 1.0v 144.755n 1.0v 149.745n 1.0v 149.755n 0.0v 154.745n 0.0v 154.755n 0.0v 159.745n 0.0v 159.755n 0.0v 164.745n 0.0v 164.755n 1.0v 169.745n 1.0v 169.755n 1.0v 174.745n 1.0v 174.755n 1.0v 179.745n 1.0v 179.755n 1.0v 184.745n 1.0v 184.755n 1.0v 189.745n 1.0v 189.755n 1.0v 194.745n 1.0v 194.755n 1.0v 199.745n 1.0v 199.755n 1.0v 204.745n 1.0v 204.755n 0.0v 209.745n 0.0v 209.755n 0.0v 214.745n 0.0v 214.755n 0.0v 219.745n 0.0v 219.755n 1.0v 224.745n 1.0v 224.755n 1.0v 229.745n 1.0v 229.755n 1.0v 234.745n 1.0v 234.755n 1.0v 239.745n 1.0v 239.755n 0.0v 244.745n 0.0v 244.755n 0.0v 249.745n 0.0v 249.755n 1.0v 254.745n 1.0v 254.755n 1.0v 259.745n 1.0v 259.755n 0.0v 264.745n 0.0v 264.755n 0.0v 269.745n 0.0v 269.755n 0.0v 274.745n 0.0v 274.755n 0.0v 279.745n 0.0v 279.755n 0.0v 284.745n 0.0v 284.755n 0.0v 289.745n 0.0v 289.755n 0.0v 294.745n 0.0v 294.755n 0.0v 299.745n 0.0v 299.755n 0.0v 304.745n 0.0v 304.755n 0.0v 309.745n 0.0v 309.755n 0.0v 314.745n 0.0v 314.755n 0.0v 319.745n 0.0v 319.755n 0.0v 324.745n 0.0v 324.755n 0.0v 329.745n 0.0v 329.755n 0.0v 334.745n 0.0v 334.755n 0.0v 339.745n 0.0v 339.755n 0.0v 344.745n 0.0v 344.755n 1.0v 349.745n 1.0v 349.755n 1.0v 354.745n 1.0v 354.755n 1.0v 359.745n 1.0v 359.755n 0.0v 364.745n 0.0v 364.755n 0.0v 369.745n 0.0v 369.755n 0.0v 374.745n 0.0v 374.755n 0.0v 379.745n 0.0v 379.755n 0.0v 384.745n 0.0v 384.755n 0.0v 389.745n 0.0v 389.755n 0.0v 394.745n 0.0v 394.755n 0.0v 399.745n 0.0v 399.755n 0.0v 404.745n 0.0v 404.755n 1.0v 409.745n 1.0v 409.755n 1.0v 414.745n 1.0v 414.755n 1.0v 419.745n 1.0v 419.755n 1.0v 424.745n 1.0v 424.755n 1.0v 429.745n 1.0v 429.755n 1.0v 434.745n 1.0v 434.755n 1.0v 439.745n 1.0v 439.755n 1.0v 444.745n 1.0v 444.755n 1.0v 449.745n 1.0v 449.755n 1.0v 454.745n 1.0v 454.755n 1.0v 459.745n 1.0v 459.755n 1.0v 464.745n 1.0v 464.755n 1.0v 469.745n 1.0v 469.755n 1.0v 474.745n 1.0v 474.755n 1.0v 479.745n 1.0v 479.755n 1.0v 484.745n 1.0v 484.755n 1.0v 489.745n 1.0v 489.755n 1.0v 494.745n 1.0v 494.755n 1.0v 499.745n 1.0v 499.755n 1.0v 504.745n 1.0v 504.755n 1.0v 509.745n 1.0v 509.755n 1.0v 514.745n 1.0v 514.755n 1.0v 519.745n 1.0v 519.755n 1.0v 524.745n 1.0v 524.755n 1.0v 529.745n 1.0v 529.755n 1.0v 534.745n 1.0v 534.755n 0.0v 539.745n 0.0v 539.755n 0.0v 544.745n 0.0v 544.755n 0.0v 549.745n 0.0v 549.755n 0.0v 554.745n 0.0v 554.755n 0.0v 559.745n 0.0v 559.755n 0.0v 564.745n 0.0v 564.755n 0.0v 569.745n 0.0v 569.755n 0.0v 574.745n 0.0v 574.755n 0.0v 579.745n 0.0v 579.755n 0.0v 584.745n 0.0v 584.755n 0.0v 589.745n 0.0v 589.755n 0.0v 594.745n 0.0v 594.755n 0.0v 599.745n 0.0v 599.755n 0.0v 604.745n 0.0v 604.755n 0.0v 609.745n 0.0v 609.755n 0.0v 614.745n 0.0v 614.755n 0.0v 619.745n 0.0v 619.755n 0.0v 624.745n 0.0v 624.755n 0.0v 629.745n 0.0v 629.755n 0.0v 634.745n 0.0v 634.755n 0.0v 639.745n 0.0v 639.755n 0.0v 644.745n 0.0v 644.755n 0.0v 649.745n 0.0v 649.755n 0.0v 654.745n 0.0v 654.755n 0.0v 659.745n 0.0v 659.755n 0.0v 664.745n 0.0v 664.755n 0.0v 669.745n 0.0v 669.755n 0.0v 674.745n 0.0v 674.755n 0.0v 679.745n 0.0v 679.755n 0.0v 684.745n 0.0v 684.755n 0.0v 689.745n 0.0v 689.755n 0.0v 694.745n 0.0v 694.755n 0.0v 699.745n 0.0v 699.755n 0.0v 704.745n 0.0v 704.755n 0.0v 709.745n 0.0v 709.755n 1.0v 714.745n 1.0v 714.755n 1.0v 719.745n 1.0v 719.755n 1.0v 724.745n 1.0v 724.755n 1.0v 729.745n 1.0v 729.755n 1.0v 734.745n 1.0v 734.755n 1.0v 739.745n 1.0v 739.755n 1.0v 744.745n 1.0v 744.755n 1.0v 749.745n 1.0v 749.755n 1.0v 754.745n 1.0v 754.755n 1.0v 759.745n 1.0v 759.755n 0.0v 764.745n 0.0v 764.755n 0.0v 769.745n 0.0v 769.755n 0.0v 774.745n 0.0v 774.755n 0.0v 779.745n 0.0v 779.755n 0.0v 784.745n 0.0v 784.755n 0.0v 789.745n 0.0v 789.755n 0.0v 794.745n 0.0v 794.755n 0.0v 799.745n 0.0v 799.755n 0.0v 804.745n 0.0v 804.755n 0.0v 809.745n 0.0v 809.755n 1.0v 814.745n 1.0v 814.755n 1.0v 819.745n 1.0v 819.755n 1.0v 824.745n 1.0v 824.755n 1.0v 829.745n 1.0v 829.755n 1.0v 834.745n 1.0v 834.755n 1.0v 839.745n 1.0v 839.755n 1.0v 844.745n 1.0v 844.755n 1.0v 849.745n 1.0v 849.755n 1.0v 854.745n 1.0v 854.755n 1.0v 859.745n 1.0v 859.755n 1.0v 864.745n 1.0v 864.755n 1.0v 869.745n 1.0v 869.755n 1.0v 874.745n 1.0v 874.755n 1.0v 879.745n 1.0v 879.755n 1.0v 884.745n 1.0v 884.755n 1.0v 889.745n 1.0v 889.755n 1.0v 894.745n 1.0v 894.755n 1.0v 899.745n 1.0v 899.755n 1.0v 904.745n 1.0v 904.755n 1.0v 909.745n 1.0v 909.755n 1.0v 914.745n 1.0v 914.755n 1.0v 919.745n 1.0v 919.755n 0.0v 924.745n 0.0v 924.755n 0.0v 929.745n 0.0v 929.755n 1.0v 934.745n 1.0v 934.755n 1.0v 939.745n 1.0v 939.755n 1.0v 944.745n 1.0v 944.755n 1.0v 949.745n 1.0v 949.755n 1.0v 954.745n 1.0v 954.755n 0.0v 959.745n 0.0v 959.755n 0.0v 964.745n 0.0v 964.755n 0.0v 969.745n 0.0v 969.755n 0.0v 974.745n 0.0v 974.755n 0.0v 979.745n 0.0v 979.755n 0.0v 984.745n 0.0v 984.755n 1.0v 989.745n 1.0v 989.755n 1.0v 994.745n 1.0v 994.755n 1.0v 999.745n 1.0v 999.755n 1.0v 1004.745n 1.0v 1004.755n 1.0v 1009.745n 1.0v 1009.755n 1.0v 1014.745n 1.0v 1014.755n 1.0v 1019.745n 1.0v 1019.755n 1.0v 1024.745n 1.0v 1024.755n 1.0v )
* (time, data): [(0, 0), (5, 1), (10, 0), (15, 0), (20, 0), (25, 0), (30, 0), (35, 0), (40, 0), (45, 0), (50, 0), (55, 0), (60, 0), (65, 0), (70, 0), (75, 0), (80, 0), (85, 1), (90, 1), (95, 1), (100, 1), (105, 1), (110, 1), (115, 0), (120, 0), (125, 0), (130, 0), (135, 0), (140, 0), (145, 0), (150, 0), (155, 0), (160, 0), (165, 1), (170, 1), (175, 1), (180, 1), (185, 1), (190, 1), (195, 1), (200, 1), (205, 0), (210, 0), (215, 0), (220, 1), (225, 1), (230, 1), (235, 1), (240, 1), (245, 1), (250, 1), (255, 1), (260, 0), (265, 0), (270, 0), (275, 0), (280, 0), (285, 0), (290, 0), (295, 0), (300, 0), (305, 0), (310, 1), (315, 1), (320, 1), (325, 1), (330, 1), (335, 1), (340, 1), (345, 1), (350, 0), (355, 0), (360, 0), (365, 0), (370, 0), (375, 0), (380, 0), (385, 0), (390, 0), (395, 0), (400, 0), (405, 1), (410, 1), (415, 1), (420, 1), (425, 1), (430, 1), (435, 1), (440, 1), (445, 1), (450, 1), (455, 1), (460, 1), (465, 1), (470, 1), (475, 1), (480, 1), (485, 1), (490, 1), (495, 1), (500, 1), (505, 1), (510, 1), (515, 1), (520, 1), (525, 1), (530, 1), (535, 0), (540, 1), (545, 1), (550, 1), (555, 1), (560, 1), (565, 1), (570, 1), (575, 1), (580, 1), (585, 1), (590, 1), (595, 1), (600, 1), (605, 1), (610, 1), (615, 1), (620, 1), (625, 1), (630, 1), (635, 1), (640, 1), (645, 1), (650, 1), (655, 1), (660, 1), (665, 1), (670, 1), (675, 1), (680, 1), (685, 1), (690, 1), (695, 1), (700, 1), (705, 1), (710, 1), (715, 1), (720, 1), (725, 1), (730, 1), (735, 1), (740, 1), (745, 1), (750, 1), (755, 1), (760, 1), (765, 1), (770, 1), (775, 1), (780, 0), (785, 0), (790, 0), (795, 0), (800, 0), (805, 0), (810, 0), (815, 0), (820, 0), (825, 0), (830, 0), (835, 0), (840, 0), (845, 0), (850, 0), (855, 0), (860, 0), (865, 0), (870, 0), (875, 0), (880, 0), (885, 0), (890, 0), (895, 0), (900, 0), (905, 0), (910, 0), (915, 0), (920, 0), (925, 0), (930, 1), (935, 1), (940, 1), (945, 1), (950, 1), (955, 1), (960, 1), (965, 1), (970, 1), (975, 1), (980, 1), (985, 0), (990, 0), (995, 0), (1000, 0), (1005, 0), (1010, 0), (1015, 0), (1020, 0), (1025, 0)]
Vdin1_14  din1_14  0 PWL (0n 0.0v 4.745n 0.0v 4.755n 1.0v 9.745n 1.0v 9.755n 0.0v 14.745n 0.0v 14.755n 0.0v 19.745n 0.0v 19.755n 0.0v 24.745n 0.0v 24.755n 0.0v 29.745n 0.0v 29.755n 0.0v 34.745n 0.0v 34.755n 0.0v 39.745n 0.0v 39.755n 0.0v 44.745n 0.0v 44.755n 0.0v 49.745n 0.0v 49.755n 0.0v 54.745n 0.0v 54.755n 0.0v 59.745n 0.0v 59.755n 0.0v 64.745n 0.0v 64.755n 0.0v 69.745n 0.0v 69.755n 0.0v 74.745n 0.0v 74.755n 0.0v 79.745n 0.0v 79.755n 0.0v 84.745n 0.0v 84.755n 1.0v 89.745n 1.0v 89.755n 1.0v 94.745n 1.0v 94.755n 1.0v 99.745n 1.0v 99.755n 1.0v 104.745n 1.0v 104.755n 1.0v 109.745n 1.0v 109.755n 1.0v 114.745n 1.0v 114.755n 0.0v 119.745n 0.0v 119.755n 0.0v 124.745n 0.0v 124.755n 0.0v 129.745n 0.0v 129.755n 0.0v 134.745n 0.0v 134.755n 0.0v 139.745n 0.0v 139.755n 0.0v 144.745n 0.0v 144.755n 0.0v 149.745n 0.0v 149.755n 0.0v 154.745n 0.0v 154.755n 0.0v 159.745n 0.0v 159.755n 0.0v 164.745n 0.0v 164.755n 1.0v 169.745n 1.0v 169.755n 1.0v 174.745n 1.0v 174.755n 1.0v 179.745n 1.0v 179.755n 1.0v 184.745n 1.0v 184.755n 1.0v 189.745n 1.0v 189.755n 1.0v 194.745n 1.0v 194.755n 1.0v 199.745n 1.0v 199.755n 1.0v 204.745n 1.0v 204.755n 0.0v 209.745n 0.0v 209.755n 0.0v 214.745n 0.0v 214.755n 0.0v 219.745n 0.0v 219.755n 1.0v 224.745n 1.0v 224.755n 1.0v 229.745n 1.0v 229.755n 1.0v 234.745n 1.0v 234.755n 1.0v 239.745n 1.0v 239.755n 1.0v 244.745n 1.0v 244.755n 1.0v 249.745n 1.0v 249.755n 1.0v 254.745n 1.0v 254.755n 1.0v 259.745n 1.0v 259.755n 0.0v 264.745n 0.0v 264.755n 0.0v 269.745n 0.0v 269.755n 0.0v 274.745n 0.0v 274.755n 0.0v 279.745n 0.0v 279.755n 0.0v 284.745n 0.0v 284.755n 0.0v 289.745n 0.0v 289.755n 0.0v 294.745n 0.0v 294.755n 0.0v 299.745n 0.0v 299.755n 0.0v 304.745n 0.0v 304.755n 0.0v 309.745n 0.0v 309.755n 1.0v 314.745n 1.0v 314.755n 1.0v 319.745n 1.0v 319.755n 1.0v 324.745n 1.0v 324.755n 1.0v 329.745n 1.0v 329.755n 1.0v 334.745n 1.0v 334.755n 1.0v 339.745n 1.0v 339.755n 1.0v 344.745n 1.0v 344.755n 1.0v 349.745n 1.0v 349.755n 0.0v 354.745n 0.0v 354.755n 0.0v 359.745n 0.0v 359.755n 0.0v 364.745n 0.0v 364.755n 0.0v 369.745n 0.0v 369.755n 0.0v 374.745n 0.0v 374.755n 0.0v 379.745n 0.0v 379.755n 0.0v 384.745n 0.0v 384.755n 0.0v 389.745n 0.0v 389.755n 0.0v 394.745n 0.0v 394.755n 0.0v 399.745n 0.0v 399.755n 0.0v 404.745n 0.0v 404.755n 1.0v 409.745n 1.0v 409.755n 1.0v 414.745n 1.0v 414.755n 1.0v 419.745n 1.0v 419.755n 1.0v 424.745n 1.0v 424.755n 1.0v 429.745n 1.0v 429.755n 1.0v 434.745n 1.0v 434.755n 1.0v 439.745n 1.0v 439.755n 1.0v 444.745n 1.0v 444.755n 1.0v 449.745n 1.0v 449.755n 1.0v 454.745n 1.0v 454.755n 1.0v 459.745n 1.0v 459.755n 1.0v 464.745n 1.0v 464.755n 1.0v 469.745n 1.0v 469.755n 1.0v 474.745n 1.0v 474.755n 1.0v 479.745n 1.0v 479.755n 1.0v 484.745n 1.0v 484.755n 1.0v 489.745n 1.0v 489.755n 1.0v 494.745n 1.0v 494.755n 1.0v 499.745n 1.0v 499.755n 1.0v 504.745n 1.0v 504.755n 1.0v 509.745n 1.0v 509.755n 1.0v 514.745n 1.0v 514.755n 1.0v 519.745n 1.0v 519.755n 1.0v 524.745n 1.0v 524.755n 1.0v 529.745n 1.0v 529.755n 1.0v 534.745n 1.0v 534.755n 0.0v 539.745n 0.0v 539.755n 1.0v 544.745n 1.0v 544.755n 1.0v 549.745n 1.0v 549.755n 1.0v 554.745n 1.0v 554.755n 1.0v 559.745n 1.0v 559.755n 1.0v 564.745n 1.0v 564.755n 1.0v 569.745n 1.0v 569.755n 1.0v 574.745n 1.0v 574.755n 1.0v 579.745n 1.0v 579.755n 1.0v 584.745n 1.0v 584.755n 1.0v 589.745n 1.0v 589.755n 1.0v 594.745n 1.0v 594.755n 1.0v 599.745n 1.0v 599.755n 1.0v 604.745n 1.0v 604.755n 1.0v 609.745n 1.0v 609.755n 1.0v 614.745n 1.0v 614.755n 1.0v 619.745n 1.0v 619.755n 1.0v 624.745n 1.0v 624.755n 1.0v 629.745n 1.0v 629.755n 1.0v 634.745n 1.0v 634.755n 1.0v 639.745n 1.0v 639.755n 1.0v 644.745n 1.0v 644.755n 1.0v 649.745n 1.0v 649.755n 1.0v 654.745n 1.0v 654.755n 1.0v 659.745n 1.0v 659.755n 1.0v 664.745n 1.0v 664.755n 1.0v 669.745n 1.0v 669.755n 1.0v 674.745n 1.0v 674.755n 1.0v 679.745n 1.0v 679.755n 1.0v 684.745n 1.0v 684.755n 1.0v 689.745n 1.0v 689.755n 1.0v 694.745n 1.0v 694.755n 1.0v 699.745n 1.0v 699.755n 1.0v 704.745n 1.0v 704.755n 1.0v 709.745n 1.0v 709.755n 1.0v 714.745n 1.0v 714.755n 1.0v 719.745n 1.0v 719.755n 1.0v 724.745n 1.0v 724.755n 1.0v 729.745n 1.0v 729.755n 1.0v 734.745n 1.0v 734.755n 1.0v 739.745n 1.0v 739.755n 1.0v 744.745n 1.0v 744.755n 1.0v 749.745n 1.0v 749.755n 1.0v 754.745n 1.0v 754.755n 1.0v 759.745n 1.0v 759.755n 1.0v 764.745n 1.0v 764.755n 1.0v 769.745n 1.0v 769.755n 1.0v 774.745n 1.0v 774.755n 1.0v 779.745n 1.0v 779.755n 0.0v 784.745n 0.0v 784.755n 0.0v 789.745n 0.0v 789.755n 0.0v 794.745n 0.0v 794.755n 0.0v 799.745n 0.0v 799.755n 0.0v 804.745n 0.0v 804.755n 0.0v 809.745n 0.0v 809.755n 0.0v 814.745n 0.0v 814.755n 0.0v 819.745n 0.0v 819.755n 0.0v 824.745n 0.0v 824.755n 0.0v 829.745n 0.0v 829.755n 0.0v 834.745n 0.0v 834.755n 0.0v 839.745n 0.0v 839.755n 0.0v 844.745n 0.0v 844.755n 0.0v 849.745n 0.0v 849.755n 0.0v 854.745n 0.0v 854.755n 0.0v 859.745n 0.0v 859.755n 0.0v 864.745n 0.0v 864.755n 0.0v 869.745n 0.0v 869.755n 0.0v 874.745n 0.0v 874.755n 0.0v 879.745n 0.0v 879.755n 0.0v 884.745n 0.0v 884.755n 0.0v 889.745n 0.0v 889.755n 0.0v 894.745n 0.0v 894.755n 0.0v 899.745n 0.0v 899.755n 0.0v 904.745n 0.0v 904.755n 0.0v 909.745n 0.0v 909.755n 0.0v 914.745n 0.0v 914.755n 0.0v 919.745n 0.0v 919.755n 0.0v 924.745n 0.0v 924.755n 0.0v 929.745n 0.0v 929.755n 1.0v 934.745n 1.0v 934.755n 1.0v 939.745n 1.0v 939.755n 1.0v 944.745n 1.0v 944.755n 1.0v 949.745n 1.0v 949.755n 1.0v 954.745n 1.0v 954.755n 1.0v 959.745n 1.0v 959.755n 1.0v 964.745n 1.0v 964.755n 1.0v 969.745n 1.0v 969.755n 1.0v 974.745n 1.0v 974.755n 1.0v 979.745n 1.0v 979.755n 1.0v 984.745n 1.0v 984.755n 0.0v 989.745n 0.0v 989.755n 0.0v 994.745n 0.0v 994.755n 0.0v 999.745n 0.0v 999.755n 0.0v 1004.745n 0.0v 1004.755n 0.0v 1009.745n 0.0v 1009.755n 0.0v 1014.745n 0.0v 1014.755n 0.0v 1019.745n 0.0v 1019.755n 0.0v 1024.745n 0.0v 1024.755n 0.0v )
* (time, data): [(0, 0), (5, 1), (10, 1), (15, 1), (20, 1), (25, 1), (30, 1), (35, 0), (40, 0), (45, 0), (50, 0), (55, 0), (60, 0), (65, 0), (70, 0), (75, 0), (80, 0), (85, 0), (90, 0), (95, 0), (100, 0), (105, 0), (110, 0), (115, 0), (120, 0), (125, 1), (130, 1), (135, 1), (140, 1), (145, 1), (150, 0), (155, 0), (160, 0), (165, 1), (170, 1), (175, 1), (180, 1), (185, 1), (190, 1), (195, 1), (200, 1), (205, 1), (210, 1), (215, 1), (220, 1), (225, 1), (230, 1), (235, 1), (240, 0), (245, 0), (250, 1), (255, 1), (260, 0), (265, 0), (270, 0), (275, 0), (280, 0), (285, 0), (290, 0), (295, 0), (300, 0), (305, 0), (310, 1), (315, 1), (320, 1), (325, 1), (330, 1), (335, 1), (340, 1), (345, 0), (350, 0), (355, 0), (360, 0), (365, 0), (370, 0), (375, 0), (380, 0), (385, 0), (390, 0), (395, 0), (400, 0), (405, 0), (410, 0), (415, 0), (420, 0), (425, 0), (430, 0), (435, 0), (440, 1), (445, 1), (450, 1), (455, 1), (460, 1), (465, 1), (470, 1), (475, 1), (480, 1), (485, 1), (490, 1), (495, 1), (500, 0), (505, 0), (510, 0), (515, 0), (520, 0), (525, 0), (530, 0), (535, 0), (540, 0), (545, 0), (550, 0), (555, 0), (560, 0), (565, 0), (570, 0), (575, 0), (580, 0), (585, 0), (590, 0), (595, 0), (600, 0), (605, 0), (610, 0), (615, 0), (620, 0), (625, 0), (630, 0), (635, 0), (640, 0), (645, 0), (650, 0), (655, 1), (660, 1), (665, 1), (670, 1), (675, 1), (680, 1), (685, 1), (690, 1), (695, 1), (700, 1), (705, 1), (710, 1), (715, 1), (720, 1), (725, 1), (730, 1), (735, 1), (740, 1), (745, 1), (750, 1), (755, 1), (760, 0), (765, 0), (770, 0), (775, 0), (780, 1), (785, 1), (790, 1), (795, 1), (800, 1), (805, 1), (810, 0), (815, 0), (820, 0), (825, 0), (830, 0), (835, 0), (840, 0), (845, 0), (850, 0), (855, 0), (860, 0), (865, 0), (870, 0), (875, 0), (880, 0), (885, 0), (890, 0), (895, 0), (900, 0), (905, 0), (910, 1), (915, 1), (920, 1), (925, 1), (930, 0), (935, 1), (940, 1), (945, 1), (950, 1), (955, 1), (960, 1), (965, 1), (970, 1), (975, 1), (980, 1), (985, 1), (990, 1), (995, 1), (1000, 1), (1005, 0), (1010, 0), (1015, 0), (1020, 0), (1025, 0)]
Vdin1_15  din1_15  0 PWL (0n 0.0v 4.745n 0.0v 4.755n 1.0v 9.745n 1.0v 9.755n 1.0v 14.745n 1.0v 14.755n 1.0v 19.745n 1.0v 19.755n 1.0v 24.745n 1.0v 24.755n 1.0v 29.745n 1.0v 29.755n 1.0v 34.745n 1.0v 34.755n 0.0v 39.745n 0.0v 39.755n 0.0v 44.745n 0.0v 44.755n 0.0v 49.745n 0.0v 49.755n 0.0v 54.745n 0.0v 54.755n 0.0v 59.745n 0.0v 59.755n 0.0v 64.745n 0.0v 64.755n 0.0v 69.745n 0.0v 69.755n 0.0v 74.745n 0.0v 74.755n 0.0v 79.745n 0.0v 79.755n 0.0v 84.745n 0.0v 84.755n 0.0v 89.745n 0.0v 89.755n 0.0v 94.745n 0.0v 94.755n 0.0v 99.745n 0.0v 99.755n 0.0v 104.745n 0.0v 104.755n 0.0v 109.745n 0.0v 109.755n 0.0v 114.745n 0.0v 114.755n 0.0v 119.745n 0.0v 119.755n 0.0v 124.745n 0.0v 124.755n 1.0v 129.745n 1.0v 129.755n 1.0v 134.745n 1.0v 134.755n 1.0v 139.745n 1.0v 139.755n 1.0v 144.745n 1.0v 144.755n 1.0v 149.745n 1.0v 149.755n 0.0v 154.745n 0.0v 154.755n 0.0v 159.745n 0.0v 159.755n 0.0v 164.745n 0.0v 164.755n 1.0v 169.745n 1.0v 169.755n 1.0v 174.745n 1.0v 174.755n 1.0v 179.745n 1.0v 179.755n 1.0v 184.745n 1.0v 184.755n 1.0v 189.745n 1.0v 189.755n 1.0v 194.745n 1.0v 194.755n 1.0v 199.745n 1.0v 199.755n 1.0v 204.745n 1.0v 204.755n 1.0v 209.745n 1.0v 209.755n 1.0v 214.745n 1.0v 214.755n 1.0v 219.745n 1.0v 219.755n 1.0v 224.745n 1.0v 224.755n 1.0v 229.745n 1.0v 229.755n 1.0v 234.745n 1.0v 234.755n 1.0v 239.745n 1.0v 239.755n 0.0v 244.745n 0.0v 244.755n 0.0v 249.745n 0.0v 249.755n 1.0v 254.745n 1.0v 254.755n 1.0v 259.745n 1.0v 259.755n 0.0v 264.745n 0.0v 264.755n 0.0v 269.745n 0.0v 269.755n 0.0v 274.745n 0.0v 274.755n 0.0v 279.745n 0.0v 279.755n 0.0v 284.745n 0.0v 284.755n 0.0v 289.745n 0.0v 289.755n 0.0v 294.745n 0.0v 294.755n 0.0v 299.745n 0.0v 299.755n 0.0v 304.745n 0.0v 304.755n 0.0v 309.745n 0.0v 309.755n 1.0v 314.745n 1.0v 314.755n 1.0v 319.745n 1.0v 319.755n 1.0v 324.745n 1.0v 324.755n 1.0v 329.745n 1.0v 329.755n 1.0v 334.745n 1.0v 334.755n 1.0v 339.745n 1.0v 339.755n 1.0v 344.745n 1.0v 344.755n 0.0v 349.745n 0.0v 349.755n 0.0v 354.745n 0.0v 354.755n 0.0v 359.745n 0.0v 359.755n 0.0v 364.745n 0.0v 364.755n 0.0v 369.745n 0.0v 369.755n 0.0v 374.745n 0.0v 374.755n 0.0v 379.745n 0.0v 379.755n 0.0v 384.745n 0.0v 384.755n 0.0v 389.745n 0.0v 389.755n 0.0v 394.745n 0.0v 394.755n 0.0v 399.745n 0.0v 399.755n 0.0v 404.745n 0.0v 404.755n 0.0v 409.745n 0.0v 409.755n 0.0v 414.745n 0.0v 414.755n 0.0v 419.745n 0.0v 419.755n 0.0v 424.745n 0.0v 424.755n 0.0v 429.745n 0.0v 429.755n 0.0v 434.745n 0.0v 434.755n 0.0v 439.745n 0.0v 439.755n 1.0v 444.745n 1.0v 444.755n 1.0v 449.745n 1.0v 449.755n 1.0v 454.745n 1.0v 454.755n 1.0v 459.745n 1.0v 459.755n 1.0v 464.745n 1.0v 464.755n 1.0v 469.745n 1.0v 469.755n 1.0v 474.745n 1.0v 474.755n 1.0v 479.745n 1.0v 479.755n 1.0v 484.745n 1.0v 484.755n 1.0v 489.745n 1.0v 489.755n 1.0v 494.745n 1.0v 494.755n 1.0v 499.745n 1.0v 499.755n 0.0v 504.745n 0.0v 504.755n 0.0v 509.745n 0.0v 509.755n 0.0v 514.745n 0.0v 514.755n 0.0v 519.745n 0.0v 519.755n 0.0v 524.745n 0.0v 524.755n 0.0v 529.745n 0.0v 529.755n 0.0v 534.745n 0.0v 534.755n 0.0v 539.745n 0.0v 539.755n 0.0v 544.745n 0.0v 544.755n 0.0v 549.745n 0.0v 549.755n 0.0v 554.745n 0.0v 554.755n 0.0v 559.745n 0.0v 559.755n 0.0v 564.745n 0.0v 564.755n 0.0v 569.745n 0.0v 569.755n 0.0v 574.745n 0.0v 574.755n 0.0v 579.745n 0.0v 579.755n 0.0v 584.745n 0.0v 584.755n 0.0v 589.745n 0.0v 589.755n 0.0v 594.745n 0.0v 594.755n 0.0v 599.745n 0.0v 599.755n 0.0v 604.745n 0.0v 604.755n 0.0v 609.745n 0.0v 609.755n 0.0v 614.745n 0.0v 614.755n 0.0v 619.745n 0.0v 619.755n 0.0v 624.745n 0.0v 624.755n 0.0v 629.745n 0.0v 629.755n 0.0v 634.745n 0.0v 634.755n 0.0v 639.745n 0.0v 639.755n 0.0v 644.745n 0.0v 644.755n 0.0v 649.745n 0.0v 649.755n 0.0v 654.745n 0.0v 654.755n 1.0v 659.745n 1.0v 659.755n 1.0v 664.745n 1.0v 664.755n 1.0v 669.745n 1.0v 669.755n 1.0v 674.745n 1.0v 674.755n 1.0v 679.745n 1.0v 679.755n 1.0v 684.745n 1.0v 684.755n 1.0v 689.745n 1.0v 689.755n 1.0v 694.745n 1.0v 694.755n 1.0v 699.745n 1.0v 699.755n 1.0v 704.745n 1.0v 704.755n 1.0v 709.745n 1.0v 709.755n 1.0v 714.745n 1.0v 714.755n 1.0v 719.745n 1.0v 719.755n 1.0v 724.745n 1.0v 724.755n 1.0v 729.745n 1.0v 729.755n 1.0v 734.745n 1.0v 734.755n 1.0v 739.745n 1.0v 739.755n 1.0v 744.745n 1.0v 744.755n 1.0v 749.745n 1.0v 749.755n 1.0v 754.745n 1.0v 754.755n 1.0v 759.745n 1.0v 759.755n 0.0v 764.745n 0.0v 764.755n 0.0v 769.745n 0.0v 769.755n 0.0v 774.745n 0.0v 774.755n 0.0v 779.745n 0.0v 779.755n 1.0v 784.745n 1.0v 784.755n 1.0v 789.745n 1.0v 789.755n 1.0v 794.745n 1.0v 794.755n 1.0v 799.745n 1.0v 799.755n 1.0v 804.745n 1.0v 804.755n 1.0v 809.745n 1.0v 809.755n 0.0v 814.745n 0.0v 814.755n 0.0v 819.745n 0.0v 819.755n 0.0v 824.745n 0.0v 824.755n 0.0v 829.745n 0.0v 829.755n 0.0v 834.745n 0.0v 834.755n 0.0v 839.745n 0.0v 839.755n 0.0v 844.745n 0.0v 844.755n 0.0v 849.745n 0.0v 849.755n 0.0v 854.745n 0.0v 854.755n 0.0v 859.745n 0.0v 859.755n 0.0v 864.745n 0.0v 864.755n 0.0v 869.745n 0.0v 869.755n 0.0v 874.745n 0.0v 874.755n 0.0v 879.745n 0.0v 879.755n 0.0v 884.745n 0.0v 884.755n 0.0v 889.745n 0.0v 889.755n 0.0v 894.745n 0.0v 894.755n 0.0v 899.745n 0.0v 899.755n 0.0v 904.745n 0.0v 904.755n 0.0v 909.745n 0.0v 909.755n 1.0v 914.745n 1.0v 914.755n 1.0v 919.745n 1.0v 919.755n 1.0v 924.745n 1.0v 924.755n 1.0v 929.745n 1.0v 929.755n 0.0v 934.745n 0.0v 934.755n 1.0v 939.745n 1.0v 939.755n 1.0v 944.745n 1.0v 944.755n 1.0v 949.745n 1.0v 949.755n 1.0v 954.745n 1.0v 954.755n 1.0v 959.745n 1.0v 959.755n 1.0v 964.745n 1.0v 964.755n 1.0v 969.745n 1.0v 969.755n 1.0v 974.745n 1.0v 974.755n 1.0v 979.745n 1.0v 979.755n 1.0v 984.745n 1.0v 984.755n 1.0v 989.745n 1.0v 989.755n 1.0v 994.745n 1.0v 994.755n 1.0v 999.745n 1.0v 999.755n 1.0v 1004.745n 1.0v 1004.755n 0.0v 1009.745n 0.0v 1009.755n 0.0v 1014.745n 0.0v 1014.755n 0.0v 1019.745n 0.0v 1019.755n 0.0v 1024.745n 0.0v 1024.755n 0.0v )
* (time, data): [(0, 0), (5, 0), (10, 0), (15, 0), (20, 0), (25, 0), (30, 0), (35, 1), (40, 1), (45, 1), (50, 1), (55, 1), (60, 1), (65, 1), (70, 1), (75, 1), (80, 1), (85, 0), (90, 0), (95, 0), (100, 1), (105, 1), (110, 1), (115, 0), (120, 0), (125, 1), (130, 1), (135, 1), (140, 1), (145, 1), (150, 1), (155, 1), (160, 1), (165, 1), (170, 1), (175, 1), (180, 1), (185, 1), (190, 1), (195, 1), (200, 1), (205, 0), (210, 0), (215, 0), (220, 1), (225, 1), (230, 1), (235, 1), (240, 1), (245, 1), (250, 0), (255, 0), (260, 1), (265, 1), (270, 1), (275, 0), (280, 0), (285, 0), (290, 0), (295, 0), (300, 0), (305, 0), (310, 1), (315, 1), (320, 1), (325, 1), (330, 1), (335, 1), (340, 1), (345, 1), (350, 1), (355, 1), (360, 1), (365, 1), (370, 1), (375, 1), (380, 1), (385, 1), (390, 1), (395, 1), (400, 1), (405, 1), (410, 1), (415, 1), (420, 1), (425, 1), (430, 1), (435, 1), (440, 1), (445, 1), (450, 1), (455, 1), (460, 1), (465, 1), (470, 1), (475, 1), (480, 1), (485, 1), (490, 1), (495, 1), (500, 1), (505, 1), (510, 1), (515, 1), (520, 1), (525, 1), (530, 1), (535, 0), (540, 1), (545, 1), (550, 1), (555, 1), (560, 1), (565, 1), (570, 1), (575, 1), (580, 1), (585, 1), (590, 1), (595, 1), (600, 1), (605, 1), (610, 1), (615, 1), (620, 1), (625, 1), (630, 1), (635, 1), (640, 1), (645, 1), (650, 1), (655, 1), (660, 1), (665, 1), (670, 1), (675, 1), (680, 1), (685, 1), (690, 1), (695, 1), (700, 1), (705, 1), (710, 0), (715, 0), (720, 0), (725, 0), (730, 0), (735, 0), (740, 0), (745, 0), (750, 0), (755, 0), (760, 1), (765, 1), (770, 1), (775, 1), (780, 1), (785, 1), (790, 1), (795, 1), (800, 1), (805, 1), (810, 1), (815, 1), (820, 1), (825, 1), (830, 1), (835, 1), (840, 1), (845, 1), (850, 1), (855, 1), (860, 0), (865, 0), (870, 0), (875, 0), (880, 1), (885, 1), (890, 1), (895, 1), (900, 1), (905, 1), (910, 1), (915, 1), (920, 1), (925, 1), (930, 0), (935, 0), (940, 0), (945, 0), (950, 0), (955, 1), (960, 1), (965, 1), (970, 1), (975, 1), (980, 1), (985, 0), (990, 0), (995, 0), (1000, 0), (1005, 1), (1010, 1), (1015, 1), (1020, 1), (1025, 1)]
Vdin1_16  din1_16  0 PWL (0n 0.0v 4.745n 0.0v 4.755n 0.0v 9.745n 0.0v 9.755n 0.0v 14.745n 0.0v 14.755n 0.0v 19.745n 0.0v 19.755n 0.0v 24.745n 0.0v 24.755n 0.0v 29.745n 0.0v 29.755n 0.0v 34.745n 0.0v 34.755n 1.0v 39.745n 1.0v 39.755n 1.0v 44.745n 1.0v 44.755n 1.0v 49.745n 1.0v 49.755n 1.0v 54.745n 1.0v 54.755n 1.0v 59.745n 1.0v 59.755n 1.0v 64.745n 1.0v 64.755n 1.0v 69.745n 1.0v 69.755n 1.0v 74.745n 1.0v 74.755n 1.0v 79.745n 1.0v 79.755n 1.0v 84.745n 1.0v 84.755n 0.0v 89.745n 0.0v 89.755n 0.0v 94.745n 0.0v 94.755n 0.0v 99.745n 0.0v 99.755n 1.0v 104.745n 1.0v 104.755n 1.0v 109.745n 1.0v 109.755n 1.0v 114.745n 1.0v 114.755n 0.0v 119.745n 0.0v 119.755n 0.0v 124.745n 0.0v 124.755n 1.0v 129.745n 1.0v 129.755n 1.0v 134.745n 1.0v 134.755n 1.0v 139.745n 1.0v 139.755n 1.0v 144.745n 1.0v 144.755n 1.0v 149.745n 1.0v 149.755n 1.0v 154.745n 1.0v 154.755n 1.0v 159.745n 1.0v 159.755n 1.0v 164.745n 1.0v 164.755n 1.0v 169.745n 1.0v 169.755n 1.0v 174.745n 1.0v 174.755n 1.0v 179.745n 1.0v 179.755n 1.0v 184.745n 1.0v 184.755n 1.0v 189.745n 1.0v 189.755n 1.0v 194.745n 1.0v 194.755n 1.0v 199.745n 1.0v 199.755n 1.0v 204.745n 1.0v 204.755n 0.0v 209.745n 0.0v 209.755n 0.0v 214.745n 0.0v 214.755n 0.0v 219.745n 0.0v 219.755n 1.0v 224.745n 1.0v 224.755n 1.0v 229.745n 1.0v 229.755n 1.0v 234.745n 1.0v 234.755n 1.0v 239.745n 1.0v 239.755n 1.0v 244.745n 1.0v 244.755n 1.0v 249.745n 1.0v 249.755n 0.0v 254.745n 0.0v 254.755n 0.0v 259.745n 0.0v 259.755n 1.0v 264.745n 1.0v 264.755n 1.0v 269.745n 1.0v 269.755n 1.0v 274.745n 1.0v 274.755n 0.0v 279.745n 0.0v 279.755n 0.0v 284.745n 0.0v 284.755n 0.0v 289.745n 0.0v 289.755n 0.0v 294.745n 0.0v 294.755n 0.0v 299.745n 0.0v 299.755n 0.0v 304.745n 0.0v 304.755n 0.0v 309.745n 0.0v 309.755n 1.0v 314.745n 1.0v 314.755n 1.0v 319.745n 1.0v 319.755n 1.0v 324.745n 1.0v 324.755n 1.0v 329.745n 1.0v 329.755n 1.0v 334.745n 1.0v 334.755n 1.0v 339.745n 1.0v 339.755n 1.0v 344.745n 1.0v 344.755n 1.0v 349.745n 1.0v 349.755n 1.0v 354.745n 1.0v 354.755n 1.0v 359.745n 1.0v 359.755n 1.0v 364.745n 1.0v 364.755n 1.0v 369.745n 1.0v 369.755n 1.0v 374.745n 1.0v 374.755n 1.0v 379.745n 1.0v 379.755n 1.0v 384.745n 1.0v 384.755n 1.0v 389.745n 1.0v 389.755n 1.0v 394.745n 1.0v 394.755n 1.0v 399.745n 1.0v 399.755n 1.0v 404.745n 1.0v 404.755n 1.0v 409.745n 1.0v 409.755n 1.0v 414.745n 1.0v 414.755n 1.0v 419.745n 1.0v 419.755n 1.0v 424.745n 1.0v 424.755n 1.0v 429.745n 1.0v 429.755n 1.0v 434.745n 1.0v 434.755n 1.0v 439.745n 1.0v 439.755n 1.0v 444.745n 1.0v 444.755n 1.0v 449.745n 1.0v 449.755n 1.0v 454.745n 1.0v 454.755n 1.0v 459.745n 1.0v 459.755n 1.0v 464.745n 1.0v 464.755n 1.0v 469.745n 1.0v 469.755n 1.0v 474.745n 1.0v 474.755n 1.0v 479.745n 1.0v 479.755n 1.0v 484.745n 1.0v 484.755n 1.0v 489.745n 1.0v 489.755n 1.0v 494.745n 1.0v 494.755n 1.0v 499.745n 1.0v 499.755n 1.0v 504.745n 1.0v 504.755n 1.0v 509.745n 1.0v 509.755n 1.0v 514.745n 1.0v 514.755n 1.0v 519.745n 1.0v 519.755n 1.0v 524.745n 1.0v 524.755n 1.0v 529.745n 1.0v 529.755n 1.0v 534.745n 1.0v 534.755n 0.0v 539.745n 0.0v 539.755n 1.0v 544.745n 1.0v 544.755n 1.0v 549.745n 1.0v 549.755n 1.0v 554.745n 1.0v 554.755n 1.0v 559.745n 1.0v 559.755n 1.0v 564.745n 1.0v 564.755n 1.0v 569.745n 1.0v 569.755n 1.0v 574.745n 1.0v 574.755n 1.0v 579.745n 1.0v 579.755n 1.0v 584.745n 1.0v 584.755n 1.0v 589.745n 1.0v 589.755n 1.0v 594.745n 1.0v 594.755n 1.0v 599.745n 1.0v 599.755n 1.0v 604.745n 1.0v 604.755n 1.0v 609.745n 1.0v 609.755n 1.0v 614.745n 1.0v 614.755n 1.0v 619.745n 1.0v 619.755n 1.0v 624.745n 1.0v 624.755n 1.0v 629.745n 1.0v 629.755n 1.0v 634.745n 1.0v 634.755n 1.0v 639.745n 1.0v 639.755n 1.0v 644.745n 1.0v 644.755n 1.0v 649.745n 1.0v 649.755n 1.0v 654.745n 1.0v 654.755n 1.0v 659.745n 1.0v 659.755n 1.0v 664.745n 1.0v 664.755n 1.0v 669.745n 1.0v 669.755n 1.0v 674.745n 1.0v 674.755n 1.0v 679.745n 1.0v 679.755n 1.0v 684.745n 1.0v 684.755n 1.0v 689.745n 1.0v 689.755n 1.0v 694.745n 1.0v 694.755n 1.0v 699.745n 1.0v 699.755n 1.0v 704.745n 1.0v 704.755n 1.0v 709.745n 1.0v 709.755n 0.0v 714.745n 0.0v 714.755n 0.0v 719.745n 0.0v 719.755n 0.0v 724.745n 0.0v 724.755n 0.0v 729.745n 0.0v 729.755n 0.0v 734.745n 0.0v 734.755n 0.0v 739.745n 0.0v 739.755n 0.0v 744.745n 0.0v 744.755n 0.0v 749.745n 0.0v 749.755n 0.0v 754.745n 0.0v 754.755n 0.0v 759.745n 0.0v 759.755n 1.0v 764.745n 1.0v 764.755n 1.0v 769.745n 1.0v 769.755n 1.0v 774.745n 1.0v 774.755n 1.0v 779.745n 1.0v 779.755n 1.0v 784.745n 1.0v 784.755n 1.0v 789.745n 1.0v 789.755n 1.0v 794.745n 1.0v 794.755n 1.0v 799.745n 1.0v 799.755n 1.0v 804.745n 1.0v 804.755n 1.0v 809.745n 1.0v 809.755n 1.0v 814.745n 1.0v 814.755n 1.0v 819.745n 1.0v 819.755n 1.0v 824.745n 1.0v 824.755n 1.0v 829.745n 1.0v 829.755n 1.0v 834.745n 1.0v 834.755n 1.0v 839.745n 1.0v 839.755n 1.0v 844.745n 1.0v 844.755n 1.0v 849.745n 1.0v 849.755n 1.0v 854.745n 1.0v 854.755n 1.0v 859.745n 1.0v 859.755n 0.0v 864.745n 0.0v 864.755n 0.0v 869.745n 0.0v 869.755n 0.0v 874.745n 0.0v 874.755n 0.0v 879.745n 0.0v 879.755n 1.0v 884.745n 1.0v 884.755n 1.0v 889.745n 1.0v 889.755n 1.0v 894.745n 1.0v 894.755n 1.0v 899.745n 1.0v 899.755n 1.0v 904.745n 1.0v 904.755n 1.0v 909.745n 1.0v 909.755n 1.0v 914.745n 1.0v 914.755n 1.0v 919.745n 1.0v 919.755n 1.0v 924.745n 1.0v 924.755n 1.0v 929.745n 1.0v 929.755n 0.0v 934.745n 0.0v 934.755n 0.0v 939.745n 0.0v 939.755n 0.0v 944.745n 0.0v 944.755n 0.0v 949.745n 0.0v 949.755n 0.0v 954.745n 0.0v 954.755n 1.0v 959.745n 1.0v 959.755n 1.0v 964.745n 1.0v 964.755n 1.0v 969.745n 1.0v 969.755n 1.0v 974.745n 1.0v 974.755n 1.0v 979.745n 1.0v 979.755n 1.0v 984.745n 1.0v 984.755n 0.0v 989.745n 0.0v 989.755n 0.0v 994.745n 0.0v 994.755n 0.0v 999.745n 0.0v 999.755n 0.0v 1004.745n 0.0v 1004.755n 1.0v 1009.745n 1.0v 1009.755n 1.0v 1014.745n 1.0v 1014.755n 1.0v 1019.745n 1.0v 1019.755n 1.0v 1024.745n 1.0v 1024.755n 1.0v )
* (time, data): [(0, 0), (5, 1), (10, 1), (15, 0), (20, 0), (25, 0), (30, 0), (35, 1), (40, 1), (45, 1), (50, 1), (55, 1), (60, 1), (65, 1), (70, 1), (75, 1), (80, 1), (85, 1), (90, 1), (95, 1), (100, 1), (105, 1), (110, 1), (115, 1), (120, 1), (125, 0), (130, 0), (135, 0), (140, 0), (145, 0), (150, 1), (155, 1), (160, 1), (165, 0), (170, 0), (175, 0), (180, 0), (185, 0), (190, 0), (195, 0), (200, 0), (205, 1), (210, 1), (215, 1), (220, 1), (225, 1), (230, 1), (235, 1), (240, 1), (245, 1), (250, 1), (255, 1), (260, 0), (265, 0), (270, 0), (275, 1), (280, 1), (285, 1), (290, 1), (295, 1), (300, 1), (305, 1), (310, 1), (315, 1), (320, 1), (325, 1), (330, 1), (335, 1), (340, 1), (345, 1), (350, 0), (355, 0), (360, 0), (365, 0), (370, 0), (375, 0), (380, 0), (385, 0), (390, 0), (395, 0), (400, 1), (405, 1), (410, 1), (415, 1), (420, 1), (425, 1), (430, 1), (435, 1), (440, 0), (445, 0), (450, 0), (455, 0), (460, 0), (465, 0), (470, 0), (475, 0), (480, 0), (485, 0), (490, 0), (495, 0), (500, 1), (505, 1), (510, 1), (515, 1), (520, 1), (525, 1), (530, 1), (535, 0), (540, 1), (545, 1), (550, 1), (555, 1), (560, 1), (565, 1), (570, 1), (575, 1), (580, 1), (585, 1), (590, 1), (595, 1), (600, 1), (605, 1), (610, 1), (615, 1), (620, 1), (625, 1), (630, 1), (635, 1), (640, 1), (645, 1), (650, 1), (655, 1), (660, 1), (665, 1), (670, 1), (675, 1), (680, 1), (685, 1), (690, 1), (695, 1), (700, 1), (705, 1), (710, 0), (715, 0), (720, 0), (725, 0), (730, 0), (735, 0), (740, 0), (745, 0), (750, 0), (755, 0), (760, 0), (765, 0), (770, 0), (775, 0), (780, 1), (785, 1), (790, 1), (795, 1), (800, 1), (805, 1), (810, 0), (815, 0), (820, 0), (825, 0), (830, 0), (835, 0), (840, 0), (845, 0), (850, 0), (855, 0), (860, 1), (865, 1), (870, 1), (875, 1), (880, 0), (885, 0), (890, 0), (895, 0), (900, 0), (905, 0), (910, 1), (915, 1), (920, 1), (925, 1), (930, 1), (935, 1), (940, 1), (945, 1), (950, 1), (955, 1), (960, 1), (965, 1), (970, 1), (975, 1), (980, 1), (985, 0), (990, 0), (995, 0), (1000, 0), (1005, 0), (1010, 0), (1015, 0), (1020, 0), (1025, 0)]
Vdin1_17  din1_17  0 PWL (0n 0.0v 4.745n 0.0v 4.755n 1.0v 9.745n 1.0v 9.755n 1.0v 14.745n 1.0v 14.755n 0.0v 19.745n 0.0v 19.755n 0.0v 24.745n 0.0v 24.755n 0.0v 29.745n 0.0v 29.755n 0.0v 34.745n 0.0v 34.755n 1.0v 39.745n 1.0v 39.755n 1.0v 44.745n 1.0v 44.755n 1.0v 49.745n 1.0v 49.755n 1.0v 54.745n 1.0v 54.755n 1.0v 59.745n 1.0v 59.755n 1.0v 64.745n 1.0v 64.755n 1.0v 69.745n 1.0v 69.755n 1.0v 74.745n 1.0v 74.755n 1.0v 79.745n 1.0v 79.755n 1.0v 84.745n 1.0v 84.755n 1.0v 89.745n 1.0v 89.755n 1.0v 94.745n 1.0v 94.755n 1.0v 99.745n 1.0v 99.755n 1.0v 104.745n 1.0v 104.755n 1.0v 109.745n 1.0v 109.755n 1.0v 114.745n 1.0v 114.755n 1.0v 119.745n 1.0v 119.755n 1.0v 124.745n 1.0v 124.755n 0.0v 129.745n 0.0v 129.755n 0.0v 134.745n 0.0v 134.755n 0.0v 139.745n 0.0v 139.755n 0.0v 144.745n 0.0v 144.755n 0.0v 149.745n 0.0v 149.755n 1.0v 154.745n 1.0v 154.755n 1.0v 159.745n 1.0v 159.755n 1.0v 164.745n 1.0v 164.755n 0.0v 169.745n 0.0v 169.755n 0.0v 174.745n 0.0v 174.755n 0.0v 179.745n 0.0v 179.755n 0.0v 184.745n 0.0v 184.755n 0.0v 189.745n 0.0v 189.755n 0.0v 194.745n 0.0v 194.755n 0.0v 199.745n 0.0v 199.755n 0.0v 204.745n 0.0v 204.755n 1.0v 209.745n 1.0v 209.755n 1.0v 214.745n 1.0v 214.755n 1.0v 219.745n 1.0v 219.755n 1.0v 224.745n 1.0v 224.755n 1.0v 229.745n 1.0v 229.755n 1.0v 234.745n 1.0v 234.755n 1.0v 239.745n 1.0v 239.755n 1.0v 244.745n 1.0v 244.755n 1.0v 249.745n 1.0v 249.755n 1.0v 254.745n 1.0v 254.755n 1.0v 259.745n 1.0v 259.755n 0.0v 264.745n 0.0v 264.755n 0.0v 269.745n 0.0v 269.755n 0.0v 274.745n 0.0v 274.755n 1.0v 279.745n 1.0v 279.755n 1.0v 284.745n 1.0v 284.755n 1.0v 289.745n 1.0v 289.755n 1.0v 294.745n 1.0v 294.755n 1.0v 299.745n 1.0v 299.755n 1.0v 304.745n 1.0v 304.755n 1.0v 309.745n 1.0v 309.755n 1.0v 314.745n 1.0v 314.755n 1.0v 319.745n 1.0v 319.755n 1.0v 324.745n 1.0v 324.755n 1.0v 329.745n 1.0v 329.755n 1.0v 334.745n 1.0v 334.755n 1.0v 339.745n 1.0v 339.755n 1.0v 344.745n 1.0v 344.755n 1.0v 349.745n 1.0v 349.755n 0.0v 354.745n 0.0v 354.755n 0.0v 359.745n 0.0v 359.755n 0.0v 364.745n 0.0v 364.755n 0.0v 369.745n 0.0v 369.755n 0.0v 374.745n 0.0v 374.755n 0.0v 379.745n 0.0v 379.755n 0.0v 384.745n 0.0v 384.755n 0.0v 389.745n 0.0v 389.755n 0.0v 394.745n 0.0v 394.755n 0.0v 399.745n 0.0v 399.755n 1.0v 404.745n 1.0v 404.755n 1.0v 409.745n 1.0v 409.755n 1.0v 414.745n 1.0v 414.755n 1.0v 419.745n 1.0v 419.755n 1.0v 424.745n 1.0v 424.755n 1.0v 429.745n 1.0v 429.755n 1.0v 434.745n 1.0v 434.755n 1.0v 439.745n 1.0v 439.755n 0.0v 444.745n 0.0v 444.755n 0.0v 449.745n 0.0v 449.755n 0.0v 454.745n 0.0v 454.755n 0.0v 459.745n 0.0v 459.755n 0.0v 464.745n 0.0v 464.755n 0.0v 469.745n 0.0v 469.755n 0.0v 474.745n 0.0v 474.755n 0.0v 479.745n 0.0v 479.755n 0.0v 484.745n 0.0v 484.755n 0.0v 489.745n 0.0v 489.755n 0.0v 494.745n 0.0v 494.755n 0.0v 499.745n 0.0v 499.755n 1.0v 504.745n 1.0v 504.755n 1.0v 509.745n 1.0v 509.755n 1.0v 514.745n 1.0v 514.755n 1.0v 519.745n 1.0v 519.755n 1.0v 524.745n 1.0v 524.755n 1.0v 529.745n 1.0v 529.755n 1.0v 534.745n 1.0v 534.755n 0.0v 539.745n 0.0v 539.755n 1.0v 544.745n 1.0v 544.755n 1.0v 549.745n 1.0v 549.755n 1.0v 554.745n 1.0v 554.755n 1.0v 559.745n 1.0v 559.755n 1.0v 564.745n 1.0v 564.755n 1.0v 569.745n 1.0v 569.755n 1.0v 574.745n 1.0v 574.755n 1.0v 579.745n 1.0v 579.755n 1.0v 584.745n 1.0v 584.755n 1.0v 589.745n 1.0v 589.755n 1.0v 594.745n 1.0v 594.755n 1.0v 599.745n 1.0v 599.755n 1.0v 604.745n 1.0v 604.755n 1.0v 609.745n 1.0v 609.755n 1.0v 614.745n 1.0v 614.755n 1.0v 619.745n 1.0v 619.755n 1.0v 624.745n 1.0v 624.755n 1.0v 629.745n 1.0v 629.755n 1.0v 634.745n 1.0v 634.755n 1.0v 639.745n 1.0v 639.755n 1.0v 644.745n 1.0v 644.755n 1.0v 649.745n 1.0v 649.755n 1.0v 654.745n 1.0v 654.755n 1.0v 659.745n 1.0v 659.755n 1.0v 664.745n 1.0v 664.755n 1.0v 669.745n 1.0v 669.755n 1.0v 674.745n 1.0v 674.755n 1.0v 679.745n 1.0v 679.755n 1.0v 684.745n 1.0v 684.755n 1.0v 689.745n 1.0v 689.755n 1.0v 694.745n 1.0v 694.755n 1.0v 699.745n 1.0v 699.755n 1.0v 704.745n 1.0v 704.755n 1.0v 709.745n 1.0v 709.755n 0.0v 714.745n 0.0v 714.755n 0.0v 719.745n 0.0v 719.755n 0.0v 724.745n 0.0v 724.755n 0.0v 729.745n 0.0v 729.755n 0.0v 734.745n 0.0v 734.755n 0.0v 739.745n 0.0v 739.755n 0.0v 744.745n 0.0v 744.755n 0.0v 749.745n 0.0v 749.755n 0.0v 754.745n 0.0v 754.755n 0.0v 759.745n 0.0v 759.755n 0.0v 764.745n 0.0v 764.755n 0.0v 769.745n 0.0v 769.755n 0.0v 774.745n 0.0v 774.755n 0.0v 779.745n 0.0v 779.755n 1.0v 784.745n 1.0v 784.755n 1.0v 789.745n 1.0v 789.755n 1.0v 794.745n 1.0v 794.755n 1.0v 799.745n 1.0v 799.755n 1.0v 804.745n 1.0v 804.755n 1.0v 809.745n 1.0v 809.755n 0.0v 814.745n 0.0v 814.755n 0.0v 819.745n 0.0v 819.755n 0.0v 824.745n 0.0v 824.755n 0.0v 829.745n 0.0v 829.755n 0.0v 834.745n 0.0v 834.755n 0.0v 839.745n 0.0v 839.755n 0.0v 844.745n 0.0v 844.755n 0.0v 849.745n 0.0v 849.755n 0.0v 854.745n 0.0v 854.755n 0.0v 859.745n 0.0v 859.755n 1.0v 864.745n 1.0v 864.755n 1.0v 869.745n 1.0v 869.755n 1.0v 874.745n 1.0v 874.755n 1.0v 879.745n 1.0v 879.755n 0.0v 884.745n 0.0v 884.755n 0.0v 889.745n 0.0v 889.755n 0.0v 894.745n 0.0v 894.755n 0.0v 899.745n 0.0v 899.755n 0.0v 904.745n 0.0v 904.755n 0.0v 909.745n 0.0v 909.755n 1.0v 914.745n 1.0v 914.755n 1.0v 919.745n 1.0v 919.755n 1.0v 924.745n 1.0v 924.755n 1.0v 929.745n 1.0v 929.755n 1.0v 934.745n 1.0v 934.755n 1.0v 939.745n 1.0v 939.755n 1.0v 944.745n 1.0v 944.755n 1.0v 949.745n 1.0v 949.755n 1.0v 954.745n 1.0v 954.755n 1.0v 959.745n 1.0v 959.755n 1.0v 964.745n 1.0v 964.755n 1.0v 969.745n 1.0v 969.755n 1.0v 974.745n 1.0v 974.755n 1.0v 979.745n 1.0v 979.755n 1.0v 984.745n 1.0v 984.755n 0.0v 989.745n 0.0v 989.755n 0.0v 994.745n 0.0v 994.755n 0.0v 999.745n 0.0v 999.755n 0.0v 1004.745n 0.0v 1004.755n 0.0v 1009.745n 0.0v 1009.755n 0.0v 1014.745n 0.0v 1014.755n 0.0v 1019.745n 0.0v 1019.755n 0.0v 1024.745n 0.0v 1024.755n 0.0v )
* (time, data): [(0, 0), (5, 1), (10, 0), (15, 1), (20, 1), (25, 1), (30, 1), (35, 1), (40, 1), (45, 1), (50, 1), (55, 1), (60, 1), (65, 1), (70, 1), (75, 1), (80, 1), (85, 1), (90, 1), (95, 1), (100, 1), (105, 1), (110, 1), (115, 1), (120, 1), (125, 0), (130, 0), (135, 0), (140, 0), (145, 0), (150, 1), (155, 1), (160, 1), (165, 0), (170, 0), (175, 0), (180, 0), (185, 0), (190, 0), (195, 0), (200, 0), (205, 1), (210, 1), (215, 1), (220, 0), (225, 0), (230, 0), (235, 0), (240, 0), (245, 0), (250, 1), (255, 1), (260, 1), (265, 1), (270, 1), (275, 1), (280, 1), (285, 1), (290, 1), (295, 1), (300, 1), (305, 1), (310, 0), (315, 0), (320, 0), (325, 0), (330, 0), (335, 0), (340, 0), (345, 1), (350, 0), (355, 0), (360, 0), (365, 0), (370, 0), (375, 0), (380, 0), (385, 0), (390, 0), (395, 0), (400, 0), (405, 0), (410, 0), (415, 0), (420, 0), (425, 0), (430, 0), (435, 0), (440, 1), (445, 1), (450, 1), (455, 1), (460, 1), (465, 1), (470, 1), (475, 1), (480, 1), (485, 1), (490, 1), (495, 1), (500, 0), (505, 0), (510, 0), (515, 0), (520, 0), (525, 0), (530, 0), (535, 0), (540, 0), (545, 0), (550, 0), (555, 0), (560, 0), (565, 0), (570, 0), (575, 0), (580, 0), (585, 0), (590, 0), (595, 0), (600, 0), (605, 0), (610, 0), (615, 0), (620, 0), (625, 0), (630, 0), (635, 0), (640, 0), (645, 0), (650, 0), (655, 0), (660, 0), (665, 0), (670, 0), (675, 0), (680, 0), (685, 0), (690, 0), (695, 0), (700, 0), (705, 0), (710, 0), (715, 0), (720, 0), (725, 0), (730, 0), (735, 0), (740, 0), (745, 0), (750, 0), (755, 0), (760, 1), (765, 1), (770, 1), (775, 1), (780, 1), (785, 1), (790, 1), (795, 1), (800, 1), (805, 1), (810, 0), (815, 0), (820, 0), (825, 0), (830, 0), (835, 0), (840, 0), (845, 0), (850, 0), (855, 0), (860, 0), (865, 0), (870, 0), (875, 0), (880, 1), (885, 1), (890, 1), (895, 1), (900, 1), (905, 1), (910, 0), (915, 0), (920, 1), (925, 1), (930, 1), (935, 1), (940, 1), (945, 1), (950, 1), (955, 0), (960, 0), (965, 0), (970, 0), (975, 0), (980, 0), (985, 0), (990, 0), (995, 0), (1000, 0), (1005, 0), (1010, 0), (1015, 0), (1020, 0), (1025, 0)]
Vdin1_18  din1_18  0 PWL (0n 0.0v 4.745n 0.0v 4.755n 1.0v 9.745n 1.0v 9.755n 0.0v 14.745n 0.0v 14.755n 1.0v 19.745n 1.0v 19.755n 1.0v 24.745n 1.0v 24.755n 1.0v 29.745n 1.0v 29.755n 1.0v 34.745n 1.0v 34.755n 1.0v 39.745n 1.0v 39.755n 1.0v 44.745n 1.0v 44.755n 1.0v 49.745n 1.0v 49.755n 1.0v 54.745n 1.0v 54.755n 1.0v 59.745n 1.0v 59.755n 1.0v 64.745n 1.0v 64.755n 1.0v 69.745n 1.0v 69.755n 1.0v 74.745n 1.0v 74.755n 1.0v 79.745n 1.0v 79.755n 1.0v 84.745n 1.0v 84.755n 1.0v 89.745n 1.0v 89.755n 1.0v 94.745n 1.0v 94.755n 1.0v 99.745n 1.0v 99.755n 1.0v 104.745n 1.0v 104.755n 1.0v 109.745n 1.0v 109.755n 1.0v 114.745n 1.0v 114.755n 1.0v 119.745n 1.0v 119.755n 1.0v 124.745n 1.0v 124.755n 0.0v 129.745n 0.0v 129.755n 0.0v 134.745n 0.0v 134.755n 0.0v 139.745n 0.0v 139.755n 0.0v 144.745n 0.0v 144.755n 0.0v 149.745n 0.0v 149.755n 1.0v 154.745n 1.0v 154.755n 1.0v 159.745n 1.0v 159.755n 1.0v 164.745n 1.0v 164.755n 0.0v 169.745n 0.0v 169.755n 0.0v 174.745n 0.0v 174.755n 0.0v 179.745n 0.0v 179.755n 0.0v 184.745n 0.0v 184.755n 0.0v 189.745n 0.0v 189.755n 0.0v 194.745n 0.0v 194.755n 0.0v 199.745n 0.0v 199.755n 0.0v 204.745n 0.0v 204.755n 1.0v 209.745n 1.0v 209.755n 1.0v 214.745n 1.0v 214.755n 1.0v 219.745n 1.0v 219.755n 0.0v 224.745n 0.0v 224.755n 0.0v 229.745n 0.0v 229.755n 0.0v 234.745n 0.0v 234.755n 0.0v 239.745n 0.0v 239.755n 0.0v 244.745n 0.0v 244.755n 0.0v 249.745n 0.0v 249.755n 1.0v 254.745n 1.0v 254.755n 1.0v 259.745n 1.0v 259.755n 1.0v 264.745n 1.0v 264.755n 1.0v 269.745n 1.0v 269.755n 1.0v 274.745n 1.0v 274.755n 1.0v 279.745n 1.0v 279.755n 1.0v 284.745n 1.0v 284.755n 1.0v 289.745n 1.0v 289.755n 1.0v 294.745n 1.0v 294.755n 1.0v 299.745n 1.0v 299.755n 1.0v 304.745n 1.0v 304.755n 1.0v 309.745n 1.0v 309.755n 0.0v 314.745n 0.0v 314.755n 0.0v 319.745n 0.0v 319.755n 0.0v 324.745n 0.0v 324.755n 0.0v 329.745n 0.0v 329.755n 0.0v 334.745n 0.0v 334.755n 0.0v 339.745n 0.0v 339.755n 0.0v 344.745n 0.0v 344.755n 1.0v 349.745n 1.0v 349.755n 0.0v 354.745n 0.0v 354.755n 0.0v 359.745n 0.0v 359.755n 0.0v 364.745n 0.0v 364.755n 0.0v 369.745n 0.0v 369.755n 0.0v 374.745n 0.0v 374.755n 0.0v 379.745n 0.0v 379.755n 0.0v 384.745n 0.0v 384.755n 0.0v 389.745n 0.0v 389.755n 0.0v 394.745n 0.0v 394.755n 0.0v 399.745n 0.0v 399.755n 0.0v 404.745n 0.0v 404.755n 0.0v 409.745n 0.0v 409.755n 0.0v 414.745n 0.0v 414.755n 0.0v 419.745n 0.0v 419.755n 0.0v 424.745n 0.0v 424.755n 0.0v 429.745n 0.0v 429.755n 0.0v 434.745n 0.0v 434.755n 0.0v 439.745n 0.0v 439.755n 1.0v 444.745n 1.0v 444.755n 1.0v 449.745n 1.0v 449.755n 1.0v 454.745n 1.0v 454.755n 1.0v 459.745n 1.0v 459.755n 1.0v 464.745n 1.0v 464.755n 1.0v 469.745n 1.0v 469.755n 1.0v 474.745n 1.0v 474.755n 1.0v 479.745n 1.0v 479.755n 1.0v 484.745n 1.0v 484.755n 1.0v 489.745n 1.0v 489.755n 1.0v 494.745n 1.0v 494.755n 1.0v 499.745n 1.0v 499.755n 0.0v 504.745n 0.0v 504.755n 0.0v 509.745n 0.0v 509.755n 0.0v 514.745n 0.0v 514.755n 0.0v 519.745n 0.0v 519.755n 0.0v 524.745n 0.0v 524.755n 0.0v 529.745n 0.0v 529.755n 0.0v 534.745n 0.0v 534.755n 0.0v 539.745n 0.0v 539.755n 0.0v 544.745n 0.0v 544.755n 0.0v 549.745n 0.0v 549.755n 0.0v 554.745n 0.0v 554.755n 0.0v 559.745n 0.0v 559.755n 0.0v 564.745n 0.0v 564.755n 0.0v 569.745n 0.0v 569.755n 0.0v 574.745n 0.0v 574.755n 0.0v 579.745n 0.0v 579.755n 0.0v 584.745n 0.0v 584.755n 0.0v 589.745n 0.0v 589.755n 0.0v 594.745n 0.0v 594.755n 0.0v 599.745n 0.0v 599.755n 0.0v 604.745n 0.0v 604.755n 0.0v 609.745n 0.0v 609.755n 0.0v 614.745n 0.0v 614.755n 0.0v 619.745n 0.0v 619.755n 0.0v 624.745n 0.0v 624.755n 0.0v 629.745n 0.0v 629.755n 0.0v 634.745n 0.0v 634.755n 0.0v 639.745n 0.0v 639.755n 0.0v 644.745n 0.0v 644.755n 0.0v 649.745n 0.0v 649.755n 0.0v 654.745n 0.0v 654.755n 0.0v 659.745n 0.0v 659.755n 0.0v 664.745n 0.0v 664.755n 0.0v 669.745n 0.0v 669.755n 0.0v 674.745n 0.0v 674.755n 0.0v 679.745n 0.0v 679.755n 0.0v 684.745n 0.0v 684.755n 0.0v 689.745n 0.0v 689.755n 0.0v 694.745n 0.0v 694.755n 0.0v 699.745n 0.0v 699.755n 0.0v 704.745n 0.0v 704.755n 0.0v 709.745n 0.0v 709.755n 0.0v 714.745n 0.0v 714.755n 0.0v 719.745n 0.0v 719.755n 0.0v 724.745n 0.0v 724.755n 0.0v 729.745n 0.0v 729.755n 0.0v 734.745n 0.0v 734.755n 0.0v 739.745n 0.0v 739.755n 0.0v 744.745n 0.0v 744.755n 0.0v 749.745n 0.0v 749.755n 0.0v 754.745n 0.0v 754.755n 0.0v 759.745n 0.0v 759.755n 1.0v 764.745n 1.0v 764.755n 1.0v 769.745n 1.0v 769.755n 1.0v 774.745n 1.0v 774.755n 1.0v 779.745n 1.0v 779.755n 1.0v 784.745n 1.0v 784.755n 1.0v 789.745n 1.0v 789.755n 1.0v 794.745n 1.0v 794.755n 1.0v 799.745n 1.0v 799.755n 1.0v 804.745n 1.0v 804.755n 1.0v 809.745n 1.0v 809.755n 0.0v 814.745n 0.0v 814.755n 0.0v 819.745n 0.0v 819.755n 0.0v 824.745n 0.0v 824.755n 0.0v 829.745n 0.0v 829.755n 0.0v 834.745n 0.0v 834.755n 0.0v 839.745n 0.0v 839.755n 0.0v 844.745n 0.0v 844.755n 0.0v 849.745n 0.0v 849.755n 0.0v 854.745n 0.0v 854.755n 0.0v 859.745n 0.0v 859.755n 0.0v 864.745n 0.0v 864.755n 0.0v 869.745n 0.0v 869.755n 0.0v 874.745n 0.0v 874.755n 0.0v 879.745n 0.0v 879.755n 1.0v 884.745n 1.0v 884.755n 1.0v 889.745n 1.0v 889.755n 1.0v 894.745n 1.0v 894.755n 1.0v 899.745n 1.0v 899.755n 1.0v 904.745n 1.0v 904.755n 1.0v 909.745n 1.0v 909.755n 0.0v 914.745n 0.0v 914.755n 0.0v 919.745n 0.0v 919.755n 1.0v 924.745n 1.0v 924.755n 1.0v 929.745n 1.0v 929.755n 1.0v 934.745n 1.0v 934.755n 1.0v 939.745n 1.0v 939.755n 1.0v 944.745n 1.0v 944.755n 1.0v 949.745n 1.0v 949.755n 1.0v 954.745n 1.0v 954.755n 0.0v 959.745n 0.0v 959.755n 0.0v 964.745n 0.0v 964.755n 0.0v 969.745n 0.0v 969.755n 0.0v 974.745n 0.0v 974.755n 0.0v 979.745n 0.0v 979.755n 0.0v 984.745n 0.0v 984.755n 0.0v 989.745n 0.0v 989.755n 0.0v 994.745n 0.0v 994.755n 0.0v 999.745n 0.0v 999.755n 0.0v 1004.745n 0.0v 1004.755n 0.0v 1009.745n 0.0v 1009.755n 0.0v 1014.745n 0.0v 1014.755n 0.0v 1019.745n 0.0v 1019.755n 0.0v 1024.745n 0.0v 1024.755n 0.0v )
* (time, data): [(0, 0), (5, 0), (10, 1), (15, 1), (20, 1), (25, 1), (30, 1), (35, 0), (40, 0), (45, 0), (50, 1), (55, 1), (60, 1), (65, 1), (70, 1), (75, 1), (80, 1), (85, 1), (90, 1), (95, 1), (100, 1), (105, 1), (110, 1), (115, 0), (120, 0), (125, 0), (130, 0), (135, 0), (140, 0), (145, 0), (150, 1), (155, 1), (160, 1), (165, 0), (170, 0), (175, 0), (180, 0), (185, 0), (190, 0), (195, 0), (200, 0), (205, 0), (210, 0), (215, 0), (220, 1), (225, 1), (230, 1), (235, 1), (240, 0), (245, 0), (250, 0), (255, 0), (260, 0), (265, 0), (270, 0), (275, 0), (280, 0), (285, 0), (290, 0), (295, 0), (300, 0), (305, 0), (310, 1), (315, 1), (320, 1), (325, 1), (330, 1), (335, 1), (340, 1), (345, 0), (350, 1), (355, 1), (360, 0), (365, 0), (370, 0), (375, 0), (380, 0), (385, 0), (390, 0), (395, 0), (400, 1), (405, 1), (410, 1), (415, 1), (420, 1), (425, 1), (430, 1), (435, 1), (440, 0), (445, 0), (450, 0), (455, 0), (460, 0), (465, 0), (470, 0), (475, 0), (480, 0), (485, 0), (490, 0), (495, 0), (500, 0), (505, 0), (510, 0), (515, 0), (520, 0), (525, 0), (530, 0), (535, 0), (540, 0), (545, 0), (550, 0), (555, 0), (560, 0), (565, 0), (570, 0), (575, 0), (580, 0), (585, 0), (590, 0), (595, 0), (600, 0), (605, 0), (610, 0), (615, 0), (620, 0), (625, 0), (630, 0), (635, 0), (640, 0), (645, 0), (650, 0), (655, 0), (660, 0), (665, 0), (670, 0), (675, 0), (680, 0), (685, 0), (690, 0), (695, 0), (700, 0), (705, 0), (710, 0), (715, 0), (720, 0), (725, 0), (730, 0), (735, 0), (740, 0), (745, 0), (750, 0), (755, 0), (760, 0), (765, 0), (770, 0), (775, 0), (780, 0), (785, 0), (790, 0), (795, 0), (800, 0), (805, 0), (810, 0), (815, 0), (820, 0), (825, 0), (830, 0), (835, 0), (840, 0), (845, 0), (850, 0), (855, 0), (860, 0), (865, 0), (870, 0), (875, 0), (880, 0), (885, 0), (890, 0), (895, 0), (900, 0), (905, 0), (910, 0), (915, 0), (920, 1), (925, 1), (930, 0), (935, 0), (940, 0), (945, 0), (950, 1), (955, 1), (960, 1), (965, 1), (970, 1), (975, 1), (980, 1), (985, 1), (990, 1), (995, 1), (1000, 1), (1005, 1), (1010, 1), (1015, 1), (1020, 1), (1025, 1)]
Vdin1_19  din1_19  0 PWL (0n 0.0v 4.745n 0.0v 4.755n 0.0v 9.745n 0.0v 9.755n 1.0v 14.745n 1.0v 14.755n 1.0v 19.745n 1.0v 19.755n 1.0v 24.745n 1.0v 24.755n 1.0v 29.745n 1.0v 29.755n 1.0v 34.745n 1.0v 34.755n 0.0v 39.745n 0.0v 39.755n 0.0v 44.745n 0.0v 44.755n 0.0v 49.745n 0.0v 49.755n 1.0v 54.745n 1.0v 54.755n 1.0v 59.745n 1.0v 59.755n 1.0v 64.745n 1.0v 64.755n 1.0v 69.745n 1.0v 69.755n 1.0v 74.745n 1.0v 74.755n 1.0v 79.745n 1.0v 79.755n 1.0v 84.745n 1.0v 84.755n 1.0v 89.745n 1.0v 89.755n 1.0v 94.745n 1.0v 94.755n 1.0v 99.745n 1.0v 99.755n 1.0v 104.745n 1.0v 104.755n 1.0v 109.745n 1.0v 109.755n 1.0v 114.745n 1.0v 114.755n 0.0v 119.745n 0.0v 119.755n 0.0v 124.745n 0.0v 124.755n 0.0v 129.745n 0.0v 129.755n 0.0v 134.745n 0.0v 134.755n 0.0v 139.745n 0.0v 139.755n 0.0v 144.745n 0.0v 144.755n 0.0v 149.745n 0.0v 149.755n 1.0v 154.745n 1.0v 154.755n 1.0v 159.745n 1.0v 159.755n 1.0v 164.745n 1.0v 164.755n 0.0v 169.745n 0.0v 169.755n 0.0v 174.745n 0.0v 174.755n 0.0v 179.745n 0.0v 179.755n 0.0v 184.745n 0.0v 184.755n 0.0v 189.745n 0.0v 189.755n 0.0v 194.745n 0.0v 194.755n 0.0v 199.745n 0.0v 199.755n 0.0v 204.745n 0.0v 204.755n 0.0v 209.745n 0.0v 209.755n 0.0v 214.745n 0.0v 214.755n 0.0v 219.745n 0.0v 219.755n 1.0v 224.745n 1.0v 224.755n 1.0v 229.745n 1.0v 229.755n 1.0v 234.745n 1.0v 234.755n 1.0v 239.745n 1.0v 239.755n 0.0v 244.745n 0.0v 244.755n 0.0v 249.745n 0.0v 249.755n 0.0v 254.745n 0.0v 254.755n 0.0v 259.745n 0.0v 259.755n 0.0v 264.745n 0.0v 264.755n 0.0v 269.745n 0.0v 269.755n 0.0v 274.745n 0.0v 274.755n 0.0v 279.745n 0.0v 279.755n 0.0v 284.745n 0.0v 284.755n 0.0v 289.745n 0.0v 289.755n 0.0v 294.745n 0.0v 294.755n 0.0v 299.745n 0.0v 299.755n 0.0v 304.745n 0.0v 304.755n 0.0v 309.745n 0.0v 309.755n 1.0v 314.745n 1.0v 314.755n 1.0v 319.745n 1.0v 319.755n 1.0v 324.745n 1.0v 324.755n 1.0v 329.745n 1.0v 329.755n 1.0v 334.745n 1.0v 334.755n 1.0v 339.745n 1.0v 339.755n 1.0v 344.745n 1.0v 344.755n 0.0v 349.745n 0.0v 349.755n 1.0v 354.745n 1.0v 354.755n 1.0v 359.745n 1.0v 359.755n 0.0v 364.745n 0.0v 364.755n 0.0v 369.745n 0.0v 369.755n 0.0v 374.745n 0.0v 374.755n 0.0v 379.745n 0.0v 379.755n 0.0v 384.745n 0.0v 384.755n 0.0v 389.745n 0.0v 389.755n 0.0v 394.745n 0.0v 394.755n 0.0v 399.745n 0.0v 399.755n 1.0v 404.745n 1.0v 404.755n 1.0v 409.745n 1.0v 409.755n 1.0v 414.745n 1.0v 414.755n 1.0v 419.745n 1.0v 419.755n 1.0v 424.745n 1.0v 424.755n 1.0v 429.745n 1.0v 429.755n 1.0v 434.745n 1.0v 434.755n 1.0v 439.745n 1.0v 439.755n 0.0v 444.745n 0.0v 444.755n 0.0v 449.745n 0.0v 449.755n 0.0v 454.745n 0.0v 454.755n 0.0v 459.745n 0.0v 459.755n 0.0v 464.745n 0.0v 464.755n 0.0v 469.745n 0.0v 469.755n 0.0v 474.745n 0.0v 474.755n 0.0v 479.745n 0.0v 479.755n 0.0v 484.745n 0.0v 484.755n 0.0v 489.745n 0.0v 489.755n 0.0v 494.745n 0.0v 494.755n 0.0v 499.745n 0.0v 499.755n 0.0v 504.745n 0.0v 504.755n 0.0v 509.745n 0.0v 509.755n 0.0v 514.745n 0.0v 514.755n 0.0v 519.745n 0.0v 519.755n 0.0v 524.745n 0.0v 524.755n 0.0v 529.745n 0.0v 529.755n 0.0v 534.745n 0.0v 534.755n 0.0v 539.745n 0.0v 539.755n 0.0v 544.745n 0.0v 544.755n 0.0v 549.745n 0.0v 549.755n 0.0v 554.745n 0.0v 554.755n 0.0v 559.745n 0.0v 559.755n 0.0v 564.745n 0.0v 564.755n 0.0v 569.745n 0.0v 569.755n 0.0v 574.745n 0.0v 574.755n 0.0v 579.745n 0.0v 579.755n 0.0v 584.745n 0.0v 584.755n 0.0v 589.745n 0.0v 589.755n 0.0v 594.745n 0.0v 594.755n 0.0v 599.745n 0.0v 599.755n 0.0v 604.745n 0.0v 604.755n 0.0v 609.745n 0.0v 609.755n 0.0v 614.745n 0.0v 614.755n 0.0v 619.745n 0.0v 619.755n 0.0v 624.745n 0.0v 624.755n 0.0v 629.745n 0.0v 629.755n 0.0v 634.745n 0.0v 634.755n 0.0v 639.745n 0.0v 639.755n 0.0v 644.745n 0.0v 644.755n 0.0v 649.745n 0.0v 649.755n 0.0v 654.745n 0.0v 654.755n 0.0v 659.745n 0.0v 659.755n 0.0v 664.745n 0.0v 664.755n 0.0v 669.745n 0.0v 669.755n 0.0v 674.745n 0.0v 674.755n 0.0v 679.745n 0.0v 679.755n 0.0v 684.745n 0.0v 684.755n 0.0v 689.745n 0.0v 689.755n 0.0v 694.745n 0.0v 694.755n 0.0v 699.745n 0.0v 699.755n 0.0v 704.745n 0.0v 704.755n 0.0v 709.745n 0.0v 709.755n 0.0v 714.745n 0.0v 714.755n 0.0v 719.745n 0.0v 719.755n 0.0v 724.745n 0.0v 724.755n 0.0v 729.745n 0.0v 729.755n 0.0v 734.745n 0.0v 734.755n 0.0v 739.745n 0.0v 739.755n 0.0v 744.745n 0.0v 744.755n 0.0v 749.745n 0.0v 749.755n 0.0v 754.745n 0.0v 754.755n 0.0v 759.745n 0.0v 759.755n 0.0v 764.745n 0.0v 764.755n 0.0v 769.745n 0.0v 769.755n 0.0v 774.745n 0.0v 774.755n 0.0v 779.745n 0.0v 779.755n 0.0v 784.745n 0.0v 784.755n 0.0v 789.745n 0.0v 789.755n 0.0v 794.745n 0.0v 794.755n 0.0v 799.745n 0.0v 799.755n 0.0v 804.745n 0.0v 804.755n 0.0v 809.745n 0.0v 809.755n 0.0v 814.745n 0.0v 814.755n 0.0v 819.745n 0.0v 819.755n 0.0v 824.745n 0.0v 824.755n 0.0v 829.745n 0.0v 829.755n 0.0v 834.745n 0.0v 834.755n 0.0v 839.745n 0.0v 839.755n 0.0v 844.745n 0.0v 844.755n 0.0v 849.745n 0.0v 849.755n 0.0v 854.745n 0.0v 854.755n 0.0v 859.745n 0.0v 859.755n 0.0v 864.745n 0.0v 864.755n 0.0v 869.745n 0.0v 869.755n 0.0v 874.745n 0.0v 874.755n 0.0v 879.745n 0.0v 879.755n 0.0v 884.745n 0.0v 884.755n 0.0v 889.745n 0.0v 889.755n 0.0v 894.745n 0.0v 894.755n 0.0v 899.745n 0.0v 899.755n 0.0v 904.745n 0.0v 904.755n 0.0v 909.745n 0.0v 909.755n 0.0v 914.745n 0.0v 914.755n 0.0v 919.745n 0.0v 919.755n 1.0v 924.745n 1.0v 924.755n 1.0v 929.745n 1.0v 929.755n 0.0v 934.745n 0.0v 934.755n 0.0v 939.745n 0.0v 939.755n 0.0v 944.745n 0.0v 944.755n 0.0v 949.745n 0.0v 949.755n 1.0v 954.745n 1.0v 954.755n 1.0v 959.745n 1.0v 959.755n 1.0v 964.745n 1.0v 964.755n 1.0v 969.745n 1.0v 969.755n 1.0v 974.745n 1.0v 974.755n 1.0v 979.745n 1.0v 979.755n 1.0v 984.745n 1.0v 984.755n 1.0v 989.745n 1.0v 989.755n 1.0v 994.745n 1.0v 994.755n 1.0v 999.745n 1.0v 999.755n 1.0v 1004.745n 1.0v 1004.755n 1.0v 1009.745n 1.0v 1009.755n 1.0v 1014.745n 1.0v 1014.755n 1.0v 1019.745n 1.0v 1019.755n 1.0v 1024.745n 1.0v 1024.755n 1.0v )
* (time, data): [(0, 0), (5, 1), (10, 1), (15, 1), (20, 1), (25, 1), (30, 1), (35, 0), (40, 0), (45, 0), (50, 0), (55, 0), (60, 0), (65, 0), (70, 0), (75, 0), (80, 0), (85, 1), (90, 1), (95, 1), (100, 1), (105, 1), (110, 1), (115, 0), (120, 0), (125, 0), (130, 0), (135, 0), (140, 0), (145, 0), (150, 1), (155, 1), (160, 1), (165, 1), (170, 1), (175, 1), (180, 1), (185, 1), (190, 1), (195, 1), (200, 1), (205, 0), (210, 0), (215, 0), (220, 1), (225, 1), (230, 1), (235, 1), (240, 1), (245, 1), (250, 0), (255, 0), (260, 0), (265, 0), (270, 0), (275, 0), (280, 0), (285, 0), (290, 0), (295, 0), (300, 0), (305, 0), (310, 0), (315, 0), (320, 0), (325, 0), (330, 0), (335, 0), (340, 0), (345, 0), (350, 1), (355, 1), (360, 1), (365, 1), (370, 1), (375, 1), (380, 1), (385, 1), (390, 1), (395, 1), (400, 1), (405, 0), (410, 0), (415, 0), (420, 0), (425, 0), (430, 0), (435, 0), (440, 1), (445, 1), (450, 1), (455, 1), (460, 1), (465, 1), (470, 1), (475, 1), (480, 1), (485, 1), (490, 1), (495, 1), (500, 1), (505, 1), (510, 1), (515, 1), (520, 1), (525, 1), (530, 1), (535, 0), (540, 1), (545, 1), (550, 1), (555, 1), (560, 1), (565, 1), (570, 1), (575, 1), (580, 1), (585, 1), (590, 1), (595, 1), (600, 1), (605, 1), (610, 1), (615, 1), (620, 1), (625, 1), (630, 1), (635, 1), (640, 1), (645, 1), (650, 1), (655, 1), (660, 1), (665, 1), (670, 1), (675, 1), (680, 1), (685, 1), (690, 1), (695, 1), (700, 1), (705, 1), (710, 1), (715, 1), (720, 1), (725, 1), (730, 1), (735, 1), (740, 1), (745, 1), (750, 1), (755, 1), (760, 1), (765, 1), (770, 1), (775, 1), (780, 0), (785, 0), (790, 0), (795, 0), (800, 0), (805, 0), (810, 1), (815, 1), (820, 1), (825, 1), (830, 1), (835, 1), (840, 1), (845, 1), (850, 1), (855, 1), (860, 1), (865, 1), (870, 1), (875, 1), (880, 1), (885, 1), (890, 1), (895, 1), (900, 1), (905, 1), (910, 0), (915, 0), (920, 1), (925, 1), (930, 0), (935, 1), (940, 1), (945, 1), (950, 0), (955, 1), (960, 1), (965, 1), (970, 1), (975, 1), (980, 1), (985, 1), (990, 1), (995, 1), (1000, 1), (1005, 0), (1010, 0), (1015, 0), (1020, 0), (1025, 0)]
Vdin1_20  din1_20  0 PWL (0n 0.0v 4.745n 0.0v 4.755n 1.0v 9.745n 1.0v 9.755n 1.0v 14.745n 1.0v 14.755n 1.0v 19.745n 1.0v 19.755n 1.0v 24.745n 1.0v 24.755n 1.0v 29.745n 1.0v 29.755n 1.0v 34.745n 1.0v 34.755n 0.0v 39.745n 0.0v 39.755n 0.0v 44.745n 0.0v 44.755n 0.0v 49.745n 0.0v 49.755n 0.0v 54.745n 0.0v 54.755n 0.0v 59.745n 0.0v 59.755n 0.0v 64.745n 0.0v 64.755n 0.0v 69.745n 0.0v 69.755n 0.0v 74.745n 0.0v 74.755n 0.0v 79.745n 0.0v 79.755n 0.0v 84.745n 0.0v 84.755n 1.0v 89.745n 1.0v 89.755n 1.0v 94.745n 1.0v 94.755n 1.0v 99.745n 1.0v 99.755n 1.0v 104.745n 1.0v 104.755n 1.0v 109.745n 1.0v 109.755n 1.0v 114.745n 1.0v 114.755n 0.0v 119.745n 0.0v 119.755n 0.0v 124.745n 0.0v 124.755n 0.0v 129.745n 0.0v 129.755n 0.0v 134.745n 0.0v 134.755n 0.0v 139.745n 0.0v 139.755n 0.0v 144.745n 0.0v 144.755n 0.0v 149.745n 0.0v 149.755n 1.0v 154.745n 1.0v 154.755n 1.0v 159.745n 1.0v 159.755n 1.0v 164.745n 1.0v 164.755n 1.0v 169.745n 1.0v 169.755n 1.0v 174.745n 1.0v 174.755n 1.0v 179.745n 1.0v 179.755n 1.0v 184.745n 1.0v 184.755n 1.0v 189.745n 1.0v 189.755n 1.0v 194.745n 1.0v 194.755n 1.0v 199.745n 1.0v 199.755n 1.0v 204.745n 1.0v 204.755n 0.0v 209.745n 0.0v 209.755n 0.0v 214.745n 0.0v 214.755n 0.0v 219.745n 0.0v 219.755n 1.0v 224.745n 1.0v 224.755n 1.0v 229.745n 1.0v 229.755n 1.0v 234.745n 1.0v 234.755n 1.0v 239.745n 1.0v 239.755n 1.0v 244.745n 1.0v 244.755n 1.0v 249.745n 1.0v 249.755n 0.0v 254.745n 0.0v 254.755n 0.0v 259.745n 0.0v 259.755n 0.0v 264.745n 0.0v 264.755n 0.0v 269.745n 0.0v 269.755n 0.0v 274.745n 0.0v 274.755n 0.0v 279.745n 0.0v 279.755n 0.0v 284.745n 0.0v 284.755n 0.0v 289.745n 0.0v 289.755n 0.0v 294.745n 0.0v 294.755n 0.0v 299.745n 0.0v 299.755n 0.0v 304.745n 0.0v 304.755n 0.0v 309.745n 0.0v 309.755n 0.0v 314.745n 0.0v 314.755n 0.0v 319.745n 0.0v 319.755n 0.0v 324.745n 0.0v 324.755n 0.0v 329.745n 0.0v 329.755n 0.0v 334.745n 0.0v 334.755n 0.0v 339.745n 0.0v 339.755n 0.0v 344.745n 0.0v 344.755n 0.0v 349.745n 0.0v 349.755n 1.0v 354.745n 1.0v 354.755n 1.0v 359.745n 1.0v 359.755n 1.0v 364.745n 1.0v 364.755n 1.0v 369.745n 1.0v 369.755n 1.0v 374.745n 1.0v 374.755n 1.0v 379.745n 1.0v 379.755n 1.0v 384.745n 1.0v 384.755n 1.0v 389.745n 1.0v 389.755n 1.0v 394.745n 1.0v 394.755n 1.0v 399.745n 1.0v 399.755n 1.0v 404.745n 1.0v 404.755n 0.0v 409.745n 0.0v 409.755n 0.0v 414.745n 0.0v 414.755n 0.0v 419.745n 0.0v 419.755n 0.0v 424.745n 0.0v 424.755n 0.0v 429.745n 0.0v 429.755n 0.0v 434.745n 0.0v 434.755n 0.0v 439.745n 0.0v 439.755n 1.0v 444.745n 1.0v 444.755n 1.0v 449.745n 1.0v 449.755n 1.0v 454.745n 1.0v 454.755n 1.0v 459.745n 1.0v 459.755n 1.0v 464.745n 1.0v 464.755n 1.0v 469.745n 1.0v 469.755n 1.0v 474.745n 1.0v 474.755n 1.0v 479.745n 1.0v 479.755n 1.0v 484.745n 1.0v 484.755n 1.0v 489.745n 1.0v 489.755n 1.0v 494.745n 1.0v 494.755n 1.0v 499.745n 1.0v 499.755n 1.0v 504.745n 1.0v 504.755n 1.0v 509.745n 1.0v 509.755n 1.0v 514.745n 1.0v 514.755n 1.0v 519.745n 1.0v 519.755n 1.0v 524.745n 1.0v 524.755n 1.0v 529.745n 1.0v 529.755n 1.0v 534.745n 1.0v 534.755n 0.0v 539.745n 0.0v 539.755n 1.0v 544.745n 1.0v 544.755n 1.0v 549.745n 1.0v 549.755n 1.0v 554.745n 1.0v 554.755n 1.0v 559.745n 1.0v 559.755n 1.0v 564.745n 1.0v 564.755n 1.0v 569.745n 1.0v 569.755n 1.0v 574.745n 1.0v 574.755n 1.0v 579.745n 1.0v 579.755n 1.0v 584.745n 1.0v 584.755n 1.0v 589.745n 1.0v 589.755n 1.0v 594.745n 1.0v 594.755n 1.0v 599.745n 1.0v 599.755n 1.0v 604.745n 1.0v 604.755n 1.0v 609.745n 1.0v 609.755n 1.0v 614.745n 1.0v 614.755n 1.0v 619.745n 1.0v 619.755n 1.0v 624.745n 1.0v 624.755n 1.0v 629.745n 1.0v 629.755n 1.0v 634.745n 1.0v 634.755n 1.0v 639.745n 1.0v 639.755n 1.0v 644.745n 1.0v 644.755n 1.0v 649.745n 1.0v 649.755n 1.0v 654.745n 1.0v 654.755n 1.0v 659.745n 1.0v 659.755n 1.0v 664.745n 1.0v 664.755n 1.0v 669.745n 1.0v 669.755n 1.0v 674.745n 1.0v 674.755n 1.0v 679.745n 1.0v 679.755n 1.0v 684.745n 1.0v 684.755n 1.0v 689.745n 1.0v 689.755n 1.0v 694.745n 1.0v 694.755n 1.0v 699.745n 1.0v 699.755n 1.0v 704.745n 1.0v 704.755n 1.0v 709.745n 1.0v 709.755n 1.0v 714.745n 1.0v 714.755n 1.0v 719.745n 1.0v 719.755n 1.0v 724.745n 1.0v 724.755n 1.0v 729.745n 1.0v 729.755n 1.0v 734.745n 1.0v 734.755n 1.0v 739.745n 1.0v 739.755n 1.0v 744.745n 1.0v 744.755n 1.0v 749.745n 1.0v 749.755n 1.0v 754.745n 1.0v 754.755n 1.0v 759.745n 1.0v 759.755n 1.0v 764.745n 1.0v 764.755n 1.0v 769.745n 1.0v 769.755n 1.0v 774.745n 1.0v 774.755n 1.0v 779.745n 1.0v 779.755n 0.0v 784.745n 0.0v 784.755n 0.0v 789.745n 0.0v 789.755n 0.0v 794.745n 0.0v 794.755n 0.0v 799.745n 0.0v 799.755n 0.0v 804.745n 0.0v 804.755n 0.0v 809.745n 0.0v 809.755n 1.0v 814.745n 1.0v 814.755n 1.0v 819.745n 1.0v 819.755n 1.0v 824.745n 1.0v 824.755n 1.0v 829.745n 1.0v 829.755n 1.0v 834.745n 1.0v 834.755n 1.0v 839.745n 1.0v 839.755n 1.0v 844.745n 1.0v 844.755n 1.0v 849.745n 1.0v 849.755n 1.0v 854.745n 1.0v 854.755n 1.0v 859.745n 1.0v 859.755n 1.0v 864.745n 1.0v 864.755n 1.0v 869.745n 1.0v 869.755n 1.0v 874.745n 1.0v 874.755n 1.0v 879.745n 1.0v 879.755n 1.0v 884.745n 1.0v 884.755n 1.0v 889.745n 1.0v 889.755n 1.0v 894.745n 1.0v 894.755n 1.0v 899.745n 1.0v 899.755n 1.0v 904.745n 1.0v 904.755n 1.0v 909.745n 1.0v 909.755n 0.0v 914.745n 0.0v 914.755n 0.0v 919.745n 0.0v 919.755n 1.0v 924.745n 1.0v 924.755n 1.0v 929.745n 1.0v 929.755n 0.0v 934.745n 0.0v 934.755n 1.0v 939.745n 1.0v 939.755n 1.0v 944.745n 1.0v 944.755n 1.0v 949.745n 1.0v 949.755n 0.0v 954.745n 0.0v 954.755n 1.0v 959.745n 1.0v 959.755n 1.0v 964.745n 1.0v 964.755n 1.0v 969.745n 1.0v 969.755n 1.0v 974.745n 1.0v 974.755n 1.0v 979.745n 1.0v 979.755n 1.0v 984.745n 1.0v 984.755n 1.0v 989.745n 1.0v 989.755n 1.0v 994.745n 1.0v 994.755n 1.0v 999.745n 1.0v 999.755n 1.0v 1004.745n 1.0v 1004.755n 0.0v 1009.745n 0.0v 1009.755n 0.0v 1014.745n 0.0v 1014.755n 0.0v 1019.745n 0.0v 1019.755n 0.0v 1024.745n 0.0v 1024.755n 0.0v )
* (time, data): [(0, 0), (5, 0), (10, 1), (15, 0), (20, 0), (25, 0), (30, 0), (35, 0), (40, 0), (45, 0), (50, 1), (55, 1), (60, 1), (65, 1), (70, 1), (75, 1), (80, 1), (85, 1), (90, 1), (95, 1), (100, 0), (105, 0), (110, 0), (115, 1), (120, 1), (125, 1), (130, 1), (135, 1), (140, 1), (145, 1), (150, 0), (155, 0), (160, 0), (165, 1), (170, 1), (175, 1), (180, 1), (185, 1), (190, 1), (195, 1), (200, 1), (205, 1), (210, 1), (215, 1), (220, 0), (225, 0), (230, 0), (235, 0), (240, 1), (245, 1), (250, 1), (255, 1), (260, 0), (265, 0), (270, 0), (275, 1), (280, 1), (285, 1), (290, 1), (295, 1), (300, 1), (305, 1), (310, 1), (315, 1), (320, 1), (325, 1), (330, 1), (335, 1), (340, 1), (345, 0), (350, 1), (355, 1), (360, 0), (365, 0), (370, 0), (375, 0), (380, 0), (385, 0), (390, 0), (395, 0), (400, 1), (405, 1), (410, 1), (415, 1), (420, 1), (425, 1), (430, 1), (435, 1), (440, 0), (445, 0), (450, 0), (455, 0), (460, 0), (465, 0), (470, 0), (475, 0), (480, 0), (485, 0), (490, 0), (495, 0), (500, 1), (505, 1), (510, 1), (515, 1), (520, 1), (525, 1), (530, 1), (535, 1), (540, 0), (545, 0), (550, 0), (555, 0), (560, 0), (565, 0), (570, 0), (575, 0), (580, 0), (585, 0), (590, 0), (595, 0), (600, 0), (605, 0), (610, 0), (615, 0), (620, 0), (625, 0), (630, 0), (635, 0), (640, 0), (645, 0), (650, 0), (655, 1), (660, 1), (665, 1), (670, 1), (675, 1), (680, 1), (685, 1), (690, 1), (695, 1), (700, 1), (705, 1), (710, 1), (715, 1), (720, 1), (725, 1), (730, 1), (735, 1), (740, 1), (745, 1), (750, 1), (755, 1), (760, 1), (765, 1), (770, 1), (775, 1), (780, 0), (785, 0), (790, 0), (795, 0), (800, 0), (805, 0), (810, 1), (815, 1), (820, 1), (825, 1), (830, 1), (835, 1), (840, 1), (845, 1), (850, 1), (855, 1), (860, 0), (865, 0), (870, 0), (875, 0), (880, 0), (885, 0), (890, 0), (895, 0), (900, 0), (905, 0), (910, 0), (915, 0), (920, 0), (925, 0), (930, 0), (935, 0), (940, 0), (945, 0), (950, 1), (955, 0), (960, 0), (965, 0), (970, 0), (975, 0), (980, 0), (985, 1), (990, 1), (995, 1), (1000, 1), (1005, 1), (1010, 1), (1015, 1), (1020, 1), (1025, 1)]
Vdin1_21  din1_21  0 PWL (0n 0.0v 4.745n 0.0v 4.755n 0.0v 9.745n 0.0v 9.755n 1.0v 14.745n 1.0v 14.755n 0.0v 19.745n 0.0v 19.755n 0.0v 24.745n 0.0v 24.755n 0.0v 29.745n 0.0v 29.755n 0.0v 34.745n 0.0v 34.755n 0.0v 39.745n 0.0v 39.755n 0.0v 44.745n 0.0v 44.755n 0.0v 49.745n 0.0v 49.755n 1.0v 54.745n 1.0v 54.755n 1.0v 59.745n 1.0v 59.755n 1.0v 64.745n 1.0v 64.755n 1.0v 69.745n 1.0v 69.755n 1.0v 74.745n 1.0v 74.755n 1.0v 79.745n 1.0v 79.755n 1.0v 84.745n 1.0v 84.755n 1.0v 89.745n 1.0v 89.755n 1.0v 94.745n 1.0v 94.755n 1.0v 99.745n 1.0v 99.755n 0.0v 104.745n 0.0v 104.755n 0.0v 109.745n 0.0v 109.755n 0.0v 114.745n 0.0v 114.755n 1.0v 119.745n 1.0v 119.755n 1.0v 124.745n 1.0v 124.755n 1.0v 129.745n 1.0v 129.755n 1.0v 134.745n 1.0v 134.755n 1.0v 139.745n 1.0v 139.755n 1.0v 144.745n 1.0v 144.755n 1.0v 149.745n 1.0v 149.755n 0.0v 154.745n 0.0v 154.755n 0.0v 159.745n 0.0v 159.755n 0.0v 164.745n 0.0v 164.755n 1.0v 169.745n 1.0v 169.755n 1.0v 174.745n 1.0v 174.755n 1.0v 179.745n 1.0v 179.755n 1.0v 184.745n 1.0v 184.755n 1.0v 189.745n 1.0v 189.755n 1.0v 194.745n 1.0v 194.755n 1.0v 199.745n 1.0v 199.755n 1.0v 204.745n 1.0v 204.755n 1.0v 209.745n 1.0v 209.755n 1.0v 214.745n 1.0v 214.755n 1.0v 219.745n 1.0v 219.755n 0.0v 224.745n 0.0v 224.755n 0.0v 229.745n 0.0v 229.755n 0.0v 234.745n 0.0v 234.755n 0.0v 239.745n 0.0v 239.755n 1.0v 244.745n 1.0v 244.755n 1.0v 249.745n 1.0v 249.755n 1.0v 254.745n 1.0v 254.755n 1.0v 259.745n 1.0v 259.755n 0.0v 264.745n 0.0v 264.755n 0.0v 269.745n 0.0v 269.755n 0.0v 274.745n 0.0v 274.755n 1.0v 279.745n 1.0v 279.755n 1.0v 284.745n 1.0v 284.755n 1.0v 289.745n 1.0v 289.755n 1.0v 294.745n 1.0v 294.755n 1.0v 299.745n 1.0v 299.755n 1.0v 304.745n 1.0v 304.755n 1.0v 309.745n 1.0v 309.755n 1.0v 314.745n 1.0v 314.755n 1.0v 319.745n 1.0v 319.755n 1.0v 324.745n 1.0v 324.755n 1.0v 329.745n 1.0v 329.755n 1.0v 334.745n 1.0v 334.755n 1.0v 339.745n 1.0v 339.755n 1.0v 344.745n 1.0v 344.755n 0.0v 349.745n 0.0v 349.755n 1.0v 354.745n 1.0v 354.755n 1.0v 359.745n 1.0v 359.755n 0.0v 364.745n 0.0v 364.755n 0.0v 369.745n 0.0v 369.755n 0.0v 374.745n 0.0v 374.755n 0.0v 379.745n 0.0v 379.755n 0.0v 384.745n 0.0v 384.755n 0.0v 389.745n 0.0v 389.755n 0.0v 394.745n 0.0v 394.755n 0.0v 399.745n 0.0v 399.755n 1.0v 404.745n 1.0v 404.755n 1.0v 409.745n 1.0v 409.755n 1.0v 414.745n 1.0v 414.755n 1.0v 419.745n 1.0v 419.755n 1.0v 424.745n 1.0v 424.755n 1.0v 429.745n 1.0v 429.755n 1.0v 434.745n 1.0v 434.755n 1.0v 439.745n 1.0v 439.755n 0.0v 444.745n 0.0v 444.755n 0.0v 449.745n 0.0v 449.755n 0.0v 454.745n 0.0v 454.755n 0.0v 459.745n 0.0v 459.755n 0.0v 464.745n 0.0v 464.755n 0.0v 469.745n 0.0v 469.755n 0.0v 474.745n 0.0v 474.755n 0.0v 479.745n 0.0v 479.755n 0.0v 484.745n 0.0v 484.755n 0.0v 489.745n 0.0v 489.755n 0.0v 494.745n 0.0v 494.755n 0.0v 499.745n 0.0v 499.755n 1.0v 504.745n 1.0v 504.755n 1.0v 509.745n 1.0v 509.755n 1.0v 514.745n 1.0v 514.755n 1.0v 519.745n 1.0v 519.755n 1.0v 524.745n 1.0v 524.755n 1.0v 529.745n 1.0v 529.755n 1.0v 534.745n 1.0v 534.755n 1.0v 539.745n 1.0v 539.755n 0.0v 544.745n 0.0v 544.755n 0.0v 549.745n 0.0v 549.755n 0.0v 554.745n 0.0v 554.755n 0.0v 559.745n 0.0v 559.755n 0.0v 564.745n 0.0v 564.755n 0.0v 569.745n 0.0v 569.755n 0.0v 574.745n 0.0v 574.755n 0.0v 579.745n 0.0v 579.755n 0.0v 584.745n 0.0v 584.755n 0.0v 589.745n 0.0v 589.755n 0.0v 594.745n 0.0v 594.755n 0.0v 599.745n 0.0v 599.755n 0.0v 604.745n 0.0v 604.755n 0.0v 609.745n 0.0v 609.755n 0.0v 614.745n 0.0v 614.755n 0.0v 619.745n 0.0v 619.755n 0.0v 624.745n 0.0v 624.755n 0.0v 629.745n 0.0v 629.755n 0.0v 634.745n 0.0v 634.755n 0.0v 639.745n 0.0v 639.755n 0.0v 644.745n 0.0v 644.755n 0.0v 649.745n 0.0v 649.755n 0.0v 654.745n 0.0v 654.755n 1.0v 659.745n 1.0v 659.755n 1.0v 664.745n 1.0v 664.755n 1.0v 669.745n 1.0v 669.755n 1.0v 674.745n 1.0v 674.755n 1.0v 679.745n 1.0v 679.755n 1.0v 684.745n 1.0v 684.755n 1.0v 689.745n 1.0v 689.755n 1.0v 694.745n 1.0v 694.755n 1.0v 699.745n 1.0v 699.755n 1.0v 704.745n 1.0v 704.755n 1.0v 709.745n 1.0v 709.755n 1.0v 714.745n 1.0v 714.755n 1.0v 719.745n 1.0v 719.755n 1.0v 724.745n 1.0v 724.755n 1.0v 729.745n 1.0v 729.755n 1.0v 734.745n 1.0v 734.755n 1.0v 739.745n 1.0v 739.755n 1.0v 744.745n 1.0v 744.755n 1.0v 749.745n 1.0v 749.755n 1.0v 754.745n 1.0v 754.755n 1.0v 759.745n 1.0v 759.755n 1.0v 764.745n 1.0v 764.755n 1.0v 769.745n 1.0v 769.755n 1.0v 774.745n 1.0v 774.755n 1.0v 779.745n 1.0v 779.755n 0.0v 784.745n 0.0v 784.755n 0.0v 789.745n 0.0v 789.755n 0.0v 794.745n 0.0v 794.755n 0.0v 799.745n 0.0v 799.755n 0.0v 804.745n 0.0v 804.755n 0.0v 809.745n 0.0v 809.755n 1.0v 814.745n 1.0v 814.755n 1.0v 819.745n 1.0v 819.755n 1.0v 824.745n 1.0v 824.755n 1.0v 829.745n 1.0v 829.755n 1.0v 834.745n 1.0v 834.755n 1.0v 839.745n 1.0v 839.755n 1.0v 844.745n 1.0v 844.755n 1.0v 849.745n 1.0v 849.755n 1.0v 854.745n 1.0v 854.755n 1.0v 859.745n 1.0v 859.755n 0.0v 864.745n 0.0v 864.755n 0.0v 869.745n 0.0v 869.755n 0.0v 874.745n 0.0v 874.755n 0.0v 879.745n 0.0v 879.755n 0.0v 884.745n 0.0v 884.755n 0.0v 889.745n 0.0v 889.755n 0.0v 894.745n 0.0v 894.755n 0.0v 899.745n 0.0v 899.755n 0.0v 904.745n 0.0v 904.755n 0.0v 909.745n 0.0v 909.755n 0.0v 914.745n 0.0v 914.755n 0.0v 919.745n 0.0v 919.755n 0.0v 924.745n 0.0v 924.755n 0.0v 929.745n 0.0v 929.755n 0.0v 934.745n 0.0v 934.755n 0.0v 939.745n 0.0v 939.755n 0.0v 944.745n 0.0v 944.755n 0.0v 949.745n 0.0v 949.755n 1.0v 954.745n 1.0v 954.755n 0.0v 959.745n 0.0v 959.755n 0.0v 964.745n 0.0v 964.755n 0.0v 969.745n 0.0v 969.755n 0.0v 974.745n 0.0v 974.755n 0.0v 979.745n 0.0v 979.755n 0.0v 984.745n 0.0v 984.755n 1.0v 989.745n 1.0v 989.755n 1.0v 994.745n 1.0v 994.755n 1.0v 999.745n 1.0v 999.755n 1.0v 1004.745n 1.0v 1004.755n 1.0v 1009.745n 1.0v 1009.755n 1.0v 1014.745n 1.0v 1014.755n 1.0v 1019.745n 1.0v 1019.755n 1.0v 1024.745n 1.0v 1024.755n 1.0v )
* (time, data): [(0, 0), (5, 0), (10, 1), (15, 1), (20, 1), (25, 1), (30, 1), (35, 0), (40, 0), (45, 0), (50, 1), (55, 1), (60, 1), (65, 1), (70, 1), (75, 1), (80, 1), (85, 0), (90, 0), (95, 0), (100, 0), (105, 0), (110, 0), (115, 0), (120, 0), (125, 1), (130, 1), (135, 1), (140, 1), (145, 1), (150, 0), (155, 0), (160, 0), (165, 0), (170, 0), (175, 0), (180, 0), (185, 0), (190, 0), (195, 0), (200, 0), (205, 1), (210, 1), (215, 1), (220, 0), (225, 0), (230, 0), (235, 0), (240, 1), (245, 1), (250, 0), (255, 0), (260, 1), (265, 1), (270, 1), (275, 0), (280, 0), (285, 0), (290, 0), (295, 0), (300, 0), (305, 0), (310, 0), (315, 0), (320, 0), (325, 0), (330, 0), (335, 0), (340, 0), (345, 1), (350, 1), (355, 1), (360, 0), (365, 0), (370, 0), (375, 0), (380, 0), (385, 0), (390, 0), (395, 0), (400, 0), (405, 0), (410, 0), (415, 0), (420, 0), (425, 0), (430, 0), (435, 0), (440, 0), (445, 0), (450, 0), (455, 0), (460, 0), (465, 0), (470, 0), (475, 0), (480, 0), (485, 0), (490, 0), (495, 0), (500, 0), (505, 0), (510, 0), (515, 0), (520, 0), (525, 0), (530, 0), (535, 1), (540, 0), (545, 0), (550, 0), (555, 0), (560, 0), (565, 0), (570, 0), (575, 0), (580, 0), (585, 0), (590, 0), (595, 0), (600, 0), (605, 0), (610, 0), (615, 0), (620, 0), (625, 0), (630, 0), (635, 0), (640, 0), (645, 0), (650, 0), (655, 0), (660, 0), (665, 0), (670, 0), (675, 0), (680, 0), (685, 0), (690, 0), (695, 0), (700, 0), (705, 0), (710, 1), (715, 1), (720, 1), (725, 1), (730, 1), (735, 1), (740, 1), (745, 1), (750, 1), (755, 1), (760, 0), (765, 0), (770, 0), (775, 0), (780, 1), (785, 1), (790, 1), (795, 1), (800, 1), (805, 1), (810, 0), (815, 0), (820, 0), (825, 0), (830, 0), (835, 0), (840, 0), (845, 0), (850, 0), (855, 0), (860, 0), (865, 0), (870, 0), (875, 0), (880, 1), (885, 1), (890, 1), (895, 1), (900, 1), (905, 1), (910, 0), (915, 0), (920, 0), (925, 0), (930, 1), (935, 0), (940, 0), (945, 0), (950, 0), (955, 0), (960, 0), (965, 0), (970, 0), (975, 0), (980, 0), (985, 0), (990, 0), (995, 0), (1000, 0), (1005, 1), (1010, 1), (1015, 1), (1020, 1), (1025, 1)]
Vdin1_22  din1_22  0 PWL (0n 0.0v 4.745n 0.0v 4.755n 0.0v 9.745n 0.0v 9.755n 1.0v 14.745n 1.0v 14.755n 1.0v 19.745n 1.0v 19.755n 1.0v 24.745n 1.0v 24.755n 1.0v 29.745n 1.0v 29.755n 1.0v 34.745n 1.0v 34.755n 0.0v 39.745n 0.0v 39.755n 0.0v 44.745n 0.0v 44.755n 0.0v 49.745n 0.0v 49.755n 1.0v 54.745n 1.0v 54.755n 1.0v 59.745n 1.0v 59.755n 1.0v 64.745n 1.0v 64.755n 1.0v 69.745n 1.0v 69.755n 1.0v 74.745n 1.0v 74.755n 1.0v 79.745n 1.0v 79.755n 1.0v 84.745n 1.0v 84.755n 0.0v 89.745n 0.0v 89.755n 0.0v 94.745n 0.0v 94.755n 0.0v 99.745n 0.0v 99.755n 0.0v 104.745n 0.0v 104.755n 0.0v 109.745n 0.0v 109.755n 0.0v 114.745n 0.0v 114.755n 0.0v 119.745n 0.0v 119.755n 0.0v 124.745n 0.0v 124.755n 1.0v 129.745n 1.0v 129.755n 1.0v 134.745n 1.0v 134.755n 1.0v 139.745n 1.0v 139.755n 1.0v 144.745n 1.0v 144.755n 1.0v 149.745n 1.0v 149.755n 0.0v 154.745n 0.0v 154.755n 0.0v 159.745n 0.0v 159.755n 0.0v 164.745n 0.0v 164.755n 0.0v 169.745n 0.0v 169.755n 0.0v 174.745n 0.0v 174.755n 0.0v 179.745n 0.0v 179.755n 0.0v 184.745n 0.0v 184.755n 0.0v 189.745n 0.0v 189.755n 0.0v 194.745n 0.0v 194.755n 0.0v 199.745n 0.0v 199.755n 0.0v 204.745n 0.0v 204.755n 1.0v 209.745n 1.0v 209.755n 1.0v 214.745n 1.0v 214.755n 1.0v 219.745n 1.0v 219.755n 0.0v 224.745n 0.0v 224.755n 0.0v 229.745n 0.0v 229.755n 0.0v 234.745n 0.0v 234.755n 0.0v 239.745n 0.0v 239.755n 1.0v 244.745n 1.0v 244.755n 1.0v 249.745n 1.0v 249.755n 0.0v 254.745n 0.0v 254.755n 0.0v 259.745n 0.0v 259.755n 1.0v 264.745n 1.0v 264.755n 1.0v 269.745n 1.0v 269.755n 1.0v 274.745n 1.0v 274.755n 0.0v 279.745n 0.0v 279.755n 0.0v 284.745n 0.0v 284.755n 0.0v 289.745n 0.0v 289.755n 0.0v 294.745n 0.0v 294.755n 0.0v 299.745n 0.0v 299.755n 0.0v 304.745n 0.0v 304.755n 0.0v 309.745n 0.0v 309.755n 0.0v 314.745n 0.0v 314.755n 0.0v 319.745n 0.0v 319.755n 0.0v 324.745n 0.0v 324.755n 0.0v 329.745n 0.0v 329.755n 0.0v 334.745n 0.0v 334.755n 0.0v 339.745n 0.0v 339.755n 0.0v 344.745n 0.0v 344.755n 1.0v 349.745n 1.0v 349.755n 1.0v 354.745n 1.0v 354.755n 1.0v 359.745n 1.0v 359.755n 0.0v 364.745n 0.0v 364.755n 0.0v 369.745n 0.0v 369.755n 0.0v 374.745n 0.0v 374.755n 0.0v 379.745n 0.0v 379.755n 0.0v 384.745n 0.0v 384.755n 0.0v 389.745n 0.0v 389.755n 0.0v 394.745n 0.0v 394.755n 0.0v 399.745n 0.0v 399.755n 0.0v 404.745n 0.0v 404.755n 0.0v 409.745n 0.0v 409.755n 0.0v 414.745n 0.0v 414.755n 0.0v 419.745n 0.0v 419.755n 0.0v 424.745n 0.0v 424.755n 0.0v 429.745n 0.0v 429.755n 0.0v 434.745n 0.0v 434.755n 0.0v 439.745n 0.0v 439.755n 0.0v 444.745n 0.0v 444.755n 0.0v 449.745n 0.0v 449.755n 0.0v 454.745n 0.0v 454.755n 0.0v 459.745n 0.0v 459.755n 0.0v 464.745n 0.0v 464.755n 0.0v 469.745n 0.0v 469.755n 0.0v 474.745n 0.0v 474.755n 0.0v 479.745n 0.0v 479.755n 0.0v 484.745n 0.0v 484.755n 0.0v 489.745n 0.0v 489.755n 0.0v 494.745n 0.0v 494.755n 0.0v 499.745n 0.0v 499.755n 0.0v 504.745n 0.0v 504.755n 0.0v 509.745n 0.0v 509.755n 0.0v 514.745n 0.0v 514.755n 0.0v 519.745n 0.0v 519.755n 0.0v 524.745n 0.0v 524.755n 0.0v 529.745n 0.0v 529.755n 0.0v 534.745n 0.0v 534.755n 1.0v 539.745n 1.0v 539.755n 0.0v 544.745n 0.0v 544.755n 0.0v 549.745n 0.0v 549.755n 0.0v 554.745n 0.0v 554.755n 0.0v 559.745n 0.0v 559.755n 0.0v 564.745n 0.0v 564.755n 0.0v 569.745n 0.0v 569.755n 0.0v 574.745n 0.0v 574.755n 0.0v 579.745n 0.0v 579.755n 0.0v 584.745n 0.0v 584.755n 0.0v 589.745n 0.0v 589.755n 0.0v 594.745n 0.0v 594.755n 0.0v 599.745n 0.0v 599.755n 0.0v 604.745n 0.0v 604.755n 0.0v 609.745n 0.0v 609.755n 0.0v 614.745n 0.0v 614.755n 0.0v 619.745n 0.0v 619.755n 0.0v 624.745n 0.0v 624.755n 0.0v 629.745n 0.0v 629.755n 0.0v 634.745n 0.0v 634.755n 0.0v 639.745n 0.0v 639.755n 0.0v 644.745n 0.0v 644.755n 0.0v 649.745n 0.0v 649.755n 0.0v 654.745n 0.0v 654.755n 0.0v 659.745n 0.0v 659.755n 0.0v 664.745n 0.0v 664.755n 0.0v 669.745n 0.0v 669.755n 0.0v 674.745n 0.0v 674.755n 0.0v 679.745n 0.0v 679.755n 0.0v 684.745n 0.0v 684.755n 0.0v 689.745n 0.0v 689.755n 0.0v 694.745n 0.0v 694.755n 0.0v 699.745n 0.0v 699.755n 0.0v 704.745n 0.0v 704.755n 0.0v 709.745n 0.0v 709.755n 1.0v 714.745n 1.0v 714.755n 1.0v 719.745n 1.0v 719.755n 1.0v 724.745n 1.0v 724.755n 1.0v 729.745n 1.0v 729.755n 1.0v 734.745n 1.0v 734.755n 1.0v 739.745n 1.0v 739.755n 1.0v 744.745n 1.0v 744.755n 1.0v 749.745n 1.0v 749.755n 1.0v 754.745n 1.0v 754.755n 1.0v 759.745n 1.0v 759.755n 0.0v 764.745n 0.0v 764.755n 0.0v 769.745n 0.0v 769.755n 0.0v 774.745n 0.0v 774.755n 0.0v 779.745n 0.0v 779.755n 1.0v 784.745n 1.0v 784.755n 1.0v 789.745n 1.0v 789.755n 1.0v 794.745n 1.0v 794.755n 1.0v 799.745n 1.0v 799.755n 1.0v 804.745n 1.0v 804.755n 1.0v 809.745n 1.0v 809.755n 0.0v 814.745n 0.0v 814.755n 0.0v 819.745n 0.0v 819.755n 0.0v 824.745n 0.0v 824.755n 0.0v 829.745n 0.0v 829.755n 0.0v 834.745n 0.0v 834.755n 0.0v 839.745n 0.0v 839.755n 0.0v 844.745n 0.0v 844.755n 0.0v 849.745n 0.0v 849.755n 0.0v 854.745n 0.0v 854.755n 0.0v 859.745n 0.0v 859.755n 0.0v 864.745n 0.0v 864.755n 0.0v 869.745n 0.0v 869.755n 0.0v 874.745n 0.0v 874.755n 0.0v 879.745n 0.0v 879.755n 1.0v 884.745n 1.0v 884.755n 1.0v 889.745n 1.0v 889.755n 1.0v 894.745n 1.0v 894.755n 1.0v 899.745n 1.0v 899.755n 1.0v 904.745n 1.0v 904.755n 1.0v 909.745n 1.0v 909.755n 0.0v 914.745n 0.0v 914.755n 0.0v 919.745n 0.0v 919.755n 0.0v 924.745n 0.0v 924.755n 0.0v 929.745n 0.0v 929.755n 1.0v 934.745n 1.0v 934.755n 0.0v 939.745n 0.0v 939.755n 0.0v 944.745n 0.0v 944.755n 0.0v 949.745n 0.0v 949.755n 0.0v 954.745n 0.0v 954.755n 0.0v 959.745n 0.0v 959.755n 0.0v 964.745n 0.0v 964.755n 0.0v 969.745n 0.0v 969.755n 0.0v 974.745n 0.0v 974.755n 0.0v 979.745n 0.0v 979.755n 0.0v 984.745n 0.0v 984.755n 0.0v 989.745n 0.0v 989.755n 0.0v 994.745n 0.0v 994.755n 0.0v 999.745n 0.0v 999.755n 0.0v 1004.745n 0.0v 1004.755n 1.0v 1009.745n 1.0v 1009.755n 1.0v 1014.745n 1.0v 1014.755n 1.0v 1019.745n 1.0v 1019.755n 1.0v 1024.745n 1.0v 1024.755n 1.0v )
* (time, data): [(0, 0), (5, 0), (10, 0), (15, 0), (20, 0), (25, 0), (30, 0), (35, 0), (40, 0), (45, 0), (50, 1), (55, 1), (60, 1), (65, 1), (70, 1), (75, 1), (80, 1), (85, 1), (90, 1), (95, 1), (100, 0), (105, 0), (110, 0), (115, 1), (120, 1), (125, 1), (130, 1), (135, 1), (140, 1), (145, 1), (150, 1), (155, 1), (160, 1), (165, 0), (170, 0), (175, 0), (180, 0), (185, 0), (190, 0), (195, 0), (200, 0), (205, 1), (210, 1), (215, 1), (220, 0), (225, 0), (230, 0), (235, 0), (240, 1), (245, 1), (250, 0), (255, 0), (260, 0), (265, 0), (270, 0), (275, 0), (280, 0), (285, 0), (290, 0), (295, 0), (300, 0), (305, 0), (310, 1), (315, 1), (320, 1), (325, 1), (330, 1), (335, 1), (340, 1), (345, 0), (350, 1), (355, 1), (360, 1), (365, 1), (370, 1), (375, 1), (380, 1), (385, 1), (390, 1), (395, 1), (400, 1), (405, 1), (410, 1), (415, 1), (420, 1), (425, 1), (430, 1), (435, 1), (440, 0), (445, 0), (450, 0), (455, 0), (460, 0), (465, 0), (470, 0), (475, 0), (480, 0), (485, 0), (490, 0), (495, 0), (500, 1), (505, 1), (510, 1), (515, 1), (520, 1), (525, 1), (530, 1), (535, 0), (540, 1), (545, 1), (550, 1), (555, 1), (560, 1), (565, 1), (570, 1), (575, 1), (580, 1), (585, 1), (590, 1), (595, 1), (600, 1), (605, 1), (610, 1), (615, 1), (620, 1), (625, 1), (630, 1), (635, 1), (640, 1), (645, 1), (650, 1), (655, 1), (660, 1), (665, 1), (670, 1), (675, 1), (680, 1), (685, 1), (690, 1), (695, 1), (700, 1), (705, 1), (710, 1), (715, 1), (720, 1), (725, 1), (730, 1), (735, 1), (740, 1), (745, 1), (750, 1), (755, 1), (760, 0), (765, 0), (770, 0), (775, 0), (780, 1), (785, 1), (790, 1), (795, 1), (800, 1), (805, 1), (810, 1), (815, 1), (820, 1), (825, 1), (830, 1), (835, 1), (840, 1), (845, 1), (850, 1), (855, 1), (860, 0), (865, 0), (870, 0), (875, 0), (880, 1), (885, 1), (890, 1), (895, 1), (900, 1), (905, 1), (910, 0), (915, 0), (920, 0), (925, 0), (930, 0), (935, 1), (940, 1), (945, 1), (950, 0), (955, 0), (960, 0), (965, 0), (970, 0), (975, 0), (980, 0), (985, 1), (990, 1), (995, 1), (1000, 1), (1005, 1), (1010, 1), (1015, 1), (1020, 1), (1025, 1)]
Vdin1_23  din1_23  0 PWL (0n 0.0v 4.745n 0.0v 4.755n 0.0v 9.745n 0.0v 9.755n 0.0v 14.745n 0.0v 14.755n 0.0v 19.745n 0.0v 19.755n 0.0v 24.745n 0.0v 24.755n 0.0v 29.745n 0.0v 29.755n 0.0v 34.745n 0.0v 34.755n 0.0v 39.745n 0.0v 39.755n 0.0v 44.745n 0.0v 44.755n 0.0v 49.745n 0.0v 49.755n 1.0v 54.745n 1.0v 54.755n 1.0v 59.745n 1.0v 59.755n 1.0v 64.745n 1.0v 64.755n 1.0v 69.745n 1.0v 69.755n 1.0v 74.745n 1.0v 74.755n 1.0v 79.745n 1.0v 79.755n 1.0v 84.745n 1.0v 84.755n 1.0v 89.745n 1.0v 89.755n 1.0v 94.745n 1.0v 94.755n 1.0v 99.745n 1.0v 99.755n 0.0v 104.745n 0.0v 104.755n 0.0v 109.745n 0.0v 109.755n 0.0v 114.745n 0.0v 114.755n 1.0v 119.745n 1.0v 119.755n 1.0v 124.745n 1.0v 124.755n 1.0v 129.745n 1.0v 129.755n 1.0v 134.745n 1.0v 134.755n 1.0v 139.745n 1.0v 139.755n 1.0v 144.745n 1.0v 144.755n 1.0v 149.745n 1.0v 149.755n 1.0v 154.745n 1.0v 154.755n 1.0v 159.745n 1.0v 159.755n 1.0v 164.745n 1.0v 164.755n 0.0v 169.745n 0.0v 169.755n 0.0v 174.745n 0.0v 174.755n 0.0v 179.745n 0.0v 179.755n 0.0v 184.745n 0.0v 184.755n 0.0v 189.745n 0.0v 189.755n 0.0v 194.745n 0.0v 194.755n 0.0v 199.745n 0.0v 199.755n 0.0v 204.745n 0.0v 204.755n 1.0v 209.745n 1.0v 209.755n 1.0v 214.745n 1.0v 214.755n 1.0v 219.745n 1.0v 219.755n 0.0v 224.745n 0.0v 224.755n 0.0v 229.745n 0.0v 229.755n 0.0v 234.745n 0.0v 234.755n 0.0v 239.745n 0.0v 239.755n 1.0v 244.745n 1.0v 244.755n 1.0v 249.745n 1.0v 249.755n 0.0v 254.745n 0.0v 254.755n 0.0v 259.745n 0.0v 259.755n 0.0v 264.745n 0.0v 264.755n 0.0v 269.745n 0.0v 269.755n 0.0v 274.745n 0.0v 274.755n 0.0v 279.745n 0.0v 279.755n 0.0v 284.745n 0.0v 284.755n 0.0v 289.745n 0.0v 289.755n 0.0v 294.745n 0.0v 294.755n 0.0v 299.745n 0.0v 299.755n 0.0v 304.745n 0.0v 304.755n 0.0v 309.745n 0.0v 309.755n 1.0v 314.745n 1.0v 314.755n 1.0v 319.745n 1.0v 319.755n 1.0v 324.745n 1.0v 324.755n 1.0v 329.745n 1.0v 329.755n 1.0v 334.745n 1.0v 334.755n 1.0v 339.745n 1.0v 339.755n 1.0v 344.745n 1.0v 344.755n 0.0v 349.745n 0.0v 349.755n 1.0v 354.745n 1.0v 354.755n 1.0v 359.745n 1.0v 359.755n 1.0v 364.745n 1.0v 364.755n 1.0v 369.745n 1.0v 369.755n 1.0v 374.745n 1.0v 374.755n 1.0v 379.745n 1.0v 379.755n 1.0v 384.745n 1.0v 384.755n 1.0v 389.745n 1.0v 389.755n 1.0v 394.745n 1.0v 394.755n 1.0v 399.745n 1.0v 399.755n 1.0v 404.745n 1.0v 404.755n 1.0v 409.745n 1.0v 409.755n 1.0v 414.745n 1.0v 414.755n 1.0v 419.745n 1.0v 419.755n 1.0v 424.745n 1.0v 424.755n 1.0v 429.745n 1.0v 429.755n 1.0v 434.745n 1.0v 434.755n 1.0v 439.745n 1.0v 439.755n 0.0v 444.745n 0.0v 444.755n 0.0v 449.745n 0.0v 449.755n 0.0v 454.745n 0.0v 454.755n 0.0v 459.745n 0.0v 459.755n 0.0v 464.745n 0.0v 464.755n 0.0v 469.745n 0.0v 469.755n 0.0v 474.745n 0.0v 474.755n 0.0v 479.745n 0.0v 479.755n 0.0v 484.745n 0.0v 484.755n 0.0v 489.745n 0.0v 489.755n 0.0v 494.745n 0.0v 494.755n 0.0v 499.745n 0.0v 499.755n 1.0v 504.745n 1.0v 504.755n 1.0v 509.745n 1.0v 509.755n 1.0v 514.745n 1.0v 514.755n 1.0v 519.745n 1.0v 519.755n 1.0v 524.745n 1.0v 524.755n 1.0v 529.745n 1.0v 529.755n 1.0v 534.745n 1.0v 534.755n 0.0v 539.745n 0.0v 539.755n 1.0v 544.745n 1.0v 544.755n 1.0v 549.745n 1.0v 549.755n 1.0v 554.745n 1.0v 554.755n 1.0v 559.745n 1.0v 559.755n 1.0v 564.745n 1.0v 564.755n 1.0v 569.745n 1.0v 569.755n 1.0v 574.745n 1.0v 574.755n 1.0v 579.745n 1.0v 579.755n 1.0v 584.745n 1.0v 584.755n 1.0v 589.745n 1.0v 589.755n 1.0v 594.745n 1.0v 594.755n 1.0v 599.745n 1.0v 599.755n 1.0v 604.745n 1.0v 604.755n 1.0v 609.745n 1.0v 609.755n 1.0v 614.745n 1.0v 614.755n 1.0v 619.745n 1.0v 619.755n 1.0v 624.745n 1.0v 624.755n 1.0v 629.745n 1.0v 629.755n 1.0v 634.745n 1.0v 634.755n 1.0v 639.745n 1.0v 639.755n 1.0v 644.745n 1.0v 644.755n 1.0v 649.745n 1.0v 649.755n 1.0v 654.745n 1.0v 654.755n 1.0v 659.745n 1.0v 659.755n 1.0v 664.745n 1.0v 664.755n 1.0v 669.745n 1.0v 669.755n 1.0v 674.745n 1.0v 674.755n 1.0v 679.745n 1.0v 679.755n 1.0v 684.745n 1.0v 684.755n 1.0v 689.745n 1.0v 689.755n 1.0v 694.745n 1.0v 694.755n 1.0v 699.745n 1.0v 699.755n 1.0v 704.745n 1.0v 704.755n 1.0v 709.745n 1.0v 709.755n 1.0v 714.745n 1.0v 714.755n 1.0v 719.745n 1.0v 719.755n 1.0v 724.745n 1.0v 724.755n 1.0v 729.745n 1.0v 729.755n 1.0v 734.745n 1.0v 734.755n 1.0v 739.745n 1.0v 739.755n 1.0v 744.745n 1.0v 744.755n 1.0v 749.745n 1.0v 749.755n 1.0v 754.745n 1.0v 754.755n 1.0v 759.745n 1.0v 759.755n 0.0v 764.745n 0.0v 764.755n 0.0v 769.745n 0.0v 769.755n 0.0v 774.745n 0.0v 774.755n 0.0v 779.745n 0.0v 779.755n 1.0v 784.745n 1.0v 784.755n 1.0v 789.745n 1.0v 789.755n 1.0v 794.745n 1.0v 794.755n 1.0v 799.745n 1.0v 799.755n 1.0v 804.745n 1.0v 804.755n 1.0v 809.745n 1.0v 809.755n 1.0v 814.745n 1.0v 814.755n 1.0v 819.745n 1.0v 819.755n 1.0v 824.745n 1.0v 824.755n 1.0v 829.745n 1.0v 829.755n 1.0v 834.745n 1.0v 834.755n 1.0v 839.745n 1.0v 839.755n 1.0v 844.745n 1.0v 844.755n 1.0v 849.745n 1.0v 849.755n 1.0v 854.745n 1.0v 854.755n 1.0v 859.745n 1.0v 859.755n 0.0v 864.745n 0.0v 864.755n 0.0v 869.745n 0.0v 869.755n 0.0v 874.745n 0.0v 874.755n 0.0v 879.745n 0.0v 879.755n 1.0v 884.745n 1.0v 884.755n 1.0v 889.745n 1.0v 889.755n 1.0v 894.745n 1.0v 894.755n 1.0v 899.745n 1.0v 899.755n 1.0v 904.745n 1.0v 904.755n 1.0v 909.745n 1.0v 909.755n 0.0v 914.745n 0.0v 914.755n 0.0v 919.745n 0.0v 919.755n 0.0v 924.745n 0.0v 924.755n 0.0v 929.745n 0.0v 929.755n 0.0v 934.745n 0.0v 934.755n 1.0v 939.745n 1.0v 939.755n 1.0v 944.745n 1.0v 944.755n 1.0v 949.745n 1.0v 949.755n 0.0v 954.745n 0.0v 954.755n 0.0v 959.745n 0.0v 959.755n 0.0v 964.745n 0.0v 964.755n 0.0v 969.745n 0.0v 969.755n 0.0v 974.745n 0.0v 974.755n 0.0v 979.745n 0.0v 979.755n 0.0v 984.745n 0.0v 984.755n 1.0v 989.745n 1.0v 989.755n 1.0v 994.745n 1.0v 994.755n 1.0v 999.745n 1.0v 999.755n 1.0v 1004.745n 1.0v 1004.755n 1.0v 1009.745n 1.0v 1009.755n 1.0v 1014.745n 1.0v 1014.755n 1.0v 1019.745n 1.0v 1019.755n 1.0v 1024.745n 1.0v 1024.755n 1.0v )
* (time, data): [(0, 0), (5, 0), (10, 0), (15, 0), (20, 0), (25, 0), (30, 0), (35, 0), (40, 0), (45, 0), (50, 0), (55, 0), (60, 0), (65, 0), (70, 0), (75, 0), (80, 0), (85, 1), (90, 1), (95, 1), (100, 0), (105, 0), (110, 0), (115, 1), (120, 1), (125, 0), (130, 0), (135, 0), (140, 0), (145, 0), (150, 1), (155, 1), (160, 1), (165, 0), (170, 0), (175, 0), (180, 0), (185, 0), (190, 0), (195, 0), (200, 0), (205, 0), (210, 0), (215, 0), (220, 0), (225, 0), (230, 0), (235, 0), (240, 0), (245, 0), (250, 0), (255, 0), (260, 0), (265, 0), (270, 0), (275, 1), (280, 1), (285, 1), (290, 1), (295, 1), (300, 1), (305, 1), (310, 0), (315, 0), (320, 0), (325, 0), (330, 0), (335, 0), (340, 0), (345, 0), (350, 1), (355, 1), (360, 0), (365, 0), (370, 0), (375, 0), (380, 0), (385, 0), (390, 0), (395, 0), (400, 1), (405, 1), (410, 1), (415, 1), (420, 1), (425, 1), (430, 1), (435, 1), (440, 0), (445, 0), (450, 0), (455, 0), (460, 0), (465, 0), (470, 0), (475, 0), (480, 0), (485, 0), (490, 0), (495, 0), (500, 0), (505, 0), (510, 0), (515, 0), (520, 0), (525, 0), (530, 0), (535, 0), (540, 0), (545, 0), (550, 0), (555, 0), (560, 0), (565, 0), (570, 0), (575, 0), (580, 0), (585, 0), (590, 0), (595, 0), (600, 0), (605, 0), (610, 0), (615, 0), (620, 0), (625, 0), (630, 0), (635, 0), (640, 0), (645, 0), (650, 0), (655, 0), (660, 0), (665, 0), (670, 0), (675, 0), (680, 0), (685, 0), (690, 0), (695, 0), (700, 0), (705, 0), (710, 1), (715, 1), (720, 1), (725, 1), (730, 1), (735, 1), (740, 1), (745, 1), (750, 1), (755, 1), (760, 0), (765, 0), (770, 0), (775, 0), (780, 1), (785, 1), (790, 1), (795, 1), (800, 1), (805, 1), (810, 0), (815, 0), (820, 0), (825, 0), (830, 0), (835, 0), (840, 0), (845, 0), (850, 0), (855, 0), (860, 0), (865, 0), (870, 0), (875, 0), (880, 0), (885, 0), (890, 0), (895, 0), (900, 0), (905, 0), (910, 1), (915, 1), (920, 1), (925, 1), (930, 0), (935, 1), (940, 1), (945, 1), (950, 0), (955, 1), (960, 1), (965, 1), (970, 1), (975, 1), (980, 1), (985, 0), (990, 0), (995, 0), (1000, 0), (1005, 0), (1010, 0), (1015, 0), (1020, 0), (1025, 0)]
Vdin1_24  din1_24  0 PWL (0n 0.0v 4.745n 0.0v 4.755n 0.0v 9.745n 0.0v 9.755n 0.0v 14.745n 0.0v 14.755n 0.0v 19.745n 0.0v 19.755n 0.0v 24.745n 0.0v 24.755n 0.0v 29.745n 0.0v 29.755n 0.0v 34.745n 0.0v 34.755n 0.0v 39.745n 0.0v 39.755n 0.0v 44.745n 0.0v 44.755n 0.0v 49.745n 0.0v 49.755n 0.0v 54.745n 0.0v 54.755n 0.0v 59.745n 0.0v 59.755n 0.0v 64.745n 0.0v 64.755n 0.0v 69.745n 0.0v 69.755n 0.0v 74.745n 0.0v 74.755n 0.0v 79.745n 0.0v 79.755n 0.0v 84.745n 0.0v 84.755n 1.0v 89.745n 1.0v 89.755n 1.0v 94.745n 1.0v 94.755n 1.0v 99.745n 1.0v 99.755n 0.0v 104.745n 0.0v 104.755n 0.0v 109.745n 0.0v 109.755n 0.0v 114.745n 0.0v 114.755n 1.0v 119.745n 1.0v 119.755n 1.0v 124.745n 1.0v 124.755n 0.0v 129.745n 0.0v 129.755n 0.0v 134.745n 0.0v 134.755n 0.0v 139.745n 0.0v 139.755n 0.0v 144.745n 0.0v 144.755n 0.0v 149.745n 0.0v 149.755n 1.0v 154.745n 1.0v 154.755n 1.0v 159.745n 1.0v 159.755n 1.0v 164.745n 1.0v 164.755n 0.0v 169.745n 0.0v 169.755n 0.0v 174.745n 0.0v 174.755n 0.0v 179.745n 0.0v 179.755n 0.0v 184.745n 0.0v 184.755n 0.0v 189.745n 0.0v 189.755n 0.0v 194.745n 0.0v 194.755n 0.0v 199.745n 0.0v 199.755n 0.0v 204.745n 0.0v 204.755n 0.0v 209.745n 0.0v 209.755n 0.0v 214.745n 0.0v 214.755n 0.0v 219.745n 0.0v 219.755n 0.0v 224.745n 0.0v 224.755n 0.0v 229.745n 0.0v 229.755n 0.0v 234.745n 0.0v 234.755n 0.0v 239.745n 0.0v 239.755n 0.0v 244.745n 0.0v 244.755n 0.0v 249.745n 0.0v 249.755n 0.0v 254.745n 0.0v 254.755n 0.0v 259.745n 0.0v 259.755n 0.0v 264.745n 0.0v 264.755n 0.0v 269.745n 0.0v 269.755n 0.0v 274.745n 0.0v 274.755n 1.0v 279.745n 1.0v 279.755n 1.0v 284.745n 1.0v 284.755n 1.0v 289.745n 1.0v 289.755n 1.0v 294.745n 1.0v 294.755n 1.0v 299.745n 1.0v 299.755n 1.0v 304.745n 1.0v 304.755n 1.0v 309.745n 1.0v 309.755n 0.0v 314.745n 0.0v 314.755n 0.0v 319.745n 0.0v 319.755n 0.0v 324.745n 0.0v 324.755n 0.0v 329.745n 0.0v 329.755n 0.0v 334.745n 0.0v 334.755n 0.0v 339.745n 0.0v 339.755n 0.0v 344.745n 0.0v 344.755n 0.0v 349.745n 0.0v 349.755n 1.0v 354.745n 1.0v 354.755n 1.0v 359.745n 1.0v 359.755n 0.0v 364.745n 0.0v 364.755n 0.0v 369.745n 0.0v 369.755n 0.0v 374.745n 0.0v 374.755n 0.0v 379.745n 0.0v 379.755n 0.0v 384.745n 0.0v 384.755n 0.0v 389.745n 0.0v 389.755n 0.0v 394.745n 0.0v 394.755n 0.0v 399.745n 0.0v 399.755n 1.0v 404.745n 1.0v 404.755n 1.0v 409.745n 1.0v 409.755n 1.0v 414.745n 1.0v 414.755n 1.0v 419.745n 1.0v 419.755n 1.0v 424.745n 1.0v 424.755n 1.0v 429.745n 1.0v 429.755n 1.0v 434.745n 1.0v 434.755n 1.0v 439.745n 1.0v 439.755n 0.0v 444.745n 0.0v 444.755n 0.0v 449.745n 0.0v 449.755n 0.0v 454.745n 0.0v 454.755n 0.0v 459.745n 0.0v 459.755n 0.0v 464.745n 0.0v 464.755n 0.0v 469.745n 0.0v 469.755n 0.0v 474.745n 0.0v 474.755n 0.0v 479.745n 0.0v 479.755n 0.0v 484.745n 0.0v 484.755n 0.0v 489.745n 0.0v 489.755n 0.0v 494.745n 0.0v 494.755n 0.0v 499.745n 0.0v 499.755n 0.0v 504.745n 0.0v 504.755n 0.0v 509.745n 0.0v 509.755n 0.0v 514.745n 0.0v 514.755n 0.0v 519.745n 0.0v 519.755n 0.0v 524.745n 0.0v 524.755n 0.0v 529.745n 0.0v 529.755n 0.0v 534.745n 0.0v 534.755n 0.0v 539.745n 0.0v 539.755n 0.0v 544.745n 0.0v 544.755n 0.0v 549.745n 0.0v 549.755n 0.0v 554.745n 0.0v 554.755n 0.0v 559.745n 0.0v 559.755n 0.0v 564.745n 0.0v 564.755n 0.0v 569.745n 0.0v 569.755n 0.0v 574.745n 0.0v 574.755n 0.0v 579.745n 0.0v 579.755n 0.0v 584.745n 0.0v 584.755n 0.0v 589.745n 0.0v 589.755n 0.0v 594.745n 0.0v 594.755n 0.0v 599.745n 0.0v 599.755n 0.0v 604.745n 0.0v 604.755n 0.0v 609.745n 0.0v 609.755n 0.0v 614.745n 0.0v 614.755n 0.0v 619.745n 0.0v 619.755n 0.0v 624.745n 0.0v 624.755n 0.0v 629.745n 0.0v 629.755n 0.0v 634.745n 0.0v 634.755n 0.0v 639.745n 0.0v 639.755n 0.0v 644.745n 0.0v 644.755n 0.0v 649.745n 0.0v 649.755n 0.0v 654.745n 0.0v 654.755n 0.0v 659.745n 0.0v 659.755n 0.0v 664.745n 0.0v 664.755n 0.0v 669.745n 0.0v 669.755n 0.0v 674.745n 0.0v 674.755n 0.0v 679.745n 0.0v 679.755n 0.0v 684.745n 0.0v 684.755n 0.0v 689.745n 0.0v 689.755n 0.0v 694.745n 0.0v 694.755n 0.0v 699.745n 0.0v 699.755n 0.0v 704.745n 0.0v 704.755n 0.0v 709.745n 0.0v 709.755n 1.0v 714.745n 1.0v 714.755n 1.0v 719.745n 1.0v 719.755n 1.0v 724.745n 1.0v 724.755n 1.0v 729.745n 1.0v 729.755n 1.0v 734.745n 1.0v 734.755n 1.0v 739.745n 1.0v 739.755n 1.0v 744.745n 1.0v 744.755n 1.0v 749.745n 1.0v 749.755n 1.0v 754.745n 1.0v 754.755n 1.0v 759.745n 1.0v 759.755n 0.0v 764.745n 0.0v 764.755n 0.0v 769.745n 0.0v 769.755n 0.0v 774.745n 0.0v 774.755n 0.0v 779.745n 0.0v 779.755n 1.0v 784.745n 1.0v 784.755n 1.0v 789.745n 1.0v 789.755n 1.0v 794.745n 1.0v 794.755n 1.0v 799.745n 1.0v 799.755n 1.0v 804.745n 1.0v 804.755n 1.0v 809.745n 1.0v 809.755n 0.0v 814.745n 0.0v 814.755n 0.0v 819.745n 0.0v 819.755n 0.0v 824.745n 0.0v 824.755n 0.0v 829.745n 0.0v 829.755n 0.0v 834.745n 0.0v 834.755n 0.0v 839.745n 0.0v 839.755n 0.0v 844.745n 0.0v 844.755n 0.0v 849.745n 0.0v 849.755n 0.0v 854.745n 0.0v 854.755n 0.0v 859.745n 0.0v 859.755n 0.0v 864.745n 0.0v 864.755n 0.0v 869.745n 0.0v 869.755n 0.0v 874.745n 0.0v 874.755n 0.0v 879.745n 0.0v 879.755n 0.0v 884.745n 0.0v 884.755n 0.0v 889.745n 0.0v 889.755n 0.0v 894.745n 0.0v 894.755n 0.0v 899.745n 0.0v 899.755n 0.0v 904.745n 0.0v 904.755n 0.0v 909.745n 0.0v 909.755n 1.0v 914.745n 1.0v 914.755n 1.0v 919.745n 1.0v 919.755n 1.0v 924.745n 1.0v 924.755n 1.0v 929.745n 1.0v 929.755n 0.0v 934.745n 0.0v 934.755n 1.0v 939.745n 1.0v 939.755n 1.0v 944.745n 1.0v 944.755n 1.0v 949.745n 1.0v 949.755n 0.0v 954.745n 0.0v 954.755n 1.0v 959.745n 1.0v 959.755n 1.0v 964.745n 1.0v 964.755n 1.0v 969.745n 1.0v 969.755n 1.0v 974.745n 1.0v 974.755n 1.0v 979.745n 1.0v 979.755n 1.0v 984.745n 1.0v 984.755n 0.0v 989.745n 0.0v 989.755n 0.0v 994.745n 0.0v 994.755n 0.0v 999.745n 0.0v 999.755n 0.0v 1004.745n 0.0v 1004.755n 0.0v 1009.745n 0.0v 1009.755n 0.0v 1014.745n 0.0v 1014.755n 0.0v 1019.745n 0.0v 1019.755n 0.0v 1024.745n 0.0v 1024.755n 0.0v )
* (time, data): [(0, 0), (5, 0), (10, 1), (15, 0), (20, 0), (25, 0), (30, 0), (35, 0), (40, 0), (45, 0), (50, 1), (55, 1), (60, 1), (65, 1), (70, 1), (75, 1), (80, 1), (85, 0), (90, 0), (95, 0), (100, 0), (105, 0), (110, 0), (115, 0), (120, 0), (125, 0), (130, 0), (135, 0), (140, 0), (145, 0), (150, 1), (155, 1), (160, 1), (165, 0), (170, 0), (175, 0), (180, 0), (185, 0), (190, 0), (195, 0), (200, 0), (205, 1), (210, 1), (215, 1), (220, 1), (225, 1), (230, 1), (235, 1), (240, 0), (245, 0), (250, 0), (255, 0), (260, 1), (265, 1), (270, 1), (275, 1), (280, 1), (285, 1), (290, 1), (295, 1), (300, 1), (305, 1), (310, 1), (315, 1), (320, 1), (325, 1), (330, 1), (335, 1), (340, 1), (345, 1), (350, 0), (355, 0), (360, 0), (365, 0), (370, 0), (375, 0), (380, 0), (385, 0), (390, 0), (395, 0), (400, 1), (405, 0), (410, 0), (415, 0), (420, 0), (425, 0), (430, 0), (435, 0), (440, 0), (445, 0), (450, 0), (455, 0), (460, 0), (465, 0), (470, 0), (475, 0), (480, 0), (485, 0), (490, 0), (495, 0), (500, 0), (505, 0), (510, 0), (515, 0), (520, 0), (525, 0), (530, 0), (535, 0), (540, 1), (545, 1), (550, 1), (555, 1), (560, 1), (565, 1), (570, 1), (575, 1), (580, 1), (585, 1), (590, 1), (595, 1), (600, 1), (605, 1), (610, 1), (615, 1), (620, 1), (625, 1), (630, 1), (635, 1), (640, 1), (645, 1), (650, 1), (655, 0), (660, 0), (665, 0), (670, 0), (675, 0), (680, 0), (685, 0), (690, 0), (695, 0), (700, 0), (705, 0), (710, 0), (715, 0), (720, 0), (725, 0), (730, 0), (735, 0), (740, 0), (745, 0), (750, 0), (755, 0), (760, 0), (765, 0), (770, 0), (775, 0), (780, 1), (785, 1), (790, 1), (795, 1), (800, 1), (805, 1), (810, 0), (815, 0), (820, 0), (825, 0), (830, 0), (835, 0), (840, 0), (845, 0), (850, 0), (855, 0), (860, 1), (865, 1), (870, 1), (875, 1), (880, 1), (885, 1), (890, 1), (895, 1), (900, 1), (905, 1), (910, 0), (915, 0), (920, 0), (925, 0), (930, 1), (935, 0), (940, 0), (945, 0), (950, 0), (955, 1), (960, 1), (965, 1), (970, 1), (975, 1), (980, 1), (985, 1), (990, 1), (995, 1), (1000, 1), (1005, 0), (1010, 0), (1015, 0), (1020, 0), (1025, 0)]
Vdin1_25  din1_25  0 PWL (0n 0.0v 4.745n 0.0v 4.755n 0.0v 9.745n 0.0v 9.755n 1.0v 14.745n 1.0v 14.755n 0.0v 19.745n 0.0v 19.755n 0.0v 24.745n 0.0v 24.755n 0.0v 29.745n 0.0v 29.755n 0.0v 34.745n 0.0v 34.755n 0.0v 39.745n 0.0v 39.755n 0.0v 44.745n 0.0v 44.755n 0.0v 49.745n 0.0v 49.755n 1.0v 54.745n 1.0v 54.755n 1.0v 59.745n 1.0v 59.755n 1.0v 64.745n 1.0v 64.755n 1.0v 69.745n 1.0v 69.755n 1.0v 74.745n 1.0v 74.755n 1.0v 79.745n 1.0v 79.755n 1.0v 84.745n 1.0v 84.755n 0.0v 89.745n 0.0v 89.755n 0.0v 94.745n 0.0v 94.755n 0.0v 99.745n 0.0v 99.755n 0.0v 104.745n 0.0v 104.755n 0.0v 109.745n 0.0v 109.755n 0.0v 114.745n 0.0v 114.755n 0.0v 119.745n 0.0v 119.755n 0.0v 124.745n 0.0v 124.755n 0.0v 129.745n 0.0v 129.755n 0.0v 134.745n 0.0v 134.755n 0.0v 139.745n 0.0v 139.755n 0.0v 144.745n 0.0v 144.755n 0.0v 149.745n 0.0v 149.755n 1.0v 154.745n 1.0v 154.755n 1.0v 159.745n 1.0v 159.755n 1.0v 164.745n 1.0v 164.755n 0.0v 169.745n 0.0v 169.755n 0.0v 174.745n 0.0v 174.755n 0.0v 179.745n 0.0v 179.755n 0.0v 184.745n 0.0v 184.755n 0.0v 189.745n 0.0v 189.755n 0.0v 194.745n 0.0v 194.755n 0.0v 199.745n 0.0v 199.755n 0.0v 204.745n 0.0v 204.755n 1.0v 209.745n 1.0v 209.755n 1.0v 214.745n 1.0v 214.755n 1.0v 219.745n 1.0v 219.755n 1.0v 224.745n 1.0v 224.755n 1.0v 229.745n 1.0v 229.755n 1.0v 234.745n 1.0v 234.755n 1.0v 239.745n 1.0v 239.755n 0.0v 244.745n 0.0v 244.755n 0.0v 249.745n 0.0v 249.755n 0.0v 254.745n 0.0v 254.755n 0.0v 259.745n 0.0v 259.755n 1.0v 264.745n 1.0v 264.755n 1.0v 269.745n 1.0v 269.755n 1.0v 274.745n 1.0v 274.755n 1.0v 279.745n 1.0v 279.755n 1.0v 284.745n 1.0v 284.755n 1.0v 289.745n 1.0v 289.755n 1.0v 294.745n 1.0v 294.755n 1.0v 299.745n 1.0v 299.755n 1.0v 304.745n 1.0v 304.755n 1.0v 309.745n 1.0v 309.755n 1.0v 314.745n 1.0v 314.755n 1.0v 319.745n 1.0v 319.755n 1.0v 324.745n 1.0v 324.755n 1.0v 329.745n 1.0v 329.755n 1.0v 334.745n 1.0v 334.755n 1.0v 339.745n 1.0v 339.755n 1.0v 344.745n 1.0v 344.755n 1.0v 349.745n 1.0v 349.755n 0.0v 354.745n 0.0v 354.755n 0.0v 359.745n 0.0v 359.755n 0.0v 364.745n 0.0v 364.755n 0.0v 369.745n 0.0v 369.755n 0.0v 374.745n 0.0v 374.755n 0.0v 379.745n 0.0v 379.755n 0.0v 384.745n 0.0v 384.755n 0.0v 389.745n 0.0v 389.755n 0.0v 394.745n 0.0v 394.755n 0.0v 399.745n 0.0v 399.755n 1.0v 404.745n 1.0v 404.755n 0.0v 409.745n 0.0v 409.755n 0.0v 414.745n 0.0v 414.755n 0.0v 419.745n 0.0v 419.755n 0.0v 424.745n 0.0v 424.755n 0.0v 429.745n 0.0v 429.755n 0.0v 434.745n 0.0v 434.755n 0.0v 439.745n 0.0v 439.755n 0.0v 444.745n 0.0v 444.755n 0.0v 449.745n 0.0v 449.755n 0.0v 454.745n 0.0v 454.755n 0.0v 459.745n 0.0v 459.755n 0.0v 464.745n 0.0v 464.755n 0.0v 469.745n 0.0v 469.755n 0.0v 474.745n 0.0v 474.755n 0.0v 479.745n 0.0v 479.755n 0.0v 484.745n 0.0v 484.755n 0.0v 489.745n 0.0v 489.755n 0.0v 494.745n 0.0v 494.755n 0.0v 499.745n 0.0v 499.755n 0.0v 504.745n 0.0v 504.755n 0.0v 509.745n 0.0v 509.755n 0.0v 514.745n 0.0v 514.755n 0.0v 519.745n 0.0v 519.755n 0.0v 524.745n 0.0v 524.755n 0.0v 529.745n 0.0v 529.755n 0.0v 534.745n 0.0v 534.755n 0.0v 539.745n 0.0v 539.755n 1.0v 544.745n 1.0v 544.755n 1.0v 549.745n 1.0v 549.755n 1.0v 554.745n 1.0v 554.755n 1.0v 559.745n 1.0v 559.755n 1.0v 564.745n 1.0v 564.755n 1.0v 569.745n 1.0v 569.755n 1.0v 574.745n 1.0v 574.755n 1.0v 579.745n 1.0v 579.755n 1.0v 584.745n 1.0v 584.755n 1.0v 589.745n 1.0v 589.755n 1.0v 594.745n 1.0v 594.755n 1.0v 599.745n 1.0v 599.755n 1.0v 604.745n 1.0v 604.755n 1.0v 609.745n 1.0v 609.755n 1.0v 614.745n 1.0v 614.755n 1.0v 619.745n 1.0v 619.755n 1.0v 624.745n 1.0v 624.755n 1.0v 629.745n 1.0v 629.755n 1.0v 634.745n 1.0v 634.755n 1.0v 639.745n 1.0v 639.755n 1.0v 644.745n 1.0v 644.755n 1.0v 649.745n 1.0v 649.755n 1.0v 654.745n 1.0v 654.755n 0.0v 659.745n 0.0v 659.755n 0.0v 664.745n 0.0v 664.755n 0.0v 669.745n 0.0v 669.755n 0.0v 674.745n 0.0v 674.755n 0.0v 679.745n 0.0v 679.755n 0.0v 684.745n 0.0v 684.755n 0.0v 689.745n 0.0v 689.755n 0.0v 694.745n 0.0v 694.755n 0.0v 699.745n 0.0v 699.755n 0.0v 704.745n 0.0v 704.755n 0.0v 709.745n 0.0v 709.755n 0.0v 714.745n 0.0v 714.755n 0.0v 719.745n 0.0v 719.755n 0.0v 724.745n 0.0v 724.755n 0.0v 729.745n 0.0v 729.755n 0.0v 734.745n 0.0v 734.755n 0.0v 739.745n 0.0v 739.755n 0.0v 744.745n 0.0v 744.755n 0.0v 749.745n 0.0v 749.755n 0.0v 754.745n 0.0v 754.755n 0.0v 759.745n 0.0v 759.755n 0.0v 764.745n 0.0v 764.755n 0.0v 769.745n 0.0v 769.755n 0.0v 774.745n 0.0v 774.755n 0.0v 779.745n 0.0v 779.755n 1.0v 784.745n 1.0v 784.755n 1.0v 789.745n 1.0v 789.755n 1.0v 794.745n 1.0v 794.755n 1.0v 799.745n 1.0v 799.755n 1.0v 804.745n 1.0v 804.755n 1.0v 809.745n 1.0v 809.755n 0.0v 814.745n 0.0v 814.755n 0.0v 819.745n 0.0v 819.755n 0.0v 824.745n 0.0v 824.755n 0.0v 829.745n 0.0v 829.755n 0.0v 834.745n 0.0v 834.755n 0.0v 839.745n 0.0v 839.755n 0.0v 844.745n 0.0v 844.755n 0.0v 849.745n 0.0v 849.755n 0.0v 854.745n 0.0v 854.755n 0.0v 859.745n 0.0v 859.755n 1.0v 864.745n 1.0v 864.755n 1.0v 869.745n 1.0v 869.755n 1.0v 874.745n 1.0v 874.755n 1.0v 879.745n 1.0v 879.755n 1.0v 884.745n 1.0v 884.755n 1.0v 889.745n 1.0v 889.755n 1.0v 894.745n 1.0v 894.755n 1.0v 899.745n 1.0v 899.755n 1.0v 904.745n 1.0v 904.755n 1.0v 909.745n 1.0v 909.755n 0.0v 914.745n 0.0v 914.755n 0.0v 919.745n 0.0v 919.755n 0.0v 924.745n 0.0v 924.755n 0.0v 929.745n 0.0v 929.755n 1.0v 934.745n 1.0v 934.755n 0.0v 939.745n 0.0v 939.755n 0.0v 944.745n 0.0v 944.755n 0.0v 949.745n 0.0v 949.755n 0.0v 954.745n 0.0v 954.755n 1.0v 959.745n 1.0v 959.755n 1.0v 964.745n 1.0v 964.755n 1.0v 969.745n 1.0v 969.755n 1.0v 974.745n 1.0v 974.755n 1.0v 979.745n 1.0v 979.755n 1.0v 984.745n 1.0v 984.755n 1.0v 989.745n 1.0v 989.755n 1.0v 994.745n 1.0v 994.755n 1.0v 999.745n 1.0v 999.755n 1.0v 1004.745n 1.0v 1004.755n 0.0v 1009.745n 0.0v 1009.755n 0.0v 1014.745n 0.0v 1014.755n 0.0v 1019.745n 0.0v 1019.755n 0.0v 1024.745n 0.0v 1024.755n 0.0v )
* (time, data): [(0, 0), (5, 1), (10, 1), (15, 0), (20, 0), (25, 0), (30, 0), (35, 1), (40, 1), (45, 1), (50, 0), (55, 0), (60, 0), (65, 0), (70, 0), (75, 0), (80, 0), (85, 1), (90, 1), (95, 1), (100, 0), (105, 0), (110, 0), (115, 0), (120, 0), (125, 1), (130, 1), (135, 1), (140, 1), (145, 1), (150, 1), (155, 1), (160, 1), (165, 0), (170, 0), (175, 0), (180, 0), (185, 0), (190, 0), (195, 0), (200, 0), (205, 0), (210, 0), (215, 0), (220, 1), (225, 1), (230, 1), (235, 1), (240, 0), (245, 0), (250, 1), (255, 1), (260, 0), (265, 0), (270, 0), (275, 1), (280, 1), (285, 1), (290, 1), (295, 1), (300, 1), (305, 1), (310, 0), (315, 0), (320, 0), (325, 0), (330, 0), (335, 0), (340, 0), (345, 1), (350, 0), (355, 0), (360, 0), (365, 0), (370, 0), (375, 0), (380, 0), (385, 0), (390, 0), (395, 0), (400, 1), (405, 1), (410, 1), (415, 1), (420, 1), (425, 1), (430, 1), (435, 1), (440, 1), (445, 1), (450, 1), (455, 1), (460, 1), (465, 1), (470, 1), (475, 1), (480, 1), (485, 1), (490, 1), (495, 1), (500, 0), (505, 0), (510, 0), (515, 0), (520, 0), (525, 0), (530, 0), (535, 1), (540, 1), (545, 1), (550, 1), (555, 1), (560, 1), (565, 1), (570, 1), (575, 1), (580, 1), (585, 1), (590, 1), (595, 1), (600, 1), (605, 1), (610, 1), (615, 1), (620, 1), (625, 1), (630, 1), (635, 1), (640, 1), (645, 1), (650, 1), (655, 1), (660, 1), (665, 1), (670, 1), (675, 1), (680, 1), (685, 1), (690, 1), (695, 1), (700, 1), (705, 1), (710, 1), (715, 1), (720, 1), (725, 1), (730, 1), (735, 1), (740, 1), (745, 1), (750, 1), (755, 1), (760, 0), (765, 0), (770, 0), (775, 0), (780, 0), (785, 0), (790, 0), (795, 0), (800, 0), (805, 0), (810, 1), (815, 1), (820, 1), (825, 1), (830, 1), (835, 1), (840, 1), (845, 1), (850, 1), (855, 1), (860, 1), (865, 1), (870, 1), (875, 1), (880, 0), (885, 0), (890, 0), (895, 0), (900, 0), (905, 0), (910, 1), (915, 1), (920, 0), (925, 0), (930, 1), (935, 0), (940, 0), (945, 0), (950, 0), (955, 0), (960, 0), (965, 0), (970, 0), (975, 0), (980, 0), (985, 1), (990, 1), (995, 1), (1000, 1), (1005, 0), (1010, 0), (1015, 0), (1020, 0), (1025, 0)]
Vdin1_26  din1_26  0 PWL (0n 0.0v 4.745n 0.0v 4.755n 1.0v 9.745n 1.0v 9.755n 1.0v 14.745n 1.0v 14.755n 0.0v 19.745n 0.0v 19.755n 0.0v 24.745n 0.0v 24.755n 0.0v 29.745n 0.0v 29.755n 0.0v 34.745n 0.0v 34.755n 1.0v 39.745n 1.0v 39.755n 1.0v 44.745n 1.0v 44.755n 1.0v 49.745n 1.0v 49.755n 0.0v 54.745n 0.0v 54.755n 0.0v 59.745n 0.0v 59.755n 0.0v 64.745n 0.0v 64.755n 0.0v 69.745n 0.0v 69.755n 0.0v 74.745n 0.0v 74.755n 0.0v 79.745n 0.0v 79.755n 0.0v 84.745n 0.0v 84.755n 1.0v 89.745n 1.0v 89.755n 1.0v 94.745n 1.0v 94.755n 1.0v 99.745n 1.0v 99.755n 0.0v 104.745n 0.0v 104.755n 0.0v 109.745n 0.0v 109.755n 0.0v 114.745n 0.0v 114.755n 0.0v 119.745n 0.0v 119.755n 0.0v 124.745n 0.0v 124.755n 1.0v 129.745n 1.0v 129.755n 1.0v 134.745n 1.0v 134.755n 1.0v 139.745n 1.0v 139.755n 1.0v 144.745n 1.0v 144.755n 1.0v 149.745n 1.0v 149.755n 1.0v 154.745n 1.0v 154.755n 1.0v 159.745n 1.0v 159.755n 1.0v 164.745n 1.0v 164.755n 0.0v 169.745n 0.0v 169.755n 0.0v 174.745n 0.0v 174.755n 0.0v 179.745n 0.0v 179.755n 0.0v 184.745n 0.0v 184.755n 0.0v 189.745n 0.0v 189.755n 0.0v 194.745n 0.0v 194.755n 0.0v 199.745n 0.0v 199.755n 0.0v 204.745n 0.0v 204.755n 0.0v 209.745n 0.0v 209.755n 0.0v 214.745n 0.0v 214.755n 0.0v 219.745n 0.0v 219.755n 1.0v 224.745n 1.0v 224.755n 1.0v 229.745n 1.0v 229.755n 1.0v 234.745n 1.0v 234.755n 1.0v 239.745n 1.0v 239.755n 0.0v 244.745n 0.0v 244.755n 0.0v 249.745n 0.0v 249.755n 1.0v 254.745n 1.0v 254.755n 1.0v 259.745n 1.0v 259.755n 0.0v 264.745n 0.0v 264.755n 0.0v 269.745n 0.0v 269.755n 0.0v 274.745n 0.0v 274.755n 1.0v 279.745n 1.0v 279.755n 1.0v 284.745n 1.0v 284.755n 1.0v 289.745n 1.0v 289.755n 1.0v 294.745n 1.0v 294.755n 1.0v 299.745n 1.0v 299.755n 1.0v 304.745n 1.0v 304.755n 1.0v 309.745n 1.0v 309.755n 0.0v 314.745n 0.0v 314.755n 0.0v 319.745n 0.0v 319.755n 0.0v 324.745n 0.0v 324.755n 0.0v 329.745n 0.0v 329.755n 0.0v 334.745n 0.0v 334.755n 0.0v 339.745n 0.0v 339.755n 0.0v 344.745n 0.0v 344.755n 1.0v 349.745n 1.0v 349.755n 0.0v 354.745n 0.0v 354.755n 0.0v 359.745n 0.0v 359.755n 0.0v 364.745n 0.0v 364.755n 0.0v 369.745n 0.0v 369.755n 0.0v 374.745n 0.0v 374.755n 0.0v 379.745n 0.0v 379.755n 0.0v 384.745n 0.0v 384.755n 0.0v 389.745n 0.0v 389.755n 0.0v 394.745n 0.0v 394.755n 0.0v 399.745n 0.0v 399.755n 1.0v 404.745n 1.0v 404.755n 1.0v 409.745n 1.0v 409.755n 1.0v 414.745n 1.0v 414.755n 1.0v 419.745n 1.0v 419.755n 1.0v 424.745n 1.0v 424.755n 1.0v 429.745n 1.0v 429.755n 1.0v 434.745n 1.0v 434.755n 1.0v 439.745n 1.0v 439.755n 1.0v 444.745n 1.0v 444.755n 1.0v 449.745n 1.0v 449.755n 1.0v 454.745n 1.0v 454.755n 1.0v 459.745n 1.0v 459.755n 1.0v 464.745n 1.0v 464.755n 1.0v 469.745n 1.0v 469.755n 1.0v 474.745n 1.0v 474.755n 1.0v 479.745n 1.0v 479.755n 1.0v 484.745n 1.0v 484.755n 1.0v 489.745n 1.0v 489.755n 1.0v 494.745n 1.0v 494.755n 1.0v 499.745n 1.0v 499.755n 0.0v 504.745n 0.0v 504.755n 0.0v 509.745n 0.0v 509.755n 0.0v 514.745n 0.0v 514.755n 0.0v 519.745n 0.0v 519.755n 0.0v 524.745n 0.0v 524.755n 0.0v 529.745n 0.0v 529.755n 0.0v 534.745n 0.0v 534.755n 1.0v 539.745n 1.0v 539.755n 1.0v 544.745n 1.0v 544.755n 1.0v 549.745n 1.0v 549.755n 1.0v 554.745n 1.0v 554.755n 1.0v 559.745n 1.0v 559.755n 1.0v 564.745n 1.0v 564.755n 1.0v 569.745n 1.0v 569.755n 1.0v 574.745n 1.0v 574.755n 1.0v 579.745n 1.0v 579.755n 1.0v 584.745n 1.0v 584.755n 1.0v 589.745n 1.0v 589.755n 1.0v 594.745n 1.0v 594.755n 1.0v 599.745n 1.0v 599.755n 1.0v 604.745n 1.0v 604.755n 1.0v 609.745n 1.0v 609.755n 1.0v 614.745n 1.0v 614.755n 1.0v 619.745n 1.0v 619.755n 1.0v 624.745n 1.0v 624.755n 1.0v 629.745n 1.0v 629.755n 1.0v 634.745n 1.0v 634.755n 1.0v 639.745n 1.0v 639.755n 1.0v 644.745n 1.0v 644.755n 1.0v 649.745n 1.0v 649.755n 1.0v 654.745n 1.0v 654.755n 1.0v 659.745n 1.0v 659.755n 1.0v 664.745n 1.0v 664.755n 1.0v 669.745n 1.0v 669.755n 1.0v 674.745n 1.0v 674.755n 1.0v 679.745n 1.0v 679.755n 1.0v 684.745n 1.0v 684.755n 1.0v 689.745n 1.0v 689.755n 1.0v 694.745n 1.0v 694.755n 1.0v 699.745n 1.0v 699.755n 1.0v 704.745n 1.0v 704.755n 1.0v 709.745n 1.0v 709.755n 1.0v 714.745n 1.0v 714.755n 1.0v 719.745n 1.0v 719.755n 1.0v 724.745n 1.0v 724.755n 1.0v 729.745n 1.0v 729.755n 1.0v 734.745n 1.0v 734.755n 1.0v 739.745n 1.0v 739.755n 1.0v 744.745n 1.0v 744.755n 1.0v 749.745n 1.0v 749.755n 1.0v 754.745n 1.0v 754.755n 1.0v 759.745n 1.0v 759.755n 0.0v 764.745n 0.0v 764.755n 0.0v 769.745n 0.0v 769.755n 0.0v 774.745n 0.0v 774.755n 0.0v 779.745n 0.0v 779.755n 0.0v 784.745n 0.0v 784.755n 0.0v 789.745n 0.0v 789.755n 0.0v 794.745n 0.0v 794.755n 0.0v 799.745n 0.0v 799.755n 0.0v 804.745n 0.0v 804.755n 0.0v 809.745n 0.0v 809.755n 1.0v 814.745n 1.0v 814.755n 1.0v 819.745n 1.0v 819.755n 1.0v 824.745n 1.0v 824.755n 1.0v 829.745n 1.0v 829.755n 1.0v 834.745n 1.0v 834.755n 1.0v 839.745n 1.0v 839.755n 1.0v 844.745n 1.0v 844.755n 1.0v 849.745n 1.0v 849.755n 1.0v 854.745n 1.0v 854.755n 1.0v 859.745n 1.0v 859.755n 1.0v 864.745n 1.0v 864.755n 1.0v 869.745n 1.0v 869.755n 1.0v 874.745n 1.0v 874.755n 1.0v 879.745n 1.0v 879.755n 0.0v 884.745n 0.0v 884.755n 0.0v 889.745n 0.0v 889.755n 0.0v 894.745n 0.0v 894.755n 0.0v 899.745n 0.0v 899.755n 0.0v 904.745n 0.0v 904.755n 0.0v 909.745n 0.0v 909.755n 1.0v 914.745n 1.0v 914.755n 1.0v 919.745n 1.0v 919.755n 0.0v 924.745n 0.0v 924.755n 0.0v 929.745n 0.0v 929.755n 1.0v 934.745n 1.0v 934.755n 0.0v 939.745n 0.0v 939.755n 0.0v 944.745n 0.0v 944.755n 0.0v 949.745n 0.0v 949.755n 0.0v 954.745n 0.0v 954.755n 0.0v 959.745n 0.0v 959.755n 0.0v 964.745n 0.0v 964.755n 0.0v 969.745n 0.0v 969.755n 0.0v 974.745n 0.0v 974.755n 0.0v 979.745n 0.0v 979.755n 0.0v 984.745n 0.0v 984.755n 1.0v 989.745n 1.0v 989.755n 1.0v 994.745n 1.0v 994.755n 1.0v 999.745n 1.0v 999.755n 1.0v 1004.745n 1.0v 1004.755n 0.0v 1009.745n 0.0v 1009.755n 0.0v 1014.745n 0.0v 1014.755n 0.0v 1019.745n 0.0v 1019.755n 0.0v 1024.745n 0.0v 1024.755n 0.0v )
* (time, data): [(0, 0), (5, 1), (10, 1), (15, 1), (20, 1), (25, 1), (30, 1), (35, 0), (40, 0), (45, 0), (50, 0), (55, 0), (60, 0), (65, 0), (70, 0), (75, 0), (80, 0), (85, 1), (90, 1), (95, 1), (100, 1), (105, 1), (110, 1), (115, 1), (120, 1), (125, 1), (130, 1), (135, 1), (140, 1), (145, 1), (150, 1), (155, 1), (160, 1), (165, 0), (170, 0), (175, 0), (180, 0), (185, 0), (190, 0), (195, 0), (200, 0), (205, 0), (210, 0), (215, 0), (220, 0), (225, 0), (230, 0), (235, 0), (240, 0), (245, 0), (250, 0), (255, 0), (260, 1), (265, 1), (270, 1), (275, 1), (280, 1), (285, 1), (290, 1), (295, 1), (300, 1), (305, 1), (310, 0), (315, 0), (320, 0), (325, 0), (330, 0), (335, 0), (340, 0), (345, 1), (350, 1), (355, 1), (360, 1), (365, 1), (370, 1), (375, 1), (380, 1), (385, 1), (390, 1), (395, 1), (400, 0), (405, 1), (410, 1), (415, 1), (420, 1), (425, 1), (430, 1), (435, 1), (440, 1), (445, 1), (450, 1), (455, 1), (460, 1), (465, 1), (470, 1), (475, 1), (480, 1), (485, 1), (490, 1), (495, 1), (500, 0), (505, 0), (510, 0), (515, 0), (520, 0), (525, 0), (530, 0), (535, 1), (540, 0), (545, 0), (550, 0), (555, 0), (560, 0), (565, 0), (570, 0), (575, 0), (580, 0), (585, 0), (590, 0), (595, 0), (600, 0), (605, 0), (610, 0), (615, 0), (620, 0), (625, 0), (630, 0), (635, 0), (640, 0), (645, 0), (650, 0), (655, 1), (660, 1), (665, 1), (670, 1), (675, 1), (680, 1), (685, 1), (690, 1), (695, 1), (700, 1), (705, 1), (710, 0), (715, 0), (720, 0), (725, 0), (730, 0), (735, 0), (740, 0), (745, 0), (750, 0), (755, 0), (760, 0), (765, 0), (770, 0), (775, 0), (780, 0), (785, 0), (790, 0), (795, 0), (800, 0), (805, 0), (810, 0), (815, 0), (820, 0), (825, 0), (830, 0), (835, 0), (840, 0), (845, 0), (850, 0), (855, 0), (860, 1), (865, 1), (870, 1), (875, 1), (880, 1), (885, 1), (890, 1), (895, 1), (900, 1), (905, 1), (910, 1), (915, 1), (920, 1), (925, 1), (930, 1), (935, 0), (940, 0), (945, 0), (950, 1), (955, 1), (960, 1), (965, 1), (970, 1), (975, 1), (980, 1), (985, 1), (990, 1), (995, 1), (1000, 1), (1005, 0), (1010, 0), (1015, 0), (1020, 0), (1025, 0)]
Vdin1_27  din1_27  0 PWL (0n 0.0v 4.745n 0.0v 4.755n 1.0v 9.745n 1.0v 9.755n 1.0v 14.745n 1.0v 14.755n 1.0v 19.745n 1.0v 19.755n 1.0v 24.745n 1.0v 24.755n 1.0v 29.745n 1.0v 29.755n 1.0v 34.745n 1.0v 34.755n 0.0v 39.745n 0.0v 39.755n 0.0v 44.745n 0.0v 44.755n 0.0v 49.745n 0.0v 49.755n 0.0v 54.745n 0.0v 54.755n 0.0v 59.745n 0.0v 59.755n 0.0v 64.745n 0.0v 64.755n 0.0v 69.745n 0.0v 69.755n 0.0v 74.745n 0.0v 74.755n 0.0v 79.745n 0.0v 79.755n 0.0v 84.745n 0.0v 84.755n 1.0v 89.745n 1.0v 89.755n 1.0v 94.745n 1.0v 94.755n 1.0v 99.745n 1.0v 99.755n 1.0v 104.745n 1.0v 104.755n 1.0v 109.745n 1.0v 109.755n 1.0v 114.745n 1.0v 114.755n 1.0v 119.745n 1.0v 119.755n 1.0v 124.745n 1.0v 124.755n 1.0v 129.745n 1.0v 129.755n 1.0v 134.745n 1.0v 134.755n 1.0v 139.745n 1.0v 139.755n 1.0v 144.745n 1.0v 144.755n 1.0v 149.745n 1.0v 149.755n 1.0v 154.745n 1.0v 154.755n 1.0v 159.745n 1.0v 159.755n 1.0v 164.745n 1.0v 164.755n 0.0v 169.745n 0.0v 169.755n 0.0v 174.745n 0.0v 174.755n 0.0v 179.745n 0.0v 179.755n 0.0v 184.745n 0.0v 184.755n 0.0v 189.745n 0.0v 189.755n 0.0v 194.745n 0.0v 194.755n 0.0v 199.745n 0.0v 199.755n 0.0v 204.745n 0.0v 204.755n 0.0v 209.745n 0.0v 209.755n 0.0v 214.745n 0.0v 214.755n 0.0v 219.745n 0.0v 219.755n 0.0v 224.745n 0.0v 224.755n 0.0v 229.745n 0.0v 229.755n 0.0v 234.745n 0.0v 234.755n 0.0v 239.745n 0.0v 239.755n 0.0v 244.745n 0.0v 244.755n 0.0v 249.745n 0.0v 249.755n 0.0v 254.745n 0.0v 254.755n 0.0v 259.745n 0.0v 259.755n 1.0v 264.745n 1.0v 264.755n 1.0v 269.745n 1.0v 269.755n 1.0v 274.745n 1.0v 274.755n 1.0v 279.745n 1.0v 279.755n 1.0v 284.745n 1.0v 284.755n 1.0v 289.745n 1.0v 289.755n 1.0v 294.745n 1.0v 294.755n 1.0v 299.745n 1.0v 299.755n 1.0v 304.745n 1.0v 304.755n 1.0v 309.745n 1.0v 309.755n 0.0v 314.745n 0.0v 314.755n 0.0v 319.745n 0.0v 319.755n 0.0v 324.745n 0.0v 324.755n 0.0v 329.745n 0.0v 329.755n 0.0v 334.745n 0.0v 334.755n 0.0v 339.745n 0.0v 339.755n 0.0v 344.745n 0.0v 344.755n 1.0v 349.745n 1.0v 349.755n 1.0v 354.745n 1.0v 354.755n 1.0v 359.745n 1.0v 359.755n 1.0v 364.745n 1.0v 364.755n 1.0v 369.745n 1.0v 369.755n 1.0v 374.745n 1.0v 374.755n 1.0v 379.745n 1.0v 379.755n 1.0v 384.745n 1.0v 384.755n 1.0v 389.745n 1.0v 389.755n 1.0v 394.745n 1.0v 394.755n 1.0v 399.745n 1.0v 399.755n 0.0v 404.745n 0.0v 404.755n 1.0v 409.745n 1.0v 409.755n 1.0v 414.745n 1.0v 414.755n 1.0v 419.745n 1.0v 419.755n 1.0v 424.745n 1.0v 424.755n 1.0v 429.745n 1.0v 429.755n 1.0v 434.745n 1.0v 434.755n 1.0v 439.745n 1.0v 439.755n 1.0v 444.745n 1.0v 444.755n 1.0v 449.745n 1.0v 449.755n 1.0v 454.745n 1.0v 454.755n 1.0v 459.745n 1.0v 459.755n 1.0v 464.745n 1.0v 464.755n 1.0v 469.745n 1.0v 469.755n 1.0v 474.745n 1.0v 474.755n 1.0v 479.745n 1.0v 479.755n 1.0v 484.745n 1.0v 484.755n 1.0v 489.745n 1.0v 489.755n 1.0v 494.745n 1.0v 494.755n 1.0v 499.745n 1.0v 499.755n 0.0v 504.745n 0.0v 504.755n 0.0v 509.745n 0.0v 509.755n 0.0v 514.745n 0.0v 514.755n 0.0v 519.745n 0.0v 519.755n 0.0v 524.745n 0.0v 524.755n 0.0v 529.745n 0.0v 529.755n 0.0v 534.745n 0.0v 534.755n 1.0v 539.745n 1.0v 539.755n 0.0v 544.745n 0.0v 544.755n 0.0v 549.745n 0.0v 549.755n 0.0v 554.745n 0.0v 554.755n 0.0v 559.745n 0.0v 559.755n 0.0v 564.745n 0.0v 564.755n 0.0v 569.745n 0.0v 569.755n 0.0v 574.745n 0.0v 574.755n 0.0v 579.745n 0.0v 579.755n 0.0v 584.745n 0.0v 584.755n 0.0v 589.745n 0.0v 589.755n 0.0v 594.745n 0.0v 594.755n 0.0v 599.745n 0.0v 599.755n 0.0v 604.745n 0.0v 604.755n 0.0v 609.745n 0.0v 609.755n 0.0v 614.745n 0.0v 614.755n 0.0v 619.745n 0.0v 619.755n 0.0v 624.745n 0.0v 624.755n 0.0v 629.745n 0.0v 629.755n 0.0v 634.745n 0.0v 634.755n 0.0v 639.745n 0.0v 639.755n 0.0v 644.745n 0.0v 644.755n 0.0v 649.745n 0.0v 649.755n 0.0v 654.745n 0.0v 654.755n 1.0v 659.745n 1.0v 659.755n 1.0v 664.745n 1.0v 664.755n 1.0v 669.745n 1.0v 669.755n 1.0v 674.745n 1.0v 674.755n 1.0v 679.745n 1.0v 679.755n 1.0v 684.745n 1.0v 684.755n 1.0v 689.745n 1.0v 689.755n 1.0v 694.745n 1.0v 694.755n 1.0v 699.745n 1.0v 699.755n 1.0v 704.745n 1.0v 704.755n 1.0v 709.745n 1.0v 709.755n 0.0v 714.745n 0.0v 714.755n 0.0v 719.745n 0.0v 719.755n 0.0v 724.745n 0.0v 724.755n 0.0v 729.745n 0.0v 729.755n 0.0v 734.745n 0.0v 734.755n 0.0v 739.745n 0.0v 739.755n 0.0v 744.745n 0.0v 744.755n 0.0v 749.745n 0.0v 749.755n 0.0v 754.745n 0.0v 754.755n 0.0v 759.745n 0.0v 759.755n 0.0v 764.745n 0.0v 764.755n 0.0v 769.745n 0.0v 769.755n 0.0v 774.745n 0.0v 774.755n 0.0v 779.745n 0.0v 779.755n 0.0v 784.745n 0.0v 784.755n 0.0v 789.745n 0.0v 789.755n 0.0v 794.745n 0.0v 794.755n 0.0v 799.745n 0.0v 799.755n 0.0v 804.745n 0.0v 804.755n 0.0v 809.745n 0.0v 809.755n 0.0v 814.745n 0.0v 814.755n 0.0v 819.745n 0.0v 819.755n 0.0v 824.745n 0.0v 824.755n 0.0v 829.745n 0.0v 829.755n 0.0v 834.745n 0.0v 834.755n 0.0v 839.745n 0.0v 839.755n 0.0v 844.745n 0.0v 844.755n 0.0v 849.745n 0.0v 849.755n 0.0v 854.745n 0.0v 854.755n 0.0v 859.745n 0.0v 859.755n 1.0v 864.745n 1.0v 864.755n 1.0v 869.745n 1.0v 869.755n 1.0v 874.745n 1.0v 874.755n 1.0v 879.745n 1.0v 879.755n 1.0v 884.745n 1.0v 884.755n 1.0v 889.745n 1.0v 889.755n 1.0v 894.745n 1.0v 894.755n 1.0v 899.745n 1.0v 899.755n 1.0v 904.745n 1.0v 904.755n 1.0v 909.745n 1.0v 909.755n 1.0v 914.745n 1.0v 914.755n 1.0v 919.745n 1.0v 919.755n 1.0v 924.745n 1.0v 924.755n 1.0v 929.745n 1.0v 929.755n 1.0v 934.745n 1.0v 934.755n 0.0v 939.745n 0.0v 939.755n 0.0v 944.745n 0.0v 944.755n 0.0v 949.745n 0.0v 949.755n 1.0v 954.745n 1.0v 954.755n 1.0v 959.745n 1.0v 959.755n 1.0v 964.745n 1.0v 964.755n 1.0v 969.745n 1.0v 969.755n 1.0v 974.745n 1.0v 974.755n 1.0v 979.745n 1.0v 979.755n 1.0v 984.745n 1.0v 984.755n 1.0v 989.745n 1.0v 989.755n 1.0v 994.745n 1.0v 994.755n 1.0v 999.745n 1.0v 999.755n 1.0v 1004.745n 1.0v 1004.755n 0.0v 1009.745n 0.0v 1009.755n 0.0v 1014.745n 0.0v 1014.755n 0.0v 1019.745n 0.0v 1019.755n 0.0v 1024.745n 0.0v 1024.755n 0.0v )
* (time, data): [(0, 0), (5, 1), (10, 0), (15, 0), (20, 0), (25, 0), (30, 0), (35, 0), (40, 0), (45, 0), (50, 1), (55, 1), (60, 1), (65, 1), (70, 1), (75, 1), (80, 1), (85, 0), (90, 0), (95, 0), (100, 1), (105, 1), (110, 1), (115, 1), (120, 1), (125, 1), (130, 1), (135, 1), (140, 1), (145, 1), (150, 1), (155, 1), (160, 1), (165, 1), (170, 1), (175, 1), (180, 1), (185, 1), (190, 1), (195, 1), (200, 1), (205, 1), (210, 1), (215, 1), (220, 0), (225, 0), (230, 0), (235, 0), (240, 1), (245, 1), (250, 1), (255, 1), (260, 0), (265, 0), (270, 0), (275, 0), (280, 0), (285, 0), (290, 0), (295, 0), (300, 0), (305, 0), (310, 1), (315, 1), (320, 1), (325, 1), (330, 1), (335, 1), (340, 1), (345, 1), (350, 1), (355, 1), (360, 0), (365, 0), (370, 0), (375, 0), (380, 0), (385, 0), (390, 0), (395, 0), (400, 0), (405, 0), (410, 0), (415, 0), (420, 0), (425, 0), (430, 0), (435, 0), (440, 1), (445, 1), (450, 1), (455, 1), (460, 1), (465, 1), (470, 1), (475, 1), (480, 1), (485, 1), (490, 1), (495, 1), (500, 1), (505, 1), (510, 1), (515, 1), (520, 1), (525, 1), (530, 1), (535, 1), (540, 1), (545, 1), (550, 1), (555, 1), (560, 1), (565, 1), (570, 1), (575, 1), (580, 1), (585, 1), (590, 1), (595, 1), (600, 1), (605, 1), (610, 1), (615, 1), (620, 1), (625, 1), (630, 1), (635, 1), (640, 1), (645, 1), (650, 1), (655, 1), (660, 1), (665, 1), (670, 1), (675, 1), (680, 1), (685, 1), (690, 1), (695, 1), (700, 1), (705, 1), (710, 1), (715, 1), (720, 1), (725, 1), (730, 1), (735, 1), (740, 1), (745, 1), (750, 1), (755, 1), (760, 1), (765, 1), (770, 1), (775, 1), (780, 0), (785, 0), (790, 0), (795, 0), (800, 0), (805, 0), (810, 0), (815, 0), (820, 0), (825, 0), (830, 0), (835, 0), (840, 0), (845, 0), (850, 0), (855, 0), (860, 0), (865, 0), (870, 0), (875, 0), (880, 0), (885, 0), (890, 0), (895, 0), (900, 0), (905, 0), (910, 0), (915, 0), (920, 0), (925, 0), (930, 1), (935, 1), (940, 1), (945, 1), (950, 0), (955, 1), (960, 1), (965, 1), (970, 1), (975, 1), (980, 1), (985, 0), (990, 0), (995, 0), (1000, 0), (1005, 1), (1010, 1), (1015, 1), (1020, 1), (1025, 1)]
Vdin1_28  din1_28  0 PWL (0n 0.0v 4.745n 0.0v 4.755n 1.0v 9.745n 1.0v 9.755n 0.0v 14.745n 0.0v 14.755n 0.0v 19.745n 0.0v 19.755n 0.0v 24.745n 0.0v 24.755n 0.0v 29.745n 0.0v 29.755n 0.0v 34.745n 0.0v 34.755n 0.0v 39.745n 0.0v 39.755n 0.0v 44.745n 0.0v 44.755n 0.0v 49.745n 0.0v 49.755n 1.0v 54.745n 1.0v 54.755n 1.0v 59.745n 1.0v 59.755n 1.0v 64.745n 1.0v 64.755n 1.0v 69.745n 1.0v 69.755n 1.0v 74.745n 1.0v 74.755n 1.0v 79.745n 1.0v 79.755n 1.0v 84.745n 1.0v 84.755n 0.0v 89.745n 0.0v 89.755n 0.0v 94.745n 0.0v 94.755n 0.0v 99.745n 0.0v 99.755n 1.0v 104.745n 1.0v 104.755n 1.0v 109.745n 1.0v 109.755n 1.0v 114.745n 1.0v 114.755n 1.0v 119.745n 1.0v 119.755n 1.0v 124.745n 1.0v 124.755n 1.0v 129.745n 1.0v 129.755n 1.0v 134.745n 1.0v 134.755n 1.0v 139.745n 1.0v 139.755n 1.0v 144.745n 1.0v 144.755n 1.0v 149.745n 1.0v 149.755n 1.0v 154.745n 1.0v 154.755n 1.0v 159.745n 1.0v 159.755n 1.0v 164.745n 1.0v 164.755n 1.0v 169.745n 1.0v 169.755n 1.0v 174.745n 1.0v 174.755n 1.0v 179.745n 1.0v 179.755n 1.0v 184.745n 1.0v 184.755n 1.0v 189.745n 1.0v 189.755n 1.0v 194.745n 1.0v 194.755n 1.0v 199.745n 1.0v 199.755n 1.0v 204.745n 1.0v 204.755n 1.0v 209.745n 1.0v 209.755n 1.0v 214.745n 1.0v 214.755n 1.0v 219.745n 1.0v 219.755n 0.0v 224.745n 0.0v 224.755n 0.0v 229.745n 0.0v 229.755n 0.0v 234.745n 0.0v 234.755n 0.0v 239.745n 0.0v 239.755n 1.0v 244.745n 1.0v 244.755n 1.0v 249.745n 1.0v 249.755n 1.0v 254.745n 1.0v 254.755n 1.0v 259.745n 1.0v 259.755n 0.0v 264.745n 0.0v 264.755n 0.0v 269.745n 0.0v 269.755n 0.0v 274.745n 0.0v 274.755n 0.0v 279.745n 0.0v 279.755n 0.0v 284.745n 0.0v 284.755n 0.0v 289.745n 0.0v 289.755n 0.0v 294.745n 0.0v 294.755n 0.0v 299.745n 0.0v 299.755n 0.0v 304.745n 0.0v 304.755n 0.0v 309.745n 0.0v 309.755n 1.0v 314.745n 1.0v 314.755n 1.0v 319.745n 1.0v 319.755n 1.0v 324.745n 1.0v 324.755n 1.0v 329.745n 1.0v 329.755n 1.0v 334.745n 1.0v 334.755n 1.0v 339.745n 1.0v 339.755n 1.0v 344.745n 1.0v 344.755n 1.0v 349.745n 1.0v 349.755n 1.0v 354.745n 1.0v 354.755n 1.0v 359.745n 1.0v 359.755n 0.0v 364.745n 0.0v 364.755n 0.0v 369.745n 0.0v 369.755n 0.0v 374.745n 0.0v 374.755n 0.0v 379.745n 0.0v 379.755n 0.0v 384.745n 0.0v 384.755n 0.0v 389.745n 0.0v 389.755n 0.0v 394.745n 0.0v 394.755n 0.0v 399.745n 0.0v 399.755n 0.0v 404.745n 0.0v 404.755n 0.0v 409.745n 0.0v 409.755n 0.0v 414.745n 0.0v 414.755n 0.0v 419.745n 0.0v 419.755n 0.0v 424.745n 0.0v 424.755n 0.0v 429.745n 0.0v 429.755n 0.0v 434.745n 0.0v 434.755n 0.0v 439.745n 0.0v 439.755n 1.0v 444.745n 1.0v 444.755n 1.0v 449.745n 1.0v 449.755n 1.0v 454.745n 1.0v 454.755n 1.0v 459.745n 1.0v 459.755n 1.0v 464.745n 1.0v 464.755n 1.0v 469.745n 1.0v 469.755n 1.0v 474.745n 1.0v 474.755n 1.0v 479.745n 1.0v 479.755n 1.0v 484.745n 1.0v 484.755n 1.0v 489.745n 1.0v 489.755n 1.0v 494.745n 1.0v 494.755n 1.0v 499.745n 1.0v 499.755n 1.0v 504.745n 1.0v 504.755n 1.0v 509.745n 1.0v 509.755n 1.0v 514.745n 1.0v 514.755n 1.0v 519.745n 1.0v 519.755n 1.0v 524.745n 1.0v 524.755n 1.0v 529.745n 1.0v 529.755n 1.0v 534.745n 1.0v 534.755n 1.0v 539.745n 1.0v 539.755n 1.0v 544.745n 1.0v 544.755n 1.0v 549.745n 1.0v 549.755n 1.0v 554.745n 1.0v 554.755n 1.0v 559.745n 1.0v 559.755n 1.0v 564.745n 1.0v 564.755n 1.0v 569.745n 1.0v 569.755n 1.0v 574.745n 1.0v 574.755n 1.0v 579.745n 1.0v 579.755n 1.0v 584.745n 1.0v 584.755n 1.0v 589.745n 1.0v 589.755n 1.0v 594.745n 1.0v 594.755n 1.0v 599.745n 1.0v 599.755n 1.0v 604.745n 1.0v 604.755n 1.0v 609.745n 1.0v 609.755n 1.0v 614.745n 1.0v 614.755n 1.0v 619.745n 1.0v 619.755n 1.0v 624.745n 1.0v 624.755n 1.0v 629.745n 1.0v 629.755n 1.0v 634.745n 1.0v 634.755n 1.0v 639.745n 1.0v 639.755n 1.0v 644.745n 1.0v 644.755n 1.0v 649.745n 1.0v 649.755n 1.0v 654.745n 1.0v 654.755n 1.0v 659.745n 1.0v 659.755n 1.0v 664.745n 1.0v 664.755n 1.0v 669.745n 1.0v 669.755n 1.0v 674.745n 1.0v 674.755n 1.0v 679.745n 1.0v 679.755n 1.0v 684.745n 1.0v 684.755n 1.0v 689.745n 1.0v 689.755n 1.0v 694.745n 1.0v 694.755n 1.0v 699.745n 1.0v 699.755n 1.0v 704.745n 1.0v 704.755n 1.0v 709.745n 1.0v 709.755n 1.0v 714.745n 1.0v 714.755n 1.0v 719.745n 1.0v 719.755n 1.0v 724.745n 1.0v 724.755n 1.0v 729.745n 1.0v 729.755n 1.0v 734.745n 1.0v 734.755n 1.0v 739.745n 1.0v 739.755n 1.0v 744.745n 1.0v 744.755n 1.0v 749.745n 1.0v 749.755n 1.0v 754.745n 1.0v 754.755n 1.0v 759.745n 1.0v 759.755n 1.0v 764.745n 1.0v 764.755n 1.0v 769.745n 1.0v 769.755n 1.0v 774.745n 1.0v 774.755n 1.0v 779.745n 1.0v 779.755n 0.0v 784.745n 0.0v 784.755n 0.0v 789.745n 0.0v 789.755n 0.0v 794.745n 0.0v 794.755n 0.0v 799.745n 0.0v 799.755n 0.0v 804.745n 0.0v 804.755n 0.0v 809.745n 0.0v 809.755n 0.0v 814.745n 0.0v 814.755n 0.0v 819.745n 0.0v 819.755n 0.0v 824.745n 0.0v 824.755n 0.0v 829.745n 0.0v 829.755n 0.0v 834.745n 0.0v 834.755n 0.0v 839.745n 0.0v 839.755n 0.0v 844.745n 0.0v 844.755n 0.0v 849.745n 0.0v 849.755n 0.0v 854.745n 0.0v 854.755n 0.0v 859.745n 0.0v 859.755n 0.0v 864.745n 0.0v 864.755n 0.0v 869.745n 0.0v 869.755n 0.0v 874.745n 0.0v 874.755n 0.0v 879.745n 0.0v 879.755n 0.0v 884.745n 0.0v 884.755n 0.0v 889.745n 0.0v 889.755n 0.0v 894.745n 0.0v 894.755n 0.0v 899.745n 0.0v 899.755n 0.0v 904.745n 0.0v 904.755n 0.0v 909.745n 0.0v 909.755n 0.0v 914.745n 0.0v 914.755n 0.0v 919.745n 0.0v 919.755n 0.0v 924.745n 0.0v 924.755n 0.0v 929.745n 0.0v 929.755n 1.0v 934.745n 1.0v 934.755n 1.0v 939.745n 1.0v 939.755n 1.0v 944.745n 1.0v 944.755n 1.0v 949.745n 1.0v 949.755n 0.0v 954.745n 0.0v 954.755n 1.0v 959.745n 1.0v 959.755n 1.0v 964.745n 1.0v 964.755n 1.0v 969.745n 1.0v 969.755n 1.0v 974.745n 1.0v 974.755n 1.0v 979.745n 1.0v 979.755n 1.0v 984.745n 1.0v 984.755n 0.0v 989.745n 0.0v 989.755n 0.0v 994.745n 0.0v 994.755n 0.0v 999.745n 0.0v 999.755n 0.0v 1004.745n 0.0v 1004.755n 1.0v 1009.745n 1.0v 1009.755n 1.0v 1014.745n 1.0v 1014.755n 1.0v 1019.745n 1.0v 1019.755n 1.0v 1024.745n 1.0v 1024.755n 1.0v )
* (time, data): [(0, 0), (5, 0), (10, 0), (15, 0), (20, 0), (25, 0), (30, 0), (35, 1), (40, 1), (45, 1), (50, 0), (55, 0), (60, 0), (65, 0), (70, 0), (75, 0), (80, 0), (85, 0), (90, 0), (95, 0), (100, 1), (105, 1), (110, 1), (115, 1), (120, 1), (125, 0), (130, 0), (135, 0), (140, 0), (145, 0), (150, 1), (155, 1), (160, 1), (165, 1), (170, 1), (175, 1), (180, 1), (185, 1), (190, 1), (195, 1), (200, 1), (205, 0), (210, 0), (215, 0), (220, 0), (225, 0), (230, 0), (235, 0), (240, 1), (245, 1), (250, 0), (255, 0), (260, 0), (265, 0), (270, 0), (275, 1), (280, 1), (285, 1), (290, 1), (295, 1), (300, 1), (305, 1), (310, 0), (315, 0), (320, 0), (325, 0), (330, 0), (335, 0), (340, 0), (345, 0), (350, 0), (355, 0), (360, 0), (365, 0), (370, 0), (375, 0), (380, 0), (385, 0), (390, 0), (395, 0), (400, 0), (405, 0), (410, 0), (415, 0), (420, 0), (425, 0), (430, 0), (435, 0), (440, 1), (445, 1), (450, 1), (455, 1), (460, 1), (465, 1), (470, 1), (475, 1), (480, 1), (485, 1), (490, 1), (495, 1), (500, 1), (505, 1), (510, 1), (515, 1), (520, 1), (525, 1), (530, 1), (535, 0), (540, 0), (545, 0), (550, 0), (555, 0), (560, 0), (565, 0), (570, 0), (575, 0), (580, 0), (585, 0), (590, 0), (595, 0), (600, 0), (605, 0), (610, 0), (615, 0), (620, 0), (625, 0), (630, 0), (635, 0), (640, 0), (645, 0), (650, 0), (655, 1), (660, 1), (665, 1), (670, 1), (675, 1), (680, 1), (685, 1), (690, 1), (695, 1), (700, 1), (705, 1), (710, 0), (715, 0), (720, 0), (725, 0), (730, 0), (735, 0), (740, 0), (745, 0), (750, 0), (755, 0), (760, 0), (765, 0), (770, 0), (775, 0), (780, 0), (785, 0), (790, 0), (795, 0), (800, 0), (805, 0), (810, 0), (815, 0), (820, 0), (825, 0), (830, 0), (835, 0), (840, 0), (845, 0), (850, 0), (855, 0), (860, 0), (865, 0), (870, 0), (875, 0), (880, 1), (885, 1), (890, 1), (895, 1), (900, 1), (905, 1), (910, 1), (915, 1), (920, 1), (925, 1), (930, 0), (935, 0), (940, 0), (945, 0), (950, 1), (955, 0), (960, 0), (965, 0), (970, 0), (975, 0), (980, 0), (985, 1), (990, 1), (995, 1), (1000, 1), (1005, 0), (1010, 0), (1015, 0), (1020, 0), (1025, 0)]
Vdin1_29  din1_29  0 PWL (0n 0.0v 4.745n 0.0v 4.755n 0.0v 9.745n 0.0v 9.755n 0.0v 14.745n 0.0v 14.755n 0.0v 19.745n 0.0v 19.755n 0.0v 24.745n 0.0v 24.755n 0.0v 29.745n 0.0v 29.755n 0.0v 34.745n 0.0v 34.755n 1.0v 39.745n 1.0v 39.755n 1.0v 44.745n 1.0v 44.755n 1.0v 49.745n 1.0v 49.755n 0.0v 54.745n 0.0v 54.755n 0.0v 59.745n 0.0v 59.755n 0.0v 64.745n 0.0v 64.755n 0.0v 69.745n 0.0v 69.755n 0.0v 74.745n 0.0v 74.755n 0.0v 79.745n 0.0v 79.755n 0.0v 84.745n 0.0v 84.755n 0.0v 89.745n 0.0v 89.755n 0.0v 94.745n 0.0v 94.755n 0.0v 99.745n 0.0v 99.755n 1.0v 104.745n 1.0v 104.755n 1.0v 109.745n 1.0v 109.755n 1.0v 114.745n 1.0v 114.755n 1.0v 119.745n 1.0v 119.755n 1.0v 124.745n 1.0v 124.755n 0.0v 129.745n 0.0v 129.755n 0.0v 134.745n 0.0v 134.755n 0.0v 139.745n 0.0v 139.755n 0.0v 144.745n 0.0v 144.755n 0.0v 149.745n 0.0v 149.755n 1.0v 154.745n 1.0v 154.755n 1.0v 159.745n 1.0v 159.755n 1.0v 164.745n 1.0v 164.755n 1.0v 169.745n 1.0v 169.755n 1.0v 174.745n 1.0v 174.755n 1.0v 179.745n 1.0v 179.755n 1.0v 184.745n 1.0v 184.755n 1.0v 189.745n 1.0v 189.755n 1.0v 194.745n 1.0v 194.755n 1.0v 199.745n 1.0v 199.755n 1.0v 204.745n 1.0v 204.755n 0.0v 209.745n 0.0v 209.755n 0.0v 214.745n 0.0v 214.755n 0.0v 219.745n 0.0v 219.755n 0.0v 224.745n 0.0v 224.755n 0.0v 229.745n 0.0v 229.755n 0.0v 234.745n 0.0v 234.755n 0.0v 239.745n 0.0v 239.755n 1.0v 244.745n 1.0v 244.755n 1.0v 249.745n 1.0v 249.755n 0.0v 254.745n 0.0v 254.755n 0.0v 259.745n 0.0v 259.755n 0.0v 264.745n 0.0v 264.755n 0.0v 269.745n 0.0v 269.755n 0.0v 274.745n 0.0v 274.755n 1.0v 279.745n 1.0v 279.755n 1.0v 284.745n 1.0v 284.755n 1.0v 289.745n 1.0v 289.755n 1.0v 294.745n 1.0v 294.755n 1.0v 299.745n 1.0v 299.755n 1.0v 304.745n 1.0v 304.755n 1.0v 309.745n 1.0v 309.755n 0.0v 314.745n 0.0v 314.755n 0.0v 319.745n 0.0v 319.755n 0.0v 324.745n 0.0v 324.755n 0.0v 329.745n 0.0v 329.755n 0.0v 334.745n 0.0v 334.755n 0.0v 339.745n 0.0v 339.755n 0.0v 344.745n 0.0v 344.755n 0.0v 349.745n 0.0v 349.755n 0.0v 354.745n 0.0v 354.755n 0.0v 359.745n 0.0v 359.755n 0.0v 364.745n 0.0v 364.755n 0.0v 369.745n 0.0v 369.755n 0.0v 374.745n 0.0v 374.755n 0.0v 379.745n 0.0v 379.755n 0.0v 384.745n 0.0v 384.755n 0.0v 389.745n 0.0v 389.755n 0.0v 394.745n 0.0v 394.755n 0.0v 399.745n 0.0v 399.755n 0.0v 404.745n 0.0v 404.755n 0.0v 409.745n 0.0v 409.755n 0.0v 414.745n 0.0v 414.755n 0.0v 419.745n 0.0v 419.755n 0.0v 424.745n 0.0v 424.755n 0.0v 429.745n 0.0v 429.755n 0.0v 434.745n 0.0v 434.755n 0.0v 439.745n 0.0v 439.755n 1.0v 444.745n 1.0v 444.755n 1.0v 449.745n 1.0v 449.755n 1.0v 454.745n 1.0v 454.755n 1.0v 459.745n 1.0v 459.755n 1.0v 464.745n 1.0v 464.755n 1.0v 469.745n 1.0v 469.755n 1.0v 474.745n 1.0v 474.755n 1.0v 479.745n 1.0v 479.755n 1.0v 484.745n 1.0v 484.755n 1.0v 489.745n 1.0v 489.755n 1.0v 494.745n 1.0v 494.755n 1.0v 499.745n 1.0v 499.755n 1.0v 504.745n 1.0v 504.755n 1.0v 509.745n 1.0v 509.755n 1.0v 514.745n 1.0v 514.755n 1.0v 519.745n 1.0v 519.755n 1.0v 524.745n 1.0v 524.755n 1.0v 529.745n 1.0v 529.755n 1.0v 534.745n 1.0v 534.755n 0.0v 539.745n 0.0v 539.755n 0.0v 544.745n 0.0v 544.755n 0.0v 549.745n 0.0v 549.755n 0.0v 554.745n 0.0v 554.755n 0.0v 559.745n 0.0v 559.755n 0.0v 564.745n 0.0v 564.755n 0.0v 569.745n 0.0v 569.755n 0.0v 574.745n 0.0v 574.755n 0.0v 579.745n 0.0v 579.755n 0.0v 584.745n 0.0v 584.755n 0.0v 589.745n 0.0v 589.755n 0.0v 594.745n 0.0v 594.755n 0.0v 599.745n 0.0v 599.755n 0.0v 604.745n 0.0v 604.755n 0.0v 609.745n 0.0v 609.755n 0.0v 614.745n 0.0v 614.755n 0.0v 619.745n 0.0v 619.755n 0.0v 624.745n 0.0v 624.755n 0.0v 629.745n 0.0v 629.755n 0.0v 634.745n 0.0v 634.755n 0.0v 639.745n 0.0v 639.755n 0.0v 644.745n 0.0v 644.755n 0.0v 649.745n 0.0v 649.755n 0.0v 654.745n 0.0v 654.755n 1.0v 659.745n 1.0v 659.755n 1.0v 664.745n 1.0v 664.755n 1.0v 669.745n 1.0v 669.755n 1.0v 674.745n 1.0v 674.755n 1.0v 679.745n 1.0v 679.755n 1.0v 684.745n 1.0v 684.755n 1.0v 689.745n 1.0v 689.755n 1.0v 694.745n 1.0v 694.755n 1.0v 699.745n 1.0v 699.755n 1.0v 704.745n 1.0v 704.755n 1.0v 709.745n 1.0v 709.755n 0.0v 714.745n 0.0v 714.755n 0.0v 719.745n 0.0v 719.755n 0.0v 724.745n 0.0v 724.755n 0.0v 729.745n 0.0v 729.755n 0.0v 734.745n 0.0v 734.755n 0.0v 739.745n 0.0v 739.755n 0.0v 744.745n 0.0v 744.755n 0.0v 749.745n 0.0v 749.755n 0.0v 754.745n 0.0v 754.755n 0.0v 759.745n 0.0v 759.755n 0.0v 764.745n 0.0v 764.755n 0.0v 769.745n 0.0v 769.755n 0.0v 774.745n 0.0v 774.755n 0.0v 779.745n 0.0v 779.755n 0.0v 784.745n 0.0v 784.755n 0.0v 789.745n 0.0v 789.755n 0.0v 794.745n 0.0v 794.755n 0.0v 799.745n 0.0v 799.755n 0.0v 804.745n 0.0v 804.755n 0.0v 809.745n 0.0v 809.755n 0.0v 814.745n 0.0v 814.755n 0.0v 819.745n 0.0v 819.755n 0.0v 824.745n 0.0v 824.755n 0.0v 829.745n 0.0v 829.755n 0.0v 834.745n 0.0v 834.755n 0.0v 839.745n 0.0v 839.755n 0.0v 844.745n 0.0v 844.755n 0.0v 849.745n 0.0v 849.755n 0.0v 854.745n 0.0v 854.755n 0.0v 859.745n 0.0v 859.755n 0.0v 864.745n 0.0v 864.755n 0.0v 869.745n 0.0v 869.755n 0.0v 874.745n 0.0v 874.755n 0.0v 879.745n 0.0v 879.755n 1.0v 884.745n 1.0v 884.755n 1.0v 889.745n 1.0v 889.755n 1.0v 894.745n 1.0v 894.755n 1.0v 899.745n 1.0v 899.755n 1.0v 904.745n 1.0v 904.755n 1.0v 909.745n 1.0v 909.755n 1.0v 914.745n 1.0v 914.755n 1.0v 919.745n 1.0v 919.755n 1.0v 924.745n 1.0v 924.755n 1.0v 929.745n 1.0v 929.755n 0.0v 934.745n 0.0v 934.755n 0.0v 939.745n 0.0v 939.755n 0.0v 944.745n 0.0v 944.755n 0.0v 949.745n 0.0v 949.755n 1.0v 954.745n 1.0v 954.755n 0.0v 959.745n 0.0v 959.755n 0.0v 964.745n 0.0v 964.755n 0.0v 969.745n 0.0v 969.755n 0.0v 974.745n 0.0v 974.755n 0.0v 979.745n 0.0v 979.755n 0.0v 984.745n 0.0v 984.755n 1.0v 989.745n 1.0v 989.755n 1.0v 994.745n 1.0v 994.755n 1.0v 999.745n 1.0v 999.755n 1.0v 1004.745n 1.0v 1004.755n 0.0v 1009.745n 0.0v 1009.755n 0.0v 1014.745n 0.0v 1014.755n 0.0v 1019.745n 0.0v 1019.755n 0.0v 1024.745n 0.0v 1024.755n 0.0v )
* (time, data): [(0, 0), (5, 1), (10, 0), (15, 0), (20, 0), (25, 0), (30, 0), (35, 1), (40, 1), (45, 1), (50, 1), (55, 1), (60, 1), (65, 1), (70, 1), (75, 1), (80, 1), (85, 1), (90, 1), (95, 1), (100, 1), (105, 1), (110, 1), (115, 0), (120, 0), (125, 0), (130, 0), (135, 0), (140, 0), (145, 0), (150, 0), (155, 0), (160, 0), (165, 1), (170, 1), (175, 1), (180, 1), (185, 1), (190, 1), (195, 1), (200, 1), (205, 1), (210, 1), (215, 1), (220, 0), (225, 0), (230, 0), (235, 0), (240, 1), (245, 1), (250, 1), (255, 1), (260, 1), (265, 1), (270, 1), (275, 0), (280, 0), (285, 0), (290, 0), (295, 0), (300, 0), (305, 0), (310, 0), (315, 0), (320, 0), (325, 0), (330, 0), (335, 0), (340, 0), (345, 0), (350, 0), (355, 0), (360, 1), (365, 1), (370, 1), (375, 1), (380, 1), (385, 1), (390, 1), (395, 1), (400, 0), (405, 0), (410, 0), (415, 0), (420, 0), (425, 0), (430, 0), (435, 0), (440, 1), (445, 1), (450, 1), (455, 1), (460, 1), (465, 1), (470, 1), (475, 1), (480, 1), (485, 1), (490, 1), (495, 1), (500, 0), (505, 0), (510, 0), (515, 0), (520, 0), (525, 0), (530, 0), (535, 1), (540, 0), (545, 0), (550, 0), (555, 0), (560, 0), (565, 0), (570, 0), (575, 0), (580, 0), (585, 0), (590, 0), (595, 0), (600, 0), (605, 0), (610, 0), (615, 0), (620, 0), (625, 0), (630, 0), (635, 0), (640, 0), (645, 0), (650, 0), (655, 1), (660, 1), (665, 1), (670, 1), (675, 1), (680, 1), (685, 1), (690, 1), (695, 1), (700, 1), (705, 1), (710, 0), (715, 0), (720, 0), (725, 0), (730, 0), (735, 0), (740, 0), (745, 0), (750, 0), (755, 0), (760, 0), (765, 0), (770, 0), (775, 0), (780, 0), (785, 0), (790, 0), (795, 0), (800, 0), (805, 0), (810, 1), (815, 1), (820, 1), (825, 1), (830, 1), (835, 1), (840, 1), (845, 1), (850, 1), (855, 1), (860, 0), (865, 0), (870, 0), (875, 0), (880, 1), (885, 1), (890, 1), (895, 1), (900, 1), (905, 1), (910, 1), (915, 1), (920, 1), (925, 1), (930, 1), (935, 0), (940, 0), (945, 0), (950, 1), (955, 0), (960, 0), (965, 0), (970, 0), (975, 0), (980, 0), (985, 1), (990, 1), (995, 1), (1000, 1), (1005, 1), (1010, 1), (1015, 1), (1020, 1), (1025, 1)]
Vdin1_30  din1_30  0 PWL (0n 0.0v 4.745n 0.0v 4.755n 1.0v 9.745n 1.0v 9.755n 0.0v 14.745n 0.0v 14.755n 0.0v 19.745n 0.0v 19.755n 0.0v 24.745n 0.0v 24.755n 0.0v 29.745n 0.0v 29.755n 0.0v 34.745n 0.0v 34.755n 1.0v 39.745n 1.0v 39.755n 1.0v 44.745n 1.0v 44.755n 1.0v 49.745n 1.0v 49.755n 1.0v 54.745n 1.0v 54.755n 1.0v 59.745n 1.0v 59.755n 1.0v 64.745n 1.0v 64.755n 1.0v 69.745n 1.0v 69.755n 1.0v 74.745n 1.0v 74.755n 1.0v 79.745n 1.0v 79.755n 1.0v 84.745n 1.0v 84.755n 1.0v 89.745n 1.0v 89.755n 1.0v 94.745n 1.0v 94.755n 1.0v 99.745n 1.0v 99.755n 1.0v 104.745n 1.0v 104.755n 1.0v 109.745n 1.0v 109.755n 1.0v 114.745n 1.0v 114.755n 0.0v 119.745n 0.0v 119.755n 0.0v 124.745n 0.0v 124.755n 0.0v 129.745n 0.0v 129.755n 0.0v 134.745n 0.0v 134.755n 0.0v 139.745n 0.0v 139.755n 0.0v 144.745n 0.0v 144.755n 0.0v 149.745n 0.0v 149.755n 0.0v 154.745n 0.0v 154.755n 0.0v 159.745n 0.0v 159.755n 0.0v 164.745n 0.0v 164.755n 1.0v 169.745n 1.0v 169.755n 1.0v 174.745n 1.0v 174.755n 1.0v 179.745n 1.0v 179.755n 1.0v 184.745n 1.0v 184.755n 1.0v 189.745n 1.0v 189.755n 1.0v 194.745n 1.0v 194.755n 1.0v 199.745n 1.0v 199.755n 1.0v 204.745n 1.0v 204.755n 1.0v 209.745n 1.0v 209.755n 1.0v 214.745n 1.0v 214.755n 1.0v 219.745n 1.0v 219.755n 0.0v 224.745n 0.0v 224.755n 0.0v 229.745n 0.0v 229.755n 0.0v 234.745n 0.0v 234.755n 0.0v 239.745n 0.0v 239.755n 1.0v 244.745n 1.0v 244.755n 1.0v 249.745n 1.0v 249.755n 1.0v 254.745n 1.0v 254.755n 1.0v 259.745n 1.0v 259.755n 1.0v 264.745n 1.0v 264.755n 1.0v 269.745n 1.0v 269.755n 1.0v 274.745n 1.0v 274.755n 0.0v 279.745n 0.0v 279.755n 0.0v 284.745n 0.0v 284.755n 0.0v 289.745n 0.0v 289.755n 0.0v 294.745n 0.0v 294.755n 0.0v 299.745n 0.0v 299.755n 0.0v 304.745n 0.0v 304.755n 0.0v 309.745n 0.0v 309.755n 0.0v 314.745n 0.0v 314.755n 0.0v 319.745n 0.0v 319.755n 0.0v 324.745n 0.0v 324.755n 0.0v 329.745n 0.0v 329.755n 0.0v 334.745n 0.0v 334.755n 0.0v 339.745n 0.0v 339.755n 0.0v 344.745n 0.0v 344.755n 0.0v 349.745n 0.0v 349.755n 0.0v 354.745n 0.0v 354.755n 0.0v 359.745n 0.0v 359.755n 1.0v 364.745n 1.0v 364.755n 1.0v 369.745n 1.0v 369.755n 1.0v 374.745n 1.0v 374.755n 1.0v 379.745n 1.0v 379.755n 1.0v 384.745n 1.0v 384.755n 1.0v 389.745n 1.0v 389.755n 1.0v 394.745n 1.0v 394.755n 1.0v 399.745n 1.0v 399.755n 0.0v 404.745n 0.0v 404.755n 0.0v 409.745n 0.0v 409.755n 0.0v 414.745n 0.0v 414.755n 0.0v 419.745n 0.0v 419.755n 0.0v 424.745n 0.0v 424.755n 0.0v 429.745n 0.0v 429.755n 0.0v 434.745n 0.0v 434.755n 0.0v 439.745n 0.0v 439.755n 1.0v 444.745n 1.0v 444.755n 1.0v 449.745n 1.0v 449.755n 1.0v 454.745n 1.0v 454.755n 1.0v 459.745n 1.0v 459.755n 1.0v 464.745n 1.0v 464.755n 1.0v 469.745n 1.0v 469.755n 1.0v 474.745n 1.0v 474.755n 1.0v 479.745n 1.0v 479.755n 1.0v 484.745n 1.0v 484.755n 1.0v 489.745n 1.0v 489.755n 1.0v 494.745n 1.0v 494.755n 1.0v 499.745n 1.0v 499.755n 0.0v 504.745n 0.0v 504.755n 0.0v 509.745n 0.0v 509.755n 0.0v 514.745n 0.0v 514.755n 0.0v 519.745n 0.0v 519.755n 0.0v 524.745n 0.0v 524.755n 0.0v 529.745n 0.0v 529.755n 0.0v 534.745n 0.0v 534.755n 1.0v 539.745n 1.0v 539.755n 0.0v 544.745n 0.0v 544.755n 0.0v 549.745n 0.0v 549.755n 0.0v 554.745n 0.0v 554.755n 0.0v 559.745n 0.0v 559.755n 0.0v 564.745n 0.0v 564.755n 0.0v 569.745n 0.0v 569.755n 0.0v 574.745n 0.0v 574.755n 0.0v 579.745n 0.0v 579.755n 0.0v 584.745n 0.0v 584.755n 0.0v 589.745n 0.0v 589.755n 0.0v 594.745n 0.0v 594.755n 0.0v 599.745n 0.0v 599.755n 0.0v 604.745n 0.0v 604.755n 0.0v 609.745n 0.0v 609.755n 0.0v 614.745n 0.0v 614.755n 0.0v 619.745n 0.0v 619.755n 0.0v 624.745n 0.0v 624.755n 0.0v 629.745n 0.0v 629.755n 0.0v 634.745n 0.0v 634.755n 0.0v 639.745n 0.0v 639.755n 0.0v 644.745n 0.0v 644.755n 0.0v 649.745n 0.0v 649.755n 0.0v 654.745n 0.0v 654.755n 1.0v 659.745n 1.0v 659.755n 1.0v 664.745n 1.0v 664.755n 1.0v 669.745n 1.0v 669.755n 1.0v 674.745n 1.0v 674.755n 1.0v 679.745n 1.0v 679.755n 1.0v 684.745n 1.0v 684.755n 1.0v 689.745n 1.0v 689.755n 1.0v 694.745n 1.0v 694.755n 1.0v 699.745n 1.0v 699.755n 1.0v 704.745n 1.0v 704.755n 1.0v 709.745n 1.0v 709.755n 0.0v 714.745n 0.0v 714.755n 0.0v 719.745n 0.0v 719.755n 0.0v 724.745n 0.0v 724.755n 0.0v 729.745n 0.0v 729.755n 0.0v 734.745n 0.0v 734.755n 0.0v 739.745n 0.0v 739.755n 0.0v 744.745n 0.0v 744.755n 0.0v 749.745n 0.0v 749.755n 0.0v 754.745n 0.0v 754.755n 0.0v 759.745n 0.0v 759.755n 0.0v 764.745n 0.0v 764.755n 0.0v 769.745n 0.0v 769.755n 0.0v 774.745n 0.0v 774.755n 0.0v 779.745n 0.0v 779.755n 0.0v 784.745n 0.0v 784.755n 0.0v 789.745n 0.0v 789.755n 0.0v 794.745n 0.0v 794.755n 0.0v 799.745n 0.0v 799.755n 0.0v 804.745n 0.0v 804.755n 0.0v 809.745n 0.0v 809.755n 1.0v 814.745n 1.0v 814.755n 1.0v 819.745n 1.0v 819.755n 1.0v 824.745n 1.0v 824.755n 1.0v 829.745n 1.0v 829.755n 1.0v 834.745n 1.0v 834.755n 1.0v 839.745n 1.0v 839.755n 1.0v 844.745n 1.0v 844.755n 1.0v 849.745n 1.0v 849.755n 1.0v 854.745n 1.0v 854.755n 1.0v 859.745n 1.0v 859.755n 0.0v 864.745n 0.0v 864.755n 0.0v 869.745n 0.0v 869.755n 0.0v 874.745n 0.0v 874.755n 0.0v 879.745n 0.0v 879.755n 1.0v 884.745n 1.0v 884.755n 1.0v 889.745n 1.0v 889.755n 1.0v 894.745n 1.0v 894.755n 1.0v 899.745n 1.0v 899.755n 1.0v 904.745n 1.0v 904.755n 1.0v 909.745n 1.0v 909.755n 1.0v 914.745n 1.0v 914.755n 1.0v 919.745n 1.0v 919.755n 1.0v 924.745n 1.0v 924.755n 1.0v 929.745n 1.0v 929.755n 1.0v 934.745n 1.0v 934.755n 0.0v 939.745n 0.0v 939.755n 0.0v 944.745n 0.0v 944.755n 0.0v 949.745n 0.0v 949.755n 1.0v 954.745n 1.0v 954.755n 0.0v 959.745n 0.0v 959.755n 0.0v 964.745n 0.0v 964.755n 0.0v 969.745n 0.0v 969.755n 0.0v 974.745n 0.0v 974.755n 0.0v 979.745n 0.0v 979.755n 0.0v 984.745n 0.0v 984.755n 1.0v 989.745n 1.0v 989.755n 1.0v 994.745n 1.0v 994.755n 1.0v 999.745n 1.0v 999.755n 1.0v 1004.745n 1.0v 1004.755n 1.0v 1009.745n 1.0v 1009.755n 1.0v 1014.745n 1.0v 1014.755n 1.0v 1019.745n 1.0v 1019.755n 1.0v 1024.745n 1.0v 1024.755n 1.0v )
* (time, data): [(0, 0), (5, 1), (10, 1), (15, 1), (20, 1), (25, 1), (30, 1), (35, 1), (40, 1), (45, 1), (50, 1), (55, 1), (60, 1), (65, 1), (70, 1), (75, 1), (80, 1), (85, 0), (90, 0), (95, 0), (100, 0), (105, 0), (110, 0), (115, 1), (120, 1), (125, 1), (130, 1), (135, 1), (140, 1), (145, 1), (150, 0), (155, 0), (160, 0), (165, 1), (170, 1), (175, 1), (180, 1), (185, 1), (190, 1), (195, 1), (200, 1), (205, 1), (210, 1), (215, 1), (220, 1), (225, 1), (230, 1), (235, 1), (240, 0), (245, 0), (250, 0), (255, 0), (260, 1), (265, 1), (270, 1), (275, 0), (280, 0), (285, 0), (290, 0), (295, 0), (300, 0), (305, 0), (310, 1), (315, 1), (320, 1), (325, 1), (330, 1), (335, 1), (340, 1), (345, 0), (350, 0), (355, 0), (360, 0), (365, 0), (370, 0), (375, 0), (380, 0), (385, 0), (390, 0), (395, 0), (400, 0), (405, 1), (410, 1), (415, 1), (420, 1), (425, 1), (430, 1), (435, 1), (440, 0), (445, 0), (450, 0), (455, 0), (460, 0), (465, 0), (470, 0), (475, 0), (480, 0), (485, 0), (490, 0), (495, 0), (500, 1), (505, 1), (510, 1), (515, 1), (520, 1), (525, 1), (530, 1), (535, 0), (540, 1), (545, 1), (550, 1), (555, 1), (560, 1), (565, 1), (570, 1), (575, 1), (580, 1), (585, 1), (590, 1), (595, 1), (600, 1), (605, 1), (610, 1), (615, 1), (620, 1), (625, 1), (630, 1), (635, 1), (640, 1), (645, 1), (650, 1), (655, 0), (660, 0), (665, 0), (670, 0), (675, 0), (680, 0), (685, 0), (690, 0), (695, 0), (700, 0), (705, 0), (710, 1), (715, 1), (720, 1), (725, 1), (730, 1), (735, 1), (740, 1), (745, 1), (750, 1), (755, 1), (760, 0), (765, 0), (770, 0), (775, 0), (780, 1), (785, 1), (790, 1), (795, 1), (800, 1), (805, 1), (810, 1), (815, 1), (820, 1), (825, 1), (830, 1), (835, 1), (840, 1), (845, 1), (850, 1), (855, 1), (860, 0), (865, 0), (870, 0), (875, 0), (880, 0), (885, 0), (890, 0), (895, 0), (900, 0), (905, 0), (910, 0), (915, 0), (920, 1), (925, 1), (930, 0), (935, 1), (940, 1), (945, 1), (950, 1), (955, 1), (960, 1), (965, 1), (970, 1), (975, 1), (980, 1), (985, 0), (990, 0), (995, 0), (1000, 0), (1005, 1), (1010, 1), (1015, 1), (1020, 1), (1025, 1)]
Vdin1_31  din1_31  0 PWL (0n 0.0v 4.745n 0.0v 4.755n 1.0v 9.745n 1.0v 9.755n 1.0v 14.745n 1.0v 14.755n 1.0v 19.745n 1.0v 19.755n 1.0v 24.745n 1.0v 24.755n 1.0v 29.745n 1.0v 29.755n 1.0v 34.745n 1.0v 34.755n 1.0v 39.745n 1.0v 39.755n 1.0v 44.745n 1.0v 44.755n 1.0v 49.745n 1.0v 49.755n 1.0v 54.745n 1.0v 54.755n 1.0v 59.745n 1.0v 59.755n 1.0v 64.745n 1.0v 64.755n 1.0v 69.745n 1.0v 69.755n 1.0v 74.745n 1.0v 74.755n 1.0v 79.745n 1.0v 79.755n 1.0v 84.745n 1.0v 84.755n 0.0v 89.745n 0.0v 89.755n 0.0v 94.745n 0.0v 94.755n 0.0v 99.745n 0.0v 99.755n 0.0v 104.745n 0.0v 104.755n 0.0v 109.745n 0.0v 109.755n 0.0v 114.745n 0.0v 114.755n 1.0v 119.745n 1.0v 119.755n 1.0v 124.745n 1.0v 124.755n 1.0v 129.745n 1.0v 129.755n 1.0v 134.745n 1.0v 134.755n 1.0v 139.745n 1.0v 139.755n 1.0v 144.745n 1.0v 144.755n 1.0v 149.745n 1.0v 149.755n 0.0v 154.745n 0.0v 154.755n 0.0v 159.745n 0.0v 159.755n 0.0v 164.745n 0.0v 164.755n 1.0v 169.745n 1.0v 169.755n 1.0v 174.745n 1.0v 174.755n 1.0v 179.745n 1.0v 179.755n 1.0v 184.745n 1.0v 184.755n 1.0v 189.745n 1.0v 189.755n 1.0v 194.745n 1.0v 194.755n 1.0v 199.745n 1.0v 199.755n 1.0v 204.745n 1.0v 204.755n 1.0v 209.745n 1.0v 209.755n 1.0v 214.745n 1.0v 214.755n 1.0v 219.745n 1.0v 219.755n 1.0v 224.745n 1.0v 224.755n 1.0v 229.745n 1.0v 229.755n 1.0v 234.745n 1.0v 234.755n 1.0v 239.745n 1.0v 239.755n 0.0v 244.745n 0.0v 244.755n 0.0v 249.745n 0.0v 249.755n 0.0v 254.745n 0.0v 254.755n 0.0v 259.745n 0.0v 259.755n 1.0v 264.745n 1.0v 264.755n 1.0v 269.745n 1.0v 269.755n 1.0v 274.745n 1.0v 274.755n 0.0v 279.745n 0.0v 279.755n 0.0v 284.745n 0.0v 284.755n 0.0v 289.745n 0.0v 289.755n 0.0v 294.745n 0.0v 294.755n 0.0v 299.745n 0.0v 299.755n 0.0v 304.745n 0.0v 304.755n 0.0v 309.745n 0.0v 309.755n 1.0v 314.745n 1.0v 314.755n 1.0v 319.745n 1.0v 319.755n 1.0v 324.745n 1.0v 324.755n 1.0v 329.745n 1.0v 329.755n 1.0v 334.745n 1.0v 334.755n 1.0v 339.745n 1.0v 339.755n 1.0v 344.745n 1.0v 344.755n 0.0v 349.745n 0.0v 349.755n 0.0v 354.745n 0.0v 354.755n 0.0v 359.745n 0.0v 359.755n 0.0v 364.745n 0.0v 364.755n 0.0v 369.745n 0.0v 369.755n 0.0v 374.745n 0.0v 374.755n 0.0v 379.745n 0.0v 379.755n 0.0v 384.745n 0.0v 384.755n 0.0v 389.745n 0.0v 389.755n 0.0v 394.745n 0.0v 394.755n 0.0v 399.745n 0.0v 399.755n 0.0v 404.745n 0.0v 404.755n 1.0v 409.745n 1.0v 409.755n 1.0v 414.745n 1.0v 414.755n 1.0v 419.745n 1.0v 419.755n 1.0v 424.745n 1.0v 424.755n 1.0v 429.745n 1.0v 429.755n 1.0v 434.745n 1.0v 434.755n 1.0v 439.745n 1.0v 439.755n 0.0v 444.745n 0.0v 444.755n 0.0v 449.745n 0.0v 449.755n 0.0v 454.745n 0.0v 454.755n 0.0v 459.745n 0.0v 459.755n 0.0v 464.745n 0.0v 464.755n 0.0v 469.745n 0.0v 469.755n 0.0v 474.745n 0.0v 474.755n 0.0v 479.745n 0.0v 479.755n 0.0v 484.745n 0.0v 484.755n 0.0v 489.745n 0.0v 489.755n 0.0v 494.745n 0.0v 494.755n 0.0v 499.745n 0.0v 499.755n 1.0v 504.745n 1.0v 504.755n 1.0v 509.745n 1.0v 509.755n 1.0v 514.745n 1.0v 514.755n 1.0v 519.745n 1.0v 519.755n 1.0v 524.745n 1.0v 524.755n 1.0v 529.745n 1.0v 529.755n 1.0v 534.745n 1.0v 534.755n 0.0v 539.745n 0.0v 539.755n 1.0v 544.745n 1.0v 544.755n 1.0v 549.745n 1.0v 549.755n 1.0v 554.745n 1.0v 554.755n 1.0v 559.745n 1.0v 559.755n 1.0v 564.745n 1.0v 564.755n 1.0v 569.745n 1.0v 569.755n 1.0v 574.745n 1.0v 574.755n 1.0v 579.745n 1.0v 579.755n 1.0v 584.745n 1.0v 584.755n 1.0v 589.745n 1.0v 589.755n 1.0v 594.745n 1.0v 594.755n 1.0v 599.745n 1.0v 599.755n 1.0v 604.745n 1.0v 604.755n 1.0v 609.745n 1.0v 609.755n 1.0v 614.745n 1.0v 614.755n 1.0v 619.745n 1.0v 619.755n 1.0v 624.745n 1.0v 624.755n 1.0v 629.745n 1.0v 629.755n 1.0v 634.745n 1.0v 634.755n 1.0v 639.745n 1.0v 639.755n 1.0v 644.745n 1.0v 644.755n 1.0v 649.745n 1.0v 649.755n 1.0v 654.745n 1.0v 654.755n 0.0v 659.745n 0.0v 659.755n 0.0v 664.745n 0.0v 664.755n 0.0v 669.745n 0.0v 669.755n 0.0v 674.745n 0.0v 674.755n 0.0v 679.745n 0.0v 679.755n 0.0v 684.745n 0.0v 684.755n 0.0v 689.745n 0.0v 689.755n 0.0v 694.745n 0.0v 694.755n 0.0v 699.745n 0.0v 699.755n 0.0v 704.745n 0.0v 704.755n 0.0v 709.745n 0.0v 709.755n 1.0v 714.745n 1.0v 714.755n 1.0v 719.745n 1.0v 719.755n 1.0v 724.745n 1.0v 724.755n 1.0v 729.745n 1.0v 729.755n 1.0v 734.745n 1.0v 734.755n 1.0v 739.745n 1.0v 739.755n 1.0v 744.745n 1.0v 744.755n 1.0v 749.745n 1.0v 749.755n 1.0v 754.745n 1.0v 754.755n 1.0v 759.745n 1.0v 759.755n 0.0v 764.745n 0.0v 764.755n 0.0v 769.745n 0.0v 769.755n 0.0v 774.745n 0.0v 774.755n 0.0v 779.745n 0.0v 779.755n 1.0v 784.745n 1.0v 784.755n 1.0v 789.745n 1.0v 789.755n 1.0v 794.745n 1.0v 794.755n 1.0v 799.745n 1.0v 799.755n 1.0v 804.745n 1.0v 804.755n 1.0v 809.745n 1.0v 809.755n 1.0v 814.745n 1.0v 814.755n 1.0v 819.745n 1.0v 819.755n 1.0v 824.745n 1.0v 824.755n 1.0v 829.745n 1.0v 829.755n 1.0v 834.745n 1.0v 834.755n 1.0v 839.745n 1.0v 839.755n 1.0v 844.745n 1.0v 844.755n 1.0v 849.745n 1.0v 849.755n 1.0v 854.745n 1.0v 854.755n 1.0v 859.745n 1.0v 859.755n 0.0v 864.745n 0.0v 864.755n 0.0v 869.745n 0.0v 869.755n 0.0v 874.745n 0.0v 874.755n 0.0v 879.745n 0.0v 879.755n 0.0v 884.745n 0.0v 884.755n 0.0v 889.745n 0.0v 889.755n 0.0v 894.745n 0.0v 894.755n 0.0v 899.745n 0.0v 899.755n 0.0v 904.745n 0.0v 904.755n 0.0v 909.745n 0.0v 909.755n 0.0v 914.745n 0.0v 914.755n 0.0v 919.745n 0.0v 919.755n 1.0v 924.745n 1.0v 924.755n 1.0v 929.745n 1.0v 929.755n 0.0v 934.745n 0.0v 934.755n 1.0v 939.745n 1.0v 939.755n 1.0v 944.745n 1.0v 944.755n 1.0v 949.745n 1.0v 949.755n 1.0v 954.745n 1.0v 954.755n 1.0v 959.745n 1.0v 959.755n 1.0v 964.745n 1.0v 964.755n 1.0v 969.745n 1.0v 969.755n 1.0v 974.745n 1.0v 974.755n 1.0v 979.745n 1.0v 979.755n 1.0v 984.745n 1.0v 984.755n 0.0v 989.745n 0.0v 989.755n 0.0v 994.745n 0.0v 994.755n 0.0v 999.745n 0.0v 999.755n 0.0v 1004.745n 0.0v 1004.755n 1.0v 1009.745n 1.0v 1009.755n 1.0v 1014.745n 1.0v 1014.755n 1.0v 1019.745n 1.0v 1019.755n 1.0v 1024.745n 1.0v 1024.755n 1.0v )
* (time, data): [(0, 0), (5, 0), (10, 1), (15, 1), (20, 0), (25, 1), (30, 1), (35, 1), (40, 0), (45, 1), (50, 1), (55, 1), (60, 1), (65, 1), (70, 0), (75, 0), (80, 0), (85, 0), (90, 0), (95, 1), (100, 1), (105, 1), (110, 0), (115, 0), (120, 0), (125, 1), (130, 0), (135, 0), (140, 0), (145, 0), (150, 0), (155, 0), (160, 0), (165, 0), (170, 1), (175, 1), (180, 1), (185, 0), (190, 0), (195, 0), (200, 1), (205, 1), (210, 1), (215, 1), (220, 1), (225, 0), (230, 0), (235, 1), (240, 1), (245, 1), (250, 0), (255, 0), (260, 0), (265, 0), (270, 0), (275, 0), (280, 1), (285, 0), (290, 1), (295, 1), (300, 1), (305, 0), (310, 0), (315, 0), (320, 1), (325, 1), (330, 1), (335, 0), (340, 1), (345, 1), (350, 1), (355, 1), (360, 0), (365, 0), (370, 0), (375, 0), (380, 1), (385, 1), (390, 1), (395, 1), (400, 0), (405, 0), (410, 0), (415, 1), (420, 1), (425, 0), (430, 0), (435, 0), (440, 0), (445, 0), (450, 0), (455, 1), (460, 1), (465, 0), (470, 0), (475, 0), (480, 1), (485, 1), (490, 0), (495, 0), (500, 1), (505, 1), (510, 0), (515, 1), (520, 1), (525, 1), (530, 0), (535, 1), (540, 1), (545, 1), (550, 1), (555, 1), (560, 1), (565, 1), (570, 1), (575, 0), (580, 0), (585, 1), (590, 1), (595, 1), (600, 1), (605, 0), (610, 0), (615, 0), (620, 0), (625, 0), (630, 0), (635, 1), (640, 0), (645, 1), (650, 1), (655, 0), (660, 0), (665, 1), (670, 0), (675, 0), (680, 0), (685, 0), (690, 0), (695, 0), (700, 0), (705, 0), (710, 1), (715, 1), (720, 0), (725, 0), (730, 1), (735, 0), (740, 0), (745, 0), (750, 0), (755, 1), (760, 1), (765, 0), (770, 0), (775, 0), (780, 1), (785, 1), (790, 1), (795, 0), (800, 0), (805, 0), (810, 0), (815, 0), (820, 1), (825, 0), (830, 0), (835, 0), (840, 0), (845, 0), (850, 0), (855, 0), (860, 1), (865, 1), (870, 1), (875, 0), (880, 1), (885, 0), (890, 0), (895, 0), (900, 0), (905, 1), (910, 0), (915, 1), (920, 1), (925, 1), (930, 1), (935, 0), (940, 1), (945, 1), (950, 0), (955, 1), (960, 1), (965, 1), (970, 0), (975, 1), (980, 1), (985, 0), (990, 1), (995, 1), (1000, 1), (1005, 0), (1010, 1), (1015, 1), (1020, 1), (1025, 1)]
Va0_0  a0_0  0 PWL (0n 0.0v 4.745n 0.0v 4.755n 0.0v 9.745n 0.0v 9.755n 1.0v 14.745n 1.0v 14.755n 1.0v 19.745n 1.0v 19.755n 0.0v 24.745n 0.0v 24.755n 1.0v 29.745n 1.0v 29.755n 1.0v 34.745n 1.0v 34.755n 1.0v 39.745n 1.0v 39.755n 0.0v 44.745n 0.0v 44.755n 1.0v 49.745n 1.0v 49.755n 1.0v 54.745n 1.0v 54.755n 1.0v 59.745n 1.0v 59.755n 1.0v 64.745n 1.0v 64.755n 1.0v 69.745n 1.0v 69.755n 0.0v 74.745n 0.0v 74.755n 0.0v 79.745n 0.0v 79.755n 0.0v 84.745n 0.0v 84.755n 0.0v 89.745n 0.0v 89.755n 0.0v 94.745n 0.0v 94.755n 1.0v 99.745n 1.0v 99.755n 1.0v 104.745n 1.0v 104.755n 1.0v 109.745n 1.0v 109.755n 0.0v 114.745n 0.0v 114.755n 0.0v 119.745n 0.0v 119.755n 0.0v 124.745n 0.0v 124.755n 1.0v 129.745n 1.0v 129.755n 0.0v 134.745n 0.0v 134.755n 0.0v 139.745n 0.0v 139.755n 0.0v 144.745n 0.0v 144.755n 0.0v 149.745n 0.0v 149.755n 0.0v 154.745n 0.0v 154.755n 0.0v 159.745n 0.0v 159.755n 0.0v 164.745n 0.0v 164.755n 0.0v 169.745n 0.0v 169.755n 1.0v 174.745n 1.0v 174.755n 1.0v 179.745n 1.0v 179.755n 1.0v 184.745n 1.0v 184.755n 0.0v 189.745n 0.0v 189.755n 0.0v 194.745n 0.0v 194.755n 0.0v 199.745n 0.0v 199.755n 1.0v 204.745n 1.0v 204.755n 1.0v 209.745n 1.0v 209.755n 1.0v 214.745n 1.0v 214.755n 1.0v 219.745n 1.0v 219.755n 1.0v 224.745n 1.0v 224.755n 0.0v 229.745n 0.0v 229.755n 0.0v 234.745n 0.0v 234.755n 1.0v 239.745n 1.0v 239.755n 1.0v 244.745n 1.0v 244.755n 1.0v 249.745n 1.0v 249.755n 0.0v 254.745n 0.0v 254.755n 0.0v 259.745n 0.0v 259.755n 0.0v 264.745n 0.0v 264.755n 0.0v 269.745n 0.0v 269.755n 0.0v 274.745n 0.0v 274.755n 0.0v 279.745n 0.0v 279.755n 1.0v 284.745n 1.0v 284.755n 0.0v 289.745n 0.0v 289.755n 1.0v 294.745n 1.0v 294.755n 1.0v 299.745n 1.0v 299.755n 1.0v 304.745n 1.0v 304.755n 0.0v 309.745n 0.0v 309.755n 0.0v 314.745n 0.0v 314.755n 0.0v 319.745n 0.0v 319.755n 1.0v 324.745n 1.0v 324.755n 1.0v 329.745n 1.0v 329.755n 1.0v 334.745n 1.0v 334.755n 0.0v 339.745n 0.0v 339.755n 1.0v 344.745n 1.0v 344.755n 1.0v 349.745n 1.0v 349.755n 1.0v 354.745n 1.0v 354.755n 1.0v 359.745n 1.0v 359.755n 0.0v 364.745n 0.0v 364.755n 0.0v 369.745n 0.0v 369.755n 0.0v 374.745n 0.0v 374.755n 0.0v 379.745n 0.0v 379.755n 1.0v 384.745n 1.0v 384.755n 1.0v 389.745n 1.0v 389.755n 1.0v 394.745n 1.0v 394.755n 1.0v 399.745n 1.0v 399.755n 0.0v 404.745n 0.0v 404.755n 0.0v 409.745n 0.0v 409.755n 0.0v 414.745n 0.0v 414.755n 1.0v 419.745n 1.0v 419.755n 1.0v 424.745n 1.0v 424.755n 0.0v 429.745n 0.0v 429.755n 0.0v 434.745n 0.0v 434.755n 0.0v 439.745n 0.0v 439.755n 0.0v 444.745n 0.0v 444.755n 0.0v 449.745n 0.0v 449.755n 0.0v 454.745n 0.0v 454.755n 1.0v 459.745n 1.0v 459.755n 1.0v 464.745n 1.0v 464.755n 0.0v 469.745n 0.0v 469.755n 0.0v 474.745n 0.0v 474.755n 0.0v 479.745n 0.0v 479.755n 1.0v 484.745n 1.0v 484.755n 1.0v 489.745n 1.0v 489.755n 0.0v 494.745n 0.0v 494.755n 0.0v 499.745n 0.0v 499.755n 1.0v 504.745n 1.0v 504.755n 1.0v 509.745n 1.0v 509.755n 0.0v 514.745n 0.0v 514.755n 1.0v 519.745n 1.0v 519.755n 1.0v 524.745n 1.0v 524.755n 1.0v 529.745n 1.0v 529.755n 0.0v 534.745n 0.0v 534.755n 1.0v 539.745n 1.0v 539.755n 1.0v 544.745n 1.0v 544.755n 1.0v 549.745n 1.0v 549.755n 1.0v 554.745n 1.0v 554.755n 1.0v 559.745n 1.0v 559.755n 1.0v 564.745n 1.0v 564.755n 1.0v 569.745n 1.0v 569.755n 1.0v 574.745n 1.0v 574.755n 0.0v 579.745n 0.0v 579.755n 0.0v 584.745n 0.0v 584.755n 1.0v 589.745n 1.0v 589.755n 1.0v 594.745n 1.0v 594.755n 1.0v 599.745n 1.0v 599.755n 1.0v 604.745n 1.0v 604.755n 0.0v 609.745n 0.0v 609.755n 0.0v 614.745n 0.0v 614.755n 0.0v 619.745n 0.0v 619.755n 0.0v 624.745n 0.0v 624.755n 0.0v 629.745n 0.0v 629.755n 0.0v 634.745n 0.0v 634.755n 1.0v 639.745n 1.0v 639.755n 0.0v 644.745n 0.0v 644.755n 1.0v 649.745n 1.0v 649.755n 1.0v 654.745n 1.0v 654.755n 0.0v 659.745n 0.0v 659.755n 0.0v 664.745n 0.0v 664.755n 1.0v 669.745n 1.0v 669.755n 0.0v 674.745n 0.0v 674.755n 0.0v 679.745n 0.0v 679.755n 0.0v 684.745n 0.0v 684.755n 0.0v 689.745n 0.0v 689.755n 0.0v 694.745n 0.0v 694.755n 0.0v 699.745n 0.0v 699.755n 0.0v 704.745n 0.0v 704.755n 0.0v 709.745n 0.0v 709.755n 1.0v 714.745n 1.0v 714.755n 1.0v 719.745n 1.0v 719.755n 0.0v 724.745n 0.0v 724.755n 0.0v 729.745n 0.0v 729.755n 1.0v 734.745n 1.0v 734.755n 0.0v 739.745n 0.0v 739.755n 0.0v 744.745n 0.0v 744.755n 0.0v 749.745n 0.0v 749.755n 0.0v 754.745n 0.0v 754.755n 1.0v 759.745n 1.0v 759.755n 1.0v 764.745n 1.0v 764.755n 0.0v 769.745n 0.0v 769.755n 0.0v 774.745n 0.0v 774.755n 0.0v 779.745n 0.0v 779.755n 1.0v 784.745n 1.0v 784.755n 1.0v 789.745n 1.0v 789.755n 1.0v 794.745n 1.0v 794.755n 0.0v 799.745n 0.0v 799.755n 0.0v 804.745n 0.0v 804.755n 0.0v 809.745n 0.0v 809.755n 0.0v 814.745n 0.0v 814.755n 0.0v 819.745n 0.0v 819.755n 1.0v 824.745n 1.0v 824.755n 0.0v 829.745n 0.0v 829.755n 0.0v 834.745n 0.0v 834.755n 0.0v 839.745n 0.0v 839.755n 0.0v 844.745n 0.0v 844.755n 0.0v 849.745n 0.0v 849.755n 0.0v 854.745n 0.0v 854.755n 0.0v 859.745n 0.0v 859.755n 1.0v 864.745n 1.0v 864.755n 1.0v 869.745n 1.0v 869.755n 1.0v 874.745n 1.0v 874.755n 0.0v 879.745n 0.0v 879.755n 1.0v 884.745n 1.0v 884.755n 0.0v 889.745n 0.0v 889.755n 0.0v 894.745n 0.0v 894.755n 0.0v 899.745n 0.0v 899.755n 0.0v 904.745n 0.0v 904.755n 1.0v 909.745n 1.0v 909.755n 0.0v 914.745n 0.0v 914.755n 1.0v 919.745n 1.0v 919.755n 1.0v 924.745n 1.0v 924.755n 1.0v 929.745n 1.0v 929.755n 1.0v 934.745n 1.0v 934.755n 0.0v 939.745n 0.0v 939.755n 1.0v 944.745n 1.0v 944.755n 1.0v 949.745n 1.0v 949.755n 0.0v 954.745n 0.0v 954.755n 1.0v 959.745n 1.0v 959.755n 1.0v 964.745n 1.0v 964.755n 1.0v 969.745n 1.0v 969.755n 0.0v 974.745n 0.0v 974.755n 1.0v 979.745n 1.0v 979.755n 1.0v 984.745n 1.0v 984.755n 0.0v 989.745n 0.0v 989.755n 1.0v 994.745n 1.0v 994.755n 1.0v 999.745n 1.0v 999.755n 1.0v 1004.745n 1.0v 1004.755n 0.0v 1009.745n 0.0v 1009.755n 1.0v 1014.745n 1.0v 1014.755n 1.0v 1019.745n 1.0v 1019.755n 1.0v 1024.745n 1.0v 1024.755n 1.0v )
* (time, data): [(0, 0), (5, 0), (10, 1), (15, 0), (20, 0), (25, 0), (30, 0), (35, 0), (40, 1), (45, 0), (50, 0), (55, 0), (60, 0), (65, 0), (70, 1), (75, 1), (80, 1), (85, 1), (90, 1), (95, 1), (100, 1), (105, 1), (110, 0), (115, 0), (120, 0), (125, 0), (130, 1), (135, 1), (140, 0), (145, 0), (150, 1), (155, 1), (160, 1), (165, 1), (170, 1), (175, 1), (180, 0), (185, 1), (190, 0), (195, 0), (200, 1), (205, 1), (210, 1), (215, 1), (220, 1), (225, 0), (230, 0), (235, 0), (240, 1), (245, 0), (250, 1), (255, 0), (260, 1), (265, 1), (270, 0), (275, 1), (280, 1), (285, 0), (290, 1), (295, 0), (300, 0), (305, 1), (310, 1), (315, 0), (320, 1), (325, 1), (330, 1), (335, 1), (340, 0), (345, 1), (350, 1), (355, 1), (360, 0), (365, 1), (370, 1), (375, 0), (380, 0), (385, 0), (390, 0), (395, 0), (400, 1), (405, 0), (410, 0), (415, 0), (420, 0), (425, 1), (430, 1), (435, 0), (440, 0), (445, 0), (450, 1), (455, 0), (460, 0), (465, 1), (470, 1), (475, 1), (480, 0), (485, 1), (490, 0), (495, 0), (500, 1), (505, 1), (510, 1), (515, 0), (520, 0), (525, 0), (530, 1), (535, 0), (540, 1), (545, 0), (550, 0), (555, 0), (560, 0), (565, 0), (570, 0), (575, 0), (580, 0), (585, 1), (590, 1), (595, 1), (600, 1), (605, 1), (610, 0), (615, 0), (620, 0), (625, 0), (630, 0), (635, 0), (640, 1), (645, 1), (650, 1), (655, 1), (660, 1), (665, 0), (670, 0), (675, 0), (680, 0), (685, 1), (690, 1), (695, 1), (700, 1), (705, 0), (710, 0), (715, 0), (720, 1), (725, 0), (730, 0), (735, 0), (740, 0), (745, 0), (750, 0), (755, 1), (760, 1), (765, 1), (770, 0), (775, 0), (780, 1), (785, 1), (790, 1), (795, 1), (800, 1), (805, 1), (810, 1), (815, 1), (820, 1), (825, 1), (830, 1), (835, 0), (840, 1), (845, 1), (850, 0), (855, 0), (860, 0), (865, 1), (870, 1), (875, 1), (880, 1), (885, 1), (890, 1), (895, 0), (900, 0), (905, 1), (910, 1), (915, 0), (920, 1), (925, 1), (930, 1), (935, 0), (940, 0), (945, 0), (950, 1), (955, 1), (960, 1), (965, 1), (970, 1), (975, 1), (980, 1), (985, 1), (990, 1), (995, 1), (1000, 0), (1005, 0), (1010, 1), (1015, 0), (1020, 0), (1025, 0)]
Va0_1  a0_1  0 PWL (0n 0.0v 4.745n 0.0v 4.755n 0.0v 9.745n 0.0v 9.755n 1.0v 14.745n 1.0v 14.755n 0.0v 19.745n 0.0v 19.755n 0.0v 24.745n 0.0v 24.755n 0.0v 29.745n 0.0v 29.755n 0.0v 34.745n 0.0v 34.755n 0.0v 39.745n 0.0v 39.755n 1.0v 44.745n 1.0v 44.755n 0.0v 49.745n 0.0v 49.755n 0.0v 54.745n 0.0v 54.755n 0.0v 59.745n 0.0v 59.755n 0.0v 64.745n 0.0v 64.755n 0.0v 69.745n 0.0v 69.755n 1.0v 74.745n 1.0v 74.755n 1.0v 79.745n 1.0v 79.755n 1.0v 84.745n 1.0v 84.755n 1.0v 89.745n 1.0v 89.755n 1.0v 94.745n 1.0v 94.755n 1.0v 99.745n 1.0v 99.755n 1.0v 104.745n 1.0v 104.755n 1.0v 109.745n 1.0v 109.755n 0.0v 114.745n 0.0v 114.755n 0.0v 119.745n 0.0v 119.755n 0.0v 124.745n 0.0v 124.755n 0.0v 129.745n 0.0v 129.755n 1.0v 134.745n 1.0v 134.755n 1.0v 139.745n 1.0v 139.755n 0.0v 144.745n 0.0v 144.755n 0.0v 149.745n 0.0v 149.755n 1.0v 154.745n 1.0v 154.755n 1.0v 159.745n 1.0v 159.755n 1.0v 164.745n 1.0v 164.755n 1.0v 169.745n 1.0v 169.755n 1.0v 174.745n 1.0v 174.755n 1.0v 179.745n 1.0v 179.755n 0.0v 184.745n 0.0v 184.755n 1.0v 189.745n 1.0v 189.755n 0.0v 194.745n 0.0v 194.755n 0.0v 199.745n 0.0v 199.755n 1.0v 204.745n 1.0v 204.755n 1.0v 209.745n 1.0v 209.755n 1.0v 214.745n 1.0v 214.755n 1.0v 219.745n 1.0v 219.755n 1.0v 224.745n 1.0v 224.755n 0.0v 229.745n 0.0v 229.755n 0.0v 234.745n 0.0v 234.755n 0.0v 239.745n 0.0v 239.755n 1.0v 244.745n 1.0v 244.755n 0.0v 249.745n 0.0v 249.755n 1.0v 254.745n 1.0v 254.755n 0.0v 259.745n 0.0v 259.755n 1.0v 264.745n 1.0v 264.755n 1.0v 269.745n 1.0v 269.755n 0.0v 274.745n 0.0v 274.755n 1.0v 279.745n 1.0v 279.755n 1.0v 284.745n 1.0v 284.755n 0.0v 289.745n 0.0v 289.755n 1.0v 294.745n 1.0v 294.755n 0.0v 299.745n 0.0v 299.755n 0.0v 304.745n 0.0v 304.755n 1.0v 309.745n 1.0v 309.755n 1.0v 314.745n 1.0v 314.755n 0.0v 319.745n 0.0v 319.755n 1.0v 324.745n 1.0v 324.755n 1.0v 329.745n 1.0v 329.755n 1.0v 334.745n 1.0v 334.755n 1.0v 339.745n 1.0v 339.755n 0.0v 344.745n 0.0v 344.755n 1.0v 349.745n 1.0v 349.755n 1.0v 354.745n 1.0v 354.755n 1.0v 359.745n 1.0v 359.755n 0.0v 364.745n 0.0v 364.755n 1.0v 369.745n 1.0v 369.755n 1.0v 374.745n 1.0v 374.755n 0.0v 379.745n 0.0v 379.755n 0.0v 384.745n 0.0v 384.755n 0.0v 389.745n 0.0v 389.755n 0.0v 394.745n 0.0v 394.755n 0.0v 399.745n 0.0v 399.755n 1.0v 404.745n 1.0v 404.755n 0.0v 409.745n 0.0v 409.755n 0.0v 414.745n 0.0v 414.755n 0.0v 419.745n 0.0v 419.755n 0.0v 424.745n 0.0v 424.755n 1.0v 429.745n 1.0v 429.755n 1.0v 434.745n 1.0v 434.755n 0.0v 439.745n 0.0v 439.755n 0.0v 444.745n 0.0v 444.755n 0.0v 449.745n 0.0v 449.755n 1.0v 454.745n 1.0v 454.755n 0.0v 459.745n 0.0v 459.755n 0.0v 464.745n 0.0v 464.755n 1.0v 469.745n 1.0v 469.755n 1.0v 474.745n 1.0v 474.755n 1.0v 479.745n 1.0v 479.755n 0.0v 484.745n 0.0v 484.755n 1.0v 489.745n 1.0v 489.755n 0.0v 494.745n 0.0v 494.755n 0.0v 499.745n 0.0v 499.755n 1.0v 504.745n 1.0v 504.755n 1.0v 509.745n 1.0v 509.755n 1.0v 514.745n 1.0v 514.755n 0.0v 519.745n 0.0v 519.755n 0.0v 524.745n 0.0v 524.755n 0.0v 529.745n 0.0v 529.755n 1.0v 534.745n 1.0v 534.755n 0.0v 539.745n 0.0v 539.755n 1.0v 544.745n 1.0v 544.755n 0.0v 549.745n 0.0v 549.755n 0.0v 554.745n 0.0v 554.755n 0.0v 559.745n 0.0v 559.755n 0.0v 564.745n 0.0v 564.755n 0.0v 569.745n 0.0v 569.755n 0.0v 574.745n 0.0v 574.755n 0.0v 579.745n 0.0v 579.755n 0.0v 584.745n 0.0v 584.755n 1.0v 589.745n 1.0v 589.755n 1.0v 594.745n 1.0v 594.755n 1.0v 599.745n 1.0v 599.755n 1.0v 604.745n 1.0v 604.755n 1.0v 609.745n 1.0v 609.755n 0.0v 614.745n 0.0v 614.755n 0.0v 619.745n 0.0v 619.755n 0.0v 624.745n 0.0v 624.755n 0.0v 629.745n 0.0v 629.755n 0.0v 634.745n 0.0v 634.755n 0.0v 639.745n 0.0v 639.755n 1.0v 644.745n 1.0v 644.755n 1.0v 649.745n 1.0v 649.755n 1.0v 654.745n 1.0v 654.755n 1.0v 659.745n 1.0v 659.755n 1.0v 664.745n 1.0v 664.755n 0.0v 669.745n 0.0v 669.755n 0.0v 674.745n 0.0v 674.755n 0.0v 679.745n 0.0v 679.755n 0.0v 684.745n 0.0v 684.755n 1.0v 689.745n 1.0v 689.755n 1.0v 694.745n 1.0v 694.755n 1.0v 699.745n 1.0v 699.755n 1.0v 704.745n 1.0v 704.755n 0.0v 709.745n 0.0v 709.755n 0.0v 714.745n 0.0v 714.755n 0.0v 719.745n 0.0v 719.755n 1.0v 724.745n 1.0v 724.755n 0.0v 729.745n 0.0v 729.755n 0.0v 734.745n 0.0v 734.755n 0.0v 739.745n 0.0v 739.755n 0.0v 744.745n 0.0v 744.755n 0.0v 749.745n 0.0v 749.755n 0.0v 754.745n 0.0v 754.755n 1.0v 759.745n 1.0v 759.755n 1.0v 764.745n 1.0v 764.755n 1.0v 769.745n 1.0v 769.755n 0.0v 774.745n 0.0v 774.755n 0.0v 779.745n 0.0v 779.755n 1.0v 784.745n 1.0v 784.755n 1.0v 789.745n 1.0v 789.755n 1.0v 794.745n 1.0v 794.755n 1.0v 799.745n 1.0v 799.755n 1.0v 804.745n 1.0v 804.755n 1.0v 809.745n 1.0v 809.755n 1.0v 814.745n 1.0v 814.755n 1.0v 819.745n 1.0v 819.755n 1.0v 824.745n 1.0v 824.755n 1.0v 829.745n 1.0v 829.755n 1.0v 834.745n 1.0v 834.755n 0.0v 839.745n 0.0v 839.755n 1.0v 844.745n 1.0v 844.755n 1.0v 849.745n 1.0v 849.755n 0.0v 854.745n 0.0v 854.755n 0.0v 859.745n 0.0v 859.755n 0.0v 864.745n 0.0v 864.755n 1.0v 869.745n 1.0v 869.755n 1.0v 874.745n 1.0v 874.755n 1.0v 879.745n 1.0v 879.755n 1.0v 884.745n 1.0v 884.755n 1.0v 889.745n 1.0v 889.755n 1.0v 894.745n 1.0v 894.755n 0.0v 899.745n 0.0v 899.755n 0.0v 904.745n 0.0v 904.755n 1.0v 909.745n 1.0v 909.755n 1.0v 914.745n 1.0v 914.755n 0.0v 919.745n 0.0v 919.755n 1.0v 924.745n 1.0v 924.755n 1.0v 929.745n 1.0v 929.755n 1.0v 934.745n 1.0v 934.755n 0.0v 939.745n 0.0v 939.755n 0.0v 944.745n 0.0v 944.755n 0.0v 949.745n 0.0v 949.755n 1.0v 954.745n 1.0v 954.755n 1.0v 959.745n 1.0v 959.755n 1.0v 964.745n 1.0v 964.755n 1.0v 969.745n 1.0v 969.755n 1.0v 974.745n 1.0v 974.755n 1.0v 979.745n 1.0v 979.755n 1.0v 984.745n 1.0v 984.755n 1.0v 989.745n 1.0v 989.755n 1.0v 994.745n 1.0v 994.755n 1.0v 999.745n 1.0v 999.755n 0.0v 1004.745n 0.0v 1004.755n 0.0v 1009.745n 0.0v 1009.755n 1.0v 1014.745n 1.0v 1014.755n 0.0v 1019.745n 0.0v 1019.755n 0.0v 1024.745n 0.0v 1024.755n 0.0v )
* (time, data): [(0, 0), (5, 0), (10, 0), (15, 1), (20, 1), (25, 1), (30, 1), (35, 0), (40, 1), (45, 1), (50, 1), (55, 1), (60, 1), (65, 1), (70, 1), (75, 1), (80, 0), (85, 0), (90, 0), (95, 0), (100, 0), (105, 0), (110, 1), (115, 1), (120, 1), (125, 1), (130, 0), (135, 0), (140, 0), (145, 0), (150, 1), (155, 1), (160, 1), (165, 1), (170, 0), (175, 0), (180, 0), (185, 1), (190, 1), (195, 1), (200, 0), (205, 0), (210, 0), (215, 0), (220, 0), (225, 1), (230, 0), (235, 0), (240, 0), (245, 1), (250, 0), (255, 1), (260, 0), (265, 0), (270, 1), (275, 0), (280, 0), (285, 1), (290, 0), (295, 0), (300, 0), (305, 0), (310, 0), (315, 1), (320, 0), (325, 0), (330, 0), (335, 0), (340, 0), (345, 0), (350, 0), (355, 0), (360, 0), (365, 1), (370, 1), (375, 1), (380, 1), (385, 1), (390, 1), (395, 0), (400, 1), (405, 0), (410, 0), (415, 0), (420, 0), (425, 0), (430, 0), (435, 0), (440, 0), (445, 0), (450, 1), (455, 1), (460, 1), (465, 1), (470, 1), (475, 1), (480, 1), (485, 0), (490, 0), (495, 0), (500, 0), (505, 0), (510, 1), (515, 1), (520, 1), (525, 1), (530, 1), (535, 0), (540, 0), (545, 0), (550, 0), (555, 0), (560, 0), (565, 0), (570, 0), (575, 0), (580, 0), (585, 0), (590, 0), (595, 0), (600, 0), (605, 0), (610, 1), (615, 0), (620, 0), (625, 0), (630, 0), (635, 1), (640, 1), (645, 0), (650, 0), (655, 0), (660, 0), (665, 0), (670, 0), (675, 1), (680, 1), (685, 0), (690, 0), (695, 0), (700, 0), (705, 1), (710, 1), (715, 1), (720, 0), (725, 0), (730, 1), (735, 0), (740, 0), (745, 0), (750, 0), (755, 0), (760, 0), (765, 0), (770, 0), (775, 0), (780, 0), (785, 0), (790, 0), (795, 0), (800, 0), (805, 0), (810, 0), (815, 0), (820, 0), (825, 0), (830, 1), (835, 1), (840, 0), (845, 0), (850, 1), (855, 1), (860, 1), (865, 0), (870, 0), (875, 1), (880, 0), (885, 1), (890, 1), (895, 0), (900, 0), (905, 0), (910, 1), (915, 0), (920, 0), (925, 0), (930, 0), (935, 1), (940, 1), (945, 1), (950, 0), (955, 0), (960, 0), (965, 0), (970, 1), (975, 0), (980, 0), (985, 1), (990, 0), (995, 0), (1000, 1), (1005, 0), (1010, 0), (1015, 0), (1020, 1), (1025, 1)]
Va0_2  a0_2  0 PWL (0n 0.0v 4.745n 0.0v 4.755n 0.0v 9.745n 0.0v 9.755n 0.0v 14.745n 0.0v 14.755n 1.0v 19.745n 1.0v 19.755n 1.0v 24.745n 1.0v 24.755n 1.0v 29.745n 1.0v 29.755n 1.0v 34.745n 1.0v 34.755n 0.0v 39.745n 0.0v 39.755n 1.0v 44.745n 1.0v 44.755n 1.0v 49.745n 1.0v 49.755n 1.0v 54.745n 1.0v 54.755n 1.0v 59.745n 1.0v 59.755n 1.0v 64.745n 1.0v 64.755n 1.0v 69.745n 1.0v 69.755n 1.0v 74.745n 1.0v 74.755n 1.0v 79.745n 1.0v 79.755n 0.0v 84.745n 0.0v 84.755n 0.0v 89.745n 0.0v 89.755n 0.0v 94.745n 0.0v 94.755n 0.0v 99.745n 0.0v 99.755n 0.0v 104.745n 0.0v 104.755n 0.0v 109.745n 0.0v 109.755n 1.0v 114.745n 1.0v 114.755n 1.0v 119.745n 1.0v 119.755n 1.0v 124.745n 1.0v 124.755n 1.0v 129.745n 1.0v 129.755n 0.0v 134.745n 0.0v 134.755n 0.0v 139.745n 0.0v 139.755n 0.0v 144.745n 0.0v 144.755n 0.0v 149.745n 0.0v 149.755n 1.0v 154.745n 1.0v 154.755n 1.0v 159.745n 1.0v 159.755n 1.0v 164.745n 1.0v 164.755n 1.0v 169.745n 1.0v 169.755n 0.0v 174.745n 0.0v 174.755n 0.0v 179.745n 0.0v 179.755n 0.0v 184.745n 0.0v 184.755n 1.0v 189.745n 1.0v 189.755n 1.0v 194.745n 1.0v 194.755n 1.0v 199.745n 1.0v 199.755n 0.0v 204.745n 0.0v 204.755n 0.0v 209.745n 0.0v 209.755n 0.0v 214.745n 0.0v 214.755n 0.0v 219.745n 0.0v 219.755n 0.0v 224.745n 0.0v 224.755n 1.0v 229.745n 1.0v 229.755n 0.0v 234.745n 0.0v 234.755n 0.0v 239.745n 0.0v 239.755n 0.0v 244.745n 0.0v 244.755n 1.0v 249.745n 1.0v 249.755n 0.0v 254.745n 0.0v 254.755n 1.0v 259.745n 1.0v 259.755n 0.0v 264.745n 0.0v 264.755n 0.0v 269.745n 0.0v 269.755n 1.0v 274.745n 1.0v 274.755n 0.0v 279.745n 0.0v 279.755n 0.0v 284.745n 0.0v 284.755n 1.0v 289.745n 1.0v 289.755n 0.0v 294.745n 0.0v 294.755n 0.0v 299.745n 0.0v 299.755n 0.0v 304.745n 0.0v 304.755n 0.0v 309.745n 0.0v 309.755n 0.0v 314.745n 0.0v 314.755n 1.0v 319.745n 1.0v 319.755n 0.0v 324.745n 0.0v 324.755n 0.0v 329.745n 0.0v 329.755n 0.0v 334.745n 0.0v 334.755n 0.0v 339.745n 0.0v 339.755n 0.0v 344.745n 0.0v 344.755n 0.0v 349.745n 0.0v 349.755n 0.0v 354.745n 0.0v 354.755n 0.0v 359.745n 0.0v 359.755n 0.0v 364.745n 0.0v 364.755n 1.0v 369.745n 1.0v 369.755n 1.0v 374.745n 1.0v 374.755n 1.0v 379.745n 1.0v 379.755n 1.0v 384.745n 1.0v 384.755n 1.0v 389.745n 1.0v 389.755n 1.0v 394.745n 1.0v 394.755n 0.0v 399.745n 0.0v 399.755n 1.0v 404.745n 1.0v 404.755n 0.0v 409.745n 0.0v 409.755n 0.0v 414.745n 0.0v 414.755n 0.0v 419.745n 0.0v 419.755n 0.0v 424.745n 0.0v 424.755n 0.0v 429.745n 0.0v 429.755n 0.0v 434.745n 0.0v 434.755n 0.0v 439.745n 0.0v 439.755n 0.0v 444.745n 0.0v 444.755n 0.0v 449.745n 0.0v 449.755n 1.0v 454.745n 1.0v 454.755n 1.0v 459.745n 1.0v 459.755n 1.0v 464.745n 1.0v 464.755n 1.0v 469.745n 1.0v 469.755n 1.0v 474.745n 1.0v 474.755n 1.0v 479.745n 1.0v 479.755n 1.0v 484.745n 1.0v 484.755n 0.0v 489.745n 0.0v 489.755n 0.0v 494.745n 0.0v 494.755n 0.0v 499.745n 0.0v 499.755n 0.0v 504.745n 0.0v 504.755n 0.0v 509.745n 0.0v 509.755n 1.0v 514.745n 1.0v 514.755n 1.0v 519.745n 1.0v 519.755n 1.0v 524.745n 1.0v 524.755n 1.0v 529.745n 1.0v 529.755n 1.0v 534.745n 1.0v 534.755n 0.0v 539.745n 0.0v 539.755n 0.0v 544.745n 0.0v 544.755n 0.0v 549.745n 0.0v 549.755n 0.0v 554.745n 0.0v 554.755n 0.0v 559.745n 0.0v 559.755n 0.0v 564.745n 0.0v 564.755n 0.0v 569.745n 0.0v 569.755n 0.0v 574.745n 0.0v 574.755n 0.0v 579.745n 0.0v 579.755n 0.0v 584.745n 0.0v 584.755n 0.0v 589.745n 0.0v 589.755n 0.0v 594.745n 0.0v 594.755n 0.0v 599.745n 0.0v 599.755n 0.0v 604.745n 0.0v 604.755n 0.0v 609.745n 0.0v 609.755n 1.0v 614.745n 1.0v 614.755n 0.0v 619.745n 0.0v 619.755n 0.0v 624.745n 0.0v 624.755n 0.0v 629.745n 0.0v 629.755n 0.0v 634.745n 0.0v 634.755n 1.0v 639.745n 1.0v 639.755n 1.0v 644.745n 1.0v 644.755n 0.0v 649.745n 0.0v 649.755n 0.0v 654.745n 0.0v 654.755n 0.0v 659.745n 0.0v 659.755n 0.0v 664.745n 0.0v 664.755n 0.0v 669.745n 0.0v 669.755n 0.0v 674.745n 0.0v 674.755n 1.0v 679.745n 1.0v 679.755n 1.0v 684.745n 1.0v 684.755n 0.0v 689.745n 0.0v 689.755n 0.0v 694.745n 0.0v 694.755n 0.0v 699.745n 0.0v 699.755n 0.0v 704.745n 0.0v 704.755n 1.0v 709.745n 1.0v 709.755n 1.0v 714.745n 1.0v 714.755n 1.0v 719.745n 1.0v 719.755n 0.0v 724.745n 0.0v 724.755n 0.0v 729.745n 0.0v 729.755n 1.0v 734.745n 1.0v 734.755n 0.0v 739.745n 0.0v 739.755n 0.0v 744.745n 0.0v 744.755n 0.0v 749.745n 0.0v 749.755n 0.0v 754.745n 0.0v 754.755n 0.0v 759.745n 0.0v 759.755n 0.0v 764.745n 0.0v 764.755n 0.0v 769.745n 0.0v 769.755n 0.0v 774.745n 0.0v 774.755n 0.0v 779.745n 0.0v 779.755n 0.0v 784.745n 0.0v 784.755n 0.0v 789.745n 0.0v 789.755n 0.0v 794.745n 0.0v 794.755n 0.0v 799.745n 0.0v 799.755n 0.0v 804.745n 0.0v 804.755n 0.0v 809.745n 0.0v 809.755n 0.0v 814.745n 0.0v 814.755n 0.0v 819.745n 0.0v 819.755n 0.0v 824.745n 0.0v 824.755n 0.0v 829.745n 0.0v 829.755n 1.0v 834.745n 1.0v 834.755n 1.0v 839.745n 1.0v 839.755n 0.0v 844.745n 0.0v 844.755n 0.0v 849.745n 0.0v 849.755n 1.0v 854.745n 1.0v 854.755n 1.0v 859.745n 1.0v 859.755n 1.0v 864.745n 1.0v 864.755n 0.0v 869.745n 0.0v 869.755n 0.0v 874.745n 0.0v 874.755n 1.0v 879.745n 1.0v 879.755n 0.0v 884.745n 0.0v 884.755n 1.0v 889.745n 1.0v 889.755n 1.0v 894.745n 1.0v 894.755n 0.0v 899.745n 0.0v 899.755n 0.0v 904.745n 0.0v 904.755n 0.0v 909.745n 0.0v 909.755n 1.0v 914.745n 1.0v 914.755n 0.0v 919.745n 0.0v 919.755n 0.0v 924.745n 0.0v 924.755n 0.0v 929.745n 0.0v 929.755n 0.0v 934.745n 0.0v 934.755n 1.0v 939.745n 1.0v 939.755n 1.0v 944.745n 1.0v 944.755n 1.0v 949.745n 1.0v 949.755n 0.0v 954.745n 0.0v 954.755n 0.0v 959.745n 0.0v 959.755n 0.0v 964.745n 0.0v 964.755n 0.0v 969.745n 0.0v 969.755n 1.0v 974.745n 1.0v 974.755n 0.0v 979.745n 0.0v 979.755n 0.0v 984.745n 0.0v 984.755n 1.0v 989.745n 1.0v 989.755n 0.0v 994.745n 0.0v 994.755n 0.0v 999.745n 0.0v 999.755n 1.0v 1004.745n 1.0v 1004.755n 0.0v 1009.745n 0.0v 1009.755n 0.0v 1014.745n 0.0v 1014.755n 0.0v 1019.745n 0.0v 1019.755n 1.0v 1024.745n 1.0v 1024.755n 1.0v )
* (time, data): [(0, 0), (5, 0), (10, 0), (15, 1), (20, 1), (25, 1), (30, 1), (35, 0), (40, 1), (45, 1), (50, 1), (55, 1), (60, 1), (65, 1), (70, 1), (75, 1), (80, 0), (85, 0), (90, 0), (95, 0), (100, 0), (105, 0), (110, 1), (115, 1), (120, 1), (125, 1), (130, 0), (135, 0), (140, 0), (145, 0), (150, 1), (155, 1), (160, 1), (165, 1), (170, 0), (175, 0), (180, 0), (185, 1), (190, 1), (195, 1), (200, 0), (205, 0), (210, 0), (215, 0), (220, 1), (225, 1), (230, 0), (235, 0), (240, 0), (245, 1), (250, 0), (255, 1), (260, 0), (265, 0), (270, 1), (275, 0), (280, 0), (285, 1), (290, 1), (295, 0), (300, 0), (305, 0), (310, 0), (315, 1), (320, 0), (325, 0), (330, 0), (335, 0), (340, 0), (345, 1), (350, 1), (355, 1), (360, 0), (365, 1), (370, 1), (375, 1), (380, 1), (385, 1), (390, 1), (395, 0), (400, 1), (405, 0), (410, 0), (415, 0), (420, 0), (425, 0), (430, 0), (435, 0), (440, 0), (445, 0), (450, 1), (455, 1), (460, 1), (465, 1), (470, 1), (475, 1), (480, 1), (485, 1), (490, 0), (495, 0), (500, 1), (505, 0), (510, 1), (515, 1), (520, 1), (525, 1), (530, 1), (535, 0), (540, 0), (545, 0), (550, 0), (555, 0), (560, 0), (565, 0), (570, 0), (575, 0), (580, 0), (585, 0), (590, 0), (595, 1), (600, 1), (605, 0), (610, 1), (615, 0), (620, 0), (625, 0), (630, 0), (635, 1), (640, 1), (645, 0), (650, 0), (655, 0), (660, 0), (665, 0), (670, 0), (675, 1), (680, 1), (685, 0), (690, 0), (695, 0), (700, 0), (705, 1), (710, 1), (715, 1), (720, 0), (725, 0), (730, 1), (735, 0), (740, 0), (745, 0), (750, 0), (755, 1), (760, 0), (765, 0), (770, 0), (775, 0), (780, 0), (785, 0), (790, 0), (795, 0), (800, 0), (805, 0), (810, 0), (815, 0), (820, 1), (825, 0), (830, 1), (835, 1), (840, 0), (845, 0), (850, 1), (855, 1), (860, 1), (865, 0), (870, 0), (875, 1), (880, 0), (885, 1), (890, 1), (895, 0), (900, 0), (905, 0), (910, 1), (915, 0), (920, 1), (925, 1), (930, 0), (935, 1), (940, 1), (945, 1), (950, 0), (955, 0), (960, 0), (965, 0), (970, 1), (975, 0), (980, 1), (985, 1), (990, 0), (995, 1), (1000, 1), (1005, 0), (1010, 1), (1015, 0), (1020, 1), (1025, 1)]
Va0_3  a0_3  0 PWL (0n 0.0v 4.745n 0.0v 4.755n 0.0v 9.745n 0.0v 9.755n 0.0v 14.745n 0.0v 14.755n 1.0v 19.745n 1.0v 19.755n 1.0v 24.745n 1.0v 24.755n 1.0v 29.745n 1.0v 29.755n 1.0v 34.745n 1.0v 34.755n 0.0v 39.745n 0.0v 39.755n 1.0v 44.745n 1.0v 44.755n 1.0v 49.745n 1.0v 49.755n 1.0v 54.745n 1.0v 54.755n 1.0v 59.745n 1.0v 59.755n 1.0v 64.745n 1.0v 64.755n 1.0v 69.745n 1.0v 69.755n 1.0v 74.745n 1.0v 74.755n 1.0v 79.745n 1.0v 79.755n 0.0v 84.745n 0.0v 84.755n 0.0v 89.745n 0.0v 89.755n 0.0v 94.745n 0.0v 94.755n 0.0v 99.745n 0.0v 99.755n 0.0v 104.745n 0.0v 104.755n 0.0v 109.745n 0.0v 109.755n 1.0v 114.745n 1.0v 114.755n 1.0v 119.745n 1.0v 119.755n 1.0v 124.745n 1.0v 124.755n 1.0v 129.745n 1.0v 129.755n 0.0v 134.745n 0.0v 134.755n 0.0v 139.745n 0.0v 139.755n 0.0v 144.745n 0.0v 144.755n 0.0v 149.745n 0.0v 149.755n 1.0v 154.745n 1.0v 154.755n 1.0v 159.745n 1.0v 159.755n 1.0v 164.745n 1.0v 164.755n 1.0v 169.745n 1.0v 169.755n 0.0v 174.745n 0.0v 174.755n 0.0v 179.745n 0.0v 179.755n 0.0v 184.745n 0.0v 184.755n 1.0v 189.745n 1.0v 189.755n 1.0v 194.745n 1.0v 194.755n 1.0v 199.745n 1.0v 199.755n 0.0v 204.745n 0.0v 204.755n 0.0v 209.745n 0.0v 209.755n 0.0v 214.745n 0.0v 214.755n 0.0v 219.745n 0.0v 219.755n 1.0v 224.745n 1.0v 224.755n 1.0v 229.745n 1.0v 229.755n 0.0v 234.745n 0.0v 234.755n 0.0v 239.745n 0.0v 239.755n 0.0v 244.745n 0.0v 244.755n 1.0v 249.745n 1.0v 249.755n 0.0v 254.745n 0.0v 254.755n 1.0v 259.745n 1.0v 259.755n 0.0v 264.745n 0.0v 264.755n 0.0v 269.745n 0.0v 269.755n 1.0v 274.745n 1.0v 274.755n 0.0v 279.745n 0.0v 279.755n 0.0v 284.745n 0.0v 284.755n 1.0v 289.745n 1.0v 289.755n 1.0v 294.745n 1.0v 294.755n 0.0v 299.745n 0.0v 299.755n 0.0v 304.745n 0.0v 304.755n 0.0v 309.745n 0.0v 309.755n 0.0v 314.745n 0.0v 314.755n 1.0v 319.745n 1.0v 319.755n 0.0v 324.745n 0.0v 324.755n 0.0v 329.745n 0.0v 329.755n 0.0v 334.745n 0.0v 334.755n 0.0v 339.745n 0.0v 339.755n 0.0v 344.745n 0.0v 344.755n 1.0v 349.745n 1.0v 349.755n 1.0v 354.745n 1.0v 354.755n 1.0v 359.745n 1.0v 359.755n 0.0v 364.745n 0.0v 364.755n 1.0v 369.745n 1.0v 369.755n 1.0v 374.745n 1.0v 374.755n 1.0v 379.745n 1.0v 379.755n 1.0v 384.745n 1.0v 384.755n 1.0v 389.745n 1.0v 389.755n 1.0v 394.745n 1.0v 394.755n 0.0v 399.745n 0.0v 399.755n 1.0v 404.745n 1.0v 404.755n 0.0v 409.745n 0.0v 409.755n 0.0v 414.745n 0.0v 414.755n 0.0v 419.745n 0.0v 419.755n 0.0v 424.745n 0.0v 424.755n 0.0v 429.745n 0.0v 429.755n 0.0v 434.745n 0.0v 434.755n 0.0v 439.745n 0.0v 439.755n 0.0v 444.745n 0.0v 444.755n 0.0v 449.745n 0.0v 449.755n 1.0v 454.745n 1.0v 454.755n 1.0v 459.745n 1.0v 459.755n 1.0v 464.745n 1.0v 464.755n 1.0v 469.745n 1.0v 469.755n 1.0v 474.745n 1.0v 474.755n 1.0v 479.745n 1.0v 479.755n 1.0v 484.745n 1.0v 484.755n 1.0v 489.745n 1.0v 489.755n 0.0v 494.745n 0.0v 494.755n 0.0v 499.745n 0.0v 499.755n 1.0v 504.745n 1.0v 504.755n 0.0v 509.745n 0.0v 509.755n 1.0v 514.745n 1.0v 514.755n 1.0v 519.745n 1.0v 519.755n 1.0v 524.745n 1.0v 524.755n 1.0v 529.745n 1.0v 529.755n 1.0v 534.745n 1.0v 534.755n 0.0v 539.745n 0.0v 539.755n 0.0v 544.745n 0.0v 544.755n 0.0v 549.745n 0.0v 549.755n 0.0v 554.745n 0.0v 554.755n 0.0v 559.745n 0.0v 559.755n 0.0v 564.745n 0.0v 564.755n 0.0v 569.745n 0.0v 569.755n 0.0v 574.745n 0.0v 574.755n 0.0v 579.745n 0.0v 579.755n 0.0v 584.745n 0.0v 584.755n 0.0v 589.745n 0.0v 589.755n 0.0v 594.745n 0.0v 594.755n 1.0v 599.745n 1.0v 599.755n 1.0v 604.745n 1.0v 604.755n 0.0v 609.745n 0.0v 609.755n 1.0v 614.745n 1.0v 614.755n 0.0v 619.745n 0.0v 619.755n 0.0v 624.745n 0.0v 624.755n 0.0v 629.745n 0.0v 629.755n 0.0v 634.745n 0.0v 634.755n 1.0v 639.745n 1.0v 639.755n 1.0v 644.745n 1.0v 644.755n 0.0v 649.745n 0.0v 649.755n 0.0v 654.745n 0.0v 654.755n 0.0v 659.745n 0.0v 659.755n 0.0v 664.745n 0.0v 664.755n 0.0v 669.745n 0.0v 669.755n 0.0v 674.745n 0.0v 674.755n 1.0v 679.745n 1.0v 679.755n 1.0v 684.745n 1.0v 684.755n 0.0v 689.745n 0.0v 689.755n 0.0v 694.745n 0.0v 694.755n 0.0v 699.745n 0.0v 699.755n 0.0v 704.745n 0.0v 704.755n 1.0v 709.745n 1.0v 709.755n 1.0v 714.745n 1.0v 714.755n 1.0v 719.745n 1.0v 719.755n 0.0v 724.745n 0.0v 724.755n 0.0v 729.745n 0.0v 729.755n 1.0v 734.745n 1.0v 734.755n 0.0v 739.745n 0.0v 739.755n 0.0v 744.745n 0.0v 744.755n 0.0v 749.745n 0.0v 749.755n 0.0v 754.745n 0.0v 754.755n 1.0v 759.745n 1.0v 759.755n 0.0v 764.745n 0.0v 764.755n 0.0v 769.745n 0.0v 769.755n 0.0v 774.745n 0.0v 774.755n 0.0v 779.745n 0.0v 779.755n 0.0v 784.745n 0.0v 784.755n 0.0v 789.745n 0.0v 789.755n 0.0v 794.745n 0.0v 794.755n 0.0v 799.745n 0.0v 799.755n 0.0v 804.745n 0.0v 804.755n 0.0v 809.745n 0.0v 809.755n 0.0v 814.745n 0.0v 814.755n 0.0v 819.745n 0.0v 819.755n 1.0v 824.745n 1.0v 824.755n 0.0v 829.745n 0.0v 829.755n 1.0v 834.745n 1.0v 834.755n 1.0v 839.745n 1.0v 839.755n 0.0v 844.745n 0.0v 844.755n 0.0v 849.745n 0.0v 849.755n 1.0v 854.745n 1.0v 854.755n 1.0v 859.745n 1.0v 859.755n 1.0v 864.745n 1.0v 864.755n 0.0v 869.745n 0.0v 869.755n 0.0v 874.745n 0.0v 874.755n 1.0v 879.745n 1.0v 879.755n 0.0v 884.745n 0.0v 884.755n 1.0v 889.745n 1.0v 889.755n 1.0v 894.745n 1.0v 894.755n 0.0v 899.745n 0.0v 899.755n 0.0v 904.745n 0.0v 904.755n 0.0v 909.745n 0.0v 909.755n 1.0v 914.745n 1.0v 914.755n 0.0v 919.745n 0.0v 919.755n 1.0v 924.745n 1.0v 924.755n 1.0v 929.745n 1.0v 929.755n 0.0v 934.745n 0.0v 934.755n 1.0v 939.745n 1.0v 939.755n 1.0v 944.745n 1.0v 944.755n 1.0v 949.745n 1.0v 949.755n 0.0v 954.745n 0.0v 954.755n 0.0v 959.745n 0.0v 959.755n 0.0v 964.745n 0.0v 964.755n 0.0v 969.745n 0.0v 969.755n 1.0v 974.745n 1.0v 974.755n 0.0v 979.745n 0.0v 979.755n 1.0v 984.745n 1.0v 984.755n 1.0v 989.745n 1.0v 989.755n 0.0v 994.745n 0.0v 994.755n 1.0v 999.745n 1.0v 999.755n 1.0v 1004.745n 1.0v 1004.755n 0.0v 1009.745n 0.0v 1009.755n 1.0v 1014.745n 1.0v 1014.755n 0.0v 1019.745n 0.0v 1019.755n 1.0v 1024.745n 1.0v 1024.755n 1.0v )
* (time, data): [(0, 0), (5, 0), (10, 0), (15, 1), (20, 1), (25, 1), (30, 1), (35, 0), (40, 1), (45, 1), (50, 1), (55, 1), (60, 1), (65, 1), (70, 1), (75, 1), (80, 0), (85, 0), (90, 0), (95, 0), (100, 0), (105, 0), (110, 1), (115, 1), (120, 1), (125, 1), (130, 0), (135, 0), (140, 0), (145, 0), (150, 1), (155, 1), (160, 1), (165, 1), (170, 0), (175, 0), (180, 0), (185, 1), (190, 1), (195, 1), (200, 0), (205, 0), (210, 0), (215, 0), (220, 1), (225, 1), (230, 0), (235, 0), (240, 0), (245, 1), (250, 0), (255, 1), (260, 0), (265, 0), (270, 1), (275, 0), (280, 0), (285, 1), (290, 1), (295, 0), (300, 0), (305, 0), (310, 0), (315, 1), (320, 0), (325, 0), (330, 0), (335, 0), (340, 0), (345, 1), (350, 1), (355, 1), (360, 0), (365, 1), (370, 1), (375, 1), (380, 1), (385, 1), (390, 1), (395, 0), (400, 1), (405, 0), (410, 0), (415, 0), (420, 0), (425, 0), (430, 0), (435, 0), (440, 0), (445, 0), (450, 1), (455, 1), (460, 1), (465, 1), (470, 1), (475, 1), (480, 1), (485, 1), (490, 0), (495, 0), (500, 1), (505, 0), (510, 1), (515, 1), (520, 1), (525, 1), (530, 1), (535, 0), (540, 0), (545, 0), (550, 0), (555, 0), (560, 0), (565, 0), (570, 0), (575, 0), (580, 0), (585, 0), (590, 0), (595, 1), (600, 1), (605, 0), (610, 1), (615, 0), (620, 0), (625, 0), (630, 0), (635, 1), (640, 1), (645, 0), (650, 0), (655, 0), (660, 0), (665, 0), (670, 0), (675, 1), (680, 1), (685, 0), (690, 0), (695, 0), (700, 0), (705, 1), (710, 1), (715, 1), (720, 0), (725, 0), (730, 1), (735, 0), (740, 0), (745, 0), (750, 0), (755, 1), (760, 0), (765, 0), (770, 0), (775, 0), (780, 0), (785, 0), (790, 0), (795, 0), (800, 0), (805, 0), (810, 0), (815, 0), (820, 1), (825, 0), (830, 1), (835, 1), (840, 0), (845, 0), (850, 1), (855, 1), (860, 1), (865, 0), (870, 0), (875, 1), (880, 0), (885, 1), (890, 1), (895, 0), (900, 0), (905, 0), (910, 1), (915, 0), (920, 1), (925, 1), (930, 0), (935, 1), (940, 1), (945, 1), (950, 0), (955, 0), (960, 0), (965, 0), (970, 1), (975, 0), (980, 1), (985, 1), (990, 0), (995, 1), (1000, 1), (1005, 0), (1010, 1), (1015, 0), (1020, 1), (1025, 1)]
Va0_4  a0_4  0 PWL (0n 0.0v 4.745n 0.0v 4.755n 0.0v 9.745n 0.0v 9.755n 0.0v 14.745n 0.0v 14.755n 1.0v 19.745n 1.0v 19.755n 1.0v 24.745n 1.0v 24.755n 1.0v 29.745n 1.0v 29.755n 1.0v 34.745n 1.0v 34.755n 0.0v 39.745n 0.0v 39.755n 1.0v 44.745n 1.0v 44.755n 1.0v 49.745n 1.0v 49.755n 1.0v 54.745n 1.0v 54.755n 1.0v 59.745n 1.0v 59.755n 1.0v 64.745n 1.0v 64.755n 1.0v 69.745n 1.0v 69.755n 1.0v 74.745n 1.0v 74.755n 1.0v 79.745n 1.0v 79.755n 0.0v 84.745n 0.0v 84.755n 0.0v 89.745n 0.0v 89.755n 0.0v 94.745n 0.0v 94.755n 0.0v 99.745n 0.0v 99.755n 0.0v 104.745n 0.0v 104.755n 0.0v 109.745n 0.0v 109.755n 1.0v 114.745n 1.0v 114.755n 1.0v 119.745n 1.0v 119.755n 1.0v 124.745n 1.0v 124.755n 1.0v 129.745n 1.0v 129.755n 0.0v 134.745n 0.0v 134.755n 0.0v 139.745n 0.0v 139.755n 0.0v 144.745n 0.0v 144.755n 0.0v 149.745n 0.0v 149.755n 1.0v 154.745n 1.0v 154.755n 1.0v 159.745n 1.0v 159.755n 1.0v 164.745n 1.0v 164.755n 1.0v 169.745n 1.0v 169.755n 0.0v 174.745n 0.0v 174.755n 0.0v 179.745n 0.0v 179.755n 0.0v 184.745n 0.0v 184.755n 1.0v 189.745n 1.0v 189.755n 1.0v 194.745n 1.0v 194.755n 1.0v 199.745n 1.0v 199.755n 0.0v 204.745n 0.0v 204.755n 0.0v 209.745n 0.0v 209.755n 0.0v 214.745n 0.0v 214.755n 0.0v 219.745n 0.0v 219.755n 1.0v 224.745n 1.0v 224.755n 1.0v 229.745n 1.0v 229.755n 0.0v 234.745n 0.0v 234.755n 0.0v 239.745n 0.0v 239.755n 0.0v 244.745n 0.0v 244.755n 1.0v 249.745n 1.0v 249.755n 0.0v 254.745n 0.0v 254.755n 1.0v 259.745n 1.0v 259.755n 0.0v 264.745n 0.0v 264.755n 0.0v 269.745n 0.0v 269.755n 1.0v 274.745n 1.0v 274.755n 0.0v 279.745n 0.0v 279.755n 0.0v 284.745n 0.0v 284.755n 1.0v 289.745n 1.0v 289.755n 1.0v 294.745n 1.0v 294.755n 0.0v 299.745n 0.0v 299.755n 0.0v 304.745n 0.0v 304.755n 0.0v 309.745n 0.0v 309.755n 0.0v 314.745n 0.0v 314.755n 1.0v 319.745n 1.0v 319.755n 0.0v 324.745n 0.0v 324.755n 0.0v 329.745n 0.0v 329.755n 0.0v 334.745n 0.0v 334.755n 0.0v 339.745n 0.0v 339.755n 0.0v 344.745n 0.0v 344.755n 1.0v 349.745n 1.0v 349.755n 1.0v 354.745n 1.0v 354.755n 1.0v 359.745n 1.0v 359.755n 0.0v 364.745n 0.0v 364.755n 1.0v 369.745n 1.0v 369.755n 1.0v 374.745n 1.0v 374.755n 1.0v 379.745n 1.0v 379.755n 1.0v 384.745n 1.0v 384.755n 1.0v 389.745n 1.0v 389.755n 1.0v 394.745n 1.0v 394.755n 0.0v 399.745n 0.0v 399.755n 1.0v 404.745n 1.0v 404.755n 0.0v 409.745n 0.0v 409.755n 0.0v 414.745n 0.0v 414.755n 0.0v 419.745n 0.0v 419.755n 0.0v 424.745n 0.0v 424.755n 0.0v 429.745n 0.0v 429.755n 0.0v 434.745n 0.0v 434.755n 0.0v 439.745n 0.0v 439.755n 0.0v 444.745n 0.0v 444.755n 0.0v 449.745n 0.0v 449.755n 1.0v 454.745n 1.0v 454.755n 1.0v 459.745n 1.0v 459.755n 1.0v 464.745n 1.0v 464.755n 1.0v 469.745n 1.0v 469.755n 1.0v 474.745n 1.0v 474.755n 1.0v 479.745n 1.0v 479.755n 1.0v 484.745n 1.0v 484.755n 1.0v 489.745n 1.0v 489.755n 0.0v 494.745n 0.0v 494.755n 0.0v 499.745n 0.0v 499.755n 1.0v 504.745n 1.0v 504.755n 0.0v 509.745n 0.0v 509.755n 1.0v 514.745n 1.0v 514.755n 1.0v 519.745n 1.0v 519.755n 1.0v 524.745n 1.0v 524.755n 1.0v 529.745n 1.0v 529.755n 1.0v 534.745n 1.0v 534.755n 0.0v 539.745n 0.0v 539.755n 0.0v 544.745n 0.0v 544.755n 0.0v 549.745n 0.0v 549.755n 0.0v 554.745n 0.0v 554.755n 0.0v 559.745n 0.0v 559.755n 0.0v 564.745n 0.0v 564.755n 0.0v 569.745n 0.0v 569.755n 0.0v 574.745n 0.0v 574.755n 0.0v 579.745n 0.0v 579.755n 0.0v 584.745n 0.0v 584.755n 0.0v 589.745n 0.0v 589.755n 0.0v 594.745n 0.0v 594.755n 1.0v 599.745n 1.0v 599.755n 1.0v 604.745n 1.0v 604.755n 0.0v 609.745n 0.0v 609.755n 1.0v 614.745n 1.0v 614.755n 0.0v 619.745n 0.0v 619.755n 0.0v 624.745n 0.0v 624.755n 0.0v 629.745n 0.0v 629.755n 0.0v 634.745n 0.0v 634.755n 1.0v 639.745n 1.0v 639.755n 1.0v 644.745n 1.0v 644.755n 0.0v 649.745n 0.0v 649.755n 0.0v 654.745n 0.0v 654.755n 0.0v 659.745n 0.0v 659.755n 0.0v 664.745n 0.0v 664.755n 0.0v 669.745n 0.0v 669.755n 0.0v 674.745n 0.0v 674.755n 1.0v 679.745n 1.0v 679.755n 1.0v 684.745n 1.0v 684.755n 0.0v 689.745n 0.0v 689.755n 0.0v 694.745n 0.0v 694.755n 0.0v 699.745n 0.0v 699.755n 0.0v 704.745n 0.0v 704.755n 1.0v 709.745n 1.0v 709.755n 1.0v 714.745n 1.0v 714.755n 1.0v 719.745n 1.0v 719.755n 0.0v 724.745n 0.0v 724.755n 0.0v 729.745n 0.0v 729.755n 1.0v 734.745n 1.0v 734.755n 0.0v 739.745n 0.0v 739.755n 0.0v 744.745n 0.0v 744.755n 0.0v 749.745n 0.0v 749.755n 0.0v 754.745n 0.0v 754.755n 1.0v 759.745n 1.0v 759.755n 0.0v 764.745n 0.0v 764.755n 0.0v 769.745n 0.0v 769.755n 0.0v 774.745n 0.0v 774.755n 0.0v 779.745n 0.0v 779.755n 0.0v 784.745n 0.0v 784.755n 0.0v 789.745n 0.0v 789.755n 0.0v 794.745n 0.0v 794.755n 0.0v 799.745n 0.0v 799.755n 0.0v 804.745n 0.0v 804.755n 0.0v 809.745n 0.0v 809.755n 0.0v 814.745n 0.0v 814.755n 0.0v 819.745n 0.0v 819.755n 1.0v 824.745n 1.0v 824.755n 0.0v 829.745n 0.0v 829.755n 1.0v 834.745n 1.0v 834.755n 1.0v 839.745n 1.0v 839.755n 0.0v 844.745n 0.0v 844.755n 0.0v 849.745n 0.0v 849.755n 1.0v 854.745n 1.0v 854.755n 1.0v 859.745n 1.0v 859.755n 1.0v 864.745n 1.0v 864.755n 0.0v 869.745n 0.0v 869.755n 0.0v 874.745n 0.0v 874.755n 1.0v 879.745n 1.0v 879.755n 0.0v 884.745n 0.0v 884.755n 1.0v 889.745n 1.0v 889.755n 1.0v 894.745n 1.0v 894.755n 0.0v 899.745n 0.0v 899.755n 0.0v 904.745n 0.0v 904.755n 0.0v 909.745n 0.0v 909.755n 1.0v 914.745n 1.0v 914.755n 0.0v 919.745n 0.0v 919.755n 1.0v 924.745n 1.0v 924.755n 1.0v 929.745n 1.0v 929.755n 0.0v 934.745n 0.0v 934.755n 1.0v 939.745n 1.0v 939.755n 1.0v 944.745n 1.0v 944.755n 1.0v 949.745n 1.0v 949.755n 0.0v 954.745n 0.0v 954.755n 0.0v 959.745n 0.0v 959.755n 0.0v 964.745n 0.0v 964.755n 0.0v 969.745n 0.0v 969.755n 1.0v 974.745n 1.0v 974.755n 0.0v 979.745n 0.0v 979.755n 1.0v 984.745n 1.0v 984.755n 1.0v 989.745n 1.0v 989.755n 0.0v 994.745n 0.0v 994.755n 1.0v 999.745n 1.0v 999.755n 1.0v 1004.745n 1.0v 1004.755n 0.0v 1009.745n 0.0v 1009.755n 1.0v 1014.745n 1.0v 1014.755n 0.0v 1019.745n 0.0v 1019.755n 1.0v 1024.745n 1.0v 1024.755n 1.0v )
* (time, data): [(0, 0), (5, 0), (10, 0), (15, 1), (20, 1), (25, 1), (30, 1), (35, 0), (40, 1), (45, 1), (50, 1), (55, 1), (60, 1), (65, 1), (70, 1), (75, 1), (80, 0), (85, 0), (90, 0), (95, 0), (100, 0), (105, 0), (110, 1), (115, 1), (120, 1), (125, 1), (130, 0), (135, 0), (140, 0), (145, 0), (150, 1), (155, 1), (160, 1), (165, 1), (170, 0), (175, 0), (180, 0), (185, 1), (190, 1), (195, 1), (200, 0), (205, 0), (210, 0), (215, 0), (220, 1), (225, 1), (230, 0), (235, 0), (240, 0), (245, 1), (250, 0), (255, 1), (260, 0), (265, 0), (270, 1), (275, 0), (280, 0), (285, 1), (290, 1), (295, 0), (300, 0), (305, 0), (310, 0), (315, 1), (320, 0), (325, 0), (330, 0), (335, 0), (340, 0), (345, 1), (350, 1), (355, 1), (360, 0), (365, 1), (370, 1), (375, 1), (380, 1), (385, 1), (390, 1), (395, 0), (400, 1), (405, 0), (410, 0), (415, 0), (420, 0), (425, 0), (430, 0), (435, 0), (440, 0), (445, 0), (450, 1), (455, 1), (460, 1), (465, 1), (470, 1), (475, 1), (480, 1), (485, 1), (490, 0), (495, 0), (500, 1), (505, 0), (510, 1), (515, 1), (520, 1), (525, 1), (530, 1), (535, 0), (540, 0), (545, 0), (550, 0), (555, 0), (560, 0), (565, 0), (570, 0), (575, 0), (580, 0), (585, 0), (590, 0), (595, 1), (600, 1), (605, 0), (610, 1), (615, 0), (620, 0), (625, 0), (630, 0), (635, 1), (640, 1), (645, 0), (650, 0), (655, 0), (660, 0), (665, 0), (670, 0), (675, 1), (680, 1), (685, 0), (690, 0), (695, 0), (700, 0), (705, 1), (710, 1), (715, 1), (720, 0), (725, 0), (730, 1), (735, 0), (740, 0), (745, 0), (750, 0), (755, 1), (760, 0), (765, 0), (770, 0), (775, 0), (780, 0), (785, 0), (790, 0), (795, 0), (800, 0), (805, 0), (810, 0), (815, 0), (820, 1), (825, 0), (830, 1), (835, 1), (840, 0), (845, 0), (850, 1), (855, 1), (860, 1), (865, 0), (870, 0), (875, 1), (880, 0), (885, 1), (890, 1), (895, 0), (900, 0), (905, 0), (910, 1), (915, 0), (920, 1), (925, 1), (930, 0), (935, 1), (940, 1), (945, 1), (950, 0), (955, 0), (960, 0), (965, 0), (970, 1), (975, 0), (980, 1), (985, 1), (990, 0), (995, 1), (1000, 1), (1005, 0), (1010, 1), (1015, 0), (1020, 1), (1025, 1)]
Va0_5  a0_5  0 PWL (0n 0.0v 4.745n 0.0v 4.755n 0.0v 9.745n 0.0v 9.755n 0.0v 14.745n 0.0v 14.755n 1.0v 19.745n 1.0v 19.755n 1.0v 24.745n 1.0v 24.755n 1.0v 29.745n 1.0v 29.755n 1.0v 34.745n 1.0v 34.755n 0.0v 39.745n 0.0v 39.755n 1.0v 44.745n 1.0v 44.755n 1.0v 49.745n 1.0v 49.755n 1.0v 54.745n 1.0v 54.755n 1.0v 59.745n 1.0v 59.755n 1.0v 64.745n 1.0v 64.755n 1.0v 69.745n 1.0v 69.755n 1.0v 74.745n 1.0v 74.755n 1.0v 79.745n 1.0v 79.755n 0.0v 84.745n 0.0v 84.755n 0.0v 89.745n 0.0v 89.755n 0.0v 94.745n 0.0v 94.755n 0.0v 99.745n 0.0v 99.755n 0.0v 104.745n 0.0v 104.755n 0.0v 109.745n 0.0v 109.755n 1.0v 114.745n 1.0v 114.755n 1.0v 119.745n 1.0v 119.755n 1.0v 124.745n 1.0v 124.755n 1.0v 129.745n 1.0v 129.755n 0.0v 134.745n 0.0v 134.755n 0.0v 139.745n 0.0v 139.755n 0.0v 144.745n 0.0v 144.755n 0.0v 149.745n 0.0v 149.755n 1.0v 154.745n 1.0v 154.755n 1.0v 159.745n 1.0v 159.755n 1.0v 164.745n 1.0v 164.755n 1.0v 169.745n 1.0v 169.755n 0.0v 174.745n 0.0v 174.755n 0.0v 179.745n 0.0v 179.755n 0.0v 184.745n 0.0v 184.755n 1.0v 189.745n 1.0v 189.755n 1.0v 194.745n 1.0v 194.755n 1.0v 199.745n 1.0v 199.755n 0.0v 204.745n 0.0v 204.755n 0.0v 209.745n 0.0v 209.755n 0.0v 214.745n 0.0v 214.755n 0.0v 219.745n 0.0v 219.755n 1.0v 224.745n 1.0v 224.755n 1.0v 229.745n 1.0v 229.755n 0.0v 234.745n 0.0v 234.755n 0.0v 239.745n 0.0v 239.755n 0.0v 244.745n 0.0v 244.755n 1.0v 249.745n 1.0v 249.755n 0.0v 254.745n 0.0v 254.755n 1.0v 259.745n 1.0v 259.755n 0.0v 264.745n 0.0v 264.755n 0.0v 269.745n 0.0v 269.755n 1.0v 274.745n 1.0v 274.755n 0.0v 279.745n 0.0v 279.755n 0.0v 284.745n 0.0v 284.755n 1.0v 289.745n 1.0v 289.755n 1.0v 294.745n 1.0v 294.755n 0.0v 299.745n 0.0v 299.755n 0.0v 304.745n 0.0v 304.755n 0.0v 309.745n 0.0v 309.755n 0.0v 314.745n 0.0v 314.755n 1.0v 319.745n 1.0v 319.755n 0.0v 324.745n 0.0v 324.755n 0.0v 329.745n 0.0v 329.755n 0.0v 334.745n 0.0v 334.755n 0.0v 339.745n 0.0v 339.755n 0.0v 344.745n 0.0v 344.755n 1.0v 349.745n 1.0v 349.755n 1.0v 354.745n 1.0v 354.755n 1.0v 359.745n 1.0v 359.755n 0.0v 364.745n 0.0v 364.755n 1.0v 369.745n 1.0v 369.755n 1.0v 374.745n 1.0v 374.755n 1.0v 379.745n 1.0v 379.755n 1.0v 384.745n 1.0v 384.755n 1.0v 389.745n 1.0v 389.755n 1.0v 394.745n 1.0v 394.755n 0.0v 399.745n 0.0v 399.755n 1.0v 404.745n 1.0v 404.755n 0.0v 409.745n 0.0v 409.755n 0.0v 414.745n 0.0v 414.755n 0.0v 419.745n 0.0v 419.755n 0.0v 424.745n 0.0v 424.755n 0.0v 429.745n 0.0v 429.755n 0.0v 434.745n 0.0v 434.755n 0.0v 439.745n 0.0v 439.755n 0.0v 444.745n 0.0v 444.755n 0.0v 449.745n 0.0v 449.755n 1.0v 454.745n 1.0v 454.755n 1.0v 459.745n 1.0v 459.755n 1.0v 464.745n 1.0v 464.755n 1.0v 469.745n 1.0v 469.755n 1.0v 474.745n 1.0v 474.755n 1.0v 479.745n 1.0v 479.755n 1.0v 484.745n 1.0v 484.755n 1.0v 489.745n 1.0v 489.755n 0.0v 494.745n 0.0v 494.755n 0.0v 499.745n 0.0v 499.755n 1.0v 504.745n 1.0v 504.755n 0.0v 509.745n 0.0v 509.755n 1.0v 514.745n 1.0v 514.755n 1.0v 519.745n 1.0v 519.755n 1.0v 524.745n 1.0v 524.755n 1.0v 529.745n 1.0v 529.755n 1.0v 534.745n 1.0v 534.755n 0.0v 539.745n 0.0v 539.755n 0.0v 544.745n 0.0v 544.755n 0.0v 549.745n 0.0v 549.755n 0.0v 554.745n 0.0v 554.755n 0.0v 559.745n 0.0v 559.755n 0.0v 564.745n 0.0v 564.755n 0.0v 569.745n 0.0v 569.755n 0.0v 574.745n 0.0v 574.755n 0.0v 579.745n 0.0v 579.755n 0.0v 584.745n 0.0v 584.755n 0.0v 589.745n 0.0v 589.755n 0.0v 594.745n 0.0v 594.755n 1.0v 599.745n 1.0v 599.755n 1.0v 604.745n 1.0v 604.755n 0.0v 609.745n 0.0v 609.755n 1.0v 614.745n 1.0v 614.755n 0.0v 619.745n 0.0v 619.755n 0.0v 624.745n 0.0v 624.755n 0.0v 629.745n 0.0v 629.755n 0.0v 634.745n 0.0v 634.755n 1.0v 639.745n 1.0v 639.755n 1.0v 644.745n 1.0v 644.755n 0.0v 649.745n 0.0v 649.755n 0.0v 654.745n 0.0v 654.755n 0.0v 659.745n 0.0v 659.755n 0.0v 664.745n 0.0v 664.755n 0.0v 669.745n 0.0v 669.755n 0.0v 674.745n 0.0v 674.755n 1.0v 679.745n 1.0v 679.755n 1.0v 684.745n 1.0v 684.755n 0.0v 689.745n 0.0v 689.755n 0.0v 694.745n 0.0v 694.755n 0.0v 699.745n 0.0v 699.755n 0.0v 704.745n 0.0v 704.755n 1.0v 709.745n 1.0v 709.755n 1.0v 714.745n 1.0v 714.755n 1.0v 719.745n 1.0v 719.755n 0.0v 724.745n 0.0v 724.755n 0.0v 729.745n 0.0v 729.755n 1.0v 734.745n 1.0v 734.755n 0.0v 739.745n 0.0v 739.755n 0.0v 744.745n 0.0v 744.755n 0.0v 749.745n 0.0v 749.755n 0.0v 754.745n 0.0v 754.755n 1.0v 759.745n 1.0v 759.755n 0.0v 764.745n 0.0v 764.755n 0.0v 769.745n 0.0v 769.755n 0.0v 774.745n 0.0v 774.755n 0.0v 779.745n 0.0v 779.755n 0.0v 784.745n 0.0v 784.755n 0.0v 789.745n 0.0v 789.755n 0.0v 794.745n 0.0v 794.755n 0.0v 799.745n 0.0v 799.755n 0.0v 804.745n 0.0v 804.755n 0.0v 809.745n 0.0v 809.755n 0.0v 814.745n 0.0v 814.755n 0.0v 819.745n 0.0v 819.755n 1.0v 824.745n 1.0v 824.755n 0.0v 829.745n 0.0v 829.755n 1.0v 834.745n 1.0v 834.755n 1.0v 839.745n 1.0v 839.755n 0.0v 844.745n 0.0v 844.755n 0.0v 849.745n 0.0v 849.755n 1.0v 854.745n 1.0v 854.755n 1.0v 859.745n 1.0v 859.755n 1.0v 864.745n 1.0v 864.755n 0.0v 869.745n 0.0v 869.755n 0.0v 874.745n 0.0v 874.755n 1.0v 879.745n 1.0v 879.755n 0.0v 884.745n 0.0v 884.755n 1.0v 889.745n 1.0v 889.755n 1.0v 894.745n 1.0v 894.755n 0.0v 899.745n 0.0v 899.755n 0.0v 904.745n 0.0v 904.755n 0.0v 909.745n 0.0v 909.755n 1.0v 914.745n 1.0v 914.755n 0.0v 919.745n 0.0v 919.755n 1.0v 924.745n 1.0v 924.755n 1.0v 929.745n 1.0v 929.755n 0.0v 934.745n 0.0v 934.755n 1.0v 939.745n 1.0v 939.755n 1.0v 944.745n 1.0v 944.755n 1.0v 949.745n 1.0v 949.755n 0.0v 954.745n 0.0v 954.755n 0.0v 959.745n 0.0v 959.755n 0.0v 964.745n 0.0v 964.755n 0.0v 969.745n 0.0v 969.755n 1.0v 974.745n 1.0v 974.755n 0.0v 979.745n 0.0v 979.755n 1.0v 984.745n 1.0v 984.755n 1.0v 989.745n 1.0v 989.755n 0.0v 994.745n 0.0v 994.755n 1.0v 999.745n 1.0v 999.755n 1.0v 1004.745n 1.0v 1004.755n 0.0v 1009.745n 0.0v 1009.755n 1.0v 1014.745n 1.0v 1014.755n 0.0v 1019.745n 0.0v 1019.755n 1.0v 1024.745n 1.0v 1024.755n 1.0v )
* (time, data): [(0, 0), (5, 0), (10, 0), (15, 1), (20, 1), (25, 1), (30, 1), (35, 0), (40, 1), (45, 1), (50, 1), (55, 1), (60, 1), (65, 1), (70, 1), (75, 1), (80, 0), (85, 0), (90, 0), (95, 0), (100, 0), (105, 0), (110, 1), (115, 1), (120, 1), (125, 1), (130, 0), (135, 0), (140, 0), (145, 0), (150, 1), (155, 1), (160, 1), (165, 1), (170, 0), (175, 0), (180, 0), (185, 1), (190, 1), (195, 1), (200, 0), (205, 0), (210, 0), (215, 0), (220, 1), (225, 1), (230, 0), (235, 0), (240, 0), (245, 1), (250, 0), (255, 1), (260, 0), (265, 0), (270, 1), (275, 0), (280, 0), (285, 1), (290, 1), (295, 0), (300, 0), (305, 0), (310, 0), (315, 1), (320, 0), (325, 0), (330, 0), (335, 0), (340, 0), (345, 1), (350, 1), (355, 1), (360, 0), (365, 1), (370, 1), (375, 1), (380, 1), (385, 1), (390, 1), (395, 0), (400, 1), (405, 0), (410, 0), (415, 0), (420, 0), (425, 0), (430, 0), (435, 0), (440, 0), (445, 0), (450, 1), (455, 1), (460, 1), (465, 1), (470, 1), (475, 1), (480, 1), (485, 1), (490, 0), (495, 0), (500, 1), (505, 0), (510, 1), (515, 1), (520, 1), (525, 1), (530, 1), (535, 0), (540, 0), (545, 0), (550, 0), (555, 0), (560, 0), (565, 0), (570, 0), (575, 0), (580, 0), (585, 0), (590, 0), (595, 1), (600, 1), (605, 0), (610, 1), (615, 0), (620, 0), (625, 0), (630, 0), (635, 1), (640, 1), (645, 0), (650, 0), (655, 0), (660, 0), (665, 0), (670, 0), (675, 1), (680, 1), (685, 0), (690, 0), (695, 0), (700, 0), (705, 1), (710, 1), (715, 1), (720, 0), (725, 0), (730, 1), (735, 0), (740, 0), (745, 0), (750, 0), (755, 1), (760, 0), (765, 0), (770, 0), (775, 0), (780, 0), (785, 0), (790, 0), (795, 0), (800, 0), (805, 0), (810, 0), (815, 0), (820, 1), (825, 0), (830, 1), (835, 1), (840, 0), (845, 0), (850, 1), (855, 1), (860, 1), (865, 0), (870, 0), (875, 1), (880, 0), (885, 1), (890, 1), (895, 0), (900, 0), (905, 0), (910, 1), (915, 0), (920, 1), (925, 1), (930, 0), (935, 1), (940, 1), (945, 1), (950, 0), (955, 0), (960, 0), (965, 0), (970, 1), (975, 0), (980, 1), (985, 1), (990, 0), (995, 1), (1000, 1), (1005, 0), (1010, 1), (1015, 0), (1020, 1), (1025, 1)]
Va0_6  a0_6  0 PWL (0n 0.0v 4.745n 0.0v 4.755n 0.0v 9.745n 0.0v 9.755n 0.0v 14.745n 0.0v 14.755n 1.0v 19.745n 1.0v 19.755n 1.0v 24.745n 1.0v 24.755n 1.0v 29.745n 1.0v 29.755n 1.0v 34.745n 1.0v 34.755n 0.0v 39.745n 0.0v 39.755n 1.0v 44.745n 1.0v 44.755n 1.0v 49.745n 1.0v 49.755n 1.0v 54.745n 1.0v 54.755n 1.0v 59.745n 1.0v 59.755n 1.0v 64.745n 1.0v 64.755n 1.0v 69.745n 1.0v 69.755n 1.0v 74.745n 1.0v 74.755n 1.0v 79.745n 1.0v 79.755n 0.0v 84.745n 0.0v 84.755n 0.0v 89.745n 0.0v 89.755n 0.0v 94.745n 0.0v 94.755n 0.0v 99.745n 0.0v 99.755n 0.0v 104.745n 0.0v 104.755n 0.0v 109.745n 0.0v 109.755n 1.0v 114.745n 1.0v 114.755n 1.0v 119.745n 1.0v 119.755n 1.0v 124.745n 1.0v 124.755n 1.0v 129.745n 1.0v 129.755n 0.0v 134.745n 0.0v 134.755n 0.0v 139.745n 0.0v 139.755n 0.0v 144.745n 0.0v 144.755n 0.0v 149.745n 0.0v 149.755n 1.0v 154.745n 1.0v 154.755n 1.0v 159.745n 1.0v 159.755n 1.0v 164.745n 1.0v 164.755n 1.0v 169.745n 1.0v 169.755n 0.0v 174.745n 0.0v 174.755n 0.0v 179.745n 0.0v 179.755n 0.0v 184.745n 0.0v 184.755n 1.0v 189.745n 1.0v 189.755n 1.0v 194.745n 1.0v 194.755n 1.0v 199.745n 1.0v 199.755n 0.0v 204.745n 0.0v 204.755n 0.0v 209.745n 0.0v 209.755n 0.0v 214.745n 0.0v 214.755n 0.0v 219.745n 0.0v 219.755n 1.0v 224.745n 1.0v 224.755n 1.0v 229.745n 1.0v 229.755n 0.0v 234.745n 0.0v 234.755n 0.0v 239.745n 0.0v 239.755n 0.0v 244.745n 0.0v 244.755n 1.0v 249.745n 1.0v 249.755n 0.0v 254.745n 0.0v 254.755n 1.0v 259.745n 1.0v 259.755n 0.0v 264.745n 0.0v 264.755n 0.0v 269.745n 0.0v 269.755n 1.0v 274.745n 1.0v 274.755n 0.0v 279.745n 0.0v 279.755n 0.0v 284.745n 0.0v 284.755n 1.0v 289.745n 1.0v 289.755n 1.0v 294.745n 1.0v 294.755n 0.0v 299.745n 0.0v 299.755n 0.0v 304.745n 0.0v 304.755n 0.0v 309.745n 0.0v 309.755n 0.0v 314.745n 0.0v 314.755n 1.0v 319.745n 1.0v 319.755n 0.0v 324.745n 0.0v 324.755n 0.0v 329.745n 0.0v 329.755n 0.0v 334.745n 0.0v 334.755n 0.0v 339.745n 0.0v 339.755n 0.0v 344.745n 0.0v 344.755n 1.0v 349.745n 1.0v 349.755n 1.0v 354.745n 1.0v 354.755n 1.0v 359.745n 1.0v 359.755n 0.0v 364.745n 0.0v 364.755n 1.0v 369.745n 1.0v 369.755n 1.0v 374.745n 1.0v 374.755n 1.0v 379.745n 1.0v 379.755n 1.0v 384.745n 1.0v 384.755n 1.0v 389.745n 1.0v 389.755n 1.0v 394.745n 1.0v 394.755n 0.0v 399.745n 0.0v 399.755n 1.0v 404.745n 1.0v 404.755n 0.0v 409.745n 0.0v 409.755n 0.0v 414.745n 0.0v 414.755n 0.0v 419.745n 0.0v 419.755n 0.0v 424.745n 0.0v 424.755n 0.0v 429.745n 0.0v 429.755n 0.0v 434.745n 0.0v 434.755n 0.0v 439.745n 0.0v 439.755n 0.0v 444.745n 0.0v 444.755n 0.0v 449.745n 0.0v 449.755n 1.0v 454.745n 1.0v 454.755n 1.0v 459.745n 1.0v 459.755n 1.0v 464.745n 1.0v 464.755n 1.0v 469.745n 1.0v 469.755n 1.0v 474.745n 1.0v 474.755n 1.0v 479.745n 1.0v 479.755n 1.0v 484.745n 1.0v 484.755n 1.0v 489.745n 1.0v 489.755n 0.0v 494.745n 0.0v 494.755n 0.0v 499.745n 0.0v 499.755n 1.0v 504.745n 1.0v 504.755n 0.0v 509.745n 0.0v 509.755n 1.0v 514.745n 1.0v 514.755n 1.0v 519.745n 1.0v 519.755n 1.0v 524.745n 1.0v 524.755n 1.0v 529.745n 1.0v 529.755n 1.0v 534.745n 1.0v 534.755n 0.0v 539.745n 0.0v 539.755n 0.0v 544.745n 0.0v 544.755n 0.0v 549.745n 0.0v 549.755n 0.0v 554.745n 0.0v 554.755n 0.0v 559.745n 0.0v 559.755n 0.0v 564.745n 0.0v 564.755n 0.0v 569.745n 0.0v 569.755n 0.0v 574.745n 0.0v 574.755n 0.0v 579.745n 0.0v 579.755n 0.0v 584.745n 0.0v 584.755n 0.0v 589.745n 0.0v 589.755n 0.0v 594.745n 0.0v 594.755n 1.0v 599.745n 1.0v 599.755n 1.0v 604.745n 1.0v 604.755n 0.0v 609.745n 0.0v 609.755n 1.0v 614.745n 1.0v 614.755n 0.0v 619.745n 0.0v 619.755n 0.0v 624.745n 0.0v 624.755n 0.0v 629.745n 0.0v 629.755n 0.0v 634.745n 0.0v 634.755n 1.0v 639.745n 1.0v 639.755n 1.0v 644.745n 1.0v 644.755n 0.0v 649.745n 0.0v 649.755n 0.0v 654.745n 0.0v 654.755n 0.0v 659.745n 0.0v 659.755n 0.0v 664.745n 0.0v 664.755n 0.0v 669.745n 0.0v 669.755n 0.0v 674.745n 0.0v 674.755n 1.0v 679.745n 1.0v 679.755n 1.0v 684.745n 1.0v 684.755n 0.0v 689.745n 0.0v 689.755n 0.0v 694.745n 0.0v 694.755n 0.0v 699.745n 0.0v 699.755n 0.0v 704.745n 0.0v 704.755n 1.0v 709.745n 1.0v 709.755n 1.0v 714.745n 1.0v 714.755n 1.0v 719.745n 1.0v 719.755n 0.0v 724.745n 0.0v 724.755n 0.0v 729.745n 0.0v 729.755n 1.0v 734.745n 1.0v 734.755n 0.0v 739.745n 0.0v 739.755n 0.0v 744.745n 0.0v 744.755n 0.0v 749.745n 0.0v 749.755n 0.0v 754.745n 0.0v 754.755n 1.0v 759.745n 1.0v 759.755n 0.0v 764.745n 0.0v 764.755n 0.0v 769.745n 0.0v 769.755n 0.0v 774.745n 0.0v 774.755n 0.0v 779.745n 0.0v 779.755n 0.0v 784.745n 0.0v 784.755n 0.0v 789.745n 0.0v 789.755n 0.0v 794.745n 0.0v 794.755n 0.0v 799.745n 0.0v 799.755n 0.0v 804.745n 0.0v 804.755n 0.0v 809.745n 0.0v 809.755n 0.0v 814.745n 0.0v 814.755n 0.0v 819.745n 0.0v 819.755n 1.0v 824.745n 1.0v 824.755n 0.0v 829.745n 0.0v 829.755n 1.0v 834.745n 1.0v 834.755n 1.0v 839.745n 1.0v 839.755n 0.0v 844.745n 0.0v 844.755n 0.0v 849.745n 0.0v 849.755n 1.0v 854.745n 1.0v 854.755n 1.0v 859.745n 1.0v 859.755n 1.0v 864.745n 1.0v 864.755n 0.0v 869.745n 0.0v 869.755n 0.0v 874.745n 0.0v 874.755n 1.0v 879.745n 1.0v 879.755n 0.0v 884.745n 0.0v 884.755n 1.0v 889.745n 1.0v 889.755n 1.0v 894.745n 1.0v 894.755n 0.0v 899.745n 0.0v 899.755n 0.0v 904.745n 0.0v 904.755n 0.0v 909.745n 0.0v 909.755n 1.0v 914.745n 1.0v 914.755n 0.0v 919.745n 0.0v 919.755n 1.0v 924.745n 1.0v 924.755n 1.0v 929.745n 1.0v 929.755n 0.0v 934.745n 0.0v 934.755n 1.0v 939.745n 1.0v 939.755n 1.0v 944.745n 1.0v 944.755n 1.0v 949.745n 1.0v 949.755n 0.0v 954.745n 0.0v 954.755n 0.0v 959.745n 0.0v 959.755n 0.0v 964.745n 0.0v 964.755n 0.0v 969.745n 0.0v 969.755n 1.0v 974.745n 1.0v 974.755n 0.0v 979.745n 0.0v 979.755n 1.0v 984.745n 1.0v 984.755n 1.0v 989.745n 1.0v 989.755n 0.0v 994.745n 0.0v 994.755n 1.0v 999.745n 1.0v 999.755n 1.0v 1004.745n 1.0v 1004.755n 0.0v 1009.745n 0.0v 1009.755n 1.0v 1014.745n 1.0v 1014.755n 0.0v 1019.745n 0.0v 1019.755n 1.0v 1024.745n 1.0v 1024.755n 1.0v )
* (time, data): [(0, 0), (5, 0), (10, 0), (15, 1), (20, 1), (25, 1), (30, 1), (35, 0), (40, 1), (45, 1), (50, 1), (55, 1), (60, 1), (65, 1), (70, 1), (75, 1), (80, 0), (85, 0), (90, 0), (95, 0), (100, 0), (105, 0), (110, 1), (115, 1), (120, 1), (125, 1), (130, 0), (135, 0), (140, 0), (145, 0), (150, 1), (155, 1), (160, 1), (165, 1), (170, 0), (175, 0), (180, 0), (185, 1), (190, 1), (195, 1), (200, 0), (205, 0), (210, 0), (215, 0), (220, 1), (225, 1), (230, 0), (235, 0), (240, 0), (245, 1), (250, 0), (255, 1), (260, 0), (265, 0), (270, 1), (275, 0), (280, 0), (285, 1), (290, 1), (295, 0), (300, 0), (305, 0), (310, 0), (315, 1), (320, 0), (325, 0), (330, 0), (335, 0), (340, 0), (345, 1), (350, 1), (355, 1), (360, 0), (365, 1), (370, 1), (375, 1), (380, 1), (385, 1), (390, 1), (395, 0), (400, 1), (405, 0), (410, 0), (415, 0), (420, 0), (425, 0), (430, 0), (435, 0), (440, 0), (445, 0), (450, 1), (455, 1), (460, 1), (465, 1), (470, 1), (475, 1), (480, 1), (485, 1), (490, 0), (495, 0), (500, 1), (505, 0), (510, 1), (515, 1), (520, 1), (525, 1), (530, 1), (535, 0), (540, 0), (545, 0), (550, 0), (555, 0), (560, 0), (565, 0), (570, 0), (575, 0), (580, 0), (585, 0), (590, 0), (595, 1), (600, 1), (605, 0), (610, 1), (615, 0), (620, 0), (625, 0), (630, 0), (635, 1), (640, 1), (645, 0), (650, 0), (655, 0), (660, 0), (665, 0), (670, 0), (675, 1), (680, 1), (685, 0), (690, 0), (695, 0), (700, 0), (705, 1), (710, 1), (715, 1), (720, 0), (725, 0), (730, 1), (735, 0), (740, 0), (745, 0), (750, 0), (755, 1), (760, 0), (765, 0), (770, 0), (775, 0), (780, 0), (785, 0), (790, 0), (795, 0), (800, 0), (805, 0), (810, 0), (815, 0), (820, 1), (825, 0), (830, 1), (835, 1), (840, 0), (845, 0), (850, 1), (855, 1), (860, 1), (865, 0), (870, 0), (875, 1), (880, 0), (885, 1), (890, 1), (895, 0), (900, 0), (905, 0), (910, 1), (915, 0), (920, 1), (925, 1), (930, 0), (935, 1), (940, 1), (945, 1), (950, 0), (955, 0), (960, 0), (965, 0), (970, 1), (975, 0), (980, 1), (985, 1), (990, 0), (995, 1), (1000, 1), (1005, 0), (1010, 1), (1015, 0), (1020, 1), (1025, 1)]
Va0_7  a0_7  0 PWL (0n 0.0v 4.745n 0.0v 4.755n 0.0v 9.745n 0.0v 9.755n 0.0v 14.745n 0.0v 14.755n 1.0v 19.745n 1.0v 19.755n 1.0v 24.745n 1.0v 24.755n 1.0v 29.745n 1.0v 29.755n 1.0v 34.745n 1.0v 34.755n 0.0v 39.745n 0.0v 39.755n 1.0v 44.745n 1.0v 44.755n 1.0v 49.745n 1.0v 49.755n 1.0v 54.745n 1.0v 54.755n 1.0v 59.745n 1.0v 59.755n 1.0v 64.745n 1.0v 64.755n 1.0v 69.745n 1.0v 69.755n 1.0v 74.745n 1.0v 74.755n 1.0v 79.745n 1.0v 79.755n 0.0v 84.745n 0.0v 84.755n 0.0v 89.745n 0.0v 89.755n 0.0v 94.745n 0.0v 94.755n 0.0v 99.745n 0.0v 99.755n 0.0v 104.745n 0.0v 104.755n 0.0v 109.745n 0.0v 109.755n 1.0v 114.745n 1.0v 114.755n 1.0v 119.745n 1.0v 119.755n 1.0v 124.745n 1.0v 124.755n 1.0v 129.745n 1.0v 129.755n 0.0v 134.745n 0.0v 134.755n 0.0v 139.745n 0.0v 139.755n 0.0v 144.745n 0.0v 144.755n 0.0v 149.745n 0.0v 149.755n 1.0v 154.745n 1.0v 154.755n 1.0v 159.745n 1.0v 159.755n 1.0v 164.745n 1.0v 164.755n 1.0v 169.745n 1.0v 169.755n 0.0v 174.745n 0.0v 174.755n 0.0v 179.745n 0.0v 179.755n 0.0v 184.745n 0.0v 184.755n 1.0v 189.745n 1.0v 189.755n 1.0v 194.745n 1.0v 194.755n 1.0v 199.745n 1.0v 199.755n 0.0v 204.745n 0.0v 204.755n 0.0v 209.745n 0.0v 209.755n 0.0v 214.745n 0.0v 214.755n 0.0v 219.745n 0.0v 219.755n 1.0v 224.745n 1.0v 224.755n 1.0v 229.745n 1.0v 229.755n 0.0v 234.745n 0.0v 234.755n 0.0v 239.745n 0.0v 239.755n 0.0v 244.745n 0.0v 244.755n 1.0v 249.745n 1.0v 249.755n 0.0v 254.745n 0.0v 254.755n 1.0v 259.745n 1.0v 259.755n 0.0v 264.745n 0.0v 264.755n 0.0v 269.745n 0.0v 269.755n 1.0v 274.745n 1.0v 274.755n 0.0v 279.745n 0.0v 279.755n 0.0v 284.745n 0.0v 284.755n 1.0v 289.745n 1.0v 289.755n 1.0v 294.745n 1.0v 294.755n 0.0v 299.745n 0.0v 299.755n 0.0v 304.745n 0.0v 304.755n 0.0v 309.745n 0.0v 309.755n 0.0v 314.745n 0.0v 314.755n 1.0v 319.745n 1.0v 319.755n 0.0v 324.745n 0.0v 324.755n 0.0v 329.745n 0.0v 329.755n 0.0v 334.745n 0.0v 334.755n 0.0v 339.745n 0.0v 339.755n 0.0v 344.745n 0.0v 344.755n 1.0v 349.745n 1.0v 349.755n 1.0v 354.745n 1.0v 354.755n 1.0v 359.745n 1.0v 359.755n 0.0v 364.745n 0.0v 364.755n 1.0v 369.745n 1.0v 369.755n 1.0v 374.745n 1.0v 374.755n 1.0v 379.745n 1.0v 379.755n 1.0v 384.745n 1.0v 384.755n 1.0v 389.745n 1.0v 389.755n 1.0v 394.745n 1.0v 394.755n 0.0v 399.745n 0.0v 399.755n 1.0v 404.745n 1.0v 404.755n 0.0v 409.745n 0.0v 409.755n 0.0v 414.745n 0.0v 414.755n 0.0v 419.745n 0.0v 419.755n 0.0v 424.745n 0.0v 424.755n 0.0v 429.745n 0.0v 429.755n 0.0v 434.745n 0.0v 434.755n 0.0v 439.745n 0.0v 439.755n 0.0v 444.745n 0.0v 444.755n 0.0v 449.745n 0.0v 449.755n 1.0v 454.745n 1.0v 454.755n 1.0v 459.745n 1.0v 459.755n 1.0v 464.745n 1.0v 464.755n 1.0v 469.745n 1.0v 469.755n 1.0v 474.745n 1.0v 474.755n 1.0v 479.745n 1.0v 479.755n 1.0v 484.745n 1.0v 484.755n 1.0v 489.745n 1.0v 489.755n 0.0v 494.745n 0.0v 494.755n 0.0v 499.745n 0.0v 499.755n 1.0v 504.745n 1.0v 504.755n 0.0v 509.745n 0.0v 509.755n 1.0v 514.745n 1.0v 514.755n 1.0v 519.745n 1.0v 519.755n 1.0v 524.745n 1.0v 524.755n 1.0v 529.745n 1.0v 529.755n 1.0v 534.745n 1.0v 534.755n 0.0v 539.745n 0.0v 539.755n 0.0v 544.745n 0.0v 544.755n 0.0v 549.745n 0.0v 549.755n 0.0v 554.745n 0.0v 554.755n 0.0v 559.745n 0.0v 559.755n 0.0v 564.745n 0.0v 564.755n 0.0v 569.745n 0.0v 569.755n 0.0v 574.745n 0.0v 574.755n 0.0v 579.745n 0.0v 579.755n 0.0v 584.745n 0.0v 584.755n 0.0v 589.745n 0.0v 589.755n 0.0v 594.745n 0.0v 594.755n 1.0v 599.745n 1.0v 599.755n 1.0v 604.745n 1.0v 604.755n 0.0v 609.745n 0.0v 609.755n 1.0v 614.745n 1.0v 614.755n 0.0v 619.745n 0.0v 619.755n 0.0v 624.745n 0.0v 624.755n 0.0v 629.745n 0.0v 629.755n 0.0v 634.745n 0.0v 634.755n 1.0v 639.745n 1.0v 639.755n 1.0v 644.745n 1.0v 644.755n 0.0v 649.745n 0.0v 649.755n 0.0v 654.745n 0.0v 654.755n 0.0v 659.745n 0.0v 659.755n 0.0v 664.745n 0.0v 664.755n 0.0v 669.745n 0.0v 669.755n 0.0v 674.745n 0.0v 674.755n 1.0v 679.745n 1.0v 679.755n 1.0v 684.745n 1.0v 684.755n 0.0v 689.745n 0.0v 689.755n 0.0v 694.745n 0.0v 694.755n 0.0v 699.745n 0.0v 699.755n 0.0v 704.745n 0.0v 704.755n 1.0v 709.745n 1.0v 709.755n 1.0v 714.745n 1.0v 714.755n 1.0v 719.745n 1.0v 719.755n 0.0v 724.745n 0.0v 724.755n 0.0v 729.745n 0.0v 729.755n 1.0v 734.745n 1.0v 734.755n 0.0v 739.745n 0.0v 739.755n 0.0v 744.745n 0.0v 744.755n 0.0v 749.745n 0.0v 749.755n 0.0v 754.745n 0.0v 754.755n 1.0v 759.745n 1.0v 759.755n 0.0v 764.745n 0.0v 764.755n 0.0v 769.745n 0.0v 769.755n 0.0v 774.745n 0.0v 774.755n 0.0v 779.745n 0.0v 779.755n 0.0v 784.745n 0.0v 784.755n 0.0v 789.745n 0.0v 789.755n 0.0v 794.745n 0.0v 794.755n 0.0v 799.745n 0.0v 799.755n 0.0v 804.745n 0.0v 804.755n 0.0v 809.745n 0.0v 809.755n 0.0v 814.745n 0.0v 814.755n 0.0v 819.745n 0.0v 819.755n 1.0v 824.745n 1.0v 824.755n 0.0v 829.745n 0.0v 829.755n 1.0v 834.745n 1.0v 834.755n 1.0v 839.745n 1.0v 839.755n 0.0v 844.745n 0.0v 844.755n 0.0v 849.745n 0.0v 849.755n 1.0v 854.745n 1.0v 854.755n 1.0v 859.745n 1.0v 859.755n 1.0v 864.745n 1.0v 864.755n 0.0v 869.745n 0.0v 869.755n 0.0v 874.745n 0.0v 874.755n 1.0v 879.745n 1.0v 879.755n 0.0v 884.745n 0.0v 884.755n 1.0v 889.745n 1.0v 889.755n 1.0v 894.745n 1.0v 894.755n 0.0v 899.745n 0.0v 899.755n 0.0v 904.745n 0.0v 904.755n 0.0v 909.745n 0.0v 909.755n 1.0v 914.745n 1.0v 914.755n 0.0v 919.745n 0.0v 919.755n 1.0v 924.745n 1.0v 924.755n 1.0v 929.745n 1.0v 929.755n 0.0v 934.745n 0.0v 934.755n 1.0v 939.745n 1.0v 939.755n 1.0v 944.745n 1.0v 944.755n 1.0v 949.745n 1.0v 949.755n 0.0v 954.745n 0.0v 954.755n 0.0v 959.745n 0.0v 959.755n 0.0v 964.745n 0.0v 964.755n 0.0v 969.745n 0.0v 969.755n 1.0v 974.745n 1.0v 974.755n 0.0v 979.745n 0.0v 979.755n 1.0v 984.745n 1.0v 984.755n 1.0v 989.745n 1.0v 989.755n 0.0v 994.745n 0.0v 994.755n 1.0v 999.745n 1.0v 999.755n 1.0v 1004.745n 1.0v 1004.755n 0.0v 1009.745n 0.0v 1009.755n 1.0v 1014.745n 1.0v 1014.755n 0.0v 1019.745n 0.0v 1019.755n 1.0v 1024.745n 1.0v 1024.755n 1.0v )
* (time, data): [(0, 0), (5, 0), (10, 0), (15, 1), (20, 1), (25, 1), (30, 1), (35, 0), (40, 1), (45, 1), (50, 1), (55, 1), (60, 1), (65, 1), (70, 1), (75, 1), (80, 0), (85, 0), (90, 0), (95, 0), (100, 0), (105, 0), (110, 1), (115, 1), (120, 1), (125, 1), (130, 0), (135, 0), (140, 0), (145, 0), (150, 1), (155, 1), (160, 1), (165, 1), (170, 0), (175, 0), (180, 0), (185, 1), (190, 1), (195, 1), (200, 0), (205, 0), (210, 0), (215, 0), (220, 1), (225, 1), (230, 0), (235, 0), (240, 0), (245, 1), (250, 0), (255, 1), (260, 0), (265, 0), (270, 1), (275, 0), (280, 0), (285, 1), (290, 1), (295, 0), (300, 0), (305, 0), (310, 0), (315, 1), (320, 0), (325, 0), (330, 0), (335, 0), (340, 0), (345, 1), (350, 1), (355, 1), (360, 0), (365, 1), (370, 1), (375, 1), (380, 1), (385, 1), (390, 1), (395, 0), (400, 1), (405, 0), (410, 0), (415, 0), (420, 0), (425, 0), (430, 0), (435, 0), (440, 0), (445, 0), (450, 1), (455, 1), (460, 1), (465, 1), (470, 1), (475, 1), (480, 1), (485, 1), (490, 0), (495, 0), (500, 1), (505, 0), (510, 1), (515, 1), (520, 1), (525, 1), (530, 1), (535, 0), (540, 0), (545, 0), (550, 0), (555, 0), (560, 0), (565, 0), (570, 0), (575, 0), (580, 0), (585, 0), (590, 0), (595, 1), (600, 1), (605, 0), (610, 1), (615, 0), (620, 0), (625, 0), (630, 0), (635, 1), (640, 1), (645, 0), (650, 0), (655, 0), (660, 0), (665, 0), (670, 0), (675, 1), (680, 1), (685, 0), (690, 0), (695, 0), (700, 0), (705, 1), (710, 1), (715, 1), (720, 0), (725, 0), (730, 1), (735, 0), (740, 0), (745, 0), (750, 0), (755, 1), (760, 0), (765, 0), (770, 0), (775, 0), (780, 0), (785, 0), (790, 0), (795, 0), (800, 0), (805, 0), (810, 0), (815, 0), (820, 1), (825, 0), (830, 1), (835, 1), (840, 0), (845, 0), (850, 1), (855, 1), (860, 1), (865, 0), (870, 0), (875, 1), (880, 0), (885, 1), (890, 1), (895, 0), (900, 0), (905, 0), (910, 1), (915, 0), (920, 1), (925, 1), (930, 0), (935, 1), (940, 1), (945, 1), (950, 0), (955, 0), (960, 0), (965, 0), (970, 1), (975, 0), (980, 1), (985, 1), (990, 0), (995, 1), (1000, 1), (1005, 0), (1010, 1), (1015, 0), (1020, 1), (1025, 1)]
Va0_8  a0_8  0 PWL (0n 0.0v 4.745n 0.0v 4.755n 0.0v 9.745n 0.0v 9.755n 0.0v 14.745n 0.0v 14.755n 1.0v 19.745n 1.0v 19.755n 1.0v 24.745n 1.0v 24.755n 1.0v 29.745n 1.0v 29.755n 1.0v 34.745n 1.0v 34.755n 0.0v 39.745n 0.0v 39.755n 1.0v 44.745n 1.0v 44.755n 1.0v 49.745n 1.0v 49.755n 1.0v 54.745n 1.0v 54.755n 1.0v 59.745n 1.0v 59.755n 1.0v 64.745n 1.0v 64.755n 1.0v 69.745n 1.0v 69.755n 1.0v 74.745n 1.0v 74.755n 1.0v 79.745n 1.0v 79.755n 0.0v 84.745n 0.0v 84.755n 0.0v 89.745n 0.0v 89.755n 0.0v 94.745n 0.0v 94.755n 0.0v 99.745n 0.0v 99.755n 0.0v 104.745n 0.0v 104.755n 0.0v 109.745n 0.0v 109.755n 1.0v 114.745n 1.0v 114.755n 1.0v 119.745n 1.0v 119.755n 1.0v 124.745n 1.0v 124.755n 1.0v 129.745n 1.0v 129.755n 0.0v 134.745n 0.0v 134.755n 0.0v 139.745n 0.0v 139.755n 0.0v 144.745n 0.0v 144.755n 0.0v 149.745n 0.0v 149.755n 1.0v 154.745n 1.0v 154.755n 1.0v 159.745n 1.0v 159.755n 1.0v 164.745n 1.0v 164.755n 1.0v 169.745n 1.0v 169.755n 0.0v 174.745n 0.0v 174.755n 0.0v 179.745n 0.0v 179.755n 0.0v 184.745n 0.0v 184.755n 1.0v 189.745n 1.0v 189.755n 1.0v 194.745n 1.0v 194.755n 1.0v 199.745n 1.0v 199.755n 0.0v 204.745n 0.0v 204.755n 0.0v 209.745n 0.0v 209.755n 0.0v 214.745n 0.0v 214.755n 0.0v 219.745n 0.0v 219.755n 1.0v 224.745n 1.0v 224.755n 1.0v 229.745n 1.0v 229.755n 0.0v 234.745n 0.0v 234.755n 0.0v 239.745n 0.0v 239.755n 0.0v 244.745n 0.0v 244.755n 1.0v 249.745n 1.0v 249.755n 0.0v 254.745n 0.0v 254.755n 1.0v 259.745n 1.0v 259.755n 0.0v 264.745n 0.0v 264.755n 0.0v 269.745n 0.0v 269.755n 1.0v 274.745n 1.0v 274.755n 0.0v 279.745n 0.0v 279.755n 0.0v 284.745n 0.0v 284.755n 1.0v 289.745n 1.0v 289.755n 1.0v 294.745n 1.0v 294.755n 0.0v 299.745n 0.0v 299.755n 0.0v 304.745n 0.0v 304.755n 0.0v 309.745n 0.0v 309.755n 0.0v 314.745n 0.0v 314.755n 1.0v 319.745n 1.0v 319.755n 0.0v 324.745n 0.0v 324.755n 0.0v 329.745n 0.0v 329.755n 0.0v 334.745n 0.0v 334.755n 0.0v 339.745n 0.0v 339.755n 0.0v 344.745n 0.0v 344.755n 1.0v 349.745n 1.0v 349.755n 1.0v 354.745n 1.0v 354.755n 1.0v 359.745n 1.0v 359.755n 0.0v 364.745n 0.0v 364.755n 1.0v 369.745n 1.0v 369.755n 1.0v 374.745n 1.0v 374.755n 1.0v 379.745n 1.0v 379.755n 1.0v 384.745n 1.0v 384.755n 1.0v 389.745n 1.0v 389.755n 1.0v 394.745n 1.0v 394.755n 0.0v 399.745n 0.0v 399.755n 1.0v 404.745n 1.0v 404.755n 0.0v 409.745n 0.0v 409.755n 0.0v 414.745n 0.0v 414.755n 0.0v 419.745n 0.0v 419.755n 0.0v 424.745n 0.0v 424.755n 0.0v 429.745n 0.0v 429.755n 0.0v 434.745n 0.0v 434.755n 0.0v 439.745n 0.0v 439.755n 0.0v 444.745n 0.0v 444.755n 0.0v 449.745n 0.0v 449.755n 1.0v 454.745n 1.0v 454.755n 1.0v 459.745n 1.0v 459.755n 1.0v 464.745n 1.0v 464.755n 1.0v 469.745n 1.0v 469.755n 1.0v 474.745n 1.0v 474.755n 1.0v 479.745n 1.0v 479.755n 1.0v 484.745n 1.0v 484.755n 1.0v 489.745n 1.0v 489.755n 0.0v 494.745n 0.0v 494.755n 0.0v 499.745n 0.0v 499.755n 1.0v 504.745n 1.0v 504.755n 0.0v 509.745n 0.0v 509.755n 1.0v 514.745n 1.0v 514.755n 1.0v 519.745n 1.0v 519.755n 1.0v 524.745n 1.0v 524.755n 1.0v 529.745n 1.0v 529.755n 1.0v 534.745n 1.0v 534.755n 0.0v 539.745n 0.0v 539.755n 0.0v 544.745n 0.0v 544.755n 0.0v 549.745n 0.0v 549.755n 0.0v 554.745n 0.0v 554.755n 0.0v 559.745n 0.0v 559.755n 0.0v 564.745n 0.0v 564.755n 0.0v 569.745n 0.0v 569.755n 0.0v 574.745n 0.0v 574.755n 0.0v 579.745n 0.0v 579.755n 0.0v 584.745n 0.0v 584.755n 0.0v 589.745n 0.0v 589.755n 0.0v 594.745n 0.0v 594.755n 1.0v 599.745n 1.0v 599.755n 1.0v 604.745n 1.0v 604.755n 0.0v 609.745n 0.0v 609.755n 1.0v 614.745n 1.0v 614.755n 0.0v 619.745n 0.0v 619.755n 0.0v 624.745n 0.0v 624.755n 0.0v 629.745n 0.0v 629.755n 0.0v 634.745n 0.0v 634.755n 1.0v 639.745n 1.0v 639.755n 1.0v 644.745n 1.0v 644.755n 0.0v 649.745n 0.0v 649.755n 0.0v 654.745n 0.0v 654.755n 0.0v 659.745n 0.0v 659.755n 0.0v 664.745n 0.0v 664.755n 0.0v 669.745n 0.0v 669.755n 0.0v 674.745n 0.0v 674.755n 1.0v 679.745n 1.0v 679.755n 1.0v 684.745n 1.0v 684.755n 0.0v 689.745n 0.0v 689.755n 0.0v 694.745n 0.0v 694.755n 0.0v 699.745n 0.0v 699.755n 0.0v 704.745n 0.0v 704.755n 1.0v 709.745n 1.0v 709.755n 1.0v 714.745n 1.0v 714.755n 1.0v 719.745n 1.0v 719.755n 0.0v 724.745n 0.0v 724.755n 0.0v 729.745n 0.0v 729.755n 1.0v 734.745n 1.0v 734.755n 0.0v 739.745n 0.0v 739.755n 0.0v 744.745n 0.0v 744.755n 0.0v 749.745n 0.0v 749.755n 0.0v 754.745n 0.0v 754.755n 1.0v 759.745n 1.0v 759.755n 0.0v 764.745n 0.0v 764.755n 0.0v 769.745n 0.0v 769.755n 0.0v 774.745n 0.0v 774.755n 0.0v 779.745n 0.0v 779.755n 0.0v 784.745n 0.0v 784.755n 0.0v 789.745n 0.0v 789.755n 0.0v 794.745n 0.0v 794.755n 0.0v 799.745n 0.0v 799.755n 0.0v 804.745n 0.0v 804.755n 0.0v 809.745n 0.0v 809.755n 0.0v 814.745n 0.0v 814.755n 0.0v 819.745n 0.0v 819.755n 1.0v 824.745n 1.0v 824.755n 0.0v 829.745n 0.0v 829.755n 1.0v 834.745n 1.0v 834.755n 1.0v 839.745n 1.0v 839.755n 0.0v 844.745n 0.0v 844.755n 0.0v 849.745n 0.0v 849.755n 1.0v 854.745n 1.0v 854.755n 1.0v 859.745n 1.0v 859.755n 1.0v 864.745n 1.0v 864.755n 0.0v 869.745n 0.0v 869.755n 0.0v 874.745n 0.0v 874.755n 1.0v 879.745n 1.0v 879.755n 0.0v 884.745n 0.0v 884.755n 1.0v 889.745n 1.0v 889.755n 1.0v 894.745n 1.0v 894.755n 0.0v 899.745n 0.0v 899.755n 0.0v 904.745n 0.0v 904.755n 0.0v 909.745n 0.0v 909.755n 1.0v 914.745n 1.0v 914.755n 0.0v 919.745n 0.0v 919.755n 1.0v 924.745n 1.0v 924.755n 1.0v 929.745n 1.0v 929.755n 0.0v 934.745n 0.0v 934.755n 1.0v 939.745n 1.0v 939.755n 1.0v 944.745n 1.0v 944.755n 1.0v 949.745n 1.0v 949.755n 0.0v 954.745n 0.0v 954.755n 0.0v 959.745n 0.0v 959.755n 0.0v 964.745n 0.0v 964.755n 0.0v 969.745n 0.0v 969.755n 1.0v 974.745n 1.0v 974.755n 0.0v 979.745n 0.0v 979.755n 1.0v 984.745n 1.0v 984.755n 1.0v 989.745n 1.0v 989.755n 0.0v 994.745n 0.0v 994.755n 1.0v 999.745n 1.0v 999.755n 1.0v 1004.745n 1.0v 1004.755n 0.0v 1009.745n 0.0v 1009.755n 1.0v 1014.745n 1.0v 1014.755n 0.0v 1019.745n 0.0v 1019.755n 1.0v 1024.745n 1.0v 1024.755n 1.0v )
* (time, data): [(0, 0), (5, 0), (10, 0), (15, 0), (20, 1), (25, 1), (30, 1), (35, 0), (40, 0), (45, 0), (50, 0), (55, 1), (60, 0), (65, 1), (70, 1), (75, 1), (80, 1), (85, 0), (90, 0), (95, 0), (100, 0), (105, 1), (110, 0), (115, 0), (120, 0), (125, 1), (130, 1), (135, 0), (140, 0), (145, 1), (150, 0), (155, 0), (160, 0), (165, 1), (170, 1), (175, 1), (180, 1), (185, 1), (190, 1), (195, 1), (200, 1), (205, 0), (210, 1), (215, 1), (220, 0), (225, 1), (230, 0), (235, 0), (240, 0), (245, 1), (250, 1), (255, 1), (260, 1), (265, 1), (270, 1), (275, 0), (280, 1), (285, 1), (290, 1), (295, 1), (300, 0), (305, 1), (310, 1), (315, 0), (320, 1), (325, 1), (330, 1), (335, 1), (340, 1), (345, 0), (350, 1), (355, 0), (360, 1), (365, 1), (370, 0), (375, 1), (380, 1), (385, 1), (390, 0), (395, 0), (400, 0), (405, 1), (410, 0), (415, 0), (420, 0), (425, 1), (430, 0), (435, 0), (440, 1), (445, 1), (450, 0), (455, 0), (460, 0), (465, 0), (470, 0), (475, 0), (480, 0), (485, 1), (490, 1), (495, 0), (500, 0), (505, 0), (510, 0), (515, 1), (520, 0), (525, 0), (530, 1), (535, 0), (540, 0), (545, 0), (550, 1), (555, 0), (560, 0), (565, 0), (570, 0), (575, 0), (580, 1), (585, 1), (590, 1), (595, 0), (600, 1), (605, 1), (610, 1), (615, 1), (620, 1), (625, 1), (630, 1), (635, 1), (640, 1), (645, 0), (650, 1), (655, 0), (660, 1), (665, 1), (670, 1), (675, 1), (680, 1), (685, 0), (690, 1), (695, 1), (700, 1), (705, 1), (710, 1), (715, 1), (720, 1), (725, 0), (730, 0), (735, 0), (740, 0), (745, 0), (750, 0), (755, 1), (760, 1), (765, 1), (770, 1), (775, 1), (780, 0), (785, 0), (790, 0), (795, 0), (800, 1), (805, 0), (810, 0), (815, 0), (820, 0), (825, 0), (830, 1), (835, 1), (840, 0), (845, 0), (850, 1), (855, 1), (860, 1), (865, 0), (870, 0), (875, 1), (880, 0), (885, 0), (890, 0), (895, 0), (900, 1), (905, 1), (910, 1), (915, 0), (920, 1), (925, 1), (930, 0), (935, 0), (940, 0), (945, 0), (950, 0), (955, 0), (960, 0), (965, 1), (970, 1), (975, 1), (980, 0), (985, 1), (990, 1), (995, 1), (1000, 1), (1005, 0), (1010, 0), (1015, 0), (1020, 0), (1025, 0)]
Va1_0  a1_0  0 PWL (0n 0.0v 4.745n 0.0v 4.755n 0.0v 9.745n 0.0v 9.755n 0.0v 14.745n 0.0v 14.755n 0.0v 19.745n 0.0v 19.755n 1.0v 24.745n 1.0v 24.755n 1.0v 29.745n 1.0v 29.755n 1.0v 34.745n 1.0v 34.755n 0.0v 39.745n 0.0v 39.755n 0.0v 44.745n 0.0v 44.755n 0.0v 49.745n 0.0v 49.755n 0.0v 54.745n 0.0v 54.755n 1.0v 59.745n 1.0v 59.755n 0.0v 64.745n 0.0v 64.755n 1.0v 69.745n 1.0v 69.755n 1.0v 74.745n 1.0v 74.755n 1.0v 79.745n 1.0v 79.755n 1.0v 84.745n 1.0v 84.755n 0.0v 89.745n 0.0v 89.755n 0.0v 94.745n 0.0v 94.755n 0.0v 99.745n 0.0v 99.755n 0.0v 104.745n 0.0v 104.755n 1.0v 109.745n 1.0v 109.755n 0.0v 114.745n 0.0v 114.755n 0.0v 119.745n 0.0v 119.755n 0.0v 124.745n 0.0v 124.755n 1.0v 129.745n 1.0v 129.755n 1.0v 134.745n 1.0v 134.755n 0.0v 139.745n 0.0v 139.755n 0.0v 144.745n 0.0v 144.755n 1.0v 149.745n 1.0v 149.755n 0.0v 154.745n 0.0v 154.755n 0.0v 159.745n 0.0v 159.755n 0.0v 164.745n 0.0v 164.755n 1.0v 169.745n 1.0v 169.755n 1.0v 174.745n 1.0v 174.755n 1.0v 179.745n 1.0v 179.755n 1.0v 184.745n 1.0v 184.755n 1.0v 189.745n 1.0v 189.755n 1.0v 194.745n 1.0v 194.755n 1.0v 199.745n 1.0v 199.755n 1.0v 204.745n 1.0v 204.755n 0.0v 209.745n 0.0v 209.755n 1.0v 214.745n 1.0v 214.755n 1.0v 219.745n 1.0v 219.755n 0.0v 224.745n 0.0v 224.755n 1.0v 229.745n 1.0v 229.755n 0.0v 234.745n 0.0v 234.755n 0.0v 239.745n 0.0v 239.755n 0.0v 244.745n 0.0v 244.755n 1.0v 249.745n 1.0v 249.755n 1.0v 254.745n 1.0v 254.755n 1.0v 259.745n 1.0v 259.755n 1.0v 264.745n 1.0v 264.755n 1.0v 269.745n 1.0v 269.755n 1.0v 274.745n 1.0v 274.755n 0.0v 279.745n 0.0v 279.755n 1.0v 284.745n 1.0v 284.755n 1.0v 289.745n 1.0v 289.755n 1.0v 294.745n 1.0v 294.755n 1.0v 299.745n 1.0v 299.755n 0.0v 304.745n 0.0v 304.755n 1.0v 309.745n 1.0v 309.755n 1.0v 314.745n 1.0v 314.755n 0.0v 319.745n 0.0v 319.755n 1.0v 324.745n 1.0v 324.755n 1.0v 329.745n 1.0v 329.755n 1.0v 334.745n 1.0v 334.755n 1.0v 339.745n 1.0v 339.755n 1.0v 344.745n 1.0v 344.755n 0.0v 349.745n 0.0v 349.755n 1.0v 354.745n 1.0v 354.755n 0.0v 359.745n 0.0v 359.755n 1.0v 364.745n 1.0v 364.755n 1.0v 369.745n 1.0v 369.755n 0.0v 374.745n 0.0v 374.755n 1.0v 379.745n 1.0v 379.755n 1.0v 384.745n 1.0v 384.755n 1.0v 389.745n 1.0v 389.755n 0.0v 394.745n 0.0v 394.755n 0.0v 399.745n 0.0v 399.755n 0.0v 404.745n 0.0v 404.755n 1.0v 409.745n 1.0v 409.755n 0.0v 414.745n 0.0v 414.755n 0.0v 419.745n 0.0v 419.755n 0.0v 424.745n 0.0v 424.755n 1.0v 429.745n 1.0v 429.755n 0.0v 434.745n 0.0v 434.755n 0.0v 439.745n 0.0v 439.755n 1.0v 444.745n 1.0v 444.755n 1.0v 449.745n 1.0v 449.755n 0.0v 454.745n 0.0v 454.755n 0.0v 459.745n 0.0v 459.755n 0.0v 464.745n 0.0v 464.755n 0.0v 469.745n 0.0v 469.755n 0.0v 474.745n 0.0v 474.755n 0.0v 479.745n 0.0v 479.755n 0.0v 484.745n 0.0v 484.755n 1.0v 489.745n 1.0v 489.755n 1.0v 494.745n 1.0v 494.755n 0.0v 499.745n 0.0v 499.755n 0.0v 504.745n 0.0v 504.755n 0.0v 509.745n 0.0v 509.755n 0.0v 514.745n 0.0v 514.755n 1.0v 519.745n 1.0v 519.755n 0.0v 524.745n 0.0v 524.755n 0.0v 529.745n 0.0v 529.755n 1.0v 534.745n 1.0v 534.755n 0.0v 539.745n 0.0v 539.755n 0.0v 544.745n 0.0v 544.755n 0.0v 549.745n 0.0v 549.755n 1.0v 554.745n 1.0v 554.755n 0.0v 559.745n 0.0v 559.755n 0.0v 564.745n 0.0v 564.755n 0.0v 569.745n 0.0v 569.755n 0.0v 574.745n 0.0v 574.755n 0.0v 579.745n 0.0v 579.755n 1.0v 584.745n 1.0v 584.755n 1.0v 589.745n 1.0v 589.755n 1.0v 594.745n 1.0v 594.755n 0.0v 599.745n 0.0v 599.755n 1.0v 604.745n 1.0v 604.755n 1.0v 609.745n 1.0v 609.755n 1.0v 614.745n 1.0v 614.755n 1.0v 619.745n 1.0v 619.755n 1.0v 624.745n 1.0v 624.755n 1.0v 629.745n 1.0v 629.755n 1.0v 634.745n 1.0v 634.755n 1.0v 639.745n 1.0v 639.755n 1.0v 644.745n 1.0v 644.755n 0.0v 649.745n 0.0v 649.755n 1.0v 654.745n 1.0v 654.755n 0.0v 659.745n 0.0v 659.755n 1.0v 664.745n 1.0v 664.755n 1.0v 669.745n 1.0v 669.755n 1.0v 674.745n 1.0v 674.755n 1.0v 679.745n 1.0v 679.755n 1.0v 684.745n 1.0v 684.755n 0.0v 689.745n 0.0v 689.755n 1.0v 694.745n 1.0v 694.755n 1.0v 699.745n 1.0v 699.755n 1.0v 704.745n 1.0v 704.755n 1.0v 709.745n 1.0v 709.755n 1.0v 714.745n 1.0v 714.755n 1.0v 719.745n 1.0v 719.755n 1.0v 724.745n 1.0v 724.755n 0.0v 729.745n 0.0v 729.755n 0.0v 734.745n 0.0v 734.755n 0.0v 739.745n 0.0v 739.755n 0.0v 744.745n 0.0v 744.755n 0.0v 749.745n 0.0v 749.755n 0.0v 754.745n 0.0v 754.755n 1.0v 759.745n 1.0v 759.755n 1.0v 764.745n 1.0v 764.755n 1.0v 769.745n 1.0v 769.755n 1.0v 774.745n 1.0v 774.755n 1.0v 779.745n 1.0v 779.755n 0.0v 784.745n 0.0v 784.755n 0.0v 789.745n 0.0v 789.755n 0.0v 794.745n 0.0v 794.755n 0.0v 799.745n 0.0v 799.755n 1.0v 804.745n 1.0v 804.755n 0.0v 809.745n 0.0v 809.755n 0.0v 814.745n 0.0v 814.755n 0.0v 819.745n 0.0v 819.755n 0.0v 824.745n 0.0v 824.755n 0.0v 829.745n 0.0v 829.755n 1.0v 834.745n 1.0v 834.755n 1.0v 839.745n 1.0v 839.755n 0.0v 844.745n 0.0v 844.755n 0.0v 849.745n 0.0v 849.755n 1.0v 854.745n 1.0v 854.755n 1.0v 859.745n 1.0v 859.755n 1.0v 864.745n 1.0v 864.755n 0.0v 869.745n 0.0v 869.755n 0.0v 874.745n 0.0v 874.755n 1.0v 879.745n 1.0v 879.755n 0.0v 884.745n 0.0v 884.755n 0.0v 889.745n 0.0v 889.755n 0.0v 894.745n 0.0v 894.755n 0.0v 899.745n 0.0v 899.755n 1.0v 904.745n 1.0v 904.755n 1.0v 909.745n 1.0v 909.755n 1.0v 914.745n 1.0v 914.755n 0.0v 919.745n 0.0v 919.755n 1.0v 924.745n 1.0v 924.755n 1.0v 929.745n 1.0v 929.755n 0.0v 934.745n 0.0v 934.755n 0.0v 939.745n 0.0v 939.755n 0.0v 944.745n 0.0v 944.755n 0.0v 949.745n 0.0v 949.755n 0.0v 954.745n 0.0v 954.755n 0.0v 959.745n 0.0v 959.755n 0.0v 964.745n 0.0v 964.755n 1.0v 969.745n 1.0v 969.755n 1.0v 974.745n 1.0v 974.755n 1.0v 979.745n 1.0v 979.755n 0.0v 984.745n 0.0v 984.755n 1.0v 989.745n 1.0v 989.755n 1.0v 994.745n 1.0v 994.755n 1.0v 999.745n 1.0v 999.755n 1.0v 1004.745n 1.0v 1004.755n 0.0v 1009.745n 0.0v 1009.755n 0.0v 1014.745n 0.0v 1014.755n 0.0v 1019.745n 0.0v 1019.755n 0.0v 1024.745n 0.0v 1024.755n 0.0v )
* (time, data): [(0, 0), (5, 0), (10, 0), (15, 0), (20, 0), (25, 0), (30, 0), (35, 0), (40, 0), (45, 0), (50, 1), (55, 1), (60, 0), (65, 0), (70, 0), (75, 0), (80, 1), (85, 0), (90, 1), (95, 1), (100, 0), (105, 0), (110, 0), (115, 1), (120, 1), (125, 1), (130, 0), (135, 0), (140, 0), (145, 1), (150, 0), (155, 0), (160, 1), (165, 1), (170, 1), (175, 1), (180, 0), (185, 0), (190, 0), (195, 0), (200, 0), (205, 1), (210, 1), (215, 1), (220, 0), (225, 0), (230, 0), (235, 0), (240, 0), (245, 1), (250, 0), (255, 0), (260, 0), (265, 0), (270, 1), (275, 0), (280, 0), (285, 0), (290, 0), (295, 1), (300, 1), (305, 1), (310, 0), (315, 0), (320, 1), (325, 1), (330, 0), (335, 1), (340, 1), (345, 0), (350, 0), (355, 0), (360, 1), (365, 0), (370, 1), (375, 1), (380, 1), (385, 1), (390, 0), (395, 1), (400, 1), (405, 1), (410, 1), (415, 1), (420, 1), (425, 1), (430, 0), (435, 0), (440, 1), (445, 0), (450, 0), (455, 0), (460, 0), (465, 0), (470, 1), (475, 0), (480, 0), (485, 1), (490, 0), (495, 0), (500, 0), (505, 0), (510, 0), (515, 1), (520, 1), (525, 1), (530, 0), (535, 1), (540, 1), (545, 1), (550, 0), (555, 0), (560, 0), (565, 0), (570, 0), (575, 1), (580, 1), (585, 1), (590, 1), (595, 1), (600, 0), (605, 0), (610, 1), (615, 1), (620, 1), (625, 0), (630, 1), (635, 1), (640, 1), (645, 0), (650, 1), (655, 0), (660, 1), (665, 1), (670, 0), (675, 0), (680, 0), (685, 0), (690, 0), (695, 0), (700, 1), (705, 1), (710, 0), (715, 1), (720, 1), (725, 1), (730, 1), (735, 1), (740, 1), (745, 1), (750, 1), (755, 0), (760, 0), (765, 0), (770, 0), (775, 1), (780, 0), (785, 1), (790, 1), (795, 1), (800, 1), (805, 0), (810, 1), (815, 1), (820, 1), (825, 0), (830, 1), (835, 0), (840, 0), (845, 0), (850, 1), (855, 1), (860, 1), (865, 1), (870, 1), (875, 1), (880, 1), (885, 0), (890, 0), (895, 0), (900, 0), (905, 0), (910, 1), (915, 0), (920, 0), (925, 0), (930, 0), (935, 1), (940, 1), (945, 0), (950, 0), (955, 1), (960, 1), (965, 1), (970, 1), (975, 0), (980, 0), (985, 0), (990, 0), (995, 0), (1000, 0), (1005, 0), (1010, 0), (1015, 1), (1020, 1), (1025, 1)]
Va1_1  a1_1  0 PWL (0n 0.0v 4.745n 0.0v 4.755n 0.0v 9.745n 0.0v 9.755n 0.0v 14.745n 0.0v 14.755n 0.0v 19.745n 0.0v 19.755n 0.0v 24.745n 0.0v 24.755n 0.0v 29.745n 0.0v 29.755n 0.0v 34.745n 0.0v 34.755n 0.0v 39.745n 0.0v 39.755n 0.0v 44.745n 0.0v 44.755n 0.0v 49.745n 0.0v 49.755n 1.0v 54.745n 1.0v 54.755n 1.0v 59.745n 1.0v 59.755n 0.0v 64.745n 0.0v 64.755n 0.0v 69.745n 0.0v 69.755n 0.0v 74.745n 0.0v 74.755n 0.0v 79.745n 0.0v 79.755n 1.0v 84.745n 1.0v 84.755n 0.0v 89.745n 0.0v 89.755n 1.0v 94.745n 1.0v 94.755n 1.0v 99.745n 1.0v 99.755n 0.0v 104.745n 0.0v 104.755n 0.0v 109.745n 0.0v 109.755n 0.0v 114.745n 0.0v 114.755n 1.0v 119.745n 1.0v 119.755n 1.0v 124.745n 1.0v 124.755n 1.0v 129.745n 1.0v 129.755n 0.0v 134.745n 0.0v 134.755n 0.0v 139.745n 0.0v 139.755n 0.0v 144.745n 0.0v 144.755n 1.0v 149.745n 1.0v 149.755n 0.0v 154.745n 0.0v 154.755n 0.0v 159.745n 0.0v 159.755n 1.0v 164.745n 1.0v 164.755n 1.0v 169.745n 1.0v 169.755n 1.0v 174.745n 1.0v 174.755n 1.0v 179.745n 1.0v 179.755n 0.0v 184.745n 0.0v 184.755n 0.0v 189.745n 0.0v 189.755n 0.0v 194.745n 0.0v 194.755n 0.0v 199.745n 0.0v 199.755n 0.0v 204.745n 0.0v 204.755n 1.0v 209.745n 1.0v 209.755n 1.0v 214.745n 1.0v 214.755n 1.0v 219.745n 1.0v 219.755n 0.0v 224.745n 0.0v 224.755n 0.0v 229.745n 0.0v 229.755n 0.0v 234.745n 0.0v 234.755n 0.0v 239.745n 0.0v 239.755n 0.0v 244.745n 0.0v 244.755n 1.0v 249.745n 1.0v 249.755n 0.0v 254.745n 0.0v 254.755n 0.0v 259.745n 0.0v 259.755n 0.0v 264.745n 0.0v 264.755n 0.0v 269.745n 0.0v 269.755n 1.0v 274.745n 1.0v 274.755n 0.0v 279.745n 0.0v 279.755n 0.0v 284.745n 0.0v 284.755n 0.0v 289.745n 0.0v 289.755n 0.0v 294.745n 0.0v 294.755n 1.0v 299.745n 1.0v 299.755n 1.0v 304.745n 1.0v 304.755n 1.0v 309.745n 1.0v 309.755n 0.0v 314.745n 0.0v 314.755n 0.0v 319.745n 0.0v 319.755n 1.0v 324.745n 1.0v 324.755n 1.0v 329.745n 1.0v 329.755n 0.0v 334.745n 0.0v 334.755n 1.0v 339.745n 1.0v 339.755n 1.0v 344.745n 1.0v 344.755n 0.0v 349.745n 0.0v 349.755n 0.0v 354.745n 0.0v 354.755n 0.0v 359.745n 0.0v 359.755n 1.0v 364.745n 1.0v 364.755n 0.0v 369.745n 0.0v 369.755n 1.0v 374.745n 1.0v 374.755n 1.0v 379.745n 1.0v 379.755n 1.0v 384.745n 1.0v 384.755n 1.0v 389.745n 1.0v 389.755n 0.0v 394.745n 0.0v 394.755n 1.0v 399.745n 1.0v 399.755n 1.0v 404.745n 1.0v 404.755n 1.0v 409.745n 1.0v 409.755n 1.0v 414.745n 1.0v 414.755n 1.0v 419.745n 1.0v 419.755n 1.0v 424.745n 1.0v 424.755n 1.0v 429.745n 1.0v 429.755n 0.0v 434.745n 0.0v 434.755n 0.0v 439.745n 0.0v 439.755n 1.0v 444.745n 1.0v 444.755n 0.0v 449.745n 0.0v 449.755n 0.0v 454.745n 0.0v 454.755n 0.0v 459.745n 0.0v 459.755n 0.0v 464.745n 0.0v 464.755n 0.0v 469.745n 0.0v 469.755n 1.0v 474.745n 1.0v 474.755n 0.0v 479.745n 0.0v 479.755n 0.0v 484.745n 0.0v 484.755n 1.0v 489.745n 1.0v 489.755n 0.0v 494.745n 0.0v 494.755n 0.0v 499.745n 0.0v 499.755n 0.0v 504.745n 0.0v 504.755n 0.0v 509.745n 0.0v 509.755n 0.0v 514.745n 0.0v 514.755n 1.0v 519.745n 1.0v 519.755n 1.0v 524.745n 1.0v 524.755n 1.0v 529.745n 1.0v 529.755n 0.0v 534.745n 0.0v 534.755n 1.0v 539.745n 1.0v 539.755n 1.0v 544.745n 1.0v 544.755n 1.0v 549.745n 1.0v 549.755n 0.0v 554.745n 0.0v 554.755n 0.0v 559.745n 0.0v 559.755n 0.0v 564.745n 0.0v 564.755n 0.0v 569.745n 0.0v 569.755n 0.0v 574.745n 0.0v 574.755n 1.0v 579.745n 1.0v 579.755n 1.0v 584.745n 1.0v 584.755n 1.0v 589.745n 1.0v 589.755n 1.0v 594.745n 1.0v 594.755n 1.0v 599.745n 1.0v 599.755n 0.0v 604.745n 0.0v 604.755n 0.0v 609.745n 0.0v 609.755n 1.0v 614.745n 1.0v 614.755n 1.0v 619.745n 1.0v 619.755n 1.0v 624.745n 1.0v 624.755n 0.0v 629.745n 0.0v 629.755n 1.0v 634.745n 1.0v 634.755n 1.0v 639.745n 1.0v 639.755n 1.0v 644.745n 1.0v 644.755n 0.0v 649.745n 0.0v 649.755n 1.0v 654.745n 1.0v 654.755n 0.0v 659.745n 0.0v 659.755n 1.0v 664.745n 1.0v 664.755n 1.0v 669.745n 1.0v 669.755n 0.0v 674.745n 0.0v 674.755n 0.0v 679.745n 0.0v 679.755n 0.0v 684.745n 0.0v 684.755n 0.0v 689.745n 0.0v 689.755n 0.0v 694.745n 0.0v 694.755n 0.0v 699.745n 0.0v 699.755n 1.0v 704.745n 1.0v 704.755n 1.0v 709.745n 1.0v 709.755n 0.0v 714.745n 0.0v 714.755n 1.0v 719.745n 1.0v 719.755n 1.0v 724.745n 1.0v 724.755n 1.0v 729.745n 1.0v 729.755n 1.0v 734.745n 1.0v 734.755n 1.0v 739.745n 1.0v 739.755n 1.0v 744.745n 1.0v 744.755n 1.0v 749.745n 1.0v 749.755n 1.0v 754.745n 1.0v 754.755n 0.0v 759.745n 0.0v 759.755n 0.0v 764.745n 0.0v 764.755n 0.0v 769.745n 0.0v 769.755n 0.0v 774.745n 0.0v 774.755n 1.0v 779.745n 1.0v 779.755n 0.0v 784.745n 0.0v 784.755n 1.0v 789.745n 1.0v 789.755n 1.0v 794.745n 1.0v 794.755n 1.0v 799.745n 1.0v 799.755n 1.0v 804.745n 1.0v 804.755n 0.0v 809.745n 0.0v 809.755n 1.0v 814.745n 1.0v 814.755n 1.0v 819.745n 1.0v 819.755n 1.0v 824.745n 1.0v 824.755n 0.0v 829.745n 0.0v 829.755n 1.0v 834.745n 1.0v 834.755n 0.0v 839.745n 0.0v 839.755n 0.0v 844.745n 0.0v 844.755n 0.0v 849.745n 0.0v 849.755n 1.0v 854.745n 1.0v 854.755n 1.0v 859.745n 1.0v 859.755n 1.0v 864.745n 1.0v 864.755n 1.0v 869.745n 1.0v 869.755n 1.0v 874.745n 1.0v 874.755n 1.0v 879.745n 1.0v 879.755n 1.0v 884.745n 1.0v 884.755n 0.0v 889.745n 0.0v 889.755n 0.0v 894.745n 0.0v 894.755n 0.0v 899.745n 0.0v 899.755n 0.0v 904.745n 0.0v 904.755n 0.0v 909.745n 0.0v 909.755n 1.0v 914.745n 1.0v 914.755n 0.0v 919.745n 0.0v 919.755n 0.0v 924.745n 0.0v 924.755n 0.0v 929.745n 0.0v 929.755n 0.0v 934.745n 0.0v 934.755n 1.0v 939.745n 1.0v 939.755n 1.0v 944.745n 1.0v 944.755n 0.0v 949.745n 0.0v 949.755n 0.0v 954.745n 0.0v 954.755n 1.0v 959.745n 1.0v 959.755n 1.0v 964.745n 1.0v 964.755n 1.0v 969.745n 1.0v 969.755n 1.0v 974.745n 1.0v 974.755n 0.0v 979.745n 0.0v 979.755n 0.0v 984.745n 0.0v 984.755n 0.0v 989.745n 0.0v 989.755n 0.0v 994.745n 0.0v 994.755n 0.0v 999.745n 0.0v 999.755n 0.0v 1004.745n 0.0v 1004.755n 0.0v 1009.745n 0.0v 1009.755n 0.0v 1014.745n 0.0v 1014.755n 1.0v 1019.745n 1.0v 1019.755n 1.0v 1024.745n 1.0v 1024.755n 1.0v )
* (time, data): [(0, 0), (5, 1), (10, 0), (15, 0), (20, 1), (25, 1), (30, 1), (35, 0), (40, 0), (45, 1), (50, 0), (55, 0), (60, 0), (65, 0), (70, 0), (75, 1), (80, 0), (85, 0), (90, 1), (95, 0), (100, 0), (105, 0), (110, 0), (115, 0), (120, 0), (125, 0), (130, 0), (135, 1), (140, 1), (145, 0), (150, 0), (155, 0), (160, 1), (165, 0), (170, 0), (175, 0), (180, 0), (185, 1), (190, 1), (195, 1), (200, 1), (205, 1), (210, 0), (215, 0), (220, 1), (225, 1), (230, 1), (235, 1), (240, 0), (245, 0), (250, 0), (255, 1), (260, 0), (265, 0), (270, 0), (275, 1), (280, 0), (285, 1), (290, 1), (295, 0), (300, 0), (305, 0), (310, 1), (315, 0), (320, 0), (325, 0), (330, 0), (335, 0), (340, 0), (345, 1), (350, 0), (355, 0), (360, 0), (365, 0), (370, 0), (375, 0), (380, 0), (385, 0), (390, 0), (395, 1), (400, 0), (405, 0), (410, 1), (415, 1), (420, 1), (425, 0), (430, 0), (435, 0), (440, 0), (445, 0), (450, 1), (455, 1), (460, 1), (465, 1), (470, 0), (475, 1), (480, 1), (485, 0), (490, 1), (495, 1), (500, 0), (505, 0), (510, 0), (515, 0), (520, 1), (525, 1), (530, 0), (535, 0), (540, 1), (545, 1), (550, 1), (555, 1), (560, 1), (565, 0), (570, 0), (575, 1), (580, 0), (585, 0), (590, 0), (595, 1), (600, 0), (605, 0), (610, 0), (615, 0), (620, 0), (625, 0), (630, 0), (635, 0), (640, 0), (645, 1), (650, 0), (655, 0), (660, 0), (665, 0), (670, 1), (675, 1), (680, 1), (685, 1), (690, 1), (695, 1), (700, 0), (705, 0), (710, 0), (715, 0), (720, 0), (725, 1), (730, 1), (735, 1), (740, 1), (745, 0), (750, 0), (755, 0), (760, 0), (765, 0), (770, 0), (775, 0), (780, 0), (785, 0), (790, 0), (795, 0), (800, 0), (805, 0), (810, 0), (815, 0), (820, 0), (825, 0), (830, 0), (835, 0), (840, 0), (845, 1), (850, 0), (855, 0), (860, 0), (865, 1), (870, 0), (875, 0), (880, 1), (885, 0), (890, 0), (895, 0), (900, 1), (905, 1), (910, 0), (915, 1), (920, 0), (925, 0), (930, 1), (935, 0), (940, 1), (945, 1), (950, 1), (955, 1), (960, 1), (965, 0), (970, 0), (975, 0), (980, 1), (985, 0), (990, 0), (995, 0), (1000, 0), (1005, 0), (1010, 0), (1015, 1), (1020, 1), (1025, 1)]
Va1_2  a1_2  0 PWL (0n 0.0v 4.745n 0.0v 4.755n 1.0v 9.745n 1.0v 9.755n 0.0v 14.745n 0.0v 14.755n 0.0v 19.745n 0.0v 19.755n 1.0v 24.745n 1.0v 24.755n 1.0v 29.745n 1.0v 29.755n 1.0v 34.745n 1.0v 34.755n 0.0v 39.745n 0.0v 39.755n 0.0v 44.745n 0.0v 44.755n 1.0v 49.745n 1.0v 49.755n 0.0v 54.745n 0.0v 54.755n 0.0v 59.745n 0.0v 59.755n 0.0v 64.745n 0.0v 64.755n 0.0v 69.745n 0.0v 69.755n 0.0v 74.745n 0.0v 74.755n 1.0v 79.745n 1.0v 79.755n 0.0v 84.745n 0.0v 84.755n 0.0v 89.745n 0.0v 89.755n 1.0v 94.745n 1.0v 94.755n 0.0v 99.745n 0.0v 99.755n 0.0v 104.745n 0.0v 104.755n 0.0v 109.745n 0.0v 109.755n 0.0v 114.745n 0.0v 114.755n 0.0v 119.745n 0.0v 119.755n 0.0v 124.745n 0.0v 124.755n 0.0v 129.745n 0.0v 129.755n 0.0v 134.745n 0.0v 134.755n 1.0v 139.745n 1.0v 139.755n 1.0v 144.745n 1.0v 144.755n 0.0v 149.745n 0.0v 149.755n 0.0v 154.745n 0.0v 154.755n 0.0v 159.745n 0.0v 159.755n 1.0v 164.745n 1.0v 164.755n 0.0v 169.745n 0.0v 169.755n 0.0v 174.745n 0.0v 174.755n 0.0v 179.745n 0.0v 179.755n 0.0v 184.745n 0.0v 184.755n 1.0v 189.745n 1.0v 189.755n 1.0v 194.745n 1.0v 194.755n 1.0v 199.745n 1.0v 199.755n 1.0v 204.745n 1.0v 204.755n 1.0v 209.745n 1.0v 209.755n 0.0v 214.745n 0.0v 214.755n 0.0v 219.745n 0.0v 219.755n 1.0v 224.745n 1.0v 224.755n 1.0v 229.745n 1.0v 229.755n 1.0v 234.745n 1.0v 234.755n 1.0v 239.745n 1.0v 239.755n 0.0v 244.745n 0.0v 244.755n 0.0v 249.745n 0.0v 249.755n 0.0v 254.745n 0.0v 254.755n 1.0v 259.745n 1.0v 259.755n 0.0v 264.745n 0.0v 264.755n 0.0v 269.745n 0.0v 269.755n 0.0v 274.745n 0.0v 274.755n 1.0v 279.745n 1.0v 279.755n 0.0v 284.745n 0.0v 284.755n 1.0v 289.745n 1.0v 289.755n 1.0v 294.745n 1.0v 294.755n 0.0v 299.745n 0.0v 299.755n 0.0v 304.745n 0.0v 304.755n 0.0v 309.745n 0.0v 309.755n 1.0v 314.745n 1.0v 314.755n 0.0v 319.745n 0.0v 319.755n 0.0v 324.745n 0.0v 324.755n 0.0v 329.745n 0.0v 329.755n 0.0v 334.745n 0.0v 334.755n 0.0v 339.745n 0.0v 339.755n 0.0v 344.745n 0.0v 344.755n 1.0v 349.745n 1.0v 349.755n 0.0v 354.745n 0.0v 354.755n 0.0v 359.745n 0.0v 359.755n 0.0v 364.745n 0.0v 364.755n 0.0v 369.745n 0.0v 369.755n 0.0v 374.745n 0.0v 374.755n 0.0v 379.745n 0.0v 379.755n 0.0v 384.745n 0.0v 384.755n 0.0v 389.745n 0.0v 389.755n 0.0v 394.745n 0.0v 394.755n 1.0v 399.745n 1.0v 399.755n 0.0v 404.745n 0.0v 404.755n 0.0v 409.745n 0.0v 409.755n 1.0v 414.745n 1.0v 414.755n 1.0v 419.745n 1.0v 419.755n 1.0v 424.745n 1.0v 424.755n 0.0v 429.745n 0.0v 429.755n 0.0v 434.745n 0.0v 434.755n 0.0v 439.745n 0.0v 439.755n 0.0v 444.745n 0.0v 444.755n 0.0v 449.745n 0.0v 449.755n 1.0v 454.745n 1.0v 454.755n 1.0v 459.745n 1.0v 459.755n 1.0v 464.745n 1.0v 464.755n 1.0v 469.745n 1.0v 469.755n 0.0v 474.745n 0.0v 474.755n 1.0v 479.745n 1.0v 479.755n 1.0v 484.745n 1.0v 484.755n 0.0v 489.745n 0.0v 489.755n 1.0v 494.745n 1.0v 494.755n 1.0v 499.745n 1.0v 499.755n 0.0v 504.745n 0.0v 504.755n 0.0v 509.745n 0.0v 509.755n 0.0v 514.745n 0.0v 514.755n 0.0v 519.745n 0.0v 519.755n 1.0v 524.745n 1.0v 524.755n 1.0v 529.745n 1.0v 529.755n 0.0v 534.745n 0.0v 534.755n 0.0v 539.745n 0.0v 539.755n 1.0v 544.745n 1.0v 544.755n 1.0v 549.745n 1.0v 549.755n 1.0v 554.745n 1.0v 554.755n 1.0v 559.745n 1.0v 559.755n 1.0v 564.745n 1.0v 564.755n 0.0v 569.745n 0.0v 569.755n 0.0v 574.745n 0.0v 574.755n 1.0v 579.745n 1.0v 579.755n 0.0v 584.745n 0.0v 584.755n 0.0v 589.745n 0.0v 589.755n 0.0v 594.745n 0.0v 594.755n 1.0v 599.745n 1.0v 599.755n 0.0v 604.745n 0.0v 604.755n 0.0v 609.745n 0.0v 609.755n 0.0v 614.745n 0.0v 614.755n 0.0v 619.745n 0.0v 619.755n 0.0v 624.745n 0.0v 624.755n 0.0v 629.745n 0.0v 629.755n 0.0v 634.745n 0.0v 634.755n 0.0v 639.745n 0.0v 639.755n 0.0v 644.745n 0.0v 644.755n 1.0v 649.745n 1.0v 649.755n 0.0v 654.745n 0.0v 654.755n 0.0v 659.745n 0.0v 659.755n 0.0v 664.745n 0.0v 664.755n 0.0v 669.745n 0.0v 669.755n 1.0v 674.745n 1.0v 674.755n 1.0v 679.745n 1.0v 679.755n 1.0v 684.745n 1.0v 684.755n 1.0v 689.745n 1.0v 689.755n 1.0v 694.745n 1.0v 694.755n 1.0v 699.745n 1.0v 699.755n 0.0v 704.745n 0.0v 704.755n 0.0v 709.745n 0.0v 709.755n 0.0v 714.745n 0.0v 714.755n 0.0v 719.745n 0.0v 719.755n 0.0v 724.745n 0.0v 724.755n 1.0v 729.745n 1.0v 729.755n 1.0v 734.745n 1.0v 734.755n 1.0v 739.745n 1.0v 739.755n 1.0v 744.745n 1.0v 744.755n 0.0v 749.745n 0.0v 749.755n 0.0v 754.745n 0.0v 754.755n 0.0v 759.745n 0.0v 759.755n 0.0v 764.745n 0.0v 764.755n 0.0v 769.745n 0.0v 769.755n 0.0v 774.745n 0.0v 774.755n 0.0v 779.745n 0.0v 779.755n 0.0v 784.745n 0.0v 784.755n 0.0v 789.745n 0.0v 789.755n 0.0v 794.745n 0.0v 794.755n 0.0v 799.745n 0.0v 799.755n 0.0v 804.745n 0.0v 804.755n 0.0v 809.745n 0.0v 809.755n 0.0v 814.745n 0.0v 814.755n 0.0v 819.745n 0.0v 819.755n 0.0v 824.745n 0.0v 824.755n 0.0v 829.745n 0.0v 829.755n 0.0v 834.745n 0.0v 834.755n 0.0v 839.745n 0.0v 839.755n 0.0v 844.745n 0.0v 844.755n 1.0v 849.745n 1.0v 849.755n 0.0v 854.745n 0.0v 854.755n 0.0v 859.745n 0.0v 859.755n 0.0v 864.745n 0.0v 864.755n 1.0v 869.745n 1.0v 869.755n 0.0v 874.745n 0.0v 874.755n 0.0v 879.745n 0.0v 879.755n 1.0v 884.745n 1.0v 884.755n 0.0v 889.745n 0.0v 889.755n 0.0v 894.745n 0.0v 894.755n 0.0v 899.745n 0.0v 899.755n 1.0v 904.745n 1.0v 904.755n 1.0v 909.745n 1.0v 909.755n 0.0v 914.745n 0.0v 914.755n 1.0v 919.745n 1.0v 919.755n 0.0v 924.745n 0.0v 924.755n 0.0v 929.745n 0.0v 929.755n 1.0v 934.745n 1.0v 934.755n 0.0v 939.745n 0.0v 939.755n 1.0v 944.745n 1.0v 944.755n 1.0v 949.745n 1.0v 949.755n 1.0v 954.745n 1.0v 954.755n 1.0v 959.745n 1.0v 959.755n 1.0v 964.745n 1.0v 964.755n 0.0v 969.745n 0.0v 969.755n 0.0v 974.745n 0.0v 974.755n 0.0v 979.745n 0.0v 979.755n 1.0v 984.745n 1.0v 984.755n 0.0v 989.745n 0.0v 989.755n 0.0v 994.745n 0.0v 994.755n 0.0v 999.745n 0.0v 999.755n 0.0v 1004.745n 0.0v 1004.755n 0.0v 1009.745n 0.0v 1009.755n 0.0v 1014.745n 0.0v 1014.755n 1.0v 1019.745n 1.0v 1019.755n 1.0v 1024.745n 1.0v 1024.755n 1.0v )
* (time, data): [(0, 0), (5, 1), (10, 0), (15, 0), (20, 1), (25, 1), (30, 1), (35, 0), (40, 0), (45, 1), (50, 0), (55, 0), (60, 0), (65, 0), (70, 0), (75, 1), (80, 0), (85, 0), (90, 1), (95, 0), (100, 0), (105, 0), (110, 0), (115, 0), (120, 0), (125, 1), (130, 0), (135, 1), (140, 1), (145, 1), (150, 0), (155, 0), (160, 1), (165, 0), (170, 0), (175, 0), (180, 0), (185, 1), (190, 1), (195, 1), (200, 1), (205, 1), (210, 0), (215, 0), (220, 1), (225, 1), (230, 1), (235, 1), (240, 0), (245, 0), (250, 0), (255, 1), (260, 0), (265, 0), (270, 1), (275, 1), (280, 0), (285, 1), (290, 1), (295, 1), (300, 0), (305, 0), (310, 1), (315, 0), (320, 0), (325, 0), (330, 0), (335, 1), (340, 1), (345, 1), (350, 0), (355, 0), (360, 0), (365, 0), (370, 0), (375, 1), (380, 1), (385, 1), (390, 0), (395, 1), (400, 0), (405, 0), (410, 1), (415, 1), (420, 1), (425, 1), (430, 0), (435, 0), (440, 0), (445, 0), (450, 1), (455, 1), (460, 1), (465, 1), (470, 0), (475, 1), (480, 1), (485, 0), (490, 1), (495, 1), (500, 0), (505, 0), (510, 0), (515, 0), (520, 1), (525, 1), (530, 0), (535, 0), (540, 1), (545, 1), (550, 1), (555, 1), (560, 1), (565, 0), (570, 0), (575, 1), (580, 0), (585, 0), (590, 0), (595, 1), (600, 0), (605, 0), (610, 1), (615, 1), (620, 1), (625, 0), (630, 1), (635, 1), (640, 1), (645, 1), (650, 1), (655, 0), (660, 1), (665, 0), (670, 1), (675, 1), (680, 1), (685, 1), (690, 1), (695, 1), (700, 0), (705, 0), (710, 0), (715, 0), (720, 0), (725, 1), (730, 1), (735, 1), (740, 1), (745, 0), (750, 0), (755, 0), (760, 0), (765, 0), (770, 0), (775, 1), (780, 0), (785, 0), (790, 0), (795, 0), (800, 1), (805, 0), (810, 0), (815, 0), (820, 0), (825, 0), (830, 0), (835, 0), (840, 0), (845, 1), (850, 1), (855, 1), (860, 1), (865, 1), (870, 0), (875, 1), (880, 1), (885, 0), (890, 0), (895, 0), (900, 1), (905, 1), (910, 0), (915, 1), (920, 0), (925, 0), (930, 1), (935, 0), (940, 1), (945, 1), (950, 1), (955, 1), (960, 1), (965, 1), (970, 1), (975, 0), (980, 1), (985, 0), (990, 0), (995, 0), (1000, 0), (1005, 0), (1010, 0), (1015, 1), (1020, 1), (1025, 1)]
Va1_3  a1_3  0 PWL (0n 0.0v 4.745n 0.0v 4.755n 1.0v 9.745n 1.0v 9.755n 0.0v 14.745n 0.0v 14.755n 0.0v 19.745n 0.0v 19.755n 1.0v 24.745n 1.0v 24.755n 1.0v 29.745n 1.0v 29.755n 1.0v 34.745n 1.0v 34.755n 0.0v 39.745n 0.0v 39.755n 0.0v 44.745n 0.0v 44.755n 1.0v 49.745n 1.0v 49.755n 0.0v 54.745n 0.0v 54.755n 0.0v 59.745n 0.0v 59.755n 0.0v 64.745n 0.0v 64.755n 0.0v 69.745n 0.0v 69.755n 0.0v 74.745n 0.0v 74.755n 1.0v 79.745n 1.0v 79.755n 0.0v 84.745n 0.0v 84.755n 0.0v 89.745n 0.0v 89.755n 1.0v 94.745n 1.0v 94.755n 0.0v 99.745n 0.0v 99.755n 0.0v 104.745n 0.0v 104.755n 0.0v 109.745n 0.0v 109.755n 0.0v 114.745n 0.0v 114.755n 0.0v 119.745n 0.0v 119.755n 0.0v 124.745n 0.0v 124.755n 1.0v 129.745n 1.0v 129.755n 0.0v 134.745n 0.0v 134.755n 1.0v 139.745n 1.0v 139.755n 1.0v 144.745n 1.0v 144.755n 1.0v 149.745n 1.0v 149.755n 0.0v 154.745n 0.0v 154.755n 0.0v 159.745n 0.0v 159.755n 1.0v 164.745n 1.0v 164.755n 0.0v 169.745n 0.0v 169.755n 0.0v 174.745n 0.0v 174.755n 0.0v 179.745n 0.0v 179.755n 0.0v 184.745n 0.0v 184.755n 1.0v 189.745n 1.0v 189.755n 1.0v 194.745n 1.0v 194.755n 1.0v 199.745n 1.0v 199.755n 1.0v 204.745n 1.0v 204.755n 1.0v 209.745n 1.0v 209.755n 0.0v 214.745n 0.0v 214.755n 0.0v 219.745n 0.0v 219.755n 1.0v 224.745n 1.0v 224.755n 1.0v 229.745n 1.0v 229.755n 1.0v 234.745n 1.0v 234.755n 1.0v 239.745n 1.0v 239.755n 0.0v 244.745n 0.0v 244.755n 0.0v 249.745n 0.0v 249.755n 0.0v 254.745n 0.0v 254.755n 1.0v 259.745n 1.0v 259.755n 0.0v 264.745n 0.0v 264.755n 0.0v 269.745n 0.0v 269.755n 1.0v 274.745n 1.0v 274.755n 1.0v 279.745n 1.0v 279.755n 0.0v 284.745n 0.0v 284.755n 1.0v 289.745n 1.0v 289.755n 1.0v 294.745n 1.0v 294.755n 1.0v 299.745n 1.0v 299.755n 0.0v 304.745n 0.0v 304.755n 0.0v 309.745n 0.0v 309.755n 1.0v 314.745n 1.0v 314.755n 0.0v 319.745n 0.0v 319.755n 0.0v 324.745n 0.0v 324.755n 0.0v 329.745n 0.0v 329.755n 0.0v 334.745n 0.0v 334.755n 1.0v 339.745n 1.0v 339.755n 1.0v 344.745n 1.0v 344.755n 1.0v 349.745n 1.0v 349.755n 0.0v 354.745n 0.0v 354.755n 0.0v 359.745n 0.0v 359.755n 0.0v 364.745n 0.0v 364.755n 0.0v 369.745n 0.0v 369.755n 0.0v 374.745n 0.0v 374.755n 1.0v 379.745n 1.0v 379.755n 1.0v 384.745n 1.0v 384.755n 1.0v 389.745n 1.0v 389.755n 0.0v 394.745n 0.0v 394.755n 1.0v 399.745n 1.0v 399.755n 0.0v 404.745n 0.0v 404.755n 0.0v 409.745n 0.0v 409.755n 1.0v 414.745n 1.0v 414.755n 1.0v 419.745n 1.0v 419.755n 1.0v 424.745n 1.0v 424.755n 1.0v 429.745n 1.0v 429.755n 0.0v 434.745n 0.0v 434.755n 0.0v 439.745n 0.0v 439.755n 0.0v 444.745n 0.0v 444.755n 0.0v 449.745n 0.0v 449.755n 1.0v 454.745n 1.0v 454.755n 1.0v 459.745n 1.0v 459.755n 1.0v 464.745n 1.0v 464.755n 1.0v 469.745n 1.0v 469.755n 0.0v 474.745n 0.0v 474.755n 1.0v 479.745n 1.0v 479.755n 1.0v 484.745n 1.0v 484.755n 0.0v 489.745n 0.0v 489.755n 1.0v 494.745n 1.0v 494.755n 1.0v 499.745n 1.0v 499.755n 0.0v 504.745n 0.0v 504.755n 0.0v 509.745n 0.0v 509.755n 0.0v 514.745n 0.0v 514.755n 0.0v 519.745n 0.0v 519.755n 1.0v 524.745n 1.0v 524.755n 1.0v 529.745n 1.0v 529.755n 0.0v 534.745n 0.0v 534.755n 0.0v 539.745n 0.0v 539.755n 1.0v 544.745n 1.0v 544.755n 1.0v 549.745n 1.0v 549.755n 1.0v 554.745n 1.0v 554.755n 1.0v 559.745n 1.0v 559.755n 1.0v 564.745n 1.0v 564.755n 0.0v 569.745n 0.0v 569.755n 0.0v 574.745n 0.0v 574.755n 1.0v 579.745n 1.0v 579.755n 0.0v 584.745n 0.0v 584.755n 0.0v 589.745n 0.0v 589.755n 0.0v 594.745n 0.0v 594.755n 1.0v 599.745n 1.0v 599.755n 0.0v 604.745n 0.0v 604.755n 0.0v 609.745n 0.0v 609.755n 1.0v 614.745n 1.0v 614.755n 1.0v 619.745n 1.0v 619.755n 1.0v 624.745n 1.0v 624.755n 0.0v 629.745n 0.0v 629.755n 1.0v 634.745n 1.0v 634.755n 1.0v 639.745n 1.0v 639.755n 1.0v 644.745n 1.0v 644.755n 1.0v 649.745n 1.0v 649.755n 1.0v 654.745n 1.0v 654.755n 0.0v 659.745n 0.0v 659.755n 1.0v 664.745n 1.0v 664.755n 0.0v 669.745n 0.0v 669.755n 1.0v 674.745n 1.0v 674.755n 1.0v 679.745n 1.0v 679.755n 1.0v 684.745n 1.0v 684.755n 1.0v 689.745n 1.0v 689.755n 1.0v 694.745n 1.0v 694.755n 1.0v 699.745n 1.0v 699.755n 0.0v 704.745n 0.0v 704.755n 0.0v 709.745n 0.0v 709.755n 0.0v 714.745n 0.0v 714.755n 0.0v 719.745n 0.0v 719.755n 0.0v 724.745n 0.0v 724.755n 1.0v 729.745n 1.0v 729.755n 1.0v 734.745n 1.0v 734.755n 1.0v 739.745n 1.0v 739.755n 1.0v 744.745n 1.0v 744.755n 0.0v 749.745n 0.0v 749.755n 0.0v 754.745n 0.0v 754.755n 0.0v 759.745n 0.0v 759.755n 0.0v 764.745n 0.0v 764.755n 0.0v 769.745n 0.0v 769.755n 0.0v 774.745n 0.0v 774.755n 1.0v 779.745n 1.0v 779.755n 0.0v 784.745n 0.0v 784.755n 0.0v 789.745n 0.0v 789.755n 0.0v 794.745n 0.0v 794.755n 0.0v 799.745n 0.0v 799.755n 1.0v 804.745n 1.0v 804.755n 0.0v 809.745n 0.0v 809.755n 0.0v 814.745n 0.0v 814.755n 0.0v 819.745n 0.0v 819.755n 0.0v 824.745n 0.0v 824.755n 0.0v 829.745n 0.0v 829.755n 0.0v 834.745n 0.0v 834.755n 0.0v 839.745n 0.0v 839.755n 0.0v 844.745n 0.0v 844.755n 1.0v 849.745n 1.0v 849.755n 1.0v 854.745n 1.0v 854.755n 1.0v 859.745n 1.0v 859.755n 1.0v 864.745n 1.0v 864.755n 1.0v 869.745n 1.0v 869.755n 0.0v 874.745n 0.0v 874.755n 1.0v 879.745n 1.0v 879.755n 1.0v 884.745n 1.0v 884.755n 0.0v 889.745n 0.0v 889.755n 0.0v 894.745n 0.0v 894.755n 0.0v 899.745n 0.0v 899.755n 1.0v 904.745n 1.0v 904.755n 1.0v 909.745n 1.0v 909.755n 0.0v 914.745n 0.0v 914.755n 1.0v 919.745n 1.0v 919.755n 0.0v 924.745n 0.0v 924.755n 0.0v 929.745n 0.0v 929.755n 1.0v 934.745n 1.0v 934.755n 0.0v 939.745n 0.0v 939.755n 1.0v 944.745n 1.0v 944.755n 1.0v 949.745n 1.0v 949.755n 1.0v 954.745n 1.0v 954.755n 1.0v 959.745n 1.0v 959.755n 1.0v 964.745n 1.0v 964.755n 1.0v 969.745n 1.0v 969.755n 1.0v 974.745n 1.0v 974.755n 0.0v 979.745n 0.0v 979.755n 1.0v 984.745n 1.0v 984.755n 0.0v 989.745n 0.0v 989.755n 0.0v 994.745n 0.0v 994.755n 0.0v 999.745n 0.0v 999.755n 0.0v 1004.745n 0.0v 1004.755n 0.0v 1009.745n 0.0v 1009.755n 0.0v 1014.745n 0.0v 1014.755n 1.0v 1019.745n 1.0v 1019.755n 1.0v 1024.745n 1.0v 1024.755n 1.0v )
* (time, data): [(0, 0), (5, 1), (10, 0), (15, 0), (20, 1), (25, 1), (30, 1), (35, 0), (40, 0), (45, 1), (50, 0), (55, 0), (60, 0), (65, 0), (70, 0), (75, 1), (80, 0), (85, 0), (90, 1), (95, 0), (100, 0), (105, 0), (110, 0), (115, 0), (120, 0), (125, 1), (130, 0), (135, 1), (140, 1), (145, 1), (150, 0), (155, 0), (160, 1), (165, 0), (170, 0), (175, 0), (180, 0), (185, 1), (190, 1), (195, 1), (200, 1), (205, 1), (210, 0), (215, 0), (220, 1), (225, 1), (230, 1), (235, 1), (240, 0), (245, 0), (250, 0), (255, 1), (260, 0), (265, 0), (270, 1), (275, 1), (280, 0), (285, 1), (290, 1), (295, 1), (300, 0), (305, 0), (310, 1), (315, 0), (320, 0), (325, 0), (330, 0), (335, 1), (340, 1), (345, 1), (350, 0), (355, 0), (360, 0), (365, 0), (370, 0), (375, 1), (380, 1), (385, 1), (390, 0), (395, 1), (400, 0), (405, 0), (410, 1), (415, 1), (420, 1), (425, 1), (430, 0), (435, 0), (440, 0), (445, 0), (450, 1), (455, 1), (460, 1), (465, 1), (470, 0), (475, 1), (480, 1), (485, 0), (490, 1), (495, 1), (500, 0), (505, 0), (510, 0), (515, 0), (520, 1), (525, 1), (530, 0), (535, 0), (540, 1), (545, 1), (550, 1), (555, 1), (560, 1), (565, 0), (570, 0), (575, 1), (580, 0), (585, 0), (590, 0), (595, 1), (600, 0), (605, 0), (610, 1), (615, 1), (620, 1), (625, 0), (630, 1), (635, 1), (640, 1), (645, 1), (650, 1), (655, 0), (660, 1), (665, 0), (670, 1), (675, 1), (680, 1), (685, 1), (690, 1), (695, 1), (700, 0), (705, 0), (710, 0), (715, 0), (720, 0), (725, 1), (730, 1), (735, 1), (740, 1), (745, 0), (750, 0), (755, 0), (760, 0), (765, 0), (770, 0), (775, 1), (780, 0), (785, 0), (790, 0), (795, 0), (800, 1), (805, 0), (810, 0), (815, 0), (820, 0), (825, 0), (830, 0), (835, 0), (840, 0), (845, 1), (850, 1), (855, 1), (860, 1), (865, 1), (870, 0), (875, 1), (880, 1), (885, 0), (890, 0), (895, 0), (900, 1), (905, 1), (910, 0), (915, 1), (920, 0), (925, 0), (930, 1), (935, 0), (940, 1), (945, 1), (950, 1), (955, 1), (960, 1), (965, 1), (970, 1), (975, 0), (980, 1), (985, 0), (990, 0), (995, 0), (1000, 0), (1005, 0), (1010, 0), (1015, 1), (1020, 1), (1025, 1)]
Va1_4  a1_4  0 PWL (0n 0.0v 4.745n 0.0v 4.755n 1.0v 9.745n 1.0v 9.755n 0.0v 14.745n 0.0v 14.755n 0.0v 19.745n 0.0v 19.755n 1.0v 24.745n 1.0v 24.755n 1.0v 29.745n 1.0v 29.755n 1.0v 34.745n 1.0v 34.755n 0.0v 39.745n 0.0v 39.755n 0.0v 44.745n 0.0v 44.755n 1.0v 49.745n 1.0v 49.755n 0.0v 54.745n 0.0v 54.755n 0.0v 59.745n 0.0v 59.755n 0.0v 64.745n 0.0v 64.755n 0.0v 69.745n 0.0v 69.755n 0.0v 74.745n 0.0v 74.755n 1.0v 79.745n 1.0v 79.755n 0.0v 84.745n 0.0v 84.755n 0.0v 89.745n 0.0v 89.755n 1.0v 94.745n 1.0v 94.755n 0.0v 99.745n 0.0v 99.755n 0.0v 104.745n 0.0v 104.755n 0.0v 109.745n 0.0v 109.755n 0.0v 114.745n 0.0v 114.755n 0.0v 119.745n 0.0v 119.755n 0.0v 124.745n 0.0v 124.755n 1.0v 129.745n 1.0v 129.755n 0.0v 134.745n 0.0v 134.755n 1.0v 139.745n 1.0v 139.755n 1.0v 144.745n 1.0v 144.755n 1.0v 149.745n 1.0v 149.755n 0.0v 154.745n 0.0v 154.755n 0.0v 159.745n 0.0v 159.755n 1.0v 164.745n 1.0v 164.755n 0.0v 169.745n 0.0v 169.755n 0.0v 174.745n 0.0v 174.755n 0.0v 179.745n 0.0v 179.755n 0.0v 184.745n 0.0v 184.755n 1.0v 189.745n 1.0v 189.755n 1.0v 194.745n 1.0v 194.755n 1.0v 199.745n 1.0v 199.755n 1.0v 204.745n 1.0v 204.755n 1.0v 209.745n 1.0v 209.755n 0.0v 214.745n 0.0v 214.755n 0.0v 219.745n 0.0v 219.755n 1.0v 224.745n 1.0v 224.755n 1.0v 229.745n 1.0v 229.755n 1.0v 234.745n 1.0v 234.755n 1.0v 239.745n 1.0v 239.755n 0.0v 244.745n 0.0v 244.755n 0.0v 249.745n 0.0v 249.755n 0.0v 254.745n 0.0v 254.755n 1.0v 259.745n 1.0v 259.755n 0.0v 264.745n 0.0v 264.755n 0.0v 269.745n 0.0v 269.755n 1.0v 274.745n 1.0v 274.755n 1.0v 279.745n 1.0v 279.755n 0.0v 284.745n 0.0v 284.755n 1.0v 289.745n 1.0v 289.755n 1.0v 294.745n 1.0v 294.755n 1.0v 299.745n 1.0v 299.755n 0.0v 304.745n 0.0v 304.755n 0.0v 309.745n 0.0v 309.755n 1.0v 314.745n 1.0v 314.755n 0.0v 319.745n 0.0v 319.755n 0.0v 324.745n 0.0v 324.755n 0.0v 329.745n 0.0v 329.755n 0.0v 334.745n 0.0v 334.755n 1.0v 339.745n 1.0v 339.755n 1.0v 344.745n 1.0v 344.755n 1.0v 349.745n 1.0v 349.755n 0.0v 354.745n 0.0v 354.755n 0.0v 359.745n 0.0v 359.755n 0.0v 364.745n 0.0v 364.755n 0.0v 369.745n 0.0v 369.755n 0.0v 374.745n 0.0v 374.755n 1.0v 379.745n 1.0v 379.755n 1.0v 384.745n 1.0v 384.755n 1.0v 389.745n 1.0v 389.755n 0.0v 394.745n 0.0v 394.755n 1.0v 399.745n 1.0v 399.755n 0.0v 404.745n 0.0v 404.755n 0.0v 409.745n 0.0v 409.755n 1.0v 414.745n 1.0v 414.755n 1.0v 419.745n 1.0v 419.755n 1.0v 424.745n 1.0v 424.755n 1.0v 429.745n 1.0v 429.755n 0.0v 434.745n 0.0v 434.755n 0.0v 439.745n 0.0v 439.755n 0.0v 444.745n 0.0v 444.755n 0.0v 449.745n 0.0v 449.755n 1.0v 454.745n 1.0v 454.755n 1.0v 459.745n 1.0v 459.755n 1.0v 464.745n 1.0v 464.755n 1.0v 469.745n 1.0v 469.755n 0.0v 474.745n 0.0v 474.755n 1.0v 479.745n 1.0v 479.755n 1.0v 484.745n 1.0v 484.755n 0.0v 489.745n 0.0v 489.755n 1.0v 494.745n 1.0v 494.755n 1.0v 499.745n 1.0v 499.755n 0.0v 504.745n 0.0v 504.755n 0.0v 509.745n 0.0v 509.755n 0.0v 514.745n 0.0v 514.755n 0.0v 519.745n 0.0v 519.755n 1.0v 524.745n 1.0v 524.755n 1.0v 529.745n 1.0v 529.755n 0.0v 534.745n 0.0v 534.755n 0.0v 539.745n 0.0v 539.755n 1.0v 544.745n 1.0v 544.755n 1.0v 549.745n 1.0v 549.755n 1.0v 554.745n 1.0v 554.755n 1.0v 559.745n 1.0v 559.755n 1.0v 564.745n 1.0v 564.755n 0.0v 569.745n 0.0v 569.755n 0.0v 574.745n 0.0v 574.755n 1.0v 579.745n 1.0v 579.755n 0.0v 584.745n 0.0v 584.755n 0.0v 589.745n 0.0v 589.755n 0.0v 594.745n 0.0v 594.755n 1.0v 599.745n 1.0v 599.755n 0.0v 604.745n 0.0v 604.755n 0.0v 609.745n 0.0v 609.755n 1.0v 614.745n 1.0v 614.755n 1.0v 619.745n 1.0v 619.755n 1.0v 624.745n 1.0v 624.755n 0.0v 629.745n 0.0v 629.755n 1.0v 634.745n 1.0v 634.755n 1.0v 639.745n 1.0v 639.755n 1.0v 644.745n 1.0v 644.755n 1.0v 649.745n 1.0v 649.755n 1.0v 654.745n 1.0v 654.755n 0.0v 659.745n 0.0v 659.755n 1.0v 664.745n 1.0v 664.755n 0.0v 669.745n 0.0v 669.755n 1.0v 674.745n 1.0v 674.755n 1.0v 679.745n 1.0v 679.755n 1.0v 684.745n 1.0v 684.755n 1.0v 689.745n 1.0v 689.755n 1.0v 694.745n 1.0v 694.755n 1.0v 699.745n 1.0v 699.755n 0.0v 704.745n 0.0v 704.755n 0.0v 709.745n 0.0v 709.755n 0.0v 714.745n 0.0v 714.755n 0.0v 719.745n 0.0v 719.755n 0.0v 724.745n 0.0v 724.755n 1.0v 729.745n 1.0v 729.755n 1.0v 734.745n 1.0v 734.755n 1.0v 739.745n 1.0v 739.755n 1.0v 744.745n 1.0v 744.755n 0.0v 749.745n 0.0v 749.755n 0.0v 754.745n 0.0v 754.755n 0.0v 759.745n 0.0v 759.755n 0.0v 764.745n 0.0v 764.755n 0.0v 769.745n 0.0v 769.755n 0.0v 774.745n 0.0v 774.755n 1.0v 779.745n 1.0v 779.755n 0.0v 784.745n 0.0v 784.755n 0.0v 789.745n 0.0v 789.755n 0.0v 794.745n 0.0v 794.755n 0.0v 799.745n 0.0v 799.755n 1.0v 804.745n 1.0v 804.755n 0.0v 809.745n 0.0v 809.755n 0.0v 814.745n 0.0v 814.755n 0.0v 819.745n 0.0v 819.755n 0.0v 824.745n 0.0v 824.755n 0.0v 829.745n 0.0v 829.755n 0.0v 834.745n 0.0v 834.755n 0.0v 839.745n 0.0v 839.755n 0.0v 844.745n 0.0v 844.755n 1.0v 849.745n 1.0v 849.755n 1.0v 854.745n 1.0v 854.755n 1.0v 859.745n 1.0v 859.755n 1.0v 864.745n 1.0v 864.755n 1.0v 869.745n 1.0v 869.755n 0.0v 874.745n 0.0v 874.755n 1.0v 879.745n 1.0v 879.755n 1.0v 884.745n 1.0v 884.755n 0.0v 889.745n 0.0v 889.755n 0.0v 894.745n 0.0v 894.755n 0.0v 899.745n 0.0v 899.755n 1.0v 904.745n 1.0v 904.755n 1.0v 909.745n 1.0v 909.755n 0.0v 914.745n 0.0v 914.755n 1.0v 919.745n 1.0v 919.755n 0.0v 924.745n 0.0v 924.755n 0.0v 929.745n 0.0v 929.755n 1.0v 934.745n 1.0v 934.755n 0.0v 939.745n 0.0v 939.755n 1.0v 944.745n 1.0v 944.755n 1.0v 949.745n 1.0v 949.755n 1.0v 954.745n 1.0v 954.755n 1.0v 959.745n 1.0v 959.755n 1.0v 964.745n 1.0v 964.755n 1.0v 969.745n 1.0v 969.755n 1.0v 974.745n 1.0v 974.755n 0.0v 979.745n 0.0v 979.755n 1.0v 984.745n 1.0v 984.755n 0.0v 989.745n 0.0v 989.755n 0.0v 994.745n 0.0v 994.755n 0.0v 999.745n 0.0v 999.755n 0.0v 1004.745n 0.0v 1004.755n 0.0v 1009.745n 0.0v 1009.755n 0.0v 1014.745n 0.0v 1014.755n 1.0v 1019.745n 1.0v 1019.755n 1.0v 1024.745n 1.0v 1024.755n 1.0v )
* (time, data): [(0, 0), (5, 1), (10, 0), (15, 0), (20, 1), (25, 1), (30, 1), (35, 0), (40, 0), (45, 1), (50, 0), (55, 0), (60, 0), (65, 0), (70, 0), (75, 1), (80, 0), (85, 0), (90, 1), (95, 0), (100, 0), (105, 0), (110, 0), (115, 0), (120, 0), (125, 1), (130, 0), (135, 1), (140, 1), (145, 1), (150, 0), (155, 0), (160, 1), (165, 0), (170, 0), (175, 0), (180, 0), (185, 1), (190, 1), (195, 1), (200, 1), (205, 1), (210, 0), (215, 0), (220, 1), (225, 1), (230, 1), (235, 1), (240, 0), (245, 0), (250, 0), (255, 1), (260, 0), (265, 0), (270, 1), (275, 1), (280, 0), (285, 1), (290, 1), (295, 1), (300, 0), (305, 0), (310, 1), (315, 0), (320, 0), (325, 0), (330, 0), (335, 1), (340, 1), (345, 1), (350, 0), (355, 0), (360, 0), (365, 0), (370, 0), (375, 1), (380, 1), (385, 1), (390, 0), (395, 1), (400, 0), (405, 0), (410, 1), (415, 1), (420, 1), (425, 1), (430, 0), (435, 0), (440, 0), (445, 0), (450, 1), (455, 1), (460, 1), (465, 1), (470, 0), (475, 1), (480, 1), (485, 0), (490, 1), (495, 1), (500, 0), (505, 0), (510, 0), (515, 0), (520, 1), (525, 1), (530, 0), (535, 0), (540, 1), (545, 1), (550, 1), (555, 1), (560, 1), (565, 0), (570, 0), (575, 1), (580, 0), (585, 0), (590, 0), (595, 1), (600, 0), (605, 0), (610, 1), (615, 1), (620, 1), (625, 0), (630, 1), (635, 1), (640, 1), (645, 1), (650, 1), (655, 0), (660, 1), (665, 0), (670, 1), (675, 1), (680, 1), (685, 1), (690, 1), (695, 1), (700, 0), (705, 0), (710, 0), (715, 0), (720, 0), (725, 1), (730, 1), (735, 1), (740, 1), (745, 0), (750, 0), (755, 0), (760, 0), (765, 0), (770, 0), (775, 1), (780, 0), (785, 0), (790, 0), (795, 0), (800, 1), (805, 0), (810, 0), (815, 0), (820, 0), (825, 0), (830, 0), (835, 0), (840, 0), (845, 1), (850, 1), (855, 1), (860, 1), (865, 1), (870, 0), (875, 1), (880, 1), (885, 0), (890, 0), (895, 0), (900, 1), (905, 1), (910, 0), (915, 1), (920, 0), (925, 0), (930, 1), (935, 0), (940, 1), (945, 1), (950, 1), (955, 1), (960, 1), (965, 1), (970, 1), (975, 0), (980, 1), (985, 0), (990, 0), (995, 0), (1000, 0), (1005, 0), (1010, 0), (1015, 1), (1020, 1), (1025, 1)]
Va1_5  a1_5  0 PWL (0n 0.0v 4.745n 0.0v 4.755n 1.0v 9.745n 1.0v 9.755n 0.0v 14.745n 0.0v 14.755n 0.0v 19.745n 0.0v 19.755n 1.0v 24.745n 1.0v 24.755n 1.0v 29.745n 1.0v 29.755n 1.0v 34.745n 1.0v 34.755n 0.0v 39.745n 0.0v 39.755n 0.0v 44.745n 0.0v 44.755n 1.0v 49.745n 1.0v 49.755n 0.0v 54.745n 0.0v 54.755n 0.0v 59.745n 0.0v 59.755n 0.0v 64.745n 0.0v 64.755n 0.0v 69.745n 0.0v 69.755n 0.0v 74.745n 0.0v 74.755n 1.0v 79.745n 1.0v 79.755n 0.0v 84.745n 0.0v 84.755n 0.0v 89.745n 0.0v 89.755n 1.0v 94.745n 1.0v 94.755n 0.0v 99.745n 0.0v 99.755n 0.0v 104.745n 0.0v 104.755n 0.0v 109.745n 0.0v 109.755n 0.0v 114.745n 0.0v 114.755n 0.0v 119.745n 0.0v 119.755n 0.0v 124.745n 0.0v 124.755n 1.0v 129.745n 1.0v 129.755n 0.0v 134.745n 0.0v 134.755n 1.0v 139.745n 1.0v 139.755n 1.0v 144.745n 1.0v 144.755n 1.0v 149.745n 1.0v 149.755n 0.0v 154.745n 0.0v 154.755n 0.0v 159.745n 0.0v 159.755n 1.0v 164.745n 1.0v 164.755n 0.0v 169.745n 0.0v 169.755n 0.0v 174.745n 0.0v 174.755n 0.0v 179.745n 0.0v 179.755n 0.0v 184.745n 0.0v 184.755n 1.0v 189.745n 1.0v 189.755n 1.0v 194.745n 1.0v 194.755n 1.0v 199.745n 1.0v 199.755n 1.0v 204.745n 1.0v 204.755n 1.0v 209.745n 1.0v 209.755n 0.0v 214.745n 0.0v 214.755n 0.0v 219.745n 0.0v 219.755n 1.0v 224.745n 1.0v 224.755n 1.0v 229.745n 1.0v 229.755n 1.0v 234.745n 1.0v 234.755n 1.0v 239.745n 1.0v 239.755n 0.0v 244.745n 0.0v 244.755n 0.0v 249.745n 0.0v 249.755n 0.0v 254.745n 0.0v 254.755n 1.0v 259.745n 1.0v 259.755n 0.0v 264.745n 0.0v 264.755n 0.0v 269.745n 0.0v 269.755n 1.0v 274.745n 1.0v 274.755n 1.0v 279.745n 1.0v 279.755n 0.0v 284.745n 0.0v 284.755n 1.0v 289.745n 1.0v 289.755n 1.0v 294.745n 1.0v 294.755n 1.0v 299.745n 1.0v 299.755n 0.0v 304.745n 0.0v 304.755n 0.0v 309.745n 0.0v 309.755n 1.0v 314.745n 1.0v 314.755n 0.0v 319.745n 0.0v 319.755n 0.0v 324.745n 0.0v 324.755n 0.0v 329.745n 0.0v 329.755n 0.0v 334.745n 0.0v 334.755n 1.0v 339.745n 1.0v 339.755n 1.0v 344.745n 1.0v 344.755n 1.0v 349.745n 1.0v 349.755n 0.0v 354.745n 0.0v 354.755n 0.0v 359.745n 0.0v 359.755n 0.0v 364.745n 0.0v 364.755n 0.0v 369.745n 0.0v 369.755n 0.0v 374.745n 0.0v 374.755n 1.0v 379.745n 1.0v 379.755n 1.0v 384.745n 1.0v 384.755n 1.0v 389.745n 1.0v 389.755n 0.0v 394.745n 0.0v 394.755n 1.0v 399.745n 1.0v 399.755n 0.0v 404.745n 0.0v 404.755n 0.0v 409.745n 0.0v 409.755n 1.0v 414.745n 1.0v 414.755n 1.0v 419.745n 1.0v 419.755n 1.0v 424.745n 1.0v 424.755n 1.0v 429.745n 1.0v 429.755n 0.0v 434.745n 0.0v 434.755n 0.0v 439.745n 0.0v 439.755n 0.0v 444.745n 0.0v 444.755n 0.0v 449.745n 0.0v 449.755n 1.0v 454.745n 1.0v 454.755n 1.0v 459.745n 1.0v 459.755n 1.0v 464.745n 1.0v 464.755n 1.0v 469.745n 1.0v 469.755n 0.0v 474.745n 0.0v 474.755n 1.0v 479.745n 1.0v 479.755n 1.0v 484.745n 1.0v 484.755n 0.0v 489.745n 0.0v 489.755n 1.0v 494.745n 1.0v 494.755n 1.0v 499.745n 1.0v 499.755n 0.0v 504.745n 0.0v 504.755n 0.0v 509.745n 0.0v 509.755n 0.0v 514.745n 0.0v 514.755n 0.0v 519.745n 0.0v 519.755n 1.0v 524.745n 1.0v 524.755n 1.0v 529.745n 1.0v 529.755n 0.0v 534.745n 0.0v 534.755n 0.0v 539.745n 0.0v 539.755n 1.0v 544.745n 1.0v 544.755n 1.0v 549.745n 1.0v 549.755n 1.0v 554.745n 1.0v 554.755n 1.0v 559.745n 1.0v 559.755n 1.0v 564.745n 1.0v 564.755n 0.0v 569.745n 0.0v 569.755n 0.0v 574.745n 0.0v 574.755n 1.0v 579.745n 1.0v 579.755n 0.0v 584.745n 0.0v 584.755n 0.0v 589.745n 0.0v 589.755n 0.0v 594.745n 0.0v 594.755n 1.0v 599.745n 1.0v 599.755n 0.0v 604.745n 0.0v 604.755n 0.0v 609.745n 0.0v 609.755n 1.0v 614.745n 1.0v 614.755n 1.0v 619.745n 1.0v 619.755n 1.0v 624.745n 1.0v 624.755n 0.0v 629.745n 0.0v 629.755n 1.0v 634.745n 1.0v 634.755n 1.0v 639.745n 1.0v 639.755n 1.0v 644.745n 1.0v 644.755n 1.0v 649.745n 1.0v 649.755n 1.0v 654.745n 1.0v 654.755n 0.0v 659.745n 0.0v 659.755n 1.0v 664.745n 1.0v 664.755n 0.0v 669.745n 0.0v 669.755n 1.0v 674.745n 1.0v 674.755n 1.0v 679.745n 1.0v 679.755n 1.0v 684.745n 1.0v 684.755n 1.0v 689.745n 1.0v 689.755n 1.0v 694.745n 1.0v 694.755n 1.0v 699.745n 1.0v 699.755n 0.0v 704.745n 0.0v 704.755n 0.0v 709.745n 0.0v 709.755n 0.0v 714.745n 0.0v 714.755n 0.0v 719.745n 0.0v 719.755n 0.0v 724.745n 0.0v 724.755n 1.0v 729.745n 1.0v 729.755n 1.0v 734.745n 1.0v 734.755n 1.0v 739.745n 1.0v 739.755n 1.0v 744.745n 1.0v 744.755n 0.0v 749.745n 0.0v 749.755n 0.0v 754.745n 0.0v 754.755n 0.0v 759.745n 0.0v 759.755n 0.0v 764.745n 0.0v 764.755n 0.0v 769.745n 0.0v 769.755n 0.0v 774.745n 0.0v 774.755n 1.0v 779.745n 1.0v 779.755n 0.0v 784.745n 0.0v 784.755n 0.0v 789.745n 0.0v 789.755n 0.0v 794.745n 0.0v 794.755n 0.0v 799.745n 0.0v 799.755n 1.0v 804.745n 1.0v 804.755n 0.0v 809.745n 0.0v 809.755n 0.0v 814.745n 0.0v 814.755n 0.0v 819.745n 0.0v 819.755n 0.0v 824.745n 0.0v 824.755n 0.0v 829.745n 0.0v 829.755n 0.0v 834.745n 0.0v 834.755n 0.0v 839.745n 0.0v 839.755n 0.0v 844.745n 0.0v 844.755n 1.0v 849.745n 1.0v 849.755n 1.0v 854.745n 1.0v 854.755n 1.0v 859.745n 1.0v 859.755n 1.0v 864.745n 1.0v 864.755n 1.0v 869.745n 1.0v 869.755n 0.0v 874.745n 0.0v 874.755n 1.0v 879.745n 1.0v 879.755n 1.0v 884.745n 1.0v 884.755n 0.0v 889.745n 0.0v 889.755n 0.0v 894.745n 0.0v 894.755n 0.0v 899.745n 0.0v 899.755n 1.0v 904.745n 1.0v 904.755n 1.0v 909.745n 1.0v 909.755n 0.0v 914.745n 0.0v 914.755n 1.0v 919.745n 1.0v 919.755n 0.0v 924.745n 0.0v 924.755n 0.0v 929.745n 0.0v 929.755n 1.0v 934.745n 1.0v 934.755n 0.0v 939.745n 0.0v 939.755n 1.0v 944.745n 1.0v 944.755n 1.0v 949.745n 1.0v 949.755n 1.0v 954.745n 1.0v 954.755n 1.0v 959.745n 1.0v 959.755n 1.0v 964.745n 1.0v 964.755n 1.0v 969.745n 1.0v 969.755n 1.0v 974.745n 1.0v 974.755n 0.0v 979.745n 0.0v 979.755n 1.0v 984.745n 1.0v 984.755n 0.0v 989.745n 0.0v 989.755n 0.0v 994.745n 0.0v 994.755n 0.0v 999.745n 0.0v 999.755n 0.0v 1004.745n 0.0v 1004.755n 0.0v 1009.745n 0.0v 1009.755n 0.0v 1014.745n 0.0v 1014.755n 1.0v 1019.745n 1.0v 1019.755n 1.0v 1024.745n 1.0v 1024.755n 1.0v )
* (time, data): [(0, 0), (5, 1), (10, 0), (15, 0), (20, 1), (25, 1), (30, 1), (35, 0), (40, 0), (45, 1), (50, 0), (55, 0), (60, 0), (65, 0), (70, 0), (75, 1), (80, 0), (85, 0), (90, 1), (95, 0), (100, 0), (105, 0), (110, 0), (115, 0), (120, 0), (125, 1), (130, 0), (135, 1), (140, 1), (145, 1), (150, 0), (155, 0), (160, 1), (165, 0), (170, 0), (175, 0), (180, 0), (185, 1), (190, 1), (195, 1), (200, 1), (205, 1), (210, 0), (215, 0), (220, 1), (225, 1), (230, 1), (235, 1), (240, 0), (245, 0), (250, 0), (255, 1), (260, 0), (265, 0), (270, 1), (275, 1), (280, 0), (285, 1), (290, 1), (295, 1), (300, 0), (305, 0), (310, 1), (315, 0), (320, 0), (325, 0), (330, 0), (335, 1), (340, 1), (345, 1), (350, 0), (355, 0), (360, 0), (365, 0), (370, 0), (375, 1), (380, 1), (385, 1), (390, 0), (395, 1), (400, 0), (405, 0), (410, 1), (415, 1), (420, 1), (425, 1), (430, 0), (435, 0), (440, 0), (445, 0), (450, 1), (455, 1), (460, 1), (465, 1), (470, 0), (475, 1), (480, 1), (485, 0), (490, 1), (495, 1), (500, 0), (505, 0), (510, 0), (515, 0), (520, 1), (525, 1), (530, 0), (535, 0), (540, 1), (545, 1), (550, 1), (555, 1), (560, 1), (565, 0), (570, 0), (575, 1), (580, 0), (585, 0), (590, 0), (595, 1), (600, 0), (605, 0), (610, 1), (615, 1), (620, 1), (625, 0), (630, 1), (635, 1), (640, 1), (645, 1), (650, 1), (655, 0), (660, 1), (665, 0), (670, 1), (675, 1), (680, 1), (685, 1), (690, 1), (695, 1), (700, 0), (705, 0), (710, 0), (715, 0), (720, 0), (725, 1), (730, 1), (735, 1), (740, 1), (745, 0), (750, 0), (755, 0), (760, 0), (765, 0), (770, 0), (775, 1), (780, 0), (785, 0), (790, 0), (795, 0), (800, 1), (805, 0), (810, 0), (815, 0), (820, 0), (825, 0), (830, 0), (835, 0), (840, 0), (845, 1), (850, 1), (855, 1), (860, 1), (865, 1), (870, 0), (875, 1), (880, 1), (885, 0), (890, 0), (895, 0), (900, 1), (905, 1), (910, 0), (915, 1), (920, 0), (925, 0), (930, 1), (935, 0), (940, 1), (945, 1), (950, 1), (955, 1), (960, 1), (965, 1), (970, 1), (975, 0), (980, 1), (985, 0), (990, 0), (995, 0), (1000, 0), (1005, 0), (1010, 0), (1015, 1), (1020, 1), (1025, 1)]
Va1_6  a1_6  0 PWL (0n 0.0v 4.745n 0.0v 4.755n 1.0v 9.745n 1.0v 9.755n 0.0v 14.745n 0.0v 14.755n 0.0v 19.745n 0.0v 19.755n 1.0v 24.745n 1.0v 24.755n 1.0v 29.745n 1.0v 29.755n 1.0v 34.745n 1.0v 34.755n 0.0v 39.745n 0.0v 39.755n 0.0v 44.745n 0.0v 44.755n 1.0v 49.745n 1.0v 49.755n 0.0v 54.745n 0.0v 54.755n 0.0v 59.745n 0.0v 59.755n 0.0v 64.745n 0.0v 64.755n 0.0v 69.745n 0.0v 69.755n 0.0v 74.745n 0.0v 74.755n 1.0v 79.745n 1.0v 79.755n 0.0v 84.745n 0.0v 84.755n 0.0v 89.745n 0.0v 89.755n 1.0v 94.745n 1.0v 94.755n 0.0v 99.745n 0.0v 99.755n 0.0v 104.745n 0.0v 104.755n 0.0v 109.745n 0.0v 109.755n 0.0v 114.745n 0.0v 114.755n 0.0v 119.745n 0.0v 119.755n 0.0v 124.745n 0.0v 124.755n 1.0v 129.745n 1.0v 129.755n 0.0v 134.745n 0.0v 134.755n 1.0v 139.745n 1.0v 139.755n 1.0v 144.745n 1.0v 144.755n 1.0v 149.745n 1.0v 149.755n 0.0v 154.745n 0.0v 154.755n 0.0v 159.745n 0.0v 159.755n 1.0v 164.745n 1.0v 164.755n 0.0v 169.745n 0.0v 169.755n 0.0v 174.745n 0.0v 174.755n 0.0v 179.745n 0.0v 179.755n 0.0v 184.745n 0.0v 184.755n 1.0v 189.745n 1.0v 189.755n 1.0v 194.745n 1.0v 194.755n 1.0v 199.745n 1.0v 199.755n 1.0v 204.745n 1.0v 204.755n 1.0v 209.745n 1.0v 209.755n 0.0v 214.745n 0.0v 214.755n 0.0v 219.745n 0.0v 219.755n 1.0v 224.745n 1.0v 224.755n 1.0v 229.745n 1.0v 229.755n 1.0v 234.745n 1.0v 234.755n 1.0v 239.745n 1.0v 239.755n 0.0v 244.745n 0.0v 244.755n 0.0v 249.745n 0.0v 249.755n 0.0v 254.745n 0.0v 254.755n 1.0v 259.745n 1.0v 259.755n 0.0v 264.745n 0.0v 264.755n 0.0v 269.745n 0.0v 269.755n 1.0v 274.745n 1.0v 274.755n 1.0v 279.745n 1.0v 279.755n 0.0v 284.745n 0.0v 284.755n 1.0v 289.745n 1.0v 289.755n 1.0v 294.745n 1.0v 294.755n 1.0v 299.745n 1.0v 299.755n 0.0v 304.745n 0.0v 304.755n 0.0v 309.745n 0.0v 309.755n 1.0v 314.745n 1.0v 314.755n 0.0v 319.745n 0.0v 319.755n 0.0v 324.745n 0.0v 324.755n 0.0v 329.745n 0.0v 329.755n 0.0v 334.745n 0.0v 334.755n 1.0v 339.745n 1.0v 339.755n 1.0v 344.745n 1.0v 344.755n 1.0v 349.745n 1.0v 349.755n 0.0v 354.745n 0.0v 354.755n 0.0v 359.745n 0.0v 359.755n 0.0v 364.745n 0.0v 364.755n 0.0v 369.745n 0.0v 369.755n 0.0v 374.745n 0.0v 374.755n 1.0v 379.745n 1.0v 379.755n 1.0v 384.745n 1.0v 384.755n 1.0v 389.745n 1.0v 389.755n 0.0v 394.745n 0.0v 394.755n 1.0v 399.745n 1.0v 399.755n 0.0v 404.745n 0.0v 404.755n 0.0v 409.745n 0.0v 409.755n 1.0v 414.745n 1.0v 414.755n 1.0v 419.745n 1.0v 419.755n 1.0v 424.745n 1.0v 424.755n 1.0v 429.745n 1.0v 429.755n 0.0v 434.745n 0.0v 434.755n 0.0v 439.745n 0.0v 439.755n 0.0v 444.745n 0.0v 444.755n 0.0v 449.745n 0.0v 449.755n 1.0v 454.745n 1.0v 454.755n 1.0v 459.745n 1.0v 459.755n 1.0v 464.745n 1.0v 464.755n 1.0v 469.745n 1.0v 469.755n 0.0v 474.745n 0.0v 474.755n 1.0v 479.745n 1.0v 479.755n 1.0v 484.745n 1.0v 484.755n 0.0v 489.745n 0.0v 489.755n 1.0v 494.745n 1.0v 494.755n 1.0v 499.745n 1.0v 499.755n 0.0v 504.745n 0.0v 504.755n 0.0v 509.745n 0.0v 509.755n 0.0v 514.745n 0.0v 514.755n 0.0v 519.745n 0.0v 519.755n 1.0v 524.745n 1.0v 524.755n 1.0v 529.745n 1.0v 529.755n 0.0v 534.745n 0.0v 534.755n 0.0v 539.745n 0.0v 539.755n 1.0v 544.745n 1.0v 544.755n 1.0v 549.745n 1.0v 549.755n 1.0v 554.745n 1.0v 554.755n 1.0v 559.745n 1.0v 559.755n 1.0v 564.745n 1.0v 564.755n 0.0v 569.745n 0.0v 569.755n 0.0v 574.745n 0.0v 574.755n 1.0v 579.745n 1.0v 579.755n 0.0v 584.745n 0.0v 584.755n 0.0v 589.745n 0.0v 589.755n 0.0v 594.745n 0.0v 594.755n 1.0v 599.745n 1.0v 599.755n 0.0v 604.745n 0.0v 604.755n 0.0v 609.745n 0.0v 609.755n 1.0v 614.745n 1.0v 614.755n 1.0v 619.745n 1.0v 619.755n 1.0v 624.745n 1.0v 624.755n 0.0v 629.745n 0.0v 629.755n 1.0v 634.745n 1.0v 634.755n 1.0v 639.745n 1.0v 639.755n 1.0v 644.745n 1.0v 644.755n 1.0v 649.745n 1.0v 649.755n 1.0v 654.745n 1.0v 654.755n 0.0v 659.745n 0.0v 659.755n 1.0v 664.745n 1.0v 664.755n 0.0v 669.745n 0.0v 669.755n 1.0v 674.745n 1.0v 674.755n 1.0v 679.745n 1.0v 679.755n 1.0v 684.745n 1.0v 684.755n 1.0v 689.745n 1.0v 689.755n 1.0v 694.745n 1.0v 694.755n 1.0v 699.745n 1.0v 699.755n 0.0v 704.745n 0.0v 704.755n 0.0v 709.745n 0.0v 709.755n 0.0v 714.745n 0.0v 714.755n 0.0v 719.745n 0.0v 719.755n 0.0v 724.745n 0.0v 724.755n 1.0v 729.745n 1.0v 729.755n 1.0v 734.745n 1.0v 734.755n 1.0v 739.745n 1.0v 739.755n 1.0v 744.745n 1.0v 744.755n 0.0v 749.745n 0.0v 749.755n 0.0v 754.745n 0.0v 754.755n 0.0v 759.745n 0.0v 759.755n 0.0v 764.745n 0.0v 764.755n 0.0v 769.745n 0.0v 769.755n 0.0v 774.745n 0.0v 774.755n 1.0v 779.745n 1.0v 779.755n 0.0v 784.745n 0.0v 784.755n 0.0v 789.745n 0.0v 789.755n 0.0v 794.745n 0.0v 794.755n 0.0v 799.745n 0.0v 799.755n 1.0v 804.745n 1.0v 804.755n 0.0v 809.745n 0.0v 809.755n 0.0v 814.745n 0.0v 814.755n 0.0v 819.745n 0.0v 819.755n 0.0v 824.745n 0.0v 824.755n 0.0v 829.745n 0.0v 829.755n 0.0v 834.745n 0.0v 834.755n 0.0v 839.745n 0.0v 839.755n 0.0v 844.745n 0.0v 844.755n 1.0v 849.745n 1.0v 849.755n 1.0v 854.745n 1.0v 854.755n 1.0v 859.745n 1.0v 859.755n 1.0v 864.745n 1.0v 864.755n 1.0v 869.745n 1.0v 869.755n 0.0v 874.745n 0.0v 874.755n 1.0v 879.745n 1.0v 879.755n 1.0v 884.745n 1.0v 884.755n 0.0v 889.745n 0.0v 889.755n 0.0v 894.745n 0.0v 894.755n 0.0v 899.745n 0.0v 899.755n 1.0v 904.745n 1.0v 904.755n 1.0v 909.745n 1.0v 909.755n 0.0v 914.745n 0.0v 914.755n 1.0v 919.745n 1.0v 919.755n 0.0v 924.745n 0.0v 924.755n 0.0v 929.745n 0.0v 929.755n 1.0v 934.745n 1.0v 934.755n 0.0v 939.745n 0.0v 939.755n 1.0v 944.745n 1.0v 944.755n 1.0v 949.745n 1.0v 949.755n 1.0v 954.745n 1.0v 954.755n 1.0v 959.745n 1.0v 959.755n 1.0v 964.745n 1.0v 964.755n 1.0v 969.745n 1.0v 969.755n 1.0v 974.745n 1.0v 974.755n 0.0v 979.745n 0.0v 979.755n 1.0v 984.745n 1.0v 984.755n 0.0v 989.745n 0.0v 989.755n 0.0v 994.745n 0.0v 994.755n 0.0v 999.745n 0.0v 999.755n 0.0v 1004.745n 0.0v 1004.755n 0.0v 1009.745n 0.0v 1009.755n 0.0v 1014.745n 0.0v 1014.755n 1.0v 1019.745n 1.0v 1019.755n 1.0v 1024.745n 1.0v 1024.755n 1.0v )
* (time, data): [(0, 0), (5, 1), (10, 0), (15, 0), (20, 1), (25, 1), (30, 1), (35, 0), (40, 0), (45, 1), (50, 0), (55, 0), (60, 0), (65, 0), (70, 0), (75, 1), (80, 0), (85, 0), (90, 1), (95, 0), (100, 0), (105, 0), (110, 0), (115, 0), (120, 0), (125, 1), (130, 0), (135, 1), (140, 1), (145, 1), (150, 0), (155, 0), (160, 1), (165, 0), (170, 0), (175, 0), (180, 0), (185, 1), (190, 1), (195, 1), (200, 1), (205, 1), (210, 0), (215, 0), (220, 1), (225, 1), (230, 1), (235, 1), (240, 0), (245, 0), (250, 0), (255, 1), (260, 0), (265, 0), (270, 1), (275, 1), (280, 0), (285, 1), (290, 1), (295, 1), (300, 0), (305, 0), (310, 1), (315, 0), (320, 0), (325, 0), (330, 0), (335, 1), (340, 1), (345, 1), (350, 0), (355, 0), (360, 0), (365, 0), (370, 0), (375, 1), (380, 1), (385, 1), (390, 0), (395, 1), (400, 0), (405, 0), (410, 1), (415, 1), (420, 1), (425, 1), (430, 0), (435, 0), (440, 0), (445, 0), (450, 1), (455, 1), (460, 1), (465, 1), (470, 0), (475, 1), (480, 1), (485, 0), (490, 1), (495, 1), (500, 0), (505, 0), (510, 0), (515, 0), (520, 1), (525, 1), (530, 0), (535, 0), (540, 1), (545, 1), (550, 1), (555, 1), (560, 1), (565, 0), (570, 0), (575, 1), (580, 0), (585, 0), (590, 0), (595, 1), (600, 0), (605, 0), (610, 1), (615, 1), (620, 1), (625, 0), (630, 1), (635, 1), (640, 1), (645, 1), (650, 1), (655, 0), (660, 1), (665, 0), (670, 1), (675, 1), (680, 1), (685, 1), (690, 1), (695, 1), (700, 0), (705, 0), (710, 0), (715, 0), (720, 0), (725, 1), (730, 1), (735, 1), (740, 1), (745, 0), (750, 0), (755, 0), (760, 0), (765, 0), (770, 0), (775, 1), (780, 0), (785, 0), (790, 0), (795, 0), (800, 1), (805, 0), (810, 0), (815, 0), (820, 0), (825, 0), (830, 0), (835, 0), (840, 0), (845, 1), (850, 1), (855, 1), (860, 1), (865, 1), (870, 0), (875, 1), (880, 1), (885, 0), (890, 0), (895, 0), (900, 1), (905, 1), (910, 0), (915, 1), (920, 0), (925, 0), (930, 1), (935, 0), (940, 1), (945, 1), (950, 1), (955, 1), (960, 1), (965, 1), (970, 1), (975, 0), (980, 1), (985, 0), (990, 0), (995, 0), (1000, 0), (1005, 0), (1010, 0), (1015, 1), (1020, 1), (1025, 1)]
Va1_7  a1_7  0 PWL (0n 0.0v 4.745n 0.0v 4.755n 1.0v 9.745n 1.0v 9.755n 0.0v 14.745n 0.0v 14.755n 0.0v 19.745n 0.0v 19.755n 1.0v 24.745n 1.0v 24.755n 1.0v 29.745n 1.0v 29.755n 1.0v 34.745n 1.0v 34.755n 0.0v 39.745n 0.0v 39.755n 0.0v 44.745n 0.0v 44.755n 1.0v 49.745n 1.0v 49.755n 0.0v 54.745n 0.0v 54.755n 0.0v 59.745n 0.0v 59.755n 0.0v 64.745n 0.0v 64.755n 0.0v 69.745n 0.0v 69.755n 0.0v 74.745n 0.0v 74.755n 1.0v 79.745n 1.0v 79.755n 0.0v 84.745n 0.0v 84.755n 0.0v 89.745n 0.0v 89.755n 1.0v 94.745n 1.0v 94.755n 0.0v 99.745n 0.0v 99.755n 0.0v 104.745n 0.0v 104.755n 0.0v 109.745n 0.0v 109.755n 0.0v 114.745n 0.0v 114.755n 0.0v 119.745n 0.0v 119.755n 0.0v 124.745n 0.0v 124.755n 1.0v 129.745n 1.0v 129.755n 0.0v 134.745n 0.0v 134.755n 1.0v 139.745n 1.0v 139.755n 1.0v 144.745n 1.0v 144.755n 1.0v 149.745n 1.0v 149.755n 0.0v 154.745n 0.0v 154.755n 0.0v 159.745n 0.0v 159.755n 1.0v 164.745n 1.0v 164.755n 0.0v 169.745n 0.0v 169.755n 0.0v 174.745n 0.0v 174.755n 0.0v 179.745n 0.0v 179.755n 0.0v 184.745n 0.0v 184.755n 1.0v 189.745n 1.0v 189.755n 1.0v 194.745n 1.0v 194.755n 1.0v 199.745n 1.0v 199.755n 1.0v 204.745n 1.0v 204.755n 1.0v 209.745n 1.0v 209.755n 0.0v 214.745n 0.0v 214.755n 0.0v 219.745n 0.0v 219.755n 1.0v 224.745n 1.0v 224.755n 1.0v 229.745n 1.0v 229.755n 1.0v 234.745n 1.0v 234.755n 1.0v 239.745n 1.0v 239.755n 0.0v 244.745n 0.0v 244.755n 0.0v 249.745n 0.0v 249.755n 0.0v 254.745n 0.0v 254.755n 1.0v 259.745n 1.0v 259.755n 0.0v 264.745n 0.0v 264.755n 0.0v 269.745n 0.0v 269.755n 1.0v 274.745n 1.0v 274.755n 1.0v 279.745n 1.0v 279.755n 0.0v 284.745n 0.0v 284.755n 1.0v 289.745n 1.0v 289.755n 1.0v 294.745n 1.0v 294.755n 1.0v 299.745n 1.0v 299.755n 0.0v 304.745n 0.0v 304.755n 0.0v 309.745n 0.0v 309.755n 1.0v 314.745n 1.0v 314.755n 0.0v 319.745n 0.0v 319.755n 0.0v 324.745n 0.0v 324.755n 0.0v 329.745n 0.0v 329.755n 0.0v 334.745n 0.0v 334.755n 1.0v 339.745n 1.0v 339.755n 1.0v 344.745n 1.0v 344.755n 1.0v 349.745n 1.0v 349.755n 0.0v 354.745n 0.0v 354.755n 0.0v 359.745n 0.0v 359.755n 0.0v 364.745n 0.0v 364.755n 0.0v 369.745n 0.0v 369.755n 0.0v 374.745n 0.0v 374.755n 1.0v 379.745n 1.0v 379.755n 1.0v 384.745n 1.0v 384.755n 1.0v 389.745n 1.0v 389.755n 0.0v 394.745n 0.0v 394.755n 1.0v 399.745n 1.0v 399.755n 0.0v 404.745n 0.0v 404.755n 0.0v 409.745n 0.0v 409.755n 1.0v 414.745n 1.0v 414.755n 1.0v 419.745n 1.0v 419.755n 1.0v 424.745n 1.0v 424.755n 1.0v 429.745n 1.0v 429.755n 0.0v 434.745n 0.0v 434.755n 0.0v 439.745n 0.0v 439.755n 0.0v 444.745n 0.0v 444.755n 0.0v 449.745n 0.0v 449.755n 1.0v 454.745n 1.0v 454.755n 1.0v 459.745n 1.0v 459.755n 1.0v 464.745n 1.0v 464.755n 1.0v 469.745n 1.0v 469.755n 0.0v 474.745n 0.0v 474.755n 1.0v 479.745n 1.0v 479.755n 1.0v 484.745n 1.0v 484.755n 0.0v 489.745n 0.0v 489.755n 1.0v 494.745n 1.0v 494.755n 1.0v 499.745n 1.0v 499.755n 0.0v 504.745n 0.0v 504.755n 0.0v 509.745n 0.0v 509.755n 0.0v 514.745n 0.0v 514.755n 0.0v 519.745n 0.0v 519.755n 1.0v 524.745n 1.0v 524.755n 1.0v 529.745n 1.0v 529.755n 0.0v 534.745n 0.0v 534.755n 0.0v 539.745n 0.0v 539.755n 1.0v 544.745n 1.0v 544.755n 1.0v 549.745n 1.0v 549.755n 1.0v 554.745n 1.0v 554.755n 1.0v 559.745n 1.0v 559.755n 1.0v 564.745n 1.0v 564.755n 0.0v 569.745n 0.0v 569.755n 0.0v 574.745n 0.0v 574.755n 1.0v 579.745n 1.0v 579.755n 0.0v 584.745n 0.0v 584.755n 0.0v 589.745n 0.0v 589.755n 0.0v 594.745n 0.0v 594.755n 1.0v 599.745n 1.0v 599.755n 0.0v 604.745n 0.0v 604.755n 0.0v 609.745n 0.0v 609.755n 1.0v 614.745n 1.0v 614.755n 1.0v 619.745n 1.0v 619.755n 1.0v 624.745n 1.0v 624.755n 0.0v 629.745n 0.0v 629.755n 1.0v 634.745n 1.0v 634.755n 1.0v 639.745n 1.0v 639.755n 1.0v 644.745n 1.0v 644.755n 1.0v 649.745n 1.0v 649.755n 1.0v 654.745n 1.0v 654.755n 0.0v 659.745n 0.0v 659.755n 1.0v 664.745n 1.0v 664.755n 0.0v 669.745n 0.0v 669.755n 1.0v 674.745n 1.0v 674.755n 1.0v 679.745n 1.0v 679.755n 1.0v 684.745n 1.0v 684.755n 1.0v 689.745n 1.0v 689.755n 1.0v 694.745n 1.0v 694.755n 1.0v 699.745n 1.0v 699.755n 0.0v 704.745n 0.0v 704.755n 0.0v 709.745n 0.0v 709.755n 0.0v 714.745n 0.0v 714.755n 0.0v 719.745n 0.0v 719.755n 0.0v 724.745n 0.0v 724.755n 1.0v 729.745n 1.0v 729.755n 1.0v 734.745n 1.0v 734.755n 1.0v 739.745n 1.0v 739.755n 1.0v 744.745n 1.0v 744.755n 0.0v 749.745n 0.0v 749.755n 0.0v 754.745n 0.0v 754.755n 0.0v 759.745n 0.0v 759.755n 0.0v 764.745n 0.0v 764.755n 0.0v 769.745n 0.0v 769.755n 0.0v 774.745n 0.0v 774.755n 1.0v 779.745n 1.0v 779.755n 0.0v 784.745n 0.0v 784.755n 0.0v 789.745n 0.0v 789.755n 0.0v 794.745n 0.0v 794.755n 0.0v 799.745n 0.0v 799.755n 1.0v 804.745n 1.0v 804.755n 0.0v 809.745n 0.0v 809.755n 0.0v 814.745n 0.0v 814.755n 0.0v 819.745n 0.0v 819.755n 0.0v 824.745n 0.0v 824.755n 0.0v 829.745n 0.0v 829.755n 0.0v 834.745n 0.0v 834.755n 0.0v 839.745n 0.0v 839.755n 0.0v 844.745n 0.0v 844.755n 1.0v 849.745n 1.0v 849.755n 1.0v 854.745n 1.0v 854.755n 1.0v 859.745n 1.0v 859.755n 1.0v 864.745n 1.0v 864.755n 1.0v 869.745n 1.0v 869.755n 0.0v 874.745n 0.0v 874.755n 1.0v 879.745n 1.0v 879.755n 1.0v 884.745n 1.0v 884.755n 0.0v 889.745n 0.0v 889.755n 0.0v 894.745n 0.0v 894.755n 0.0v 899.745n 0.0v 899.755n 1.0v 904.745n 1.0v 904.755n 1.0v 909.745n 1.0v 909.755n 0.0v 914.745n 0.0v 914.755n 1.0v 919.745n 1.0v 919.755n 0.0v 924.745n 0.0v 924.755n 0.0v 929.745n 0.0v 929.755n 1.0v 934.745n 1.0v 934.755n 0.0v 939.745n 0.0v 939.755n 1.0v 944.745n 1.0v 944.755n 1.0v 949.745n 1.0v 949.755n 1.0v 954.745n 1.0v 954.755n 1.0v 959.745n 1.0v 959.755n 1.0v 964.745n 1.0v 964.755n 1.0v 969.745n 1.0v 969.755n 1.0v 974.745n 1.0v 974.755n 0.0v 979.745n 0.0v 979.755n 1.0v 984.745n 1.0v 984.755n 0.0v 989.745n 0.0v 989.755n 0.0v 994.745n 0.0v 994.755n 0.0v 999.745n 0.0v 999.755n 0.0v 1004.745n 0.0v 1004.755n 0.0v 1009.745n 0.0v 1009.755n 0.0v 1014.745n 0.0v 1014.755n 1.0v 1019.745n 1.0v 1019.755n 1.0v 1024.745n 1.0v 1024.755n 1.0v )
* (time, data): [(0, 0), (5, 1), (10, 0), (15, 0), (20, 1), (25, 1), (30, 1), (35, 0), (40, 0), (45, 1), (50, 0), (55, 0), (60, 0), (65, 0), (70, 0), (75, 1), (80, 0), (85, 0), (90, 1), (95, 0), (100, 0), (105, 0), (110, 0), (115, 0), (120, 0), (125, 1), (130, 0), (135, 1), (140, 1), (145, 1), (150, 0), (155, 0), (160, 1), (165, 0), (170, 0), (175, 0), (180, 0), (185, 1), (190, 1), (195, 1), (200, 1), (205, 1), (210, 0), (215, 0), (220, 1), (225, 1), (230, 1), (235, 1), (240, 0), (245, 0), (250, 0), (255, 1), (260, 0), (265, 0), (270, 1), (275, 1), (280, 0), (285, 1), (290, 1), (295, 1), (300, 0), (305, 0), (310, 1), (315, 0), (320, 0), (325, 0), (330, 0), (335, 1), (340, 1), (345, 1), (350, 0), (355, 0), (360, 0), (365, 0), (370, 0), (375, 1), (380, 1), (385, 1), (390, 0), (395, 1), (400, 0), (405, 0), (410, 1), (415, 1), (420, 1), (425, 1), (430, 0), (435, 0), (440, 0), (445, 0), (450, 1), (455, 1), (460, 1), (465, 1), (470, 0), (475, 1), (480, 1), (485, 0), (490, 1), (495, 1), (500, 0), (505, 0), (510, 0), (515, 0), (520, 1), (525, 1), (530, 0), (535, 0), (540, 1), (545, 1), (550, 1), (555, 1), (560, 1), (565, 0), (570, 0), (575, 1), (580, 0), (585, 0), (590, 0), (595, 1), (600, 0), (605, 0), (610, 1), (615, 1), (620, 1), (625, 0), (630, 1), (635, 1), (640, 1), (645, 1), (650, 1), (655, 0), (660, 1), (665, 0), (670, 1), (675, 1), (680, 1), (685, 1), (690, 1), (695, 1), (700, 0), (705, 0), (710, 0), (715, 0), (720, 0), (725, 1), (730, 1), (735, 1), (740, 1), (745, 0), (750, 0), (755, 0), (760, 0), (765, 0), (770, 0), (775, 1), (780, 0), (785, 0), (790, 0), (795, 0), (800, 1), (805, 0), (810, 0), (815, 0), (820, 0), (825, 0), (830, 0), (835, 0), (840, 0), (845, 1), (850, 1), (855, 1), (860, 1), (865, 1), (870, 0), (875, 1), (880, 1), (885, 0), (890, 0), (895, 0), (900, 1), (905, 1), (910, 0), (915, 1), (920, 0), (925, 0), (930, 1), (935, 0), (940, 1), (945, 1), (950, 1), (955, 1), (960, 1), (965, 1), (970, 1), (975, 0), (980, 1), (985, 0), (990, 0), (995, 0), (1000, 0), (1005, 0), (1010, 0), (1015, 1), (1020, 1), (1025, 1)]
Va1_8  a1_8  0 PWL (0n 0.0v 4.745n 0.0v 4.755n 1.0v 9.745n 1.0v 9.755n 0.0v 14.745n 0.0v 14.755n 0.0v 19.745n 0.0v 19.755n 1.0v 24.745n 1.0v 24.755n 1.0v 29.745n 1.0v 29.755n 1.0v 34.745n 1.0v 34.755n 0.0v 39.745n 0.0v 39.755n 0.0v 44.745n 0.0v 44.755n 1.0v 49.745n 1.0v 49.755n 0.0v 54.745n 0.0v 54.755n 0.0v 59.745n 0.0v 59.755n 0.0v 64.745n 0.0v 64.755n 0.0v 69.745n 0.0v 69.755n 0.0v 74.745n 0.0v 74.755n 1.0v 79.745n 1.0v 79.755n 0.0v 84.745n 0.0v 84.755n 0.0v 89.745n 0.0v 89.755n 1.0v 94.745n 1.0v 94.755n 0.0v 99.745n 0.0v 99.755n 0.0v 104.745n 0.0v 104.755n 0.0v 109.745n 0.0v 109.755n 0.0v 114.745n 0.0v 114.755n 0.0v 119.745n 0.0v 119.755n 0.0v 124.745n 0.0v 124.755n 1.0v 129.745n 1.0v 129.755n 0.0v 134.745n 0.0v 134.755n 1.0v 139.745n 1.0v 139.755n 1.0v 144.745n 1.0v 144.755n 1.0v 149.745n 1.0v 149.755n 0.0v 154.745n 0.0v 154.755n 0.0v 159.745n 0.0v 159.755n 1.0v 164.745n 1.0v 164.755n 0.0v 169.745n 0.0v 169.755n 0.0v 174.745n 0.0v 174.755n 0.0v 179.745n 0.0v 179.755n 0.0v 184.745n 0.0v 184.755n 1.0v 189.745n 1.0v 189.755n 1.0v 194.745n 1.0v 194.755n 1.0v 199.745n 1.0v 199.755n 1.0v 204.745n 1.0v 204.755n 1.0v 209.745n 1.0v 209.755n 0.0v 214.745n 0.0v 214.755n 0.0v 219.745n 0.0v 219.755n 1.0v 224.745n 1.0v 224.755n 1.0v 229.745n 1.0v 229.755n 1.0v 234.745n 1.0v 234.755n 1.0v 239.745n 1.0v 239.755n 0.0v 244.745n 0.0v 244.755n 0.0v 249.745n 0.0v 249.755n 0.0v 254.745n 0.0v 254.755n 1.0v 259.745n 1.0v 259.755n 0.0v 264.745n 0.0v 264.755n 0.0v 269.745n 0.0v 269.755n 1.0v 274.745n 1.0v 274.755n 1.0v 279.745n 1.0v 279.755n 0.0v 284.745n 0.0v 284.755n 1.0v 289.745n 1.0v 289.755n 1.0v 294.745n 1.0v 294.755n 1.0v 299.745n 1.0v 299.755n 0.0v 304.745n 0.0v 304.755n 0.0v 309.745n 0.0v 309.755n 1.0v 314.745n 1.0v 314.755n 0.0v 319.745n 0.0v 319.755n 0.0v 324.745n 0.0v 324.755n 0.0v 329.745n 0.0v 329.755n 0.0v 334.745n 0.0v 334.755n 1.0v 339.745n 1.0v 339.755n 1.0v 344.745n 1.0v 344.755n 1.0v 349.745n 1.0v 349.755n 0.0v 354.745n 0.0v 354.755n 0.0v 359.745n 0.0v 359.755n 0.0v 364.745n 0.0v 364.755n 0.0v 369.745n 0.0v 369.755n 0.0v 374.745n 0.0v 374.755n 1.0v 379.745n 1.0v 379.755n 1.0v 384.745n 1.0v 384.755n 1.0v 389.745n 1.0v 389.755n 0.0v 394.745n 0.0v 394.755n 1.0v 399.745n 1.0v 399.755n 0.0v 404.745n 0.0v 404.755n 0.0v 409.745n 0.0v 409.755n 1.0v 414.745n 1.0v 414.755n 1.0v 419.745n 1.0v 419.755n 1.0v 424.745n 1.0v 424.755n 1.0v 429.745n 1.0v 429.755n 0.0v 434.745n 0.0v 434.755n 0.0v 439.745n 0.0v 439.755n 0.0v 444.745n 0.0v 444.755n 0.0v 449.745n 0.0v 449.755n 1.0v 454.745n 1.0v 454.755n 1.0v 459.745n 1.0v 459.755n 1.0v 464.745n 1.0v 464.755n 1.0v 469.745n 1.0v 469.755n 0.0v 474.745n 0.0v 474.755n 1.0v 479.745n 1.0v 479.755n 1.0v 484.745n 1.0v 484.755n 0.0v 489.745n 0.0v 489.755n 1.0v 494.745n 1.0v 494.755n 1.0v 499.745n 1.0v 499.755n 0.0v 504.745n 0.0v 504.755n 0.0v 509.745n 0.0v 509.755n 0.0v 514.745n 0.0v 514.755n 0.0v 519.745n 0.0v 519.755n 1.0v 524.745n 1.0v 524.755n 1.0v 529.745n 1.0v 529.755n 0.0v 534.745n 0.0v 534.755n 0.0v 539.745n 0.0v 539.755n 1.0v 544.745n 1.0v 544.755n 1.0v 549.745n 1.0v 549.755n 1.0v 554.745n 1.0v 554.755n 1.0v 559.745n 1.0v 559.755n 1.0v 564.745n 1.0v 564.755n 0.0v 569.745n 0.0v 569.755n 0.0v 574.745n 0.0v 574.755n 1.0v 579.745n 1.0v 579.755n 0.0v 584.745n 0.0v 584.755n 0.0v 589.745n 0.0v 589.755n 0.0v 594.745n 0.0v 594.755n 1.0v 599.745n 1.0v 599.755n 0.0v 604.745n 0.0v 604.755n 0.0v 609.745n 0.0v 609.755n 1.0v 614.745n 1.0v 614.755n 1.0v 619.745n 1.0v 619.755n 1.0v 624.745n 1.0v 624.755n 0.0v 629.745n 0.0v 629.755n 1.0v 634.745n 1.0v 634.755n 1.0v 639.745n 1.0v 639.755n 1.0v 644.745n 1.0v 644.755n 1.0v 649.745n 1.0v 649.755n 1.0v 654.745n 1.0v 654.755n 0.0v 659.745n 0.0v 659.755n 1.0v 664.745n 1.0v 664.755n 0.0v 669.745n 0.0v 669.755n 1.0v 674.745n 1.0v 674.755n 1.0v 679.745n 1.0v 679.755n 1.0v 684.745n 1.0v 684.755n 1.0v 689.745n 1.0v 689.755n 1.0v 694.745n 1.0v 694.755n 1.0v 699.745n 1.0v 699.755n 0.0v 704.745n 0.0v 704.755n 0.0v 709.745n 0.0v 709.755n 0.0v 714.745n 0.0v 714.755n 0.0v 719.745n 0.0v 719.755n 0.0v 724.745n 0.0v 724.755n 1.0v 729.745n 1.0v 729.755n 1.0v 734.745n 1.0v 734.755n 1.0v 739.745n 1.0v 739.755n 1.0v 744.745n 1.0v 744.755n 0.0v 749.745n 0.0v 749.755n 0.0v 754.745n 0.0v 754.755n 0.0v 759.745n 0.0v 759.755n 0.0v 764.745n 0.0v 764.755n 0.0v 769.745n 0.0v 769.755n 0.0v 774.745n 0.0v 774.755n 1.0v 779.745n 1.0v 779.755n 0.0v 784.745n 0.0v 784.755n 0.0v 789.745n 0.0v 789.755n 0.0v 794.745n 0.0v 794.755n 0.0v 799.745n 0.0v 799.755n 1.0v 804.745n 1.0v 804.755n 0.0v 809.745n 0.0v 809.755n 0.0v 814.745n 0.0v 814.755n 0.0v 819.745n 0.0v 819.755n 0.0v 824.745n 0.0v 824.755n 0.0v 829.745n 0.0v 829.755n 0.0v 834.745n 0.0v 834.755n 0.0v 839.745n 0.0v 839.755n 0.0v 844.745n 0.0v 844.755n 1.0v 849.745n 1.0v 849.755n 1.0v 854.745n 1.0v 854.755n 1.0v 859.745n 1.0v 859.755n 1.0v 864.745n 1.0v 864.755n 1.0v 869.745n 1.0v 869.755n 0.0v 874.745n 0.0v 874.755n 1.0v 879.745n 1.0v 879.755n 1.0v 884.745n 1.0v 884.755n 0.0v 889.745n 0.0v 889.755n 0.0v 894.745n 0.0v 894.755n 0.0v 899.745n 0.0v 899.755n 1.0v 904.745n 1.0v 904.755n 1.0v 909.745n 1.0v 909.755n 0.0v 914.745n 0.0v 914.755n 1.0v 919.745n 1.0v 919.755n 0.0v 924.745n 0.0v 924.755n 0.0v 929.745n 0.0v 929.755n 1.0v 934.745n 1.0v 934.755n 0.0v 939.745n 0.0v 939.755n 1.0v 944.745n 1.0v 944.755n 1.0v 949.745n 1.0v 949.755n 1.0v 954.745n 1.0v 954.755n 1.0v 959.745n 1.0v 959.755n 1.0v 964.745n 1.0v 964.755n 1.0v 969.745n 1.0v 969.755n 1.0v 974.745n 1.0v 974.755n 0.0v 979.745n 0.0v 979.755n 1.0v 984.745n 1.0v 984.755n 0.0v 989.745n 0.0v 989.755n 0.0v 994.745n 0.0v 994.755n 0.0v 999.745n 0.0v 999.755n 0.0v 1004.745n 0.0v 1004.755n 0.0v 1009.745n 0.0v 1009.755n 0.0v 1014.745n 0.0v 1014.755n 1.0v 1019.745n 1.0v 1019.755n 1.0v 1024.745n 1.0v 1024.755n 1.0v )

 * Generation of control signals
* (time, data): [(0, 1), (5, 0), (10, 0), (15, 0), (20, 0), (25, 0), (30, 0), (35, 0), (40, 0), (45, 0), (50, 1), (55, 0), (60, 1), (65, 0), (70, 0), (75, 1), (80, 0), (85, 1), (90, 1), (95, 0), (100, 1), (105, 0), (110, 0), (115, 1), (120, 1), (125, 0), (130, 0), (135, 1), (140, 0), (145, 0), (150, 0), (155, 0), (160, 1), (165, 0), (170, 0), (175, 1), (180, 0), (185, 0), (190, 0), (195, 0), (200, 0), (205, 1), (210, 1), (215, 0), (220, 0), (225, 0), (230, 0), (235, 0), (240, 0), (245, 0), (250, 0), (255, 0), (260, 0), (265, 1), (270, 0), (275, 0), (280, 0), (285, 0), (290, 0), (295, 0), (300, 0), (305, 0), (310, 1), (315, 0), (320, 0), (325, 1), (330, 1), (335, 0), (340, 0), (345, 0), (350, 0), (355, 1), (360, 0), (365, 0), (370, 1), (375, 0), (380, 0), (385, 1), (390, 1), (395, 0), (400, 0), (405, 0), (410, 1), (415, 0), (420, 0), (425, 0), (430, 1), (435, 0), (440, 1), (445, 1), (450, 0), (455, 0), (460, 1), (465, 0), (470, 1), (475, 0), (480, 0), (485, 0), (490, 0), (495, 1), (500, 0), (505, 0), (510, 0), (515, 0), (520, 1), (525, 0), (530, 0), (535, 0), (540, 0), (545, 0), (550, 0), (555, 1), (560, 1), (565, 1), (570, 0), (575, 0), (580, 1), (585, 0), (590, 0), (595, 0), (600, 1), (605, 0), (610, 0), (615, 0), (620, 1), (625, 0), (630, 1), (635, 0), (640, 0), (645, 0), (650, 1), (655, 0), (660, 0), (665, 0), (670, 0), (675, 0), (680, 0), (685, 0), (690, 1), (695, 0), (700, 1), (705, 0), (710, 0), (715, 1), (720, 0), (725, 0), (730, 0), (735, 0), (740, 1), (745, 1), (750, 1), (755, 0), (760, 0), (765, 0), (770, 0), (775, 1), (780, 0), (785, 1), (790, 0), (795, 0), (800, 0), (805, 0), (810, 1), (815, 1), (820, 0), (825, 0), (830, 0), (835, 0), (840, 0), (845, 0), (850, 0), (855, 1), (860, 0), (865, 0), (870, 1), (875, 0), (880, 0), (885, 0), (890, 0), (895, 0), (900, 1), (905, 0), (910, 0), (915, 0), (920, 0), (925, 1), (930, 0), (935, 0), (940, 0), (945, 1), (950, 0), (955, 0), (960, 0), (965, 0), (970, 0), (975, 0), (980, 0), (985, 0), (990, 0), (995, 0), (1000, 0), (1005, 0), (1010, 0), (1015, 0), (1020, 0), (1025, 1)]
VCSB0 CSB0 0 PWL (0n 1.0v 4.745n 1.0v 4.755n 0.0v 9.745n 0.0v 9.755n 0.0v 14.745n 0.0v 14.755n 0.0v 19.745n 0.0v 19.755n 0.0v 24.745n 0.0v 24.755n 0.0v 29.745n 0.0v 29.755n 0.0v 34.745n 0.0v 34.755n 0.0v 39.745n 0.0v 39.755n 0.0v 44.745n 0.0v 44.755n 0.0v 49.745n 0.0v 49.755n 1.0v 54.745n 1.0v 54.755n 0.0v 59.745n 0.0v 59.755n 1.0v 64.745n 1.0v 64.755n 0.0v 69.745n 0.0v 69.755n 0.0v 74.745n 0.0v 74.755n 1.0v 79.745n 1.0v 79.755n 0.0v 84.745n 0.0v 84.755n 1.0v 89.745n 1.0v 89.755n 1.0v 94.745n 1.0v 94.755n 0.0v 99.745n 0.0v 99.755n 1.0v 104.745n 1.0v 104.755n 0.0v 109.745n 0.0v 109.755n 0.0v 114.745n 0.0v 114.755n 1.0v 119.745n 1.0v 119.755n 1.0v 124.745n 1.0v 124.755n 0.0v 129.745n 0.0v 129.755n 0.0v 134.745n 0.0v 134.755n 1.0v 139.745n 1.0v 139.755n 0.0v 144.745n 0.0v 144.755n 0.0v 149.745n 0.0v 149.755n 0.0v 154.745n 0.0v 154.755n 0.0v 159.745n 0.0v 159.755n 1.0v 164.745n 1.0v 164.755n 0.0v 169.745n 0.0v 169.755n 0.0v 174.745n 0.0v 174.755n 1.0v 179.745n 1.0v 179.755n 0.0v 184.745n 0.0v 184.755n 0.0v 189.745n 0.0v 189.755n 0.0v 194.745n 0.0v 194.755n 0.0v 199.745n 0.0v 199.755n 0.0v 204.745n 0.0v 204.755n 1.0v 209.745n 1.0v 209.755n 1.0v 214.745n 1.0v 214.755n 0.0v 219.745n 0.0v 219.755n 0.0v 224.745n 0.0v 224.755n 0.0v 229.745n 0.0v 229.755n 0.0v 234.745n 0.0v 234.755n 0.0v 239.745n 0.0v 239.755n 0.0v 244.745n 0.0v 244.755n 0.0v 249.745n 0.0v 249.755n 0.0v 254.745n 0.0v 254.755n 0.0v 259.745n 0.0v 259.755n 0.0v 264.745n 0.0v 264.755n 1.0v 269.745n 1.0v 269.755n 0.0v 274.745n 0.0v 274.755n 0.0v 279.745n 0.0v 279.755n 0.0v 284.745n 0.0v 284.755n 0.0v 289.745n 0.0v 289.755n 0.0v 294.745n 0.0v 294.755n 0.0v 299.745n 0.0v 299.755n 0.0v 304.745n 0.0v 304.755n 0.0v 309.745n 0.0v 309.755n 1.0v 314.745n 1.0v 314.755n 0.0v 319.745n 0.0v 319.755n 0.0v 324.745n 0.0v 324.755n 1.0v 329.745n 1.0v 329.755n 1.0v 334.745n 1.0v 334.755n 0.0v 339.745n 0.0v 339.755n 0.0v 344.745n 0.0v 344.755n 0.0v 349.745n 0.0v 349.755n 0.0v 354.745n 0.0v 354.755n 1.0v 359.745n 1.0v 359.755n 0.0v 364.745n 0.0v 364.755n 0.0v 369.745n 0.0v 369.755n 1.0v 374.745n 1.0v 374.755n 0.0v 379.745n 0.0v 379.755n 0.0v 384.745n 0.0v 384.755n 1.0v 389.745n 1.0v 389.755n 1.0v 394.745n 1.0v 394.755n 0.0v 399.745n 0.0v 399.755n 0.0v 404.745n 0.0v 404.755n 0.0v 409.745n 0.0v 409.755n 1.0v 414.745n 1.0v 414.755n 0.0v 419.745n 0.0v 419.755n 0.0v 424.745n 0.0v 424.755n 0.0v 429.745n 0.0v 429.755n 1.0v 434.745n 1.0v 434.755n 0.0v 439.745n 0.0v 439.755n 1.0v 444.745n 1.0v 444.755n 1.0v 449.745n 1.0v 449.755n 0.0v 454.745n 0.0v 454.755n 0.0v 459.745n 0.0v 459.755n 1.0v 464.745n 1.0v 464.755n 0.0v 469.745n 0.0v 469.755n 1.0v 474.745n 1.0v 474.755n 0.0v 479.745n 0.0v 479.755n 0.0v 484.745n 0.0v 484.755n 0.0v 489.745n 0.0v 489.755n 0.0v 494.745n 0.0v 494.755n 1.0v 499.745n 1.0v 499.755n 0.0v 504.745n 0.0v 504.755n 0.0v 509.745n 0.0v 509.755n 0.0v 514.745n 0.0v 514.755n 0.0v 519.745n 0.0v 519.755n 1.0v 524.745n 1.0v 524.755n 0.0v 529.745n 0.0v 529.755n 0.0v 534.745n 0.0v 534.755n 0.0v 539.745n 0.0v 539.755n 0.0v 544.745n 0.0v 544.755n 0.0v 549.745n 0.0v 549.755n 0.0v 554.745n 0.0v 554.755n 1.0v 559.745n 1.0v 559.755n 1.0v 564.745n 1.0v 564.755n 1.0v 569.745n 1.0v 569.755n 0.0v 574.745n 0.0v 574.755n 0.0v 579.745n 0.0v 579.755n 1.0v 584.745n 1.0v 584.755n 0.0v 589.745n 0.0v 589.755n 0.0v 594.745n 0.0v 594.755n 0.0v 599.745n 0.0v 599.755n 1.0v 604.745n 1.0v 604.755n 0.0v 609.745n 0.0v 609.755n 0.0v 614.745n 0.0v 614.755n 0.0v 619.745n 0.0v 619.755n 1.0v 624.745n 1.0v 624.755n 0.0v 629.745n 0.0v 629.755n 1.0v 634.745n 1.0v 634.755n 0.0v 639.745n 0.0v 639.755n 0.0v 644.745n 0.0v 644.755n 0.0v 649.745n 0.0v 649.755n 1.0v 654.745n 1.0v 654.755n 0.0v 659.745n 0.0v 659.755n 0.0v 664.745n 0.0v 664.755n 0.0v 669.745n 0.0v 669.755n 0.0v 674.745n 0.0v 674.755n 0.0v 679.745n 0.0v 679.755n 0.0v 684.745n 0.0v 684.755n 0.0v 689.745n 0.0v 689.755n 1.0v 694.745n 1.0v 694.755n 0.0v 699.745n 0.0v 699.755n 1.0v 704.745n 1.0v 704.755n 0.0v 709.745n 0.0v 709.755n 0.0v 714.745n 0.0v 714.755n 1.0v 719.745n 1.0v 719.755n 0.0v 724.745n 0.0v 724.755n 0.0v 729.745n 0.0v 729.755n 0.0v 734.745n 0.0v 734.755n 0.0v 739.745n 0.0v 739.755n 1.0v 744.745n 1.0v 744.755n 1.0v 749.745n 1.0v 749.755n 1.0v 754.745n 1.0v 754.755n 0.0v 759.745n 0.0v 759.755n 0.0v 764.745n 0.0v 764.755n 0.0v 769.745n 0.0v 769.755n 0.0v 774.745n 0.0v 774.755n 1.0v 779.745n 1.0v 779.755n 0.0v 784.745n 0.0v 784.755n 1.0v 789.745n 1.0v 789.755n 0.0v 794.745n 0.0v 794.755n 0.0v 799.745n 0.0v 799.755n 0.0v 804.745n 0.0v 804.755n 0.0v 809.745n 0.0v 809.755n 1.0v 814.745n 1.0v 814.755n 1.0v 819.745n 1.0v 819.755n 0.0v 824.745n 0.0v 824.755n 0.0v 829.745n 0.0v 829.755n 0.0v 834.745n 0.0v 834.755n 0.0v 839.745n 0.0v 839.755n 0.0v 844.745n 0.0v 844.755n 0.0v 849.745n 0.0v 849.755n 0.0v 854.745n 0.0v 854.755n 1.0v 859.745n 1.0v 859.755n 0.0v 864.745n 0.0v 864.755n 0.0v 869.745n 0.0v 869.755n 1.0v 874.745n 1.0v 874.755n 0.0v 879.745n 0.0v 879.755n 0.0v 884.745n 0.0v 884.755n 0.0v 889.745n 0.0v 889.755n 0.0v 894.745n 0.0v 894.755n 0.0v 899.745n 0.0v 899.755n 1.0v 904.745n 1.0v 904.755n 0.0v 909.745n 0.0v 909.755n 0.0v 914.745n 0.0v 914.755n 0.0v 919.745n 0.0v 919.755n 0.0v 924.745n 0.0v 924.755n 1.0v 929.745n 1.0v 929.755n 0.0v 934.745n 0.0v 934.755n 0.0v 939.745n 0.0v 939.755n 0.0v 944.745n 0.0v 944.755n 1.0v 949.745n 1.0v 949.755n 0.0v 954.745n 0.0v 954.755n 0.0v 959.745n 0.0v 959.755n 0.0v 964.745n 0.0v 964.755n 0.0v 969.745n 0.0v 969.755n 0.0v 974.745n 0.0v 974.755n 0.0v 979.745n 0.0v 979.755n 0.0v 984.745n 0.0v 984.755n 0.0v 989.745n 0.0v 989.755n 0.0v 994.745n 0.0v 994.755n 0.0v 999.745n 0.0v 999.755n 0.0v 1004.745n 0.0v 1004.755n 0.0v 1009.745n 0.0v 1009.755n 0.0v 1014.745n 0.0v 1014.755n 0.0v 1019.745n 0.0v 1019.755n 0.0v 1024.745n 0.0v 1024.755n 1.0v )
* (time, data): [(0, 1), (5, 0), (10, 0), (15, 0), (20, 0), (25, 1), (30, 1), (35, 0), (40, 0), (45, 0), (50, 0), (55, 0), (60, 0), (65, 0), (70, 1), (75, 0), (80, 0), (85, 0), (90, 0), (95, 0), (100, 0), (105, 0), (110, 0), (115, 0), (120, 0), (125, 0), (130, 0), (135, 0), (140, 1), (145, 0), (150, 0), (155, 0), (160, 0), (165, 0), (170, 0), (175, 1), (180, 0), (185, 0), (190, 1), (195, 1), (200, 0), (205, 0), (210, 0), (215, 0), (220, 0), (225, 0), (230, 0), (235, 1), (240, 0), (245, 0), (250, 0), (255, 0), (260, 0), (265, 0), (270, 0), (275, 0), (280, 0), (285, 0), (290, 1), (295, 0), (300, 0), (305, 0), (310, 0), (315, 0), (320, 0), (325, 1), (330, 0), (335, 0), (340, 1), (345, 0), (350, 0), (355, 0), (360, 0), (365, 0), (370, 0), (375, 0), (380, 1), (385, 1), (390, 0), (395, 0), (400, 0), (405, 0), (410, 0), (415, 1), (420, 1), (425, 0), (430, 0), (435, 1), (440, 0), (445, 0), (450, 0), (455, 1), (460, 1), (465, 1), (470, 0), (475, 0), (480, 1), (485, 0), (490, 0), (495, 0), (500, 0), (505, 1), (510, 1), (515, 0), (520, 0), (525, 1), (530, 0), (535, 0), (540, 0), (545, 1), (550, 0), (555, 0), (560, 0), (565, 0), (570, 1), (575, 0), (580, 0), (585, 1), (590, 1), (595, 0), (600, 0), (605, 1), (610, 0), (615, 1), (620, 1), (625, 0), (630, 0), (635, 1), (640, 1), (645, 0), (650, 0), (655, 0), (660, 0), (665, 0), (670, 0), (675, 1), (680, 1), (685, 0), (690, 0), (695, 1), (700, 0), (705, 1), (710, 0), (715, 0), (720, 1), (725, 0), (730, 0), (735, 1), (740, 1), (745, 0), (750, 1), (755, 0), (760, 0), (765, 1), (770, 1), (775, 0), (780, 0), (785, 0), (790, 1), (795, 1), (800, 0), (805, 0), (810, 0), (815, 1), (820, 1), (825, 0), (830, 0), (835, 0), (840, 0), (845, 0), (850, 0), (855, 1), (860, 0), (865, 0), (870, 0), (875, 0), (880, 0), (885, 0), (890, 1), (895, 1), (900, 0), (905, 0), (910, 0), (915, 0), (920, 0), (925, 1), (930, 0), (935, 0), (940, 0), (945, 0), (950, 0), (955, 0), (960, 1), (965, 0), (970, 0), (975, 0), (980, 0), (985, 0), (990, 1), (995, 1), (1000, 1), (1005, 0), (1010, 1), (1015, 0), (1020, 1), (1025, 1)]
VCSB1 CSB1 0 PWL (0n 1.0v 4.745n 1.0v 4.755n 0.0v 9.745n 0.0v 9.755n 0.0v 14.745n 0.0v 14.755n 0.0v 19.745n 0.0v 19.755n 0.0v 24.745n 0.0v 24.755n 1.0v 29.745n 1.0v 29.755n 1.0v 34.745n 1.0v 34.755n 0.0v 39.745n 0.0v 39.755n 0.0v 44.745n 0.0v 44.755n 0.0v 49.745n 0.0v 49.755n 0.0v 54.745n 0.0v 54.755n 0.0v 59.745n 0.0v 59.755n 0.0v 64.745n 0.0v 64.755n 0.0v 69.745n 0.0v 69.755n 1.0v 74.745n 1.0v 74.755n 0.0v 79.745n 0.0v 79.755n 0.0v 84.745n 0.0v 84.755n 0.0v 89.745n 0.0v 89.755n 0.0v 94.745n 0.0v 94.755n 0.0v 99.745n 0.0v 99.755n 0.0v 104.745n 0.0v 104.755n 0.0v 109.745n 0.0v 109.755n 0.0v 114.745n 0.0v 114.755n 0.0v 119.745n 0.0v 119.755n 0.0v 124.745n 0.0v 124.755n 0.0v 129.745n 0.0v 129.755n 0.0v 134.745n 0.0v 134.755n 0.0v 139.745n 0.0v 139.755n 1.0v 144.745n 1.0v 144.755n 0.0v 149.745n 0.0v 149.755n 0.0v 154.745n 0.0v 154.755n 0.0v 159.745n 0.0v 159.755n 0.0v 164.745n 0.0v 164.755n 0.0v 169.745n 0.0v 169.755n 0.0v 174.745n 0.0v 174.755n 1.0v 179.745n 1.0v 179.755n 0.0v 184.745n 0.0v 184.755n 0.0v 189.745n 0.0v 189.755n 1.0v 194.745n 1.0v 194.755n 1.0v 199.745n 1.0v 199.755n 0.0v 204.745n 0.0v 204.755n 0.0v 209.745n 0.0v 209.755n 0.0v 214.745n 0.0v 214.755n 0.0v 219.745n 0.0v 219.755n 0.0v 224.745n 0.0v 224.755n 0.0v 229.745n 0.0v 229.755n 0.0v 234.745n 0.0v 234.755n 1.0v 239.745n 1.0v 239.755n 0.0v 244.745n 0.0v 244.755n 0.0v 249.745n 0.0v 249.755n 0.0v 254.745n 0.0v 254.755n 0.0v 259.745n 0.0v 259.755n 0.0v 264.745n 0.0v 264.755n 0.0v 269.745n 0.0v 269.755n 0.0v 274.745n 0.0v 274.755n 0.0v 279.745n 0.0v 279.755n 0.0v 284.745n 0.0v 284.755n 0.0v 289.745n 0.0v 289.755n 1.0v 294.745n 1.0v 294.755n 0.0v 299.745n 0.0v 299.755n 0.0v 304.745n 0.0v 304.755n 0.0v 309.745n 0.0v 309.755n 0.0v 314.745n 0.0v 314.755n 0.0v 319.745n 0.0v 319.755n 0.0v 324.745n 0.0v 324.755n 1.0v 329.745n 1.0v 329.755n 0.0v 334.745n 0.0v 334.755n 0.0v 339.745n 0.0v 339.755n 1.0v 344.745n 1.0v 344.755n 0.0v 349.745n 0.0v 349.755n 0.0v 354.745n 0.0v 354.755n 0.0v 359.745n 0.0v 359.755n 0.0v 364.745n 0.0v 364.755n 0.0v 369.745n 0.0v 369.755n 0.0v 374.745n 0.0v 374.755n 0.0v 379.745n 0.0v 379.755n 1.0v 384.745n 1.0v 384.755n 1.0v 389.745n 1.0v 389.755n 0.0v 394.745n 0.0v 394.755n 0.0v 399.745n 0.0v 399.755n 0.0v 404.745n 0.0v 404.755n 0.0v 409.745n 0.0v 409.755n 0.0v 414.745n 0.0v 414.755n 1.0v 419.745n 1.0v 419.755n 1.0v 424.745n 1.0v 424.755n 0.0v 429.745n 0.0v 429.755n 0.0v 434.745n 0.0v 434.755n 1.0v 439.745n 1.0v 439.755n 0.0v 444.745n 0.0v 444.755n 0.0v 449.745n 0.0v 449.755n 0.0v 454.745n 0.0v 454.755n 1.0v 459.745n 1.0v 459.755n 1.0v 464.745n 1.0v 464.755n 1.0v 469.745n 1.0v 469.755n 0.0v 474.745n 0.0v 474.755n 0.0v 479.745n 0.0v 479.755n 1.0v 484.745n 1.0v 484.755n 0.0v 489.745n 0.0v 489.755n 0.0v 494.745n 0.0v 494.755n 0.0v 499.745n 0.0v 499.755n 0.0v 504.745n 0.0v 504.755n 1.0v 509.745n 1.0v 509.755n 1.0v 514.745n 1.0v 514.755n 0.0v 519.745n 0.0v 519.755n 0.0v 524.745n 0.0v 524.755n 1.0v 529.745n 1.0v 529.755n 0.0v 534.745n 0.0v 534.755n 0.0v 539.745n 0.0v 539.755n 0.0v 544.745n 0.0v 544.755n 1.0v 549.745n 1.0v 549.755n 0.0v 554.745n 0.0v 554.755n 0.0v 559.745n 0.0v 559.755n 0.0v 564.745n 0.0v 564.755n 0.0v 569.745n 0.0v 569.755n 1.0v 574.745n 1.0v 574.755n 0.0v 579.745n 0.0v 579.755n 0.0v 584.745n 0.0v 584.755n 1.0v 589.745n 1.0v 589.755n 1.0v 594.745n 1.0v 594.755n 0.0v 599.745n 0.0v 599.755n 0.0v 604.745n 0.0v 604.755n 1.0v 609.745n 1.0v 609.755n 0.0v 614.745n 0.0v 614.755n 1.0v 619.745n 1.0v 619.755n 1.0v 624.745n 1.0v 624.755n 0.0v 629.745n 0.0v 629.755n 0.0v 634.745n 0.0v 634.755n 1.0v 639.745n 1.0v 639.755n 1.0v 644.745n 1.0v 644.755n 0.0v 649.745n 0.0v 649.755n 0.0v 654.745n 0.0v 654.755n 0.0v 659.745n 0.0v 659.755n 0.0v 664.745n 0.0v 664.755n 0.0v 669.745n 0.0v 669.755n 0.0v 674.745n 0.0v 674.755n 1.0v 679.745n 1.0v 679.755n 1.0v 684.745n 1.0v 684.755n 0.0v 689.745n 0.0v 689.755n 0.0v 694.745n 0.0v 694.755n 1.0v 699.745n 1.0v 699.755n 0.0v 704.745n 0.0v 704.755n 1.0v 709.745n 1.0v 709.755n 0.0v 714.745n 0.0v 714.755n 0.0v 719.745n 0.0v 719.755n 1.0v 724.745n 1.0v 724.755n 0.0v 729.745n 0.0v 729.755n 0.0v 734.745n 0.0v 734.755n 1.0v 739.745n 1.0v 739.755n 1.0v 744.745n 1.0v 744.755n 0.0v 749.745n 0.0v 749.755n 1.0v 754.745n 1.0v 754.755n 0.0v 759.745n 0.0v 759.755n 0.0v 764.745n 0.0v 764.755n 1.0v 769.745n 1.0v 769.755n 1.0v 774.745n 1.0v 774.755n 0.0v 779.745n 0.0v 779.755n 0.0v 784.745n 0.0v 784.755n 0.0v 789.745n 0.0v 789.755n 1.0v 794.745n 1.0v 794.755n 1.0v 799.745n 1.0v 799.755n 0.0v 804.745n 0.0v 804.755n 0.0v 809.745n 0.0v 809.755n 0.0v 814.745n 0.0v 814.755n 1.0v 819.745n 1.0v 819.755n 1.0v 824.745n 1.0v 824.755n 0.0v 829.745n 0.0v 829.755n 0.0v 834.745n 0.0v 834.755n 0.0v 839.745n 0.0v 839.755n 0.0v 844.745n 0.0v 844.755n 0.0v 849.745n 0.0v 849.755n 0.0v 854.745n 0.0v 854.755n 1.0v 859.745n 1.0v 859.755n 0.0v 864.745n 0.0v 864.755n 0.0v 869.745n 0.0v 869.755n 0.0v 874.745n 0.0v 874.755n 0.0v 879.745n 0.0v 879.755n 0.0v 884.745n 0.0v 884.755n 0.0v 889.745n 0.0v 889.755n 1.0v 894.745n 1.0v 894.755n 1.0v 899.745n 1.0v 899.755n 0.0v 904.745n 0.0v 904.755n 0.0v 909.745n 0.0v 909.755n 0.0v 914.745n 0.0v 914.755n 0.0v 919.745n 0.0v 919.755n 0.0v 924.745n 0.0v 924.755n 1.0v 929.745n 1.0v 929.755n 0.0v 934.745n 0.0v 934.755n 0.0v 939.745n 0.0v 939.755n 0.0v 944.745n 0.0v 944.755n 0.0v 949.745n 0.0v 949.755n 0.0v 954.745n 0.0v 954.755n 0.0v 959.745n 0.0v 959.755n 1.0v 964.745n 1.0v 964.755n 0.0v 969.745n 0.0v 969.755n 0.0v 974.745n 0.0v 974.755n 0.0v 979.745n 0.0v 979.755n 0.0v 984.745n 0.0v 984.755n 0.0v 989.745n 0.0v 989.755n 1.0v 994.745n 1.0v 994.755n 1.0v 999.745n 1.0v 999.755n 1.0v 1004.745n 1.0v 1004.755n 0.0v 1009.745n 0.0v 1009.755n 1.0v 1014.745n 1.0v 1014.755n 0.0v 1019.745n 0.0v 1019.755n 1.0v 1024.745n 1.0v 1024.755n 1.0v )
* (time, data): [(0, 1), (5, 0), (10, 0), (15, 0), (20, 1), (25, 1), (30, 0), (35, 0), (40, 0), (45, 0), (50, 1), (55, 1), (60, 1), (65, 0), (70, 1), (75, 1), (80, 0), (85, 1), (90, 1), (95, 1), (100, 1), (105, 1), (110, 0), (115, 1), (120, 1), (125, 0), (130, 1), (135, 1), (140, 0), (145, 0), (150, 1), (155, 1), (160, 1), (165, 1), (170, 1), (175, 1), (180, 1), (185, 1), (190, 1), (195, 1), (200, 1), (205, 1), (210, 1), (215, 1), (220, 1), (225, 1), (230, 0), (235, 0), (240, 0), (245, 0), (250, 0), (255, 1), (260, 1), (265, 1), (270, 1), (275, 0), (280, 1), (285, 0), (290, 1), (295, 1), (300, 0), (305, 1), (310, 1), (315, 1), (320, 1), (325, 1), (330, 1), (335, 1), (340, 0), (345, 0), (350, 0), (355, 1), (360, 1), (365, 1), (370, 1), (375, 1), (380, 1), (385, 1), (390, 1), (395, 1), (400, 1), (405, 1), (410, 1), (415, 1), (420, 1), (425, 1), (430, 1), (435, 0), (440, 1), (445, 1), (450, 1), (455, 0), (460, 1), (465, 0), (470, 1), (475, 1), (480, 1), (485, 1), (490, 1), (495, 1), (500, 1), (505, 1), (510, 0), (515, 1), (520, 1), (525, 1), (530, 1), (535, 1), (540, 1), (545, 0), (550, 1), (555, 1), (560, 1), (565, 1), (570, 1), (575, 1), (580, 1), (585, 1), (590, 1), (595, 1), (600, 1), (605, 1), (610, 1), (615, 0), (620, 1), (625, 0), (630, 1), (635, 1), (640, 1), (645, 0), (650, 1), (655, 1), (660, 1), (665, 1), (670, 1), (675, 1), (680, 0), (685, 1), (690, 1), (695, 1), (700, 1), (705, 1), (710, 0), (715, 1), (720, 0), (725, 1), (730, 1), (735, 0), (740, 1), (745, 1), (750, 1), (755, 1), (760, 1), (765, 1), (770, 0), (775, 1), (780, 0), (785, 1), (790, 1), (795, 0), (800, 1), (805, 1), (810, 1), (815, 1), (820, 0), (825, 1), (830, 1), (835, 1), (840, 1), (845, 1), (850, 0), (855, 1), (860, 0), (865, 1), (870, 1), (875, 1), (880, 1), (885, 1), (890, 1), (895, 1), (900, 1), (905, 0), (910, 0), (915, 1), (920, 0), (925, 1), (930, 1), (935, 0), (940, 1), (945, 1), (950, 1), (955, 0), (960, 0), (965, 1), (970, 0), (975, 1), (980, 1), (985, 1), (990, 0), (995, 1), (1000, 1), (1005, 1), (1010, 1), (1015, 0), (1020, 1), (1025, 1)]
VWEB0 WEB0 0 PWL (0n 1.0v 4.745n 1.0v 4.755n 0.0v 9.745n 0.0v 9.755n 0.0v 14.745n 0.0v 14.755n 0.0v 19.745n 0.0v 19.755n 1.0v 24.745n 1.0v 24.755n 1.0v 29.745n 1.0v 29.755n 0.0v 34.745n 0.0v 34.755n 0.0v 39.745n 0.0v 39.755n 0.0v 44.745n 0.0v 44.755n 0.0v 49.745n 0.0v 49.755n 1.0v 54.745n 1.0v 54.755n 1.0v 59.745n 1.0v 59.755n 1.0v 64.745n 1.0v 64.755n 0.0v 69.745n 0.0v 69.755n 1.0v 74.745n 1.0v 74.755n 1.0v 79.745n 1.0v 79.755n 0.0v 84.745n 0.0v 84.755n 1.0v 89.745n 1.0v 89.755n 1.0v 94.745n 1.0v 94.755n 1.0v 99.745n 1.0v 99.755n 1.0v 104.745n 1.0v 104.755n 1.0v 109.745n 1.0v 109.755n 0.0v 114.745n 0.0v 114.755n 1.0v 119.745n 1.0v 119.755n 1.0v 124.745n 1.0v 124.755n 0.0v 129.745n 0.0v 129.755n 1.0v 134.745n 1.0v 134.755n 1.0v 139.745n 1.0v 139.755n 0.0v 144.745n 0.0v 144.755n 0.0v 149.745n 0.0v 149.755n 1.0v 154.745n 1.0v 154.755n 1.0v 159.745n 1.0v 159.755n 1.0v 164.745n 1.0v 164.755n 1.0v 169.745n 1.0v 169.755n 1.0v 174.745n 1.0v 174.755n 1.0v 179.745n 1.0v 179.755n 1.0v 184.745n 1.0v 184.755n 1.0v 189.745n 1.0v 189.755n 1.0v 194.745n 1.0v 194.755n 1.0v 199.745n 1.0v 199.755n 1.0v 204.745n 1.0v 204.755n 1.0v 209.745n 1.0v 209.755n 1.0v 214.745n 1.0v 214.755n 1.0v 219.745n 1.0v 219.755n 1.0v 224.745n 1.0v 224.755n 1.0v 229.745n 1.0v 229.755n 0.0v 234.745n 0.0v 234.755n 0.0v 239.745n 0.0v 239.755n 0.0v 244.745n 0.0v 244.755n 0.0v 249.745n 0.0v 249.755n 0.0v 254.745n 0.0v 254.755n 1.0v 259.745n 1.0v 259.755n 1.0v 264.745n 1.0v 264.755n 1.0v 269.745n 1.0v 269.755n 1.0v 274.745n 1.0v 274.755n 0.0v 279.745n 0.0v 279.755n 1.0v 284.745n 1.0v 284.755n 0.0v 289.745n 0.0v 289.755n 1.0v 294.745n 1.0v 294.755n 1.0v 299.745n 1.0v 299.755n 0.0v 304.745n 0.0v 304.755n 1.0v 309.745n 1.0v 309.755n 1.0v 314.745n 1.0v 314.755n 1.0v 319.745n 1.0v 319.755n 1.0v 324.745n 1.0v 324.755n 1.0v 329.745n 1.0v 329.755n 1.0v 334.745n 1.0v 334.755n 1.0v 339.745n 1.0v 339.755n 0.0v 344.745n 0.0v 344.755n 0.0v 349.745n 0.0v 349.755n 0.0v 354.745n 0.0v 354.755n 1.0v 359.745n 1.0v 359.755n 1.0v 364.745n 1.0v 364.755n 1.0v 369.745n 1.0v 369.755n 1.0v 374.745n 1.0v 374.755n 1.0v 379.745n 1.0v 379.755n 1.0v 384.745n 1.0v 384.755n 1.0v 389.745n 1.0v 389.755n 1.0v 394.745n 1.0v 394.755n 1.0v 399.745n 1.0v 399.755n 1.0v 404.745n 1.0v 404.755n 1.0v 409.745n 1.0v 409.755n 1.0v 414.745n 1.0v 414.755n 1.0v 419.745n 1.0v 419.755n 1.0v 424.745n 1.0v 424.755n 1.0v 429.745n 1.0v 429.755n 1.0v 434.745n 1.0v 434.755n 0.0v 439.745n 0.0v 439.755n 1.0v 444.745n 1.0v 444.755n 1.0v 449.745n 1.0v 449.755n 1.0v 454.745n 1.0v 454.755n 0.0v 459.745n 0.0v 459.755n 1.0v 464.745n 1.0v 464.755n 0.0v 469.745n 0.0v 469.755n 1.0v 474.745n 1.0v 474.755n 1.0v 479.745n 1.0v 479.755n 1.0v 484.745n 1.0v 484.755n 1.0v 489.745n 1.0v 489.755n 1.0v 494.745n 1.0v 494.755n 1.0v 499.745n 1.0v 499.755n 1.0v 504.745n 1.0v 504.755n 1.0v 509.745n 1.0v 509.755n 0.0v 514.745n 0.0v 514.755n 1.0v 519.745n 1.0v 519.755n 1.0v 524.745n 1.0v 524.755n 1.0v 529.745n 1.0v 529.755n 1.0v 534.745n 1.0v 534.755n 1.0v 539.745n 1.0v 539.755n 1.0v 544.745n 1.0v 544.755n 0.0v 549.745n 0.0v 549.755n 1.0v 554.745n 1.0v 554.755n 1.0v 559.745n 1.0v 559.755n 1.0v 564.745n 1.0v 564.755n 1.0v 569.745n 1.0v 569.755n 1.0v 574.745n 1.0v 574.755n 1.0v 579.745n 1.0v 579.755n 1.0v 584.745n 1.0v 584.755n 1.0v 589.745n 1.0v 589.755n 1.0v 594.745n 1.0v 594.755n 1.0v 599.745n 1.0v 599.755n 1.0v 604.745n 1.0v 604.755n 1.0v 609.745n 1.0v 609.755n 1.0v 614.745n 1.0v 614.755n 0.0v 619.745n 0.0v 619.755n 1.0v 624.745n 1.0v 624.755n 0.0v 629.745n 0.0v 629.755n 1.0v 634.745n 1.0v 634.755n 1.0v 639.745n 1.0v 639.755n 1.0v 644.745n 1.0v 644.755n 0.0v 649.745n 0.0v 649.755n 1.0v 654.745n 1.0v 654.755n 1.0v 659.745n 1.0v 659.755n 1.0v 664.745n 1.0v 664.755n 1.0v 669.745n 1.0v 669.755n 1.0v 674.745n 1.0v 674.755n 1.0v 679.745n 1.0v 679.755n 0.0v 684.745n 0.0v 684.755n 1.0v 689.745n 1.0v 689.755n 1.0v 694.745n 1.0v 694.755n 1.0v 699.745n 1.0v 699.755n 1.0v 704.745n 1.0v 704.755n 1.0v 709.745n 1.0v 709.755n 0.0v 714.745n 0.0v 714.755n 1.0v 719.745n 1.0v 719.755n 0.0v 724.745n 0.0v 724.755n 1.0v 729.745n 1.0v 729.755n 1.0v 734.745n 1.0v 734.755n 0.0v 739.745n 0.0v 739.755n 1.0v 744.745n 1.0v 744.755n 1.0v 749.745n 1.0v 749.755n 1.0v 754.745n 1.0v 754.755n 1.0v 759.745n 1.0v 759.755n 1.0v 764.745n 1.0v 764.755n 1.0v 769.745n 1.0v 769.755n 0.0v 774.745n 0.0v 774.755n 1.0v 779.745n 1.0v 779.755n 0.0v 784.745n 0.0v 784.755n 1.0v 789.745n 1.0v 789.755n 1.0v 794.745n 1.0v 794.755n 0.0v 799.745n 0.0v 799.755n 1.0v 804.745n 1.0v 804.755n 1.0v 809.745n 1.0v 809.755n 1.0v 814.745n 1.0v 814.755n 1.0v 819.745n 1.0v 819.755n 0.0v 824.745n 0.0v 824.755n 1.0v 829.745n 1.0v 829.755n 1.0v 834.745n 1.0v 834.755n 1.0v 839.745n 1.0v 839.755n 1.0v 844.745n 1.0v 844.755n 1.0v 849.745n 1.0v 849.755n 0.0v 854.745n 0.0v 854.755n 1.0v 859.745n 1.0v 859.755n 0.0v 864.745n 0.0v 864.755n 1.0v 869.745n 1.0v 869.755n 1.0v 874.745n 1.0v 874.755n 1.0v 879.745n 1.0v 879.755n 1.0v 884.745n 1.0v 884.755n 1.0v 889.745n 1.0v 889.755n 1.0v 894.745n 1.0v 894.755n 1.0v 899.745n 1.0v 899.755n 1.0v 904.745n 1.0v 904.755n 0.0v 909.745n 0.0v 909.755n 0.0v 914.745n 0.0v 914.755n 1.0v 919.745n 1.0v 919.755n 0.0v 924.745n 0.0v 924.755n 1.0v 929.745n 1.0v 929.755n 1.0v 934.745n 1.0v 934.755n 0.0v 939.745n 0.0v 939.755n 1.0v 944.745n 1.0v 944.755n 1.0v 949.745n 1.0v 949.755n 1.0v 954.745n 1.0v 954.755n 0.0v 959.745n 0.0v 959.755n 0.0v 964.745n 0.0v 964.755n 1.0v 969.745n 1.0v 969.755n 0.0v 974.745n 0.0v 974.755n 1.0v 979.745n 1.0v 979.755n 1.0v 984.745n 1.0v 984.755n 1.0v 989.745n 1.0v 989.755n 0.0v 994.745n 0.0v 994.755n 1.0v 999.745n 1.0v 999.755n 1.0v 1004.745n 1.0v 1004.755n 1.0v 1009.745n 1.0v 1009.755n 1.0v 1014.745n 1.0v 1014.755n 0.0v 1019.745n 0.0v 1019.755n 1.0v 1024.745n 1.0v 1024.755n 1.0v )
* (time, data): [(0, 1), (5, 0), (10, 0), (15, 0), (20, 1), (25, 1), (30, 1), (35, 0), (40, 1), (45, 1), (50, 0), (55, 1), (60, 1), (65, 1), (70, 1), (75, 1), (80, 1), (85, 0), (90, 1), (95, 1), (100, 0), (105, 1), (110, 1), (115, 0), (120, 1), (125, 0), (130, 1), (135, 1), (140, 1), (145, 1), (150, 0), (155, 1), (160, 1), (165, 0), (170, 1), (175, 1), (180, 1), (185, 1), (190, 1), (195, 1), (200, 1), (205, 0), (210, 1), (215, 1), (220, 0), (225, 1), (230, 1), (235, 1), (240, 0), (245, 1), (250, 0), (255, 1), (260, 0), (265, 1), (270, 1), (275, 0), (280, 1), (285, 1), (290, 1), (295, 1), (300, 1), (305, 1), (310, 0), (315, 1), (320, 1), (325, 1), (330, 1), (335, 1), (340, 1), (345, 0), (350, 0), (355, 1), (360, 0), (365, 1), (370, 1), (375, 1), (380, 1), (385, 1), (390, 1), (395, 1), (400, 0), (405, 0), (410, 1), (415, 1), (420, 1), (425, 1), (430, 1), (435, 1), (440, 0), (445, 1), (450, 1), (455, 1), (460, 1), (465, 1), (470, 1), (475, 1), (480, 1), (485, 1), (490, 1), (495, 1), (500, 0), (505, 1), (510, 1), (515, 1), (520, 1), (525, 1), (530, 1), (535, 0), (540, 0), (545, 1), (550, 1), (555, 1), (560, 1), (565, 1), (570, 1), (575, 1), (580, 1), (585, 1), (590, 1), (595, 1), (600, 1), (605, 1), (610, 1), (615, 1), (620, 1), (625, 1), (630, 1), (635, 1), (640, 1), (645, 1), (650, 1), (655, 0), (660, 1), (665, 1), (670, 1), (675, 1), (680, 1), (685, 1), (690, 1), (695, 1), (700, 1), (705, 1), (710, 0), (715, 1), (720, 1), (725, 1), (730, 1), (735, 1), (740, 1), (745, 1), (750, 1), (755, 1), (760, 0), (765, 1), (770, 1), (775, 1), (780, 0), (785, 1), (790, 1), (795, 1), (800, 1), (805, 1), (810, 0), (815, 1), (820, 1), (825, 1), (830, 1), (835, 1), (840, 1), (845, 1), (850, 1), (855, 1), (860, 0), (865, 1), (870, 1), (875, 1), (880, 0), (885, 1), (890, 1), (895, 1), (900, 1), (905, 1), (910, 0), (915, 1), (920, 0), (925, 1), (930, 0), (935, 0), (940, 1), (945, 1), (950, 0), (955, 0), (960, 1), (965, 1), (970, 1), (975, 1), (980, 1), (985, 0), (990, 1), (995, 1), (1000, 1), (1005, 0), (1010, 1), (1015, 1), (1020, 1), (1025, 1)]
VWEB1 WEB1 0 PWL (0n 1.0v 4.745n 1.0v 4.755n 0.0v 9.745n 0.0v 9.755n 0.0v 14.745n 0.0v 14.755n 0.0v 19.745n 0.0v 19.755n 1.0v 24.745n 1.0v 24.755n 1.0v 29.745n 1.0v 29.755n 1.0v 34.745n 1.0v 34.755n 0.0v 39.745n 0.0v 39.755n 1.0v 44.745n 1.0v 44.755n 1.0v 49.745n 1.0v 49.755n 0.0v 54.745n 0.0v 54.755n 1.0v 59.745n 1.0v 59.755n 1.0v 64.745n 1.0v 64.755n 1.0v 69.745n 1.0v 69.755n 1.0v 74.745n 1.0v 74.755n 1.0v 79.745n 1.0v 79.755n 1.0v 84.745n 1.0v 84.755n 0.0v 89.745n 0.0v 89.755n 1.0v 94.745n 1.0v 94.755n 1.0v 99.745n 1.0v 99.755n 0.0v 104.745n 0.0v 104.755n 1.0v 109.745n 1.0v 109.755n 1.0v 114.745n 1.0v 114.755n 0.0v 119.745n 0.0v 119.755n 1.0v 124.745n 1.0v 124.755n 0.0v 129.745n 0.0v 129.755n 1.0v 134.745n 1.0v 134.755n 1.0v 139.745n 1.0v 139.755n 1.0v 144.745n 1.0v 144.755n 1.0v 149.745n 1.0v 149.755n 0.0v 154.745n 0.0v 154.755n 1.0v 159.745n 1.0v 159.755n 1.0v 164.745n 1.0v 164.755n 0.0v 169.745n 0.0v 169.755n 1.0v 174.745n 1.0v 174.755n 1.0v 179.745n 1.0v 179.755n 1.0v 184.745n 1.0v 184.755n 1.0v 189.745n 1.0v 189.755n 1.0v 194.745n 1.0v 194.755n 1.0v 199.745n 1.0v 199.755n 1.0v 204.745n 1.0v 204.755n 0.0v 209.745n 0.0v 209.755n 1.0v 214.745n 1.0v 214.755n 1.0v 219.745n 1.0v 219.755n 0.0v 224.745n 0.0v 224.755n 1.0v 229.745n 1.0v 229.755n 1.0v 234.745n 1.0v 234.755n 1.0v 239.745n 1.0v 239.755n 0.0v 244.745n 0.0v 244.755n 1.0v 249.745n 1.0v 249.755n 0.0v 254.745n 0.0v 254.755n 1.0v 259.745n 1.0v 259.755n 0.0v 264.745n 0.0v 264.755n 1.0v 269.745n 1.0v 269.755n 1.0v 274.745n 1.0v 274.755n 0.0v 279.745n 0.0v 279.755n 1.0v 284.745n 1.0v 284.755n 1.0v 289.745n 1.0v 289.755n 1.0v 294.745n 1.0v 294.755n 1.0v 299.745n 1.0v 299.755n 1.0v 304.745n 1.0v 304.755n 1.0v 309.745n 1.0v 309.755n 0.0v 314.745n 0.0v 314.755n 1.0v 319.745n 1.0v 319.755n 1.0v 324.745n 1.0v 324.755n 1.0v 329.745n 1.0v 329.755n 1.0v 334.745n 1.0v 334.755n 1.0v 339.745n 1.0v 339.755n 1.0v 344.745n 1.0v 344.755n 0.0v 349.745n 0.0v 349.755n 0.0v 354.745n 0.0v 354.755n 1.0v 359.745n 1.0v 359.755n 0.0v 364.745n 0.0v 364.755n 1.0v 369.745n 1.0v 369.755n 1.0v 374.745n 1.0v 374.755n 1.0v 379.745n 1.0v 379.755n 1.0v 384.745n 1.0v 384.755n 1.0v 389.745n 1.0v 389.755n 1.0v 394.745n 1.0v 394.755n 1.0v 399.745n 1.0v 399.755n 0.0v 404.745n 0.0v 404.755n 0.0v 409.745n 0.0v 409.755n 1.0v 414.745n 1.0v 414.755n 1.0v 419.745n 1.0v 419.755n 1.0v 424.745n 1.0v 424.755n 1.0v 429.745n 1.0v 429.755n 1.0v 434.745n 1.0v 434.755n 1.0v 439.745n 1.0v 439.755n 0.0v 444.745n 0.0v 444.755n 1.0v 449.745n 1.0v 449.755n 1.0v 454.745n 1.0v 454.755n 1.0v 459.745n 1.0v 459.755n 1.0v 464.745n 1.0v 464.755n 1.0v 469.745n 1.0v 469.755n 1.0v 474.745n 1.0v 474.755n 1.0v 479.745n 1.0v 479.755n 1.0v 484.745n 1.0v 484.755n 1.0v 489.745n 1.0v 489.755n 1.0v 494.745n 1.0v 494.755n 1.0v 499.745n 1.0v 499.755n 0.0v 504.745n 0.0v 504.755n 1.0v 509.745n 1.0v 509.755n 1.0v 514.745n 1.0v 514.755n 1.0v 519.745n 1.0v 519.755n 1.0v 524.745n 1.0v 524.755n 1.0v 529.745n 1.0v 529.755n 1.0v 534.745n 1.0v 534.755n 0.0v 539.745n 0.0v 539.755n 0.0v 544.745n 0.0v 544.755n 1.0v 549.745n 1.0v 549.755n 1.0v 554.745n 1.0v 554.755n 1.0v 559.745n 1.0v 559.755n 1.0v 564.745n 1.0v 564.755n 1.0v 569.745n 1.0v 569.755n 1.0v 574.745n 1.0v 574.755n 1.0v 579.745n 1.0v 579.755n 1.0v 584.745n 1.0v 584.755n 1.0v 589.745n 1.0v 589.755n 1.0v 594.745n 1.0v 594.755n 1.0v 599.745n 1.0v 599.755n 1.0v 604.745n 1.0v 604.755n 1.0v 609.745n 1.0v 609.755n 1.0v 614.745n 1.0v 614.755n 1.0v 619.745n 1.0v 619.755n 1.0v 624.745n 1.0v 624.755n 1.0v 629.745n 1.0v 629.755n 1.0v 634.745n 1.0v 634.755n 1.0v 639.745n 1.0v 639.755n 1.0v 644.745n 1.0v 644.755n 1.0v 649.745n 1.0v 649.755n 1.0v 654.745n 1.0v 654.755n 0.0v 659.745n 0.0v 659.755n 1.0v 664.745n 1.0v 664.755n 1.0v 669.745n 1.0v 669.755n 1.0v 674.745n 1.0v 674.755n 1.0v 679.745n 1.0v 679.755n 1.0v 684.745n 1.0v 684.755n 1.0v 689.745n 1.0v 689.755n 1.0v 694.745n 1.0v 694.755n 1.0v 699.745n 1.0v 699.755n 1.0v 704.745n 1.0v 704.755n 1.0v 709.745n 1.0v 709.755n 0.0v 714.745n 0.0v 714.755n 1.0v 719.745n 1.0v 719.755n 1.0v 724.745n 1.0v 724.755n 1.0v 729.745n 1.0v 729.755n 1.0v 734.745n 1.0v 734.755n 1.0v 739.745n 1.0v 739.755n 1.0v 744.745n 1.0v 744.755n 1.0v 749.745n 1.0v 749.755n 1.0v 754.745n 1.0v 754.755n 1.0v 759.745n 1.0v 759.755n 0.0v 764.745n 0.0v 764.755n 1.0v 769.745n 1.0v 769.755n 1.0v 774.745n 1.0v 774.755n 1.0v 779.745n 1.0v 779.755n 0.0v 784.745n 0.0v 784.755n 1.0v 789.745n 1.0v 789.755n 1.0v 794.745n 1.0v 794.755n 1.0v 799.745n 1.0v 799.755n 1.0v 804.745n 1.0v 804.755n 1.0v 809.745n 1.0v 809.755n 0.0v 814.745n 0.0v 814.755n 1.0v 819.745n 1.0v 819.755n 1.0v 824.745n 1.0v 824.755n 1.0v 829.745n 1.0v 829.755n 1.0v 834.745n 1.0v 834.755n 1.0v 839.745n 1.0v 839.755n 1.0v 844.745n 1.0v 844.755n 1.0v 849.745n 1.0v 849.755n 1.0v 854.745n 1.0v 854.755n 1.0v 859.745n 1.0v 859.755n 0.0v 864.745n 0.0v 864.755n 1.0v 869.745n 1.0v 869.755n 1.0v 874.745n 1.0v 874.755n 1.0v 879.745n 1.0v 879.755n 0.0v 884.745n 0.0v 884.755n 1.0v 889.745n 1.0v 889.755n 1.0v 894.745n 1.0v 894.755n 1.0v 899.745n 1.0v 899.755n 1.0v 904.745n 1.0v 904.755n 1.0v 909.745n 1.0v 909.755n 0.0v 914.745n 0.0v 914.755n 1.0v 919.745n 1.0v 919.755n 0.0v 924.745n 0.0v 924.755n 1.0v 929.745n 1.0v 929.755n 0.0v 934.745n 0.0v 934.755n 0.0v 939.745n 0.0v 939.755n 1.0v 944.745n 1.0v 944.755n 1.0v 949.745n 1.0v 949.755n 0.0v 954.745n 0.0v 954.755n 0.0v 959.745n 0.0v 959.755n 1.0v 964.745n 1.0v 964.755n 1.0v 969.745n 1.0v 969.755n 1.0v 974.745n 1.0v 974.755n 1.0v 979.745n 1.0v 979.755n 1.0v 984.745n 1.0v 984.755n 0.0v 989.745n 0.0v 989.755n 1.0v 994.745n 1.0v 994.755n 1.0v 999.745n 1.0v 999.755n 1.0v 1004.745n 1.0v 1004.755n 0.0v 1009.745n 0.0v 1009.755n 1.0v 1014.745n 1.0v 1014.755n 1.0v 1019.745n 1.0v 1019.755n 1.0v 1024.745n 1.0v 1024.755n 1.0v )
* PULSE: period=5
Vclk0 clk0 0 PULSE (0 1.0 4.995n 0.01n 0.01n 2.49n 5n)
* PULSE: period=5
Vclk1 clk1 0 PULSE (0 1.0 4.995n 0.01n 0.01n 2.49n 5n)

 * Generation of dout measurements
* CHECK dout0_0 vdout0_0ck4 = 1.0 time = 25
* CHECK dout0_1 vdout0_1ck4 = 1.0 time = 25
* CHECK dout0_2 vdout0_2ck4 = 1.0 time = 25
* CHECK dout0_3 vdout0_3ck4 = 0 time = 25
* CHECK dout0_4 vdout0_4ck4 = 0 time = 25
* CHECK dout0_5 vdout0_5ck4 = 1.0 time = 25
* CHECK dout0_6 vdout0_6ck4 = 0 time = 25
* CHECK dout0_7 vdout0_7ck4 = 1.0 time = 25
* CHECK dout0_8 vdout0_8ck4 = 0 time = 25
* CHECK dout0_9 vdout0_9ck4 = 1.0 time = 25
* CHECK dout0_10 vdout0_10ck4 = 0 time = 25
* CHECK dout0_11 vdout0_11ck4 = 1.0 time = 25
* CHECK dout0_12 vdout0_12ck4 = 0 time = 25
* CHECK dout0_13 vdout0_13ck4 = 1.0 time = 25
* CHECK dout0_14 vdout0_14ck4 = 1.0 time = 25
* CHECK dout0_15 vdout0_15ck4 = 1.0 time = 25
* CHECK dout0_16 vdout0_16ck4 = 0 time = 25
* CHECK dout0_17 vdout0_17ck4 = 1.0 time = 25
* CHECK dout0_18 vdout0_18ck4 = 1.0 time = 25
* CHECK dout0_19 vdout0_19ck4 = 0 time = 25
* CHECK dout0_20 vdout0_20ck4 = 1.0 time = 25
* CHECK dout0_21 vdout0_21ck4 = 0 time = 25
* CHECK dout0_22 vdout0_22ck4 = 0 time = 25
* CHECK dout0_23 vdout0_23ck4 = 0 time = 25
* CHECK dout0_24 vdout0_24ck4 = 0 time = 25
* CHECK dout0_25 vdout0_25ck4 = 0 time = 25
* CHECK dout0_26 vdout0_26ck4 = 1.0 time = 25
* CHECK dout0_27 vdout0_27ck4 = 1.0 time = 25
* CHECK dout0_28 vdout0_28ck4 = 1.0 time = 25
* CHECK dout0_29 vdout0_29ck4 = 0 time = 25
* CHECK dout0_30 vdout0_30ck4 = 1.0 time = 25
* CHECK dout0_31 vdout0_31ck4 = 1.0 time = 25
* CHECK dout1_0 vdout1_0ck4 = 0 time = 25
* CHECK dout1_1 vdout1_1ck4 = 1.0 time = 25
* CHECK dout1_2 vdout1_2ck4 = 1.0 time = 25
* CHECK dout1_3 vdout1_3ck4 = 0 time = 25
* CHECK dout1_4 vdout1_4ck4 = 1.0 time = 25
* CHECK dout1_5 vdout1_5ck4 = 0 time = 25
* CHECK dout1_6 vdout1_6ck4 = 1.0 time = 25
* CHECK dout1_7 vdout1_7ck4 = 0 time = 25
* CHECK dout1_8 vdout1_8ck4 = 0 time = 25
* CHECK dout1_9 vdout1_9ck4 = 1.0 time = 25
* CHECK dout1_10 vdout1_10ck4 = 0 time = 25
* CHECK dout1_11 vdout1_11ck4 = 0 time = 25
* CHECK dout1_12 vdout1_12ck4 = 1.0 time = 25
* CHECK dout1_13 vdout1_13ck4 = 0 time = 25
* CHECK dout1_14 vdout1_14ck4 = 1.0 time = 25
* CHECK dout1_15 vdout1_15ck4 = 1.0 time = 25
* CHECK dout1_16 vdout1_16ck4 = 0 time = 25
* CHECK dout1_17 vdout1_17ck4 = 1.0 time = 25
* CHECK dout1_18 vdout1_18ck4 = 0 time = 25
* CHECK dout1_19 vdout1_19ck4 = 0 time = 25
* CHECK dout1_20 vdout1_20ck4 = 1.0 time = 25
* CHECK dout1_21 vdout1_21ck4 = 0 time = 25
* CHECK dout1_22 vdout1_22ck4 = 1.0 time = 25
* CHECK dout1_23 vdout1_23ck4 = 0 time = 25
* CHECK dout1_24 vdout1_24ck4 = 1.0 time = 25
* CHECK dout1_25 vdout1_25ck4 = 0 time = 25
* CHECK dout1_26 vdout1_26ck4 = 1.0 time = 25
* CHECK dout1_27 vdout1_27ck4 = 0 time = 25
* CHECK dout1_28 vdout1_28ck4 = 0 time = 25
* CHECK dout1_29 vdout1_29ck4 = 1.0 time = 25
* CHECK dout1_30 vdout1_30ck4 = 1.0 time = 25
* CHECK dout1_31 vdout1_31ck4 = 1.0 time = 25
* CHECK dout0_0 vdout0_0ck5 = 0 time = 30
* CHECK dout0_1 vdout0_1ck5 = 1.0 time = 30
* CHECK dout0_2 vdout0_2ck5 = 1.0 time = 30
* CHECK dout0_3 vdout0_3ck5 = 0 time = 30
* CHECK dout0_4 vdout0_4ck5 = 1.0 time = 30
* CHECK dout0_5 vdout0_5ck5 = 0 time = 30
* CHECK dout0_6 vdout0_6ck5 = 1.0 time = 30
* CHECK dout0_7 vdout0_7ck5 = 0 time = 30
* CHECK dout0_8 vdout0_8ck5 = 0 time = 30
* CHECK dout0_9 vdout0_9ck5 = 1.0 time = 30
* CHECK dout0_10 vdout0_10ck5 = 0 time = 30
* CHECK dout0_11 vdout0_11ck5 = 0 time = 30
* CHECK dout0_12 vdout0_12ck5 = 1.0 time = 30
* CHECK dout0_13 vdout0_13ck5 = 0 time = 30
* CHECK dout0_14 vdout0_14ck5 = 1.0 time = 30
* CHECK dout0_15 vdout0_15ck5 = 1.0 time = 30
* CHECK dout0_16 vdout0_16ck5 = 0 time = 30
* CHECK dout0_17 vdout0_17ck5 = 1.0 time = 30
* CHECK dout0_18 vdout0_18ck5 = 0 time = 30
* CHECK dout0_19 vdout0_19ck5 = 0 time = 30
* CHECK dout0_20 vdout0_20ck5 = 1.0 time = 30
* CHECK dout0_21 vdout0_21ck5 = 0 time = 30
* CHECK dout0_22 vdout0_22ck5 = 1.0 time = 30
* CHECK dout0_23 vdout0_23ck5 = 0 time = 30
* CHECK dout0_24 vdout0_24ck5 = 1.0 time = 30
* CHECK dout0_25 vdout0_25ck5 = 0 time = 30
* CHECK dout0_26 vdout0_26ck5 = 1.0 time = 30
* CHECK dout0_27 vdout0_27ck5 = 0 time = 30
* CHECK dout0_28 vdout0_28ck5 = 0 time = 30
* CHECK dout0_29 vdout0_29ck5 = 1.0 time = 30
* CHECK dout0_30 vdout0_30ck5 = 1.0 time = 30
* CHECK dout0_31 vdout0_31ck5 = 1.0 time = 30
* CHECK dout1_0 vdout1_0ck8 = 0 time = 45
* CHECK dout1_1 vdout1_1ck8 = 0 time = 45
* CHECK dout1_2 vdout1_2ck8 = 1.0 time = 45
* CHECK dout1_3 vdout1_3ck8 = 1.0 time = 45
* CHECK dout1_4 vdout1_4ck8 = 0 time = 45
* CHECK dout1_5 vdout1_5ck8 = 0 time = 45
* CHECK dout1_6 vdout1_6ck8 = 0 time = 45
* CHECK dout1_7 vdout1_7ck8 = 1.0 time = 45
* CHECK dout1_8 vdout1_8ck8 = 0 time = 45
* CHECK dout1_9 vdout1_9ck8 = 1.0 time = 45
* CHECK dout1_10 vdout1_10ck8 = 0 time = 45
* CHECK dout1_11 vdout1_11ck8 = 0 time = 45
* CHECK dout1_12 vdout1_12ck8 = 1.0 time = 45
* CHECK dout1_13 vdout1_13ck8 = 0 time = 45
* CHECK dout1_14 vdout1_14ck8 = 0 time = 45
* CHECK dout1_15 vdout1_15ck8 = 0 time = 45
* CHECK dout1_16 vdout1_16ck8 = 1.0 time = 45
* CHECK dout1_17 vdout1_17ck8 = 1.0 time = 45
* CHECK dout1_18 vdout1_18ck8 = 1.0 time = 45
* CHECK dout1_19 vdout1_19ck8 = 0 time = 45
* CHECK dout1_20 vdout1_20ck8 = 0 time = 45
* CHECK dout1_21 vdout1_21ck8 = 0 time = 45
* CHECK dout1_22 vdout1_22ck8 = 0 time = 45
* CHECK dout1_23 vdout1_23ck8 = 0 time = 45
* CHECK dout1_24 vdout1_24ck8 = 0 time = 45
* CHECK dout1_25 vdout1_25ck8 = 0 time = 45
* CHECK dout1_26 vdout1_26ck8 = 1.0 time = 45
* CHECK dout1_27 vdout1_27ck8 = 0 time = 45
* CHECK dout1_28 vdout1_28ck8 = 0 time = 45
* CHECK dout1_29 vdout1_29ck8 = 1.0 time = 45
* CHECK dout1_30 vdout1_30ck8 = 1.0 time = 45
* CHECK dout1_31 vdout1_31ck8 = 1.0 time = 45
* CHECK dout1_0 vdout1_0ck9 = 1.0 time = 50
* CHECK dout1_1 vdout1_1ck9 = 1.0 time = 50
* CHECK dout1_2 vdout1_2ck9 = 1.0 time = 50
* CHECK dout1_3 vdout1_3ck9 = 0 time = 50
* CHECK dout1_4 vdout1_4ck9 = 0 time = 50
* CHECK dout1_5 vdout1_5ck9 = 1.0 time = 50
* CHECK dout1_6 vdout1_6ck9 = 0 time = 50
* CHECK dout1_7 vdout1_7ck9 = 1.0 time = 50
* CHECK dout1_8 vdout1_8ck9 = 0 time = 50
* CHECK dout1_9 vdout1_9ck9 = 1.0 time = 50
* CHECK dout1_10 vdout1_10ck9 = 0 time = 50
* CHECK dout1_11 vdout1_11ck9 = 1.0 time = 50
* CHECK dout1_12 vdout1_12ck9 = 0 time = 50
* CHECK dout1_13 vdout1_13ck9 = 1.0 time = 50
* CHECK dout1_14 vdout1_14ck9 = 1.0 time = 50
* CHECK dout1_15 vdout1_15ck9 = 1.0 time = 50
* CHECK dout1_16 vdout1_16ck9 = 0 time = 50
* CHECK dout1_17 vdout1_17ck9 = 1.0 time = 50
* CHECK dout1_18 vdout1_18ck9 = 1.0 time = 50
* CHECK dout1_19 vdout1_19ck9 = 0 time = 50
* CHECK dout1_20 vdout1_20ck9 = 1.0 time = 50
* CHECK dout1_21 vdout1_21ck9 = 0 time = 50
* CHECK dout1_22 vdout1_22ck9 = 0 time = 50
* CHECK dout1_23 vdout1_23ck9 = 0 time = 50
* CHECK dout1_24 vdout1_24ck9 = 0 time = 50
* CHECK dout1_25 vdout1_25ck9 = 0 time = 50
* CHECK dout1_26 vdout1_26ck9 = 1.0 time = 50
* CHECK dout1_27 vdout1_27ck9 = 1.0 time = 50
* CHECK dout1_28 vdout1_28ck9 = 1.0 time = 50
* CHECK dout1_29 vdout1_29ck9 = 0 time = 50
* CHECK dout1_30 vdout1_30ck9 = 1.0 time = 50
* CHECK dout1_31 vdout1_31ck9 = 1.0 time = 50
* CHECK dout0_0 vdout0_0ck11 = 1.0 time = 60
* CHECK dout0_1 vdout0_1ck11 = 1.0 time = 60
* CHECK dout0_2 vdout0_2ck11 = 1.0 time = 60
* CHECK dout0_3 vdout0_3ck11 = 0 time = 60
* CHECK dout0_4 vdout0_4ck11 = 1.0 time = 60
* CHECK dout0_5 vdout0_5ck11 = 1.0 time = 60
* CHECK dout0_6 vdout0_6ck11 = 1.0 time = 60
* CHECK dout0_7 vdout0_7ck11 = 1.0 time = 60
* CHECK dout0_8 vdout0_8ck11 = 0 time = 60
* CHECK dout0_9 vdout0_9ck11 = 0 time = 60
* CHECK dout0_10 vdout0_10ck11 = 0 time = 60
* CHECK dout0_11 vdout0_11ck11 = 0 time = 60
* CHECK dout0_12 vdout0_12ck11 = 1.0 time = 60
* CHECK dout0_13 vdout0_13ck11 = 0 time = 60
* CHECK dout0_14 vdout0_14ck11 = 1.0 time = 60
* CHECK dout0_15 vdout0_15ck11 = 0 time = 60
* CHECK dout0_16 vdout0_16ck11 = 1.0 time = 60
* CHECK dout0_17 vdout0_17ck11 = 1.0 time = 60
* CHECK dout0_18 vdout0_18ck11 = 0 time = 60
* CHECK dout0_19 vdout0_19ck11 = 0 time = 60
* CHECK dout0_20 vdout0_20ck11 = 1.0 time = 60
* CHECK dout0_21 vdout0_21ck11 = 0 time = 60
* CHECK dout0_22 vdout0_22ck11 = 1.0 time = 60
* CHECK dout0_23 vdout0_23ck11 = 0 time = 60
* CHECK dout0_24 vdout0_24ck11 = 1.0 time = 60
* CHECK dout0_25 vdout0_25ck11 = 0 time = 60
* CHECK dout0_26 vdout0_26ck11 = 0 time = 60
* CHECK dout0_27 vdout0_27ck11 = 0 time = 60
* CHECK dout0_28 vdout0_28ck11 = 1.0 time = 60
* CHECK dout0_29 vdout0_29ck11 = 1.0 time = 60
* CHECK dout0_30 vdout0_30ck11 = 0 time = 60
* CHECK dout0_31 vdout0_31ck11 = 0 time = 60
* CHECK dout1_0 vdout1_0ck11 = 1.0 time = 60
* CHECK dout1_1 vdout1_1ck11 = 0 time = 60
* CHECK dout1_2 vdout1_2ck11 = 0 time = 60
* CHECK dout1_3 vdout1_3ck11 = 0 time = 60
* CHECK dout1_4 vdout1_4ck11 = 0 time = 60
* CHECK dout1_5 vdout1_5ck11 = 0 time = 60
* CHECK dout1_6 vdout1_6ck11 = 0 time = 60
* CHECK dout1_7 vdout1_7ck11 = 0 time = 60
* CHECK dout1_8 vdout1_8ck11 = 0 time = 60
* CHECK dout1_9 vdout1_9ck11 = 1.0 time = 60
* CHECK dout1_10 vdout1_10ck11 = 0 time = 60
* CHECK dout1_11 vdout1_11ck11 = 0 time = 60
* CHECK dout1_12 vdout1_12ck11 = 0 time = 60
* CHECK dout1_13 vdout1_13ck11 = 0 time = 60
* CHECK dout1_14 vdout1_14ck11 = 1.0 time = 60
* CHECK dout1_15 vdout1_15ck11 = 1.0 time = 60
* CHECK dout1_16 vdout1_16ck11 = 1.0 time = 60
* CHECK dout1_17 vdout1_17ck11 = 0 time = 60
* CHECK dout1_18 vdout1_18ck11 = 1.0 time = 60
* CHECK dout1_19 vdout1_19ck11 = 0 time = 60
* CHECK dout1_20 vdout1_20ck11 = 1.0 time = 60
* CHECK dout1_21 vdout1_21ck11 = 0 time = 60
* CHECK dout1_22 vdout1_22ck11 = 0 time = 60
* CHECK dout1_23 vdout1_23ck11 = 0 time = 60
* CHECK dout1_24 vdout1_24ck11 = 0 time = 60
* CHECK dout1_25 vdout1_25ck11 = 0 time = 60
* CHECK dout1_26 vdout1_26ck11 = 1.0 time = 60
* CHECK dout1_27 vdout1_27ck11 = 0 time = 60
* CHECK dout1_28 vdout1_28ck11 = 0 time = 60
* CHECK dout1_29 vdout1_29ck11 = 1.0 time = 60
* CHECK dout1_30 vdout1_30ck11 = 1.0 time = 60
* CHECK dout1_31 vdout1_31ck11 = 1.0 time = 60
* CHECK dout1_0 vdout1_0ck12 = 0 time = 65
* CHECK dout1_1 vdout1_1ck12 = 0 time = 65
* CHECK dout1_2 vdout1_2ck12 = 1.0 time = 65
* CHECK dout1_3 vdout1_3ck12 = 1.0 time = 65
* CHECK dout1_4 vdout1_4ck12 = 0 time = 65
* CHECK dout1_5 vdout1_5ck12 = 0 time = 65
* CHECK dout1_6 vdout1_6ck12 = 0 time = 65
* CHECK dout1_7 vdout1_7ck12 = 1.0 time = 65
* CHECK dout1_8 vdout1_8ck12 = 0 time = 65
* CHECK dout1_9 vdout1_9ck12 = 1.0 time = 65
* CHECK dout1_10 vdout1_10ck12 = 0 time = 65
* CHECK dout1_11 vdout1_11ck12 = 0 time = 65
* CHECK dout1_12 vdout1_12ck12 = 1.0 time = 65
* CHECK dout1_13 vdout1_13ck12 = 0 time = 65
* CHECK dout1_14 vdout1_14ck12 = 0 time = 65
* CHECK dout1_15 vdout1_15ck12 = 0 time = 65
* CHECK dout1_16 vdout1_16ck12 = 1.0 time = 65
* CHECK dout1_17 vdout1_17ck12 = 1.0 time = 65
* CHECK dout1_18 vdout1_18ck12 = 1.0 time = 65
* CHECK dout1_19 vdout1_19ck12 = 0 time = 65
* CHECK dout1_20 vdout1_20ck12 = 0 time = 65
* CHECK dout1_21 vdout1_21ck12 = 0 time = 65
* CHECK dout1_22 vdout1_22ck12 = 0 time = 65
* CHECK dout1_23 vdout1_23ck12 = 0 time = 65
* CHECK dout1_24 vdout1_24ck12 = 0 time = 65
* CHECK dout1_25 vdout1_25ck12 = 0 time = 65
* CHECK dout1_26 vdout1_26ck12 = 1.0 time = 65
* CHECK dout1_27 vdout1_27ck12 = 0 time = 65
* CHECK dout1_28 vdout1_28ck12 = 0 time = 65
* CHECK dout1_29 vdout1_29ck12 = 1.0 time = 65
* CHECK dout1_30 vdout1_30ck12 = 1.0 time = 65
* CHECK dout1_31 vdout1_31ck12 = 1.0 time = 65
* CHECK dout1_0 vdout1_0ck13 = 0 time = 70
* CHECK dout1_1 vdout1_1ck13 = 1.0 time = 70
* CHECK dout1_2 vdout1_2ck13 = 1.0 time = 70
* CHECK dout1_3 vdout1_3ck13 = 0 time = 70
* CHECK dout1_4 vdout1_4ck13 = 0 time = 70
* CHECK dout1_5 vdout1_5ck13 = 1.0 time = 70
* CHECK dout1_6 vdout1_6ck13 = 0 time = 70
* CHECK dout1_7 vdout1_7ck13 = 1.0 time = 70
* CHECK dout1_8 vdout1_8ck13 = 1.0 time = 70
* CHECK dout1_9 vdout1_9ck13 = 1.0 time = 70
* CHECK dout1_10 vdout1_10ck13 = 0 time = 70
* CHECK dout1_11 vdout1_11ck13 = 1.0 time = 70
* CHECK dout1_12 vdout1_12ck13 = 1.0 time = 70
* CHECK dout1_13 vdout1_13ck13 = 1.0 time = 70
* CHECK dout1_14 vdout1_14ck13 = 1.0 time = 70
* CHECK dout1_15 vdout1_15ck13 = 1.0 time = 70
* CHECK dout1_16 vdout1_16ck13 = 1.0 time = 70
* CHECK dout1_17 vdout1_17ck13 = 0 time = 70
* CHECK dout1_18 vdout1_18ck13 = 0 time = 70
* CHECK dout1_19 vdout1_19ck13 = 0 time = 70
* CHECK dout1_20 vdout1_20ck13 = 0 time = 70
* CHECK dout1_21 vdout1_21ck13 = 0 time = 70
* CHECK dout1_22 vdout1_22ck13 = 0 time = 70
* CHECK dout1_23 vdout1_23ck13 = 0 time = 70
* CHECK dout1_24 vdout1_24ck13 = 1.0 time = 70
* CHECK dout1_25 vdout1_25ck13 = 1.0 time = 70
* CHECK dout1_26 vdout1_26ck13 = 0 time = 70
* CHECK dout1_27 vdout1_27ck13 = 0 time = 70
* CHECK dout1_28 vdout1_28ck13 = 1.0 time = 70
* CHECK dout1_29 vdout1_29ck13 = 1.0 time = 70
* CHECK dout1_30 vdout1_30ck13 = 0 time = 70
* CHECK dout1_31 vdout1_31ck13 = 1.0 time = 70
* CHECK dout0_0 vdout0_0ck14 = 1.0 time = 75
* CHECK dout0_1 vdout0_1ck14 = 1.0 time = 75
* CHECK dout0_2 vdout0_2ck14 = 1.0 time = 75
* CHECK dout0_3 vdout0_3ck14 = 1.0 time = 75
* CHECK dout0_4 vdout0_4ck14 = 0 time = 75
* CHECK dout0_5 vdout0_5ck14 = 0 time = 75
* CHECK dout0_6 vdout0_6ck14 = 1.0 time = 75
* CHECK dout0_7 vdout0_7ck14 = 0 time = 75
* CHECK dout0_8 vdout0_8ck14 = 0 time = 75
* CHECK dout0_9 vdout0_9ck14 = 0 time = 75
* CHECK dout0_10 vdout0_10ck14 = 1.0 time = 75
* CHECK dout0_11 vdout0_11ck14 = 1.0 time = 75
* CHECK dout0_12 vdout0_12ck14 = 1.0 time = 75
* CHECK dout0_13 vdout0_13ck14 = 1.0 time = 75
* CHECK dout0_14 vdout0_14ck14 = 1.0 time = 75
* CHECK dout0_15 vdout0_15ck14 = 0 time = 75
* CHECK dout0_16 vdout0_16ck14 = 0 time = 75
* CHECK dout0_17 vdout0_17ck14 = 1.0 time = 75
* CHECK dout0_18 vdout0_18ck14 = 0 time = 75
* CHECK dout0_19 vdout0_19ck14 = 0 time = 75
* CHECK dout0_20 vdout0_20ck14 = 1.0 time = 75
* CHECK dout0_21 vdout0_21ck14 = 0 time = 75
* CHECK dout0_22 vdout0_22ck14 = 1.0 time = 75
* CHECK dout0_23 vdout0_23ck14 = 1.0 time = 75
* CHECK dout0_24 vdout0_24ck14 = 0 time = 75
* CHECK dout0_25 vdout0_25ck14 = 0 time = 75
* CHECK dout0_26 vdout0_26ck14 = 0 time = 75
* CHECK dout0_27 vdout0_27ck14 = 1.0 time = 75
* CHECK dout0_28 vdout0_28ck14 = 1.0 time = 75
* CHECK dout0_29 vdout0_29ck14 = 0 time = 75
* CHECK dout0_30 vdout0_30ck14 = 1.0 time = 75
* CHECK dout0_31 vdout0_31ck14 = 0 time = 75
* CHECK dout1_0 vdout1_0ck15 = 1.0 time = 80
* CHECK dout1_1 vdout1_1ck15 = 0 time = 80
* CHECK dout1_2 vdout1_2ck15 = 1.0 time = 80
* CHECK dout1_3 vdout1_3ck15 = 0 time = 80
* CHECK dout1_4 vdout1_4ck15 = 0 time = 80
* CHECK dout1_5 vdout1_5ck15 = 0 time = 80
* CHECK dout1_6 vdout1_6ck15 = 1.0 time = 80
* CHECK dout1_7 vdout1_7ck15 = 1.0 time = 80
* CHECK dout1_8 vdout1_8ck15 = 1.0 time = 80
* CHECK dout1_9 vdout1_9ck15 = 0 time = 80
* CHECK dout1_10 vdout1_10ck15 = 0 time = 80
* CHECK dout1_11 vdout1_11ck15 = 1.0 time = 80
* CHECK dout1_12 vdout1_12ck15 = 1.0 time = 80
* CHECK dout1_13 vdout1_13ck15 = 0 time = 80
* CHECK dout1_14 vdout1_14ck15 = 1.0 time = 80
* CHECK dout1_15 vdout1_15ck15 = 0 time = 80
* CHECK dout1_16 vdout1_16ck15 = 0 time = 80
* CHECK dout1_17 vdout1_17ck15 = 1.0 time = 80
* CHECK dout1_18 vdout1_18ck15 = 0 time = 80
* CHECK dout1_19 vdout1_19ck15 = 1.0 time = 80
* CHECK dout1_20 vdout1_20ck15 = 0 time = 80
* CHECK dout1_21 vdout1_21ck15 = 0 time = 80
* CHECK dout1_22 vdout1_22ck15 = 1.0 time = 80
* CHECK dout1_23 vdout1_23ck15 = 1.0 time = 80
* CHECK dout1_24 vdout1_24ck15 = 0 time = 80
* CHECK dout1_25 vdout1_25ck15 = 1.0 time = 80
* CHECK dout1_26 vdout1_26ck15 = 0 time = 80
* CHECK dout1_27 vdout1_27ck15 = 1.0 time = 80
* CHECK dout1_28 vdout1_28ck15 = 1.0 time = 80
* CHECK dout1_29 vdout1_29ck15 = 0 time = 80
* CHECK dout1_30 vdout1_30ck15 = 0 time = 80
* CHECK dout1_31 vdout1_31ck15 = 1.0 time = 80
* CHECK dout1_0 vdout1_0ck16 = 1.0 time = 85
* CHECK dout1_1 vdout1_1ck16 = 0 time = 85
* CHECK dout1_2 vdout1_2ck16 = 0 time = 85
* CHECK dout1_3 vdout1_3ck16 = 0 time = 85
* CHECK dout1_4 vdout1_4ck16 = 0 time = 85
* CHECK dout1_5 vdout1_5ck16 = 0 time = 85
* CHECK dout1_6 vdout1_6ck16 = 0 time = 85
* CHECK dout1_7 vdout1_7ck16 = 0 time = 85
* CHECK dout1_8 vdout1_8ck16 = 0 time = 85
* CHECK dout1_9 vdout1_9ck16 = 1.0 time = 85
* CHECK dout1_10 vdout1_10ck16 = 0 time = 85
* CHECK dout1_11 vdout1_11ck16 = 0 time = 85
* CHECK dout1_12 vdout1_12ck16 = 0 time = 85
* CHECK dout1_13 vdout1_13ck16 = 0 time = 85
* CHECK dout1_14 vdout1_14ck16 = 1.0 time = 85
* CHECK dout1_15 vdout1_15ck16 = 1.0 time = 85
* CHECK dout1_16 vdout1_16ck16 = 1.0 time = 85
* CHECK dout1_17 vdout1_17ck16 = 0 time = 85
* CHECK dout1_18 vdout1_18ck16 = 1.0 time = 85
* CHECK dout1_19 vdout1_19ck16 = 0 time = 85
* CHECK dout1_20 vdout1_20ck16 = 1.0 time = 85
* CHECK dout1_21 vdout1_21ck16 = 0 time = 85
* CHECK dout1_22 vdout1_22ck16 = 0 time = 85
* CHECK dout1_23 vdout1_23ck16 = 0 time = 85
* CHECK dout1_24 vdout1_24ck16 = 0 time = 85
* CHECK dout1_25 vdout1_25ck16 = 0 time = 85
* CHECK dout1_26 vdout1_26ck16 = 1.0 time = 85
* CHECK dout1_27 vdout1_27ck16 = 0 time = 85
* CHECK dout1_28 vdout1_28ck16 = 0 time = 85
* CHECK dout1_29 vdout1_29ck16 = 1.0 time = 85
* CHECK dout1_30 vdout1_30ck16 = 1.0 time = 85
* CHECK dout1_31 vdout1_31ck16 = 1.0 time = 85
* CHECK dout1_0 vdout1_0ck18 = 1.0 time = 95
* CHECK dout1_1 vdout1_1ck18 = 1.0 time = 95
* CHECK dout1_2 vdout1_2ck18 = 1.0 time = 95
* CHECK dout1_3 vdout1_3ck18 = 1.0 time = 95
* CHECK dout1_4 vdout1_4ck18 = 0 time = 95
* CHECK dout1_5 vdout1_5ck18 = 0 time = 95
* CHECK dout1_6 vdout1_6ck18 = 1.0 time = 95
* CHECK dout1_7 vdout1_7ck18 = 0 time = 95
* CHECK dout1_8 vdout1_8ck18 = 0 time = 95
* CHECK dout1_9 vdout1_9ck18 = 0 time = 95
* CHECK dout1_10 vdout1_10ck18 = 1.0 time = 95
* CHECK dout1_11 vdout1_11ck18 = 1.0 time = 95
* CHECK dout1_12 vdout1_12ck18 = 1.0 time = 95
* CHECK dout1_13 vdout1_13ck18 = 1.0 time = 95
* CHECK dout1_14 vdout1_14ck18 = 1.0 time = 95
* CHECK dout1_15 vdout1_15ck18 = 0 time = 95
* CHECK dout1_16 vdout1_16ck18 = 0 time = 95
* CHECK dout1_17 vdout1_17ck18 = 1.0 time = 95
* CHECK dout1_18 vdout1_18ck18 = 0 time = 95
* CHECK dout1_19 vdout1_19ck18 = 0 time = 95
* CHECK dout1_20 vdout1_20ck18 = 1.0 time = 95
* CHECK dout1_21 vdout1_21ck18 = 0 time = 95
* CHECK dout1_22 vdout1_22ck18 = 1.0 time = 95
* CHECK dout1_23 vdout1_23ck18 = 1.0 time = 95
* CHECK dout1_24 vdout1_24ck18 = 0 time = 95
* CHECK dout1_25 vdout1_25ck18 = 0 time = 95
* CHECK dout1_26 vdout1_26ck18 = 0 time = 95
* CHECK dout1_27 vdout1_27ck18 = 1.0 time = 95
* CHECK dout1_28 vdout1_28ck18 = 1.0 time = 95
* CHECK dout1_29 vdout1_29ck18 = 0 time = 95
* CHECK dout1_30 vdout1_30ck18 = 1.0 time = 95
* CHECK dout1_31 vdout1_31ck18 = 0 time = 95
* CHECK dout0_0 vdout0_0ck19 = 1.0 time = 100
* CHECK dout0_1 vdout0_1ck19 = 0 time = 100
* CHECK dout0_2 vdout0_2ck19 = 0 time = 100
* CHECK dout0_3 vdout0_3ck19 = 0 time = 100
* CHECK dout0_4 vdout0_4ck19 = 0 time = 100
* CHECK dout0_5 vdout0_5ck19 = 0 time = 100
* CHECK dout0_6 vdout0_6ck19 = 0 time = 100
* CHECK dout0_7 vdout0_7ck19 = 0 time = 100
* CHECK dout0_8 vdout0_8ck19 = 0 time = 100
* CHECK dout0_9 vdout0_9ck19 = 1.0 time = 100
* CHECK dout0_10 vdout0_10ck19 = 0 time = 100
* CHECK dout0_11 vdout0_11ck19 = 0 time = 100
* CHECK dout0_12 vdout0_12ck19 = 0 time = 100
* CHECK dout0_13 vdout0_13ck19 = 0 time = 100
* CHECK dout0_14 vdout0_14ck19 = 1.0 time = 100
* CHECK dout0_15 vdout0_15ck19 = 1.0 time = 100
* CHECK dout0_16 vdout0_16ck19 = 1.0 time = 100
* CHECK dout0_17 vdout0_17ck19 = 0 time = 100
* CHECK dout0_18 vdout0_18ck19 = 1.0 time = 100
* CHECK dout0_19 vdout0_19ck19 = 0 time = 100
* CHECK dout0_20 vdout0_20ck19 = 1.0 time = 100
* CHECK dout0_21 vdout0_21ck19 = 0 time = 100
* CHECK dout0_22 vdout0_22ck19 = 0 time = 100
* CHECK dout0_23 vdout0_23ck19 = 0 time = 100
* CHECK dout0_24 vdout0_24ck19 = 0 time = 100
* CHECK dout0_25 vdout0_25ck19 = 0 time = 100
* CHECK dout0_26 vdout0_26ck19 = 1.0 time = 100
* CHECK dout0_27 vdout0_27ck19 = 0 time = 100
* CHECK dout0_28 vdout0_28ck19 = 0 time = 100
* CHECK dout0_29 vdout0_29ck19 = 1.0 time = 100
* CHECK dout0_30 vdout0_30ck19 = 1.0 time = 100
* CHECK dout0_31 vdout0_31ck19 = 1.0 time = 100
* CHECK dout1_0 vdout1_0ck19 = 1.0 time = 100
* CHECK dout1_1 vdout1_1ck19 = 0 time = 100
* CHECK dout1_2 vdout1_2ck19 = 1.0 time = 100
* CHECK dout1_3 vdout1_3ck19 = 0 time = 100
* CHECK dout1_4 vdout1_4ck19 = 1.0 time = 100
* CHECK dout1_5 vdout1_5ck19 = 0 time = 100
* CHECK dout1_6 vdout1_6ck19 = 1.0 time = 100
* CHECK dout1_7 vdout1_7ck19 = 0 time = 100
* CHECK dout1_8 vdout1_8ck19 = 0 time = 100
* CHECK dout1_9 vdout1_9ck19 = 0 time = 100
* CHECK dout1_10 vdout1_10ck19 = 1.0 time = 100
* CHECK dout1_11 vdout1_11ck19 = 0 time = 100
* CHECK dout1_12 vdout1_12ck19 = 0 time = 100
* CHECK dout1_13 vdout1_13ck19 = 1.0 time = 100
* CHECK dout1_14 vdout1_14ck19 = 1.0 time = 100
* CHECK dout1_15 vdout1_15ck19 = 1.0 time = 100
* CHECK dout1_16 vdout1_16ck19 = 0 time = 100
* CHECK dout1_17 vdout1_17ck19 = 0 time = 100
* CHECK dout1_18 vdout1_18ck19 = 0 time = 100
* CHECK dout1_19 vdout1_19ck19 = 1.0 time = 100
* CHECK dout1_20 vdout1_20ck19 = 1.0 time = 100
* CHECK dout1_21 vdout1_21ck19 = 0 time = 100
* CHECK dout1_22 vdout1_22ck19 = 0 time = 100
* CHECK dout1_23 vdout1_23ck19 = 1.0 time = 100
* CHECK dout1_24 vdout1_24ck19 = 0 time = 100
* CHECK dout1_25 vdout1_25ck19 = 0 time = 100
* CHECK dout1_26 vdout1_26ck19 = 0 time = 100
* CHECK dout1_27 vdout1_27ck19 = 1.0 time = 100
* CHECK dout1_28 vdout1_28ck19 = 0 time = 100
* CHECK dout1_29 vdout1_29ck19 = 1.0 time = 100
* CHECK dout1_30 vdout1_30ck19 = 1.0 time = 100
* CHECK dout1_31 vdout1_31ck19 = 0 time = 100
* CHECK dout0_0 vdout0_0ck21 = 1.0 time = 110
* CHECK dout0_1 vdout0_1ck21 = 0 time = 110
* CHECK dout0_2 vdout0_2ck21 = 0 time = 110
* CHECK dout0_3 vdout0_3ck21 = 0 time = 110
* CHECK dout0_4 vdout0_4ck21 = 0 time = 110
* CHECK dout0_5 vdout0_5ck21 = 0 time = 110
* CHECK dout0_6 vdout0_6ck21 = 0 time = 110
* CHECK dout0_7 vdout0_7ck21 = 0 time = 110
* CHECK dout0_8 vdout0_8ck21 = 0 time = 110
* CHECK dout0_9 vdout0_9ck21 = 1.0 time = 110
* CHECK dout0_10 vdout0_10ck21 = 0 time = 110
* CHECK dout0_11 vdout0_11ck21 = 0 time = 110
* CHECK dout0_12 vdout0_12ck21 = 0 time = 110
* CHECK dout0_13 vdout0_13ck21 = 0 time = 110
* CHECK dout0_14 vdout0_14ck21 = 1.0 time = 110
* CHECK dout0_15 vdout0_15ck21 = 1.0 time = 110
* CHECK dout0_16 vdout0_16ck21 = 1.0 time = 110
* CHECK dout0_17 vdout0_17ck21 = 0 time = 110
* CHECK dout0_18 vdout0_18ck21 = 1.0 time = 110
* CHECK dout0_19 vdout0_19ck21 = 0 time = 110
* CHECK dout0_20 vdout0_20ck21 = 1.0 time = 110
* CHECK dout0_21 vdout0_21ck21 = 0 time = 110
* CHECK dout0_22 vdout0_22ck21 = 0 time = 110
* CHECK dout0_23 vdout0_23ck21 = 0 time = 110
* CHECK dout0_24 vdout0_24ck21 = 0 time = 110
* CHECK dout0_25 vdout0_25ck21 = 0 time = 110
* CHECK dout0_26 vdout0_26ck21 = 1.0 time = 110
* CHECK dout0_27 vdout0_27ck21 = 0 time = 110
* CHECK dout0_28 vdout0_28ck21 = 0 time = 110
* CHECK dout0_29 vdout0_29ck21 = 1.0 time = 110
* CHECK dout0_30 vdout0_30ck21 = 1.0 time = 110
* CHECK dout0_31 vdout0_31ck21 = 1.0 time = 110
* CHECK dout1_0 vdout1_0ck21 = 0 time = 110
* CHECK dout1_1 vdout1_1ck21 = 1.0 time = 110
* CHECK dout1_2 vdout1_2ck21 = 1.0 time = 110
* CHECK dout1_3 vdout1_3ck21 = 0 time = 110
* CHECK dout1_4 vdout1_4ck21 = 0 time = 110
* CHECK dout1_5 vdout1_5ck21 = 1.0 time = 110
* CHECK dout1_6 vdout1_6ck21 = 0 time = 110
* CHECK dout1_7 vdout1_7ck21 = 1.0 time = 110
* CHECK dout1_8 vdout1_8ck21 = 1.0 time = 110
* CHECK dout1_9 vdout1_9ck21 = 1.0 time = 110
* CHECK dout1_10 vdout1_10ck21 = 0 time = 110
* CHECK dout1_11 vdout1_11ck21 = 1.0 time = 110
* CHECK dout1_12 vdout1_12ck21 = 1.0 time = 110
* CHECK dout1_13 vdout1_13ck21 = 1.0 time = 110
* CHECK dout1_14 vdout1_14ck21 = 1.0 time = 110
* CHECK dout1_15 vdout1_15ck21 = 1.0 time = 110
* CHECK dout1_16 vdout1_16ck21 = 1.0 time = 110
* CHECK dout1_17 vdout1_17ck21 = 0 time = 110
* CHECK dout1_18 vdout1_18ck21 = 0 time = 110
* CHECK dout1_19 vdout1_19ck21 = 0 time = 110
* CHECK dout1_20 vdout1_20ck21 = 0 time = 110
* CHECK dout1_21 vdout1_21ck21 = 0 time = 110
* CHECK dout1_22 vdout1_22ck21 = 0 time = 110
* CHECK dout1_23 vdout1_23ck21 = 0 time = 110
* CHECK dout1_24 vdout1_24ck21 = 1.0 time = 110
* CHECK dout1_25 vdout1_25ck21 = 1.0 time = 110
* CHECK dout1_26 vdout1_26ck21 = 0 time = 110
* CHECK dout1_27 vdout1_27ck21 = 0 time = 110
* CHECK dout1_28 vdout1_28ck21 = 1.0 time = 110
* CHECK dout1_29 vdout1_29ck21 = 1.0 time = 110
* CHECK dout1_30 vdout1_30ck21 = 0 time = 110
* CHECK dout1_31 vdout1_31ck21 = 1.0 time = 110
* CHECK dout1_0 vdout1_0ck22 = 1.0 time = 115
* CHECK dout1_1 vdout1_1ck22 = 1.0 time = 115
* CHECK dout1_2 vdout1_2ck22 = 0 time = 115
* CHECK dout1_3 vdout1_3ck22 = 1.0 time = 115
* CHECK dout1_4 vdout1_4ck22 = 1.0 time = 115
* CHECK dout1_5 vdout1_5ck22 = 1.0 time = 115
* CHECK dout1_6 vdout1_6ck22 = 0 time = 115
* CHECK dout1_7 vdout1_7ck22 = 1.0 time = 115
* CHECK dout1_8 vdout1_8ck22 = 1.0 time = 115
* CHECK dout1_9 vdout1_9ck22 = 0 time = 115
* CHECK dout1_10 vdout1_10ck22 = 1.0 time = 115
* CHECK dout1_11 vdout1_11ck22 = 0 time = 115
* CHECK dout1_12 vdout1_12ck22 = 0 time = 115
* CHECK dout1_13 vdout1_13ck22 = 1.0 time = 115
* CHECK dout1_14 vdout1_14ck22 = 1.0 time = 115
* CHECK dout1_15 vdout1_15ck22 = 0 time = 115
* CHECK dout1_16 vdout1_16ck22 = 1.0 time = 115
* CHECK dout1_17 vdout1_17ck22 = 1.0 time = 115
* CHECK dout1_18 vdout1_18ck22 = 1.0 time = 115
* CHECK dout1_19 vdout1_19ck22 = 1.0 time = 115
* CHECK dout1_20 vdout1_20ck22 = 1.0 time = 115
* CHECK dout1_21 vdout1_21ck22 = 0 time = 115
* CHECK dout1_22 vdout1_22ck22 = 0 time = 115
* CHECK dout1_23 vdout1_23ck22 = 0 time = 115
* CHECK dout1_24 vdout1_24ck22 = 0 time = 115
* CHECK dout1_25 vdout1_25ck22 = 0 time = 115
* CHECK dout1_26 vdout1_26ck22 = 0 time = 115
* CHECK dout1_27 vdout1_27ck22 = 1.0 time = 115
* CHECK dout1_28 vdout1_28ck22 = 1.0 time = 115
* CHECK dout1_29 vdout1_29ck22 = 1.0 time = 115
* CHECK dout1_30 vdout1_30ck22 = 1.0 time = 115
* CHECK dout1_31 vdout1_31ck22 = 0 time = 115
* CHECK dout1_0 vdout1_0ck24 = 1.0 time = 125
* CHECK dout1_1 vdout1_1ck24 = 1.0 time = 125
* CHECK dout1_2 vdout1_2ck24 = 1.0 time = 125
* CHECK dout1_3 vdout1_3ck24 = 1.0 time = 125
* CHECK dout1_4 vdout1_4ck24 = 0 time = 125
* CHECK dout1_5 vdout1_5ck24 = 1.0 time = 125
* CHECK dout1_6 vdout1_6ck24 = 0 time = 125
* CHECK dout1_7 vdout1_7ck24 = 0 time = 125
* CHECK dout1_8 vdout1_8ck24 = 1.0 time = 125
* CHECK dout1_9 vdout1_9ck24 = 1.0 time = 125
* CHECK dout1_10 vdout1_10ck24 = 0 time = 125
* CHECK dout1_11 vdout1_11ck24 = 1.0 time = 125
* CHECK dout1_12 vdout1_12ck24 = 0 time = 125
* CHECK dout1_13 vdout1_13ck24 = 1.0 time = 125
* CHECK dout1_14 vdout1_14ck24 = 0 time = 125
* CHECK dout1_15 vdout1_15ck24 = 0 time = 125
* CHECK dout1_16 vdout1_16ck24 = 0 time = 125
* CHECK dout1_17 vdout1_17ck24 = 1.0 time = 125
* CHECK dout1_18 vdout1_18ck24 = 1.0 time = 125
* CHECK dout1_19 vdout1_19ck24 = 0 time = 125
* CHECK dout1_20 vdout1_20ck24 = 0 time = 125
* CHECK dout1_21 vdout1_21ck24 = 1.0 time = 125
* CHECK dout1_22 vdout1_22ck24 = 0 time = 125
* CHECK dout1_23 vdout1_23ck24 = 1.0 time = 125
* CHECK dout1_24 vdout1_24ck24 = 1.0 time = 125
* CHECK dout1_25 vdout1_25ck24 = 0 time = 125
* CHECK dout1_26 vdout1_26ck24 = 0 time = 125
* CHECK dout1_27 vdout1_27ck24 = 1.0 time = 125
* CHECK dout1_28 vdout1_28ck24 = 1.0 time = 125
* CHECK dout1_29 vdout1_29ck24 = 1.0 time = 125
* CHECK dout1_30 vdout1_30ck24 = 0 time = 125
* CHECK dout1_31 vdout1_31ck24 = 1.0 time = 125
* CHECK dout0_0 vdout0_0ck26 = 1.0 time = 135
* CHECK dout0_1 vdout0_1ck26 = 1.0 time = 135
* CHECK dout0_2 vdout0_2ck26 = 1.0 time = 135
* CHECK dout0_3 vdout0_3ck26 = 1.0 time = 135
* CHECK dout0_4 vdout0_4ck26 = 0 time = 135
* CHECK dout0_5 vdout0_5ck26 = 1.0 time = 135
* CHECK dout0_6 vdout0_6ck26 = 0 time = 135
* CHECK dout0_7 vdout0_7ck26 = 0 time = 135
* CHECK dout0_8 vdout0_8ck26 = 1.0 time = 135
* CHECK dout0_9 vdout0_9ck26 = 1.0 time = 135
* CHECK dout0_10 vdout0_10ck26 = 0 time = 135
* CHECK dout0_11 vdout0_11ck26 = 1.0 time = 135
* CHECK dout0_12 vdout0_12ck26 = 0 time = 135
* CHECK dout0_13 vdout0_13ck26 = 1.0 time = 135
* CHECK dout0_14 vdout0_14ck26 = 0 time = 135
* CHECK dout0_15 vdout0_15ck26 = 0 time = 135
* CHECK dout0_16 vdout0_16ck26 = 0 time = 135
* CHECK dout0_17 vdout0_17ck26 = 1.0 time = 135
* CHECK dout0_18 vdout0_18ck26 = 1.0 time = 135
* CHECK dout0_19 vdout0_19ck26 = 0 time = 135
* CHECK dout0_20 vdout0_20ck26 = 0 time = 135
* CHECK dout0_21 vdout0_21ck26 = 1.0 time = 135
* CHECK dout0_22 vdout0_22ck26 = 0 time = 135
* CHECK dout0_23 vdout0_23ck26 = 1.0 time = 135
* CHECK dout0_24 vdout0_24ck26 = 1.0 time = 135
* CHECK dout0_25 vdout0_25ck26 = 0 time = 135
* CHECK dout0_26 vdout0_26ck26 = 0 time = 135
* CHECK dout0_27 vdout0_27ck26 = 1.0 time = 135
* CHECK dout0_28 vdout0_28ck26 = 1.0 time = 135
* CHECK dout0_29 vdout0_29ck26 = 1.0 time = 135
* CHECK dout0_30 vdout0_30ck26 = 0 time = 135
* CHECK dout0_31 vdout0_31ck26 = 1.0 time = 135
* CHECK dout1_0 vdout1_0ck26 = 0 time = 135
* CHECK dout1_1 vdout1_1ck26 = 1.0 time = 135
* CHECK dout1_2 vdout1_2ck26 = 1.0 time = 135
* CHECK dout1_3 vdout1_3ck26 = 0 time = 135
* CHECK dout1_4 vdout1_4ck26 = 0 time = 135
* CHECK dout1_5 vdout1_5ck26 = 1.0 time = 135
* CHECK dout1_6 vdout1_6ck26 = 0 time = 135
* CHECK dout1_7 vdout1_7ck26 = 1.0 time = 135
* CHECK dout1_8 vdout1_8ck26 = 1.0 time = 135
* CHECK dout1_9 vdout1_9ck26 = 1.0 time = 135
* CHECK dout1_10 vdout1_10ck26 = 0 time = 135
* CHECK dout1_11 vdout1_11ck26 = 1.0 time = 135
* CHECK dout1_12 vdout1_12ck26 = 1.0 time = 135
* CHECK dout1_13 vdout1_13ck26 = 1.0 time = 135
* CHECK dout1_14 vdout1_14ck26 = 1.0 time = 135
* CHECK dout1_15 vdout1_15ck26 = 1.0 time = 135
* CHECK dout1_16 vdout1_16ck26 = 1.0 time = 135
* CHECK dout1_17 vdout1_17ck26 = 0 time = 135
* CHECK dout1_18 vdout1_18ck26 = 0 time = 135
* CHECK dout1_19 vdout1_19ck26 = 0 time = 135
* CHECK dout1_20 vdout1_20ck26 = 0 time = 135
* CHECK dout1_21 vdout1_21ck26 = 0 time = 135
* CHECK dout1_22 vdout1_22ck26 = 0 time = 135
* CHECK dout1_23 vdout1_23ck26 = 0 time = 135
* CHECK dout1_24 vdout1_24ck26 = 1.0 time = 135
* CHECK dout1_25 vdout1_25ck26 = 1.0 time = 135
* CHECK dout1_26 vdout1_26ck26 = 0 time = 135
* CHECK dout1_27 vdout1_27ck26 = 0 time = 135
* CHECK dout1_28 vdout1_28ck26 = 1.0 time = 135
* CHECK dout1_29 vdout1_29ck26 = 1.0 time = 135
* CHECK dout1_30 vdout1_30ck26 = 0 time = 135
* CHECK dout1_31 vdout1_31ck26 = 1.0 time = 135
* CHECK dout1_0 vdout1_0ck27 = 0 time = 140
* CHECK dout1_1 vdout1_1ck27 = 1.0 time = 140
* CHECK dout1_2 vdout1_2ck27 = 0 time = 140
* CHECK dout1_3 vdout1_3ck27 = 1.0 time = 140
* CHECK dout1_4 vdout1_4ck27 = 0 time = 140
* CHECK dout1_5 vdout1_5ck27 = 1.0 time = 140
* CHECK dout1_6 vdout1_6ck27 = 1.0 time = 140
* CHECK dout1_7 vdout1_7ck27 = 1.0 time = 140
* CHECK dout1_8 vdout1_8ck27 = 0 time = 140
* CHECK dout1_9 vdout1_9ck27 = 0 time = 140
* CHECK dout1_10 vdout1_10ck27 = 0 time = 140
* CHECK dout1_11 vdout1_11ck27 = 1.0 time = 140
* CHECK dout1_12 vdout1_12ck27 = 1.0 time = 140
* CHECK dout1_13 vdout1_13ck27 = 1.0 time = 140
* CHECK dout1_14 vdout1_14ck27 = 1.0 time = 140
* CHECK dout1_15 vdout1_15ck27 = 1.0 time = 140
* CHECK dout1_16 vdout1_16ck27 = 1.0 time = 140
* CHECK dout1_17 vdout1_17ck27 = 0 time = 140
* CHECK dout1_18 vdout1_18ck27 = 0 time = 140
* CHECK dout1_19 vdout1_19ck27 = 0 time = 140
* CHECK dout1_20 vdout1_20ck27 = 1.0 time = 140
* CHECK dout1_21 vdout1_21ck27 = 0 time = 140
* CHECK dout1_22 vdout1_22ck27 = 0 time = 140
* CHECK dout1_23 vdout1_23ck27 = 1.0 time = 140
* CHECK dout1_24 vdout1_24ck27 = 1.0 time = 140
* CHECK dout1_25 vdout1_25ck27 = 1.0 time = 140
* CHECK dout1_26 vdout1_26ck27 = 1.0 time = 140
* CHECK dout1_27 vdout1_27ck27 = 0 time = 140
* CHECK dout1_28 vdout1_28ck27 = 0 time = 140
* CHECK dout1_29 vdout1_29ck27 = 0 time = 140
* CHECK dout1_30 vdout1_30ck27 = 0 time = 140
* CHECK dout1_31 vdout1_31ck27 = 1.0 time = 140
* CHECK dout1_0 vdout1_0ck29 = 0 time = 150
* CHECK dout1_1 vdout1_1ck29 = 0 time = 150
* CHECK dout1_2 vdout1_2ck29 = 0 time = 150
* CHECK dout1_3 vdout1_3ck29 = 0 time = 150
* CHECK dout1_4 vdout1_4ck29 = 0 time = 150
* CHECK dout1_5 vdout1_5ck29 = 0 time = 150
* CHECK dout1_6 vdout1_6ck29 = 1.0 time = 150
* CHECK dout1_7 vdout1_7ck29 = 1.0 time = 150
* CHECK dout1_8 vdout1_8ck29 = 0 time = 150
* CHECK dout1_9 vdout1_9ck29 = 1.0 time = 150
* CHECK dout1_10 vdout1_10ck29 = 0 time = 150
* CHECK dout1_11 vdout1_11ck29 = 0 time = 150
* CHECK dout1_12 vdout1_12ck29 = 0 time = 150
* CHECK dout1_13 vdout1_13ck29 = 1.0 time = 150
* CHECK dout1_14 vdout1_14ck29 = 0 time = 150
* CHECK dout1_15 vdout1_15ck29 = 1.0 time = 150
* CHECK dout1_16 vdout1_16ck29 = 1.0 time = 150
* CHECK dout1_17 vdout1_17ck29 = 0 time = 150
* CHECK dout1_18 vdout1_18ck29 = 0 time = 150
* CHECK dout1_19 vdout1_19ck29 = 0 time = 150
* CHECK dout1_20 vdout1_20ck29 = 0 time = 150
* CHECK dout1_21 vdout1_21ck29 = 1.0 time = 150
* CHECK dout1_22 vdout1_22ck29 = 1.0 time = 150
* CHECK dout1_23 vdout1_23ck29 = 1.0 time = 150
* CHECK dout1_24 vdout1_24ck29 = 0 time = 150
* CHECK dout1_25 vdout1_25ck29 = 0 time = 150
* CHECK dout1_26 vdout1_26ck29 = 1.0 time = 150
* CHECK dout1_27 vdout1_27ck29 = 1.0 time = 150
* CHECK dout1_28 vdout1_28ck29 = 1.0 time = 150
* CHECK dout1_29 vdout1_29ck29 = 0 time = 150
* CHECK dout1_30 vdout1_30ck29 = 0 time = 150
* CHECK dout1_31 vdout1_31ck29 = 1.0 time = 150
* CHECK dout0_0 vdout0_0ck30 = 1.0 time = 155
* CHECK dout0_1 vdout0_1ck30 = 1.0 time = 155
* CHECK dout0_2 vdout0_2ck30 = 1.0 time = 155
* CHECK dout0_3 vdout0_3ck30 = 1.0 time = 155
* CHECK dout0_4 vdout0_4ck30 = 0 time = 155
* CHECK dout0_5 vdout0_5ck30 = 0 time = 155
* CHECK dout0_6 vdout0_6ck30 = 1.0 time = 155
* CHECK dout0_7 vdout0_7ck30 = 0 time = 155
* CHECK dout0_8 vdout0_8ck30 = 0 time = 155
* CHECK dout0_9 vdout0_9ck30 = 0 time = 155
* CHECK dout0_10 vdout0_10ck30 = 1.0 time = 155
* CHECK dout0_11 vdout0_11ck30 = 1.0 time = 155
* CHECK dout0_12 vdout0_12ck30 = 1.0 time = 155
* CHECK dout0_13 vdout0_13ck30 = 1.0 time = 155
* CHECK dout0_14 vdout0_14ck30 = 1.0 time = 155
* CHECK dout0_15 vdout0_15ck30 = 0 time = 155
* CHECK dout0_16 vdout0_16ck30 = 0 time = 155
* CHECK dout0_17 vdout0_17ck30 = 1.0 time = 155
* CHECK dout0_18 vdout0_18ck30 = 0 time = 155
* CHECK dout0_19 vdout0_19ck30 = 0 time = 155
* CHECK dout0_20 vdout0_20ck30 = 1.0 time = 155
* CHECK dout0_21 vdout0_21ck30 = 0 time = 155
* CHECK dout0_22 vdout0_22ck30 = 1.0 time = 155
* CHECK dout0_23 vdout0_23ck30 = 1.0 time = 155
* CHECK dout0_24 vdout0_24ck30 = 0 time = 155
* CHECK dout0_25 vdout0_25ck30 = 0 time = 155
* CHECK dout0_26 vdout0_26ck30 = 0 time = 155
* CHECK dout0_27 vdout0_27ck30 = 1.0 time = 155
* CHECK dout0_28 vdout0_28ck30 = 1.0 time = 155
* CHECK dout0_29 vdout0_29ck30 = 0 time = 155
* CHECK dout0_30 vdout0_30ck30 = 1.0 time = 155
* CHECK dout0_31 vdout0_31ck30 = 0 time = 155
* CHECK dout0_0 vdout0_0ck31 = 1.0 time = 160
* CHECK dout0_1 vdout0_1ck31 = 1.0 time = 160
* CHECK dout0_2 vdout0_2ck31 = 1.0 time = 160
* CHECK dout0_3 vdout0_3ck31 = 1.0 time = 160
* CHECK dout0_4 vdout0_4ck31 = 0 time = 160
* CHECK dout0_5 vdout0_5ck31 = 0 time = 160
* CHECK dout0_6 vdout0_6ck31 = 1.0 time = 160
* CHECK dout0_7 vdout0_7ck31 = 0 time = 160
* CHECK dout0_8 vdout0_8ck31 = 0 time = 160
* CHECK dout0_9 vdout0_9ck31 = 0 time = 160
* CHECK dout0_10 vdout0_10ck31 = 1.0 time = 160
* CHECK dout0_11 vdout0_11ck31 = 1.0 time = 160
* CHECK dout0_12 vdout0_12ck31 = 1.0 time = 160
* CHECK dout0_13 vdout0_13ck31 = 1.0 time = 160
* CHECK dout0_14 vdout0_14ck31 = 1.0 time = 160
* CHECK dout0_15 vdout0_15ck31 = 0 time = 160
* CHECK dout0_16 vdout0_16ck31 = 0 time = 160
* CHECK dout0_17 vdout0_17ck31 = 1.0 time = 160
* CHECK dout0_18 vdout0_18ck31 = 0 time = 160
* CHECK dout0_19 vdout0_19ck31 = 0 time = 160
* CHECK dout0_20 vdout0_20ck31 = 1.0 time = 160
* CHECK dout0_21 vdout0_21ck31 = 0 time = 160
* CHECK dout0_22 vdout0_22ck31 = 1.0 time = 160
* CHECK dout0_23 vdout0_23ck31 = 1.0 time = 160
* CHECK dout0_24 vdout0_24ck31 = 0 time = 160
* CHECK dout0_25 vdout0_25ck31 = 0 time = 160
* CHECK dout0_26 vdout0_26ck31 = 0 time = 160
* CHECK dout0_27 vdout0_27ck31 = 1.0 time = 160
* CHECK dout0_28 vdout0_28ck31 = 1.0 time = 160
* CHECK dout0_29 vdout0_29ck31 = 0 time = 160
* CHECK dout0_30 vdout0_30ck31 = 1.0 time = 160
* CHECK dout0_31 vdout0_31ck31 = 0 time = 160
* CHECK dout1_0 vdout1_0ck31 = 1.0 time = 160
* CHECK dout1_1 vdout1_1ck31 = 1.0 time = 160
* CHECK dout1_2 vdout1_2ck31 = 0 time = 160
* CHECK dout1_3 vdout1_3ck31 = 0 time = 160
* CHECK dout1_4 vdout1_4ck31 = 1.0 time = 160
* CHECK dout1_5 vdout1_5ck31 = 0 time = 160
* CHECK dout1_6 vdout1_6ck31 = 0 time = 160
* CHECK dout1_7 vdout1_7ck31 = 1.0 time = 160
* CHECK dout1_8 vdout1_8ck31 = 1.0 time = 160
* CHECK dout1_9 vdout1_9ck31 = 1.0 time = 160
* CHECK dout1_10 vdout1_10ck31 = 1.0 time = 160
* CHECK dout1_11 vdout1_11ck31 = 0 time = 160
* CHECK dout1_12 vdout1_12ck31 = 1.0 time = 160
* CHECK dout1_13 vdout1_13ck31 = 0 time = 160
* CHECK dout1_14 vdout1_14ck31 = 0 time = 160
* CHECK dout1_15 vdout1_15ck31 = 0 time = 160
* CHECK dout1_16 vdout1_16ck31 = 1.0 time = 160
* CHECK dout1_17 vdout1_17ck31 = 1.0 time = 160
* CHECK dout1_18 vdout1_18ck31 = 1.0 time = 160
* CHECK dout1_19 vdout1_19ck31 = 1.0 time = 160
* CHECK dout1_20 vdout1_20ck31 = 1.0 time = 160
* CHECK dout1_21 vdout1_21ck31 = 0 time = 160
* CHECK dout1_22 vdout1_22ck31 = 0 time = 160
* CHECK dout1_23 vdout1_23ck31 = 1.0 time = 160
* CHECK dout1_24 vdout1_24ck31 = 1.0 time = 160
* CHECK dout1_25 vdout1_25ck31 = 1.0 time = 160
* CHECK dout1_26 vdout1_26ck31 = 1.0 time = 160
* CHECK dout1_27 vdout1_27ck31 = 1.0 time = 160
* CHECK dout1_28 vdout1_28ck31 = 1.0 time = 160
* CHECK dout1_29 vdout1_29ck31 = 1.0 time = 160
* CHECK dout1_30 vdout1_30ck31 = 0 time = 160
* CHECK dout1_31 vdout1_31ck31 = 0 time = 160
* CHECK dout1_0 vdout1_0ck32 = 1.0 time = 165
* CHECK dout1_1 vdout1_1ck32 = 1.0 time = 165
* CHECK dout1_2 vdout1_2ck32 = 1.0 time = 165
* CHECK dout1_3 vdout1_3ck32 = 1.0 time = 165
* CHECK dout1_4 vdout1_4ck32 = 0 time = 165
* CHECK dout1_5 vdout1_5ck32 = 0 time = 165
* CHECK dout1_6 vdout1_6ck32 = 1.0 time = 165
* CHECK dout1_7 vdout1_7ck32 = 0 time = 165
* CHECK dout1_8 vdout1_8ck32 = 0 time = 165
* CHECK dout1_9 vdout1_9ck32 = 0 time = 165
* CHECK dout1_10 vdout1_10ck32 = 1.0 time = 165
* CHECK dout1_11 vdout1_11ck32 = 1.0 time = 165
* CHECK dout1_12 vdout1_12ck32 = 1.0 time = 165
* CHECK dout1_13 vdout1_13ck32 = 1.0 time = 165
* CHECK dout1_14 vdout1_14ck32 = 1.0 time = 165
* CHECK dout1_15 vdout1_15ck32 = 0 time = 165
* CHECK dout1_16 vdout1_16ck32 = 0 time = 165
* CHECK dout1_17 vdout1_17ck32 = 1.0 time = 165
* CHECK dout1_18 vdout1_18ck32 = 0 time = 165
* CHECK dout1_19 vdout1_19ck32 = 0 time = 165
* CHECK dout1_20 vdout1_20ck32 = 1.0 time = 165
* CHECK dout1_21 vdout1_21ck32 = 0 time = 165
* CHECK dout1_22 vdout1_22ck32 = 1.0 time = 165
* CHECK dout1_23 vdout1_23ck32 = 1.0 time = 165
* CHECK dout1_24 vdout1_24ck32 = 0 time = 165
* CHECK dout1_25 vdout1_25ck32 = 0 time = 165
* CHECK dout1_26 vdout1_26ck32 = 0 time = 165
* CHECK dout1_27 vdout1_27ck32 = 1.0 time = 165
* CHECK dout1_28 vdout1_28ck32 = 1.0 time = 165
* CHECK dout1_29 vdout1_29ck32 = 0 time = 165
* CHECK dout1_30 vdout1_30ck32 = 1.0 time = 165
* CHECK dout1_31 vdout1_31ck32 = 0 time = 165
* CHECK dout0_0 vdout0_0ck33 = 1.0 time = 170
* CHECK dout0_1 vdout0_1ck33 = 1.0 time = 170
* CHECK dout0_2 vdout0_2ck33 = 1.0 time = 170
* CHECK dout0_3 vdout0_3ck33 = 1.0 time = 170
* CHECK dout0_4 vdout0_4ck33 = 0 time = 170
* CHECK dout0_5 vdout0_5ck33 = 0 time = 170
* CHECK dout0_6 vdout0_6ck33 = 1.0 time = 170
* CHECK dout0_7 vdout0_7ck33 = 0 time = 170
* CHECK dout0_8 vdout0_8ck33 = 0 time = 170
* CHECK dout0_9 vdout0_9ck33 = 0 time = 170
* CHECK dout0_10 vdout0_10ck33 = 1.0 time = 170
* CHECK dout0_11 vdout0_11ck33 = 1.0 time = 170
* CHECK dout0_12 vdout0_12ck33 = 1.0 time = 170
* CHECK dout0_13 vdout0_13ck33 = 1.0 time = 170
* CHECK dout0_14 vdout0_14ck33 = 1.0 time = 170
* CHECK dout0_15 vdout0_15ck33 = 0 time = 170
* CHECK dout0_16 vdout0_16ck33 = 0 time = 170
* CHECK dout0_17 vdout0_17ck33 = 1.0 time = 170
* CHECK dout0_18 vdout0_18ck33 = 0 time = 170
* CHECK dout0_19 vdout0_19ck33 = 0 time = 170
* CHECK dout0_20 vdout0_20ck33 = 1.0 time = 170
* CHECK dout0_21 vdout0_21ck33 = 0 time = 170
* CHECK dout0_22 vdout0_22ck33 = 1.0 time = 170
* CHECK dout0_23 vdout0_23ck33 = 1.0 time = 170
* CHECK dout0_24 vdout0_24ck33 = 0 time = 170
* CHECK dout0_25 vdout0_25ck33 = 0 time = 170
* CHECK dout0_26 vdout0_26ck33 = 0 time = 170
* CHECK dout0_27 vdout0_27ck33 = 1.0 time = 170
* CHECK dout0_28 vdout0_28ck33 = 1.0 time = 170
* CHECK dout0_29 vdout0_29ck33 = 0 time = 170
* CHECK dout0_30 vdout0_30ck33 = 1.0 time = 170
* CHECK dout0_31 vdout0_31ck33 = 0 time = 170
* CHECK dout0_0 vdout0_0ck34 = 1.0 time = 175
* CHECK dout0_1 vdout0_1ck34 = 0 time = 175
* CHECK dout0_2 vdout0_2ck34 = 0 time = 175
* CHECK dout0_3 vdout0_3ck34 = 1.0 time = 175
* CHECK dout0_4 vdout0_4ck34 = 1.0 time = 175
* CHECK dout0_5 vdout0_5ck34 = 1.0 time = 175
* CHECK dout0_6 vdout0_6ck34 = 1.0 time = 175
* CHECK dout0_7 vdout0_7ck34 = 1.0 time = 175
* CHECK dout0_8 vdout0_8ck34 = 0 time = 175
* CHECK dout0_9 vdout0_9ck34 = 1.0 time = 175
* CHECK dout0_10 vdout0_10ck34 = 0 time = 175
* CHECK dout0_11 vdout0_11ck34 = 0 time = 175
* CHECK dout0_12 vdout0_12ck34 = 0 time = 175
* CHECK dout0_13 vdout0_13ck34 = 1.0 time = 175
* CHECK dout0_14 vdout0_14ck34 = 1.0 time = 175
* CHECK dout0_15 vdout0_15ck34 = 1.0 time = 175
* CHECK dout0_16 vdout0_16ck34 = 1.0 time = 175
* CHECK dout0_17 vdout0_17ck34 = 0 time = 175
* CHECK dout0_18 vdout0_18ck34 = 0 time = 175
* CHECK dout0_19 vdout0_19ck34 = 0 time = 175
* CHECK dout0_20 vdout0_20ck34 = 1.0 time = 175
* CHECK dout0_21 vdout0_21ck34 = 1.0 time = 175
* CHECK dout0_22 vdout0_22ck34 = 0 time = 175
* CHECK dout0_23 vdout0_23ck34 = 0 time = 175
* CHECK dout0_24 vdout0_24ck34 = 0 time = 175
* CHECK dout0_25 vdout0_25ck34 = 0 time = 175
* CHECK dout0_26 vdout0_26ck34 = 0 time = 175
* CHECK dout0_27 vdout0_27ck34 = 0 time = 175
* CHECK dout0_28 vdout0_28ck34 = 1.0 time = 175
* CHECK dout0_29 vdout0_29ck34 = 1.0 time = 175
* CHECK dout0_30 vdout0_30ck34 = 1.0 time = 175
* CHECK dout0_31 vdout0_31ck34 = 1.0 time = 175
* CHECK dout1_0 vdout1_0ck34 = 1.0 time = 175
* CHECK dout1_1 vdout1_1ck34 = 0 time = 175
* CHECK dout1_2 vdout1_2ck34 = 0 time = 175
* CHECK dout1_3 vdout1_3ck34 = 1.0 time = 175
* CHECK dout1_4 vdout1_4ck34 = 1.0 time = 175
* CHECK dout1_5 vdout1_5ck34 = 1.0 time = 175
* CHECK dout1_6 vdout1_6ck34 = 1.0 time = 175
* CHECK dout1_7 vdout1_7ck34 = 1.0 time = 175
* CHECK dout1_8 vdout1_8ck34 = 0 time = 175
* CHECK dout1_9 vdout1_9ck34 = 1.0 time = 175
* CHECK dout1_10 vdout1_10ck34 = 0 time = 175
* CHECK dout1_11 vdout1_11ck34 = 0 time = 175
* CHECK dout1_12 vdout1_12ck34 = 0 time = 175
* CHECK dout1_13 vdout1_13ck34 = 1.0 time = 175
* CHECK dout1_14 vdout1_14ck34 = 1.0 time = 175
* CHECK dout1_15 vdout1_15ck34 = 1.0 time = 175
* CHECK dout1_16 vdout1_16ck34 = 1.0 time = 175
* CHECK dout1_17 vdout1_17ck34 = 0 time = 175
* CHECK dout1_18 vdout1_18ck34 = 0 time = 175
* CHECK dout1_19 vdout1_19ck34 = 0 time = 175
* CHECK dout1_20 vdout1_20ck34 = 1.0 time = 175
* CHECK dout1_21 vdout1_21ck34 = 1.0 time = 175
* CHECK dout1_22 vdout1_22ck34 = 0 time = 175
* CHECK dout1_23 vdout1_23ck34 = 0 time = 175
* CHECK dout1_24 vdout1_24ck34 = 0 time = 175
* CHECK dout1_25 vdout1_25ck34 = 0 time = 175
* CHECK dout1_26 vdout1_26ck34 = 0 time = 175
* CHECK dout1_27 vdout1_27ck34 = 0 time = 175
* CHECK dout1_28 vdout1_28ck34 = 1.0 time = 175
* CHECK dout1_29 vdout1_29ck34 = 1.0 time = 175
* CHECK dout1_30 vdout1_30ck34 = 1.0 time = 175
* CHECK dout1_31 vdout1_31ck34 = 1.0 time = 175
* CHECK dout0_0 vdout0_0ck36 = 0 time = 185
* CHECK dout0_1 vdout0_1ck36 = 1.0 time = 185
* CHECK dout0_2 vdout0_2ck36 = 1.0 time = 185
* CHECK dout0_3 vdout0_3ck36 = 0 time = 185
* CHECK dout0_4 vdout0_4ck36 = 0 time = 185
* CHECK dout0_5 vdout0_5ck36 = 1.0 time = 185
* CHECK dout0_6 vdout0_6ck36 = 0 time = 185
* CHECK dout0_7 vdout0_7ck36 = 1.0 time = 185
* CHECK dout0_8 vdout0_8ck36 = 1.0 time = 185
* CHECK dout0_9 vdout0_9ck36 = 1.0 time = 185
* CHECK dout0_10 vdout0_10ck36 = 0 time = 185
* CHECK dout0_11 vdout0_11ck36 = 1.0 time = 185
* CHECK dout0_12 vdout0_12ck36 = 1.0 time = 185
* CHECK dout0_13 vdout0_13ck36 = 1.0 time = 185
* CHECK dout0_14 vdout0_14ck36 = 1.0 time = 185
* CHECK dout0_15 vdout0_15ck36 = 1.0 time = 185
* CHECK dout0_16 vdout0_16ck36 = 1.0 time = 185
* CHECK dout0_17 vdout0_17ck36 = 0 time = 185
* CHECK dout0_18 vdout0_18ck36 = 0 time = 185
* CHECK dout0_19 vdout0_19ck36 = 0 time = 185
* CHECK dout0_20 vdout0_20ck36 = 0 time = 185
* CHECK dout0_21 vdout0_21ck36 = 0 time = 185
* CHECK dout0_22 vdout0_22ck36 = 0 time = 185
* CHECK dout0_23 vdout0_23ck36 = 0 time = 185
* CHECK dout0_24 vdout0_24ck36 = 1.0 time = 185
* CHECK dout0_25 vdout0_25ck36 = 1.0 time = 185
* CHECK dout0_26 vdout0_26ck36 = 0 time = 185
* CHECK dout0_27 vdout0_27ck36 = 0 time = 185
* CHECK dout0_28 vdout0_28ck36 = 1.0 time = 185
* CHECK dout0_29 vdout0_29ck36 = 1.0 time = 185
* CHECK dout0_30 vdout0_30ck36 = 0 time = 185
* CHECK dout0_31 vdout0_31ck36 = 1.0 time = 185
* CHECK dout1_0 vdout1_0ck36 = 0 time = 185
* CHECK dout1_1 vdout1_1ck36 = 1.0 time = 185
* CHECK dout1_2 vdout1_2ck36 = 1.0 time = 185
* CHECK dout1_3 vdout1_3ck36 = 0 time = 185
* CHECK dout1_4 vdout1_4ck36 = 0 time = 185
* CHECK dout1_5 vdout1_5ck36 = 1.0 time = 185
* CHECK dout1_6 vdout1_6ck36 = 0 time = 185
* CHECK dout1_7 vdout1_7ck36 = 1.0 time = 185
* CHECK dout1_8 vdout1_8ck36 = 1.0 time = 185
* CHECK dout1_9 vdout1_9ck36 = 1.0 time = 185
* CHECK dout1_10 vdout1_10ck36 = 0 time = 185
* CHECK dout1_11 vdout1_11ck36 = 1.0 time = 185
* CHECK dout1_12 vdout1_12ck36 = 1.0 time = 185
* CHECK dout1_13 vdout1_13ck36 = 1.0 time = 185
* CHECK dout1_14 vdout1_14ck36 = 1.0 time = 185
* CHECK dout1_15 vdout1_15ck36 = 1.0 time = 185
* CHECK dout1_16 vdout1_16ck36 = 1.0 time = 185
* CHECK dout1_17 vdout1_17ck36 = 0 time = 185
* CHECK dout1_18 vdout1_18ck36 = 0 time = 185
* CHECK dout1_19 vdout1_19ck36 = 0 time = 185
* CHECK dout1_20 vdout1_20ck36 = 0 time = 185
* CHECK dout1_21 vdout1_21ck36 = 0 time = 185
* CHECK dout1_22 vdout1_22ck36 = 0 time = 185
* CHECK dout1_23 vdout1_23ck36 = 0 time = 185
* CHECK dout1_24 vdout1_24ck36 = 1.0 time = 185
* CHECK dout1_25 vdout1_25ck36 = 1.0 time = 185
* CHECK dout1_26 vdout1_26ck36 = 0 time = 185
* CHECK dout1_27 vdout1_27ck36 = 0 time = 185
* CHECK dout1_28 vdout1_28ck36 = 1.0 time = 185
* CHECK dout1_29 vdout1_29ck36 = 1.0 time = 185
* CHECK dout1_30 vdout1_30ck36 = 0 time = 185
* CHECK dout1_31 vdout1_31ck36 = 1.0 time = 185
* CHECK dout0_0 vdout0_0ck37 = 1.0 time = 190
* CHECK dout0_1 vdout0_1ck37 = 1.0 time = 190
* CHECK dout0_2 vdout0_2ck37 = 1.0 time = 190
* CHECK dout0_3 vdout0_3ck37 = 1.0 time = 190
* CHECK dout0_4 vdout0_4ck37 = 0 time = 190
* CHECK dout0_5 vdout0_5ck37 = 0 time = 190
* CHECK dout0_6 vdout0_6ck37 = 1.0 time = 190
* CHECK dout0_7 vdout0_7ck37 = 0 time = 190
* CHECK dout0_8 vdout0_8ck37 = 0 time = 190
* CHECK dout0_9 vdout0_9ck37 = 0 time = 190
* CHECK dout0_10 vdout0_10ck37 = 1.0 time = 190
* CHECK dout0_11 vdout0_11ck37 = 1.0 time = 190
* CHECK dout0_12 vdout0_12ck37 = 1.0 time = 190
* CHECK dout0_13 vdout0_13ck37 = 1.0 time = 190
* CHECK dout0_14 vdout0_14ck37 = 1.0 time = 190
* CHECK dout0_15 vdout0_15ck37 = 0 time = 190
* CHECK dout0_16 vdout0_16ck37 = 0 time = 190
* CHECK dout0_17 vdout0_17ck37 = 1.0 time = 190
* CHECK dout0_18 vdout0_18ck37 = 0 time = 190
* CHECK dout0_19 vdout0_19ck37 = 0 time = 190
* CHECK dout0_20 vdout0_20ck37 = 1.0 time = 190
* CHECK dout0_21 vdout0_21ck37 = 0 time = 190
* CHECK dout0_22 vdout0_22ck37 = 1.0 time = 190
* CHECK dout0_23 vdout0_23ck37 = 1.0 time = 190
* CHECK dout0_24 vdout0_24ck37 = 0 time = 190
* CHECK dout0_25 vdout0_25ck37 = 0 time = 190
* CHECK dout0_26 vdout0_26ck37 = 0 time = 190
* CHECK dout0_27 vdout0_27ck37 = 1.0 time = 190
* CHECK dout0_28 vdout0_28ck37 = 1.0 time = 190
* CHECK dout0_29 vdout0_29ck37 = 0 time = 190
* CHECK dout0_30 vdout0_30ck37 = 1.0 time = 190
* CHECK dout0_31 vdout0_31ck37 = 0 time = 190
* CHECK dout1_0 vdout1_0ck37 = 0 time = 190
* CHECK dout1_1 vdout1_1ck37 = 1.0 time = 190
* CHECK dout1_2 vdout1_2ck37 = 1.0 time = 190
* CHECK dout1_3 vdout1_3ck37 = 1.0 time = 190
* CHECK dout1_4 vdout1_4ck37 = 1.0 time = 190
* CHECK dout1_5 vdout1_5ck37 = 0 time = 190
* CHECK dout1_6 vdout1_6ck37 = 1.0 time = 190
* CHECK dout1_7 vdout1_7ck37 = 0 time = 190
* CHECK dout1_8 vdout1_8ck37 = 0 time = 190
* CHECK dout1_9 vdout1_9ck37 = 0 time = 190
* CHECK dout1_10 vdout1_10ck37 = 0 time = 190
* CHECK dout1_11 vdout1_11ck37 = 0 time = 190
* CHECK dout1_12 vdout1_12ck37 = 0 time = 190
* CHECK dout1_13 vdout1_13ck37 = 1.0 time = 190
* CHECK dout1_14 vdout1_14ck37 = 1.0 time = 190
* CHECK dout1_15 vdout1_15ck37 = 0 time = 190
* CHECK dout1_16 vdout1_16ck37 = 1.0 time = 190
* CHECK dout1_17 vdout1_17ck37 = 0 time = 190
* CHECK dout1_18 vdout1_18ck37 = 0 time = 190
* CHECK dout1_19 vdout1_19ck37 = 1.0 time = 190
* CHECK dout1_20 vdout1_20ck37 = 0 time = 190
* CHECK dout1_21 vdout1_21ck37 = 0 time = 190
* CHECK dout1_22 vdout1_22ck37 = 1.0 time = 190
* CHECK dout1_23 vdout1_23ck37 = 1.0 time = 190
* CHECK dout1_24 vdout1_24ck37 = 1.0 time = 190
* CHECK dout1_25 vdout1_25ck37 = 1.0 time = 190
* CHECK dout1_26 vdout1_26ck37 = 1.0 time = 190
* CHECK dout1_27 vdout1_27ck37 = 0 time = 190
* CHECK dout1_28 vdout1_28ck37 = 1.0 time = 190
* CHECK dout1_29 vdout1_29ck37 = 1.0 time = 190
* CHECK dout1_30 vdout1_30ck37 = 0 time = 190
* CHECK dout1_31 vdout1_31ck37 = 1.0 time = 190
* CHECK dout0_0 vdout0_0ck38 = 0 time = 195
* CHECK dout0_1 vdout0_1ck38 = 1.0 time = 195
* CHECK dout0_2 vdout0_2ck38 = 0 time = 195
* CHECK dout0_3 vdout0_3ck38 = 1.0 time = 195
* CHECK dout0_4 vdout0_4ck38 = 0 time = 195
* CHECK dout0_5 vdout0_5ck38 = 1.0 time = 195
* CHECK dout0_6 vdout0_6ck38 = 1.0 time = 195
* CHECK dout0_7 vdout0_7ck38 = 1.0 time = 195
* CHECK dout0_8 vdout0_8ck38 = 0 time = 195
* CHECK dout0_9 vdout0_9ck38 = 0 time = 195
* CHECK dout0_10 vdout0_10ck38 = 0 time = 195
* CHECK dout0_11 vdout0_11ck38 = 1.0 time = 195
* CHECK dout0_12 vdout0_12ck38 = 1.0 time = 195
* CHECK dout0_13 vdout0_13ck38 = 1.0 time = 195
* CHECK dout0_14 vdout0_14ck38 = 1.0 time = 195
* CHECK dout0_15 vdout0_15ck38 = 1.0 time = 195
* CHECK dout0_16 vdout0_16ck38 = 1.0 time = 195
* CHECK dout0_17 vdout0_17ck38 = 0 time = 195
* CHECK dout0_18 vdout0_18ck38 = 0 time = 195
* CHECK dout0_19 vdout0_19ck38 = 0 time = 195
* CHECK dout0_20 vdout0_20ck38 = 1.0 time = 195
* CHECK dout0_21 vdout0_21ck38 = 0 time = 195
* CHECK dout0_22 vdout0_22ck38 = 0 time = 195
* CHECK dout0_23 vdout0_23ck38 = 1.0 time = 195
* CHECK dout0_24 vdout0_24ck38 = 1.0 time = 195
* CHECK dout0_25 vdout0_25ck38 = 1.0 time = 195
* CHECK dout0_26 vdout0_26ck38 = 1.0 time = 195
* CHECK dout0_27 vdout0_27ck38 = 0 time = 195
* CHECK dout0_28 vdout0_28ck38 = 0 time = 195
* CHECK dout0_29 vdout0_29ck38 = 0 time = 195
* CHECK dout0_30 vdout0_30ck38 = 0 time = 195
* CHECK dout0_31 vdout0_31ck38 = 1.0 time = 195
* CHECK dout0_0 vdout0_0ck39 = 0 time = 200
* CHECK dout0_1 vdout0_1ck39 = 1.0 time = 200
* CHECK dout0_2 vdout0_2ck39 = 0 time = 200
* CHECK dout0_3 vdout0_3ck39 = 1.0 time = 200
* CHECK dout0_4 vdout0_4ck39 = 0 time = 200
* CHECK dout0_5 vdout0_5ck39 = 1.0 time = 200
* CHECK dout0_6 vdout0_6ck39 = 1.0 time = 200
* CHECK dout0_7 vdout0_7ck39 = 1.0 time = 200
* CHECK dout0_8 vdout0_8ck39 = 0 time = 200
* CHECK dout0_9 vdout0_9ck39 = 0 time = 200
* CHECK dout0_10 vdout0_10ck39 = 0 time = 200
* CHECK dout0_11 vdout0_11ck39 = 1.0 time = 200
* CHECK dout0_12 vdout0_12ck39 = 1.0 time = 200
* CHECK dout0_13 vdout0_13ck39 = 1.0 time = 200
* CHECK dout0_14 vdout0_14ck39 = 1.0 time = 200
* CHECK dout0_15 vdout0_15ck39 = 1.0 time = 200
* CHECK dout0_16 vdout0_16ck39 = 1.0 time = 200
* CHECK dout0_17 vdout0_17ck39 = 0 time = 200
* CHECK dout0_18 vdout0_18ck39 = 0 time = 200
* CHECK dout0_19 vdout0_19ck39 = 0 time = 200
* CHECK dout0_20 vdout0_20ck39 = 1.0 time = 200
* CHECK dout0_21 vdout0_21ck39 = 0 time = 200
* CHECK dout0_22 vdout0_22ck39 = 0 time = 200
* CHECK dout0_23 vdout0_23ck39 = 1.0 time = 200
* CHECK dout0_24 vdout0_24ck39 = 1.0 time = 200
* CHECK dout0_25 vdout0_25ck39 = 1.0 time = 200
* CHECK dout0_26 vdout0_26ck39 = 1.0 time = 200
* CHECK dout0_27 vdout0_27ck39 = 0 time = 200
* CHECK dout0_28 vdout0_28ck39 = 0 time = 200
* CHECK dout0_29 vdout0_29ck39 = 0 time = 200
* CHECK dout0_30 vdout0_30ck39 = 0 time = 200
* CHECK dout0_31 vdout0_31ck39 = 1.0 time = 200
* CHECK dout0_0 vdout0_0ck40 = 1.0 time = 205
* CHECK dout0_1 vdout0_1ck40 = 0 time = 205
* CHECK dout0_2 vdout0_2ck40 = 0 time = 205
* CHECK dout0_3 vdout0_3ck40 = 1.0 time = 205
* CHECK dout0_4 vdout0_4ck40 = 1.0 time = 205
* CHECK dout0_5 vdout0_5ck40 = 1.0 time = 205
* CHECK dout0_6 vdout0_6ck40 = 1.0 time = 205
* CHECK dout0_7 vdout0_7ck40 = 1.0 time = 205
* CHECK dout0_8 vdout0_8ck40 = 0 time = 205
* CHECK dout0_9 vdout0_9ck40 = 1.0 time = 205
* CHECK dout0_10 vdout0_10ck40 = 0 time = 205
* CHECK dout0_11 vdout0_11ck40 = 0 time = 205
* CHECK dout0_12 vdout0_12ck40 = 0 time = 205
* CHECK dout0_13 vdout0_13ck40 = 1.0 time = 205
* CHECK dout0_14 vdout0_14ck40 = 1.0 time = 205
* CHECK dout0_15 vdout0_15ck40 = 1.0 time = 205
* CHECK dout0_16 vdout0_16ck40 = 1.0 time = 205
* CHECK dout0_17 vdout0_17ck40 = 0 time = 205
* CHECK dout0_18 vdout0_18ck40 = 0 time = 205
* CHECK dout0_19 vdout0_19ck40 = 0 time = 205
* CHECK dout0_20 vdout0_20ck40 = 1.0 time = 205
* CHECK dout0_21 vdout0_21ck40 = 1.0 time = 205
* CHECK dout0_22 vdout0_22ck40 = 0 time = 205
* CHECK dout0_23 vdout0_23ck40 = 0 time = 205
* CHECK dout0_24 vdout0_24ck40 = 0 time = 205
* CHECK dout0_25 vdout0_25ck40 = 0 time = 205
* CHECK dout0_26 vdout0_26ck40 = 0 time = 205
* CHECK dout0_27 vdout0_27ck40 = 0 time = 205
* CHECK dout0_28 vdout0_28ck40 = 1.0 time = 205
* CHECK dout0_29 vdout0_29ck40 = 1.0 time = 205
* CHECK dout0_30 vdout0_30ck40 = 1.0 time = 205
* CHECK dout0_31 vdout0_31ck40 = 1.0 time = 205
* CHECK dout1_0 vdout1_0ck40 = 0 time = 205
* CHECK dout1_1 vdout1_1ck40 = 1.0 time = 205
* CHECK dout1_2 vdout1_2ck40 = 1.0 time = 205
* CHECK dout1_3 vdout1_3ck40 = 1.0 time = 205
* CHECK dout1_4 vdout1_4ck40 = 1.0 time = 205
* CHECK dout1_5 vdout1_5ck40 = 0 time = 205
* CHECK dout1_6 vdout1_6ck40 = 1.0 time = 205
* CHECK dout1_7 vdout1_7ck40 = 0 time = 205
* CHECK dout1_8 vdout1_8ck40 = 0 time = 205
* CHECK dout1_9 vdout1_9ck40 = 0 time = 205
* CHECK dout1_10 vdout1_10ck40 = 0 time = 205
* CHECK dout1_11 vdout1_11ck40 = 0 time = 205
* CHECK dout1_12 vdout1_12ck40 = 0 time = 205
* CHECK dout1_13 vdout1_13ck40 = 1.0 time = 205
* CHECK dout1_14 vdout1_14ck40 = 1.0 time = 205
* CHECK dout1_15 vdout1_15ck40 = 0 time = 205
* CHECK dout1_16 vdout1_16ck40 = 1.0 time = 205
* CHECK dout1_17 vdout1_17ck40 = 0 time = 205
* CHECK dout1_18 vdout1_18ck40 = 0 time = 205
* CHECK dout1_19 vdout1_19ck40 = 1.0 time = 205
* CHECK dout1_20 vdout1_20ck40 = 0 time = 205
* CHECK dout1_21 vdout1_21ck40 = 0 time = 205
* CHECK dout1_22 vdout1_22ck40 = 1.0 time = 205
* CHECK dout1_23 vdout1_23ck40 = 1.0 time = 205
* CHECK dout1_24 vdout1_24ck40 = 1.0 time = 205
* CHECK dout1_25 vdout1_25ck40 = 1.0 time = 205
* CHECK dout1_26 vdout1_26ck40 = 1.0 time = 205
* CHECK dout1_27 vdout1_27ck40 = 0 time = 205
* CHECK dout1_28 vdout1_28ck40 = 1.0 time = 205
* CHECK dout1_29 vdout1_29ck40 = 1.0 time = 205
* CHECK dout1_30 vdout1_30ck40 = 0 time = 205
* CHECK dout1_31 vdout1_31ck40 = 1.0 time = 205
* CHECK dout1_0 vdout1_0ck42 = 1.0 time = 215
* CHECK dout1_1 vdout1_1ck42 = 0 time = 215
* CHECK dout1_2 vdout1_2ck42 = 0 time = 215
* CHECK dout1_3 vdout1_3ck42 = 1.0 time = 215
* CHECK dout1_4 vdout1_4ck42 = 1.0 time = 215
* CHECK dout1_5 vdout1_5ck42 = 1.0 time = 215
* CHECK dout1_6 vdout1_6ck42 = 1.0 time = 215
* CHECK dout1_7 vdout1_7ck42 = 1.0 time = 215
* CHECK dout1_8 vdout1_8ck42 = 0 time = 215
* CHECK dout1_9 vdout1_9ck42 = 1.0 time = 215
* CHECK dout1_10 vdout1_10ck42 = 0 time = 215
* CHECK dout1_11 vdout1_11ck42 = 0 time = 215
* CHECK dout1_12 vdout1_12ck42 = 0 time = 215
* CHECK dout1_13 vdout1_13ck42 = 1.0 time = 215
* CHECK dout1_14 vdout1_14ck42 = 1.0 time = 215
* CHECK dout1_15 vdout1_15ck42 = 1.0 time = 215
* CHECK dout1_16 vdout1_16ck42 = 1.0 time = 215
* CHECK dout1_17 vdout1_17ck42 = 0 time = 215
* CHECK dout1_18 vdout1_18ck42 = 0 time = 215
* CHECK dout1_19 vdout1_19ck42 = 0 time = 215
* CHECK dout1_20 vdout1_20ck42 = 1.0 time = 215
* CHECK dout1_21 vdout1_21ck42 = 1.0 time = 215
* CHECK dout1_22 vdout1_22ck42 = 0 time = 215
* CHECK dout1_23 vdout1_23ck42 = 0 time = 215
* CHECK dout1_24 vdout1_24ck42 = 0 time = 215
* CHECK dout1_25 vdout1_25ck42 = 0 time = 215
* CHECK dout1_26 vdout1_26ck42 = 0 time = 215
* CHECK dout1_27 vdout1_27ck42 = 0 time = 215
* CHECK dout1_28 vdout1_28ck42 = 1.0 time = 215
* CHECK dout1_29 vdout1_29ck42 = 1.0 time = 215
* CHECK dout1_30 vdout1_30ck42 = 1.0 time = 215
* CHECK dout1_31 vdout1_31ck42 = 1.0 time = 215
* CHECK dout0_0 vdout0_0ck43 = 1.0 time = 220
* CHECK dout0_1 vdout0_1ck43 = 0 time = 220
* CHECK dout0_2 vdout0_2ck43 = 0 time = 220
* CHECK dout0_3 vdout0_3ck43 = 1.0 time = 220
* CHECK dout0_4 vdout0_4ck43 = 1.0 time = 220
* CHECK dout0_5 vdout0_5ck43 = 1.0 time = 220
* CHECK dout0_6 vdout0_6ck43 = 1.0 time = 220
* CHECK dout0_7 vdout0_7ck43 = 1.0 time = 220
* CHECK dout0_8 vdout0_8ck43 = 0 time = 220
* CHECK dout0_9 vdout0_9ck43 = 1.0 time = 220
* CHECK dout0_10 vdout0_10ck43 = 0 time = 220
* CHECK dout0_11 vdout0_11ck43 = 0 time = 220
* CHECK dout0_12 vdout0_12ck43 = 0 time = 220
* CHECK dout0_13 vdout0_13ck43 = 1.0 time = 220
* CHECK dout0_14 vdout0_14ck43 = 1.0 time = 220
* CHECK dout0_15 vdout0_15ck43 = 1.0 time = 220
* CHECK dout0_16 vdout0_16ck43 = 1.0 time = 220
* CHECK dout0_17 vdout0_17ck43 = 0 time = 220
* CHECK dout0_18 vdout0_18ck43 = 0 time = 220
* CHECK dout0_19 vdout0_19ck43 = 0 time = 220
* CHECK dout0_20 vdout0_20ck43 = 1.0 time = 220
* CHECK dout0_21 vdout0_21ck43 = 1.0 time = 220
* CHECK dout0_22 vdout0_22ck43 = 0 time = 220
* CHECK dout0_23 vdout0_23ck43 = 0 time = 220
* CHECK dout0_24 vdout0_24ck43 = 0 time = 220
* CHECK dout0_25 vdout0_25ck43 = 0 time = 220
* CHECK dout0_26 vdout0_26ck43 = 0 time = 220
* CHECK dout0_27 vdout0_27ck43 = 0 time = 220
* CHECK dout0_28 vdout0_28ck43 = 1.0 time = 220
* CHECK dout0_29 vdout0_29ck43 = 1.0 time = 220
* CHECK dout0_30 vdout0_30ck43 = 1.0 time = 220
* CHECK dout0_31 vdout0_31ck43 = 1.0 time = 220
* CHECK dout1_0 vdout1_0ck43 = 1.0 time = 220
* CHECK dout1_1 vdout1_1ck43 = 0 time = 220
* CHECK dout1_2 vdout1_2ck43 = 0 time = 220
* CHECK dout1_3 vdout1_3ck43 = 1.0 time = 220
* CHECK dout1_4 vdout1_4ck43 = 1.0 time = 220
* CHECK dout1_5 vdout1_5ck43 = 1.0 time = 220
* CHECK dout1_6 vdout1_6ck43 = 1.0 time = 220
* CHECK dout1_7 vdout1_7ck43 = 1.0 time = 220
* CHECK dout1_8 vdout1_8ck43 = 0 time = 220
* CHECK dout1_9 vdout1_9ck43 = 1.0 time = 220
* CHECK dout1_10 vdout1_10ck43 = 0 time = 220
* CHECK dout1_11 vdout1_11ck43 = 0 time = 220
* CHECK dout1_12 vdout1_12ck43 = 0 time = 220
* CHECK dout1_13 vdout1_13ck43 = 1.0 time = 220
* CHECK dout1_14 vdout1_14ck43 = 1.0 time = 220
* CHECK dout1_15 vdout1_15ck43 = 1.0 time = 220
* CHECK dout1_16 vdout1_16ck43 = 1.0 time = 220
* CHECK dout1_17 vdout1_17ck43 = 0 time = 220
* CHECK dout1_18 vdout1_18ck43 = 0 time = 220
* CHECK dout1_19 vdout1_19ck43 = 0 time = 220
* CHECK dout1_20 vdout1_20ck43 = 1.0 time = 220
* CHECK dout1_21 vdout1_21ck43 = 1.0 time = 220
* CHECK dout1_22 vdout1_22ck43 = 0 time = 220
* CHECK dout1_23 vdout1_23ck43 = 0 time = 220
* CHECK dout1_24 vdout1_24ck43 = 0 time = 220
* CHECK dout1_25 vdout1_25ck43 = 0 time = 220
* CHECK dout1_26 vdout1_26ck43 = 0 time = 220
* CHECK dout1_27 vdout1_27ck43 = 0 time = 220
* CHECK dout1_28 vdout1_28ck43 = 1.0 time = 220
* CHECK dout1_29 vdout1_29ck43 = 1.0 time = 220
* CHECK dout1_30 vdout1_30ck43 = 1.0 time = 220
* CHECK dout1_31 vdout1_31ck43 = 1.0 time = 220
* CHECK dout0_0 vdout0_0ck44 = 0 time = 225
* CHECK dout0_1 vdout0_1ck44 = 0 time = 225
* CHECK dout0_2 vdout0_2ck44 = 0 time = 225
* CHECK dout0_3 vdout0_3ck44 = 0 time = 225
* CHECK dout0_4 vdout0_4ck44 = 0 time = 225
* CHECK dout0_5 vdout0_5ck44 = 0 time = 225
* CHECK dout0_6 vdout0_6ck44 = 1.0 time = 225
* CHECK dout0_7 vdout0_7ck44 = 1.0 time = 225
* CHECK dout0_8 vdout0_8ck44 = 0 time = 225
* CHECK dout0_9 vdout0_9ck44 = 1.0 time = 225
* CHECK dout0_10 vdout0_10ck44 = 0 time = 225
* CHECK dout0_11 vdout0_11ck44 = 0 time = 225
* CHECK dout0_12 vdout0_12ck44 = 0 time = 225
* CHECK dout0_13 vdout0_13ck44 = 1.0 time = 225
* CHECK dout0_14 vdout0_14ck44 = 0 time = 225
* CHECK dout0_15 vdout0_15ck44 = 1.0 time = 225
* CHECK dout0_16 vdout0_16ck44 = 1.0 time = 225
* CHECK dout0_17 vdout0_17ck44 = 0 time = 225
* CHECK dout0_18 vdout0_18ck44 = 0 time = 225
* CHECK dout0_19 vdout0_19ck44 = 0 time = 225
* CHECK dout0_20 vdout0_20ck44 = 0 time = 225
* CHECK dout0_21 vdout0_21ck44 = 1.0 time = 225
* CHECK dout0_22 vdout0_22ck44 = 1.0 time = 225
* CHECK dout0_23 vdout0_23ck44 = 1.0 time = 225
* CHECK dout0_24 vdout0_24ck44 = 0 time = 225
* CHECK dout0_25 vdout0_25ck44 = 0 time = 225
* CHECK dout0_26 vdout0_26ck44 = 1.0 time = 225
* CHECK dout0_27 vdout0_27ck44 = 1.0 time = 225
* CHECK dout0_28 vdout0_28ck44 = 1.0 time = 225
* CHECK dout0_29 vdout0_29ck44 = 0 time = 225
* CHECK dout0_30 vdout0_30ck44 = 0 time = 225
* CHECK dout0_31 vdout0_31ck44 = 1.0 time = 225
* CHECK dout0_0 vdout0_0ck45 = 1.0 time = 230
* CHECK dout0_1 vdout0_1ck45 = 1.0 time = 230
* CHECK dout0_2 vdout0_2ck45 = 0 time = 230
* CHECK dout0_3 vdout0_3ck45 = 0 time = 230
* CHECK dout0_4 vdout0_4ck45 = 0 time = 230
* CHECK dout0_5 vdout0_5ck45 = 1.0 time = 230
* CHECK dout0_6 vdout0_6ck45 = 0 time = 230
* CHECK dout0_7 vdout0_7ck45 = 1.0 time = 230
* CHECK dout0_8 vdout0_8ck45 = 1.0 time = 230
* CHECK dout0_9 vdout0_9ck45 = 0 time = 230
* CHECK dout0_10 vdout0_10ck45 = 1.0 time = 230
* CHECK dout0_11 vdout0_11ck45 = 1.0 time = 230
* CHECK dout0_12 vdout0_12ck45 = 0 time = 230
* CHECK dout0_13 vdout0_13ck45 = 1.0 time = 230
* CHECK dout0_14 vdout0_14ck45 = 1.0 time = 230
* CHECK dout0_15 vdout0_15ck45 = 1.0 time = 230
* CHECK dout0_16 vdout0_16ck45 = 1.0 time = 230
* CHECK dout0_17 vdout0_17ck45 = 1.0 time = 230
* CHECK dout0_18 vdout0_18ck45 = 0 time = 230
* CHECK dout0_19 vdout0_19ck45 = 1.0 time = 230
* CHECK dout0_20 vdout0_20ck45 = 1.0 time = 230
* CHECK dout0_21 vdout0_21ck45 = 0 time = 230
* CHECK dout0_22 vdout0_22ck45 = 0 time = 230
* CHECK dout0_23 vdout0_23ck45 = 0 time = 230
* CHECK dout0_24 vdout0_24ck45 = 0 time = 230
* CHECK dout0_25 vdout0_25ck45 = 1.0 time = 230
* CHECK dout0_26 vdout0_26ck45 = 1.0 time = 230
* CHECK dout0_27 vdout0_27ck45 = 0 time = 230
* CHECK dout0_28 vdout0_28ck45 = 0 time = 230
* CHECK dout0_29 vdout0_29ck45 = 0 time = 230
* CHECK dout0_30 vdout0_30ck45 = 0 time = 230
* CHECK dout0_31 vdout0_31ck45 = 1.0 time = 230
* CHECK dout1_0 vdout1_0ck45 = 0 time = 230
* CHECK dout1_1 vdout1_1ck45 = 1.0 time = 230
* CHECK dout1_2 vdout1_2ck45 = 1.0 time = 230
* CHECK dout1_3 vdout1_3ck45 = 1.0 time = 230
* CHECK dout1_4 vdout1_4ck45 = 1.0 time = 230
* CHECK dout1_5 vdout1_5ck45 = 0 time = 230
* CHECK dout1_6 vdout1_6ck45 = 1.0 time = 230
* CHECK dout1_7 vdout1_7ck45 = 0 time = 230
* CHECK dout1_8 vdout1_8ck45 = 0 time = 230
* CHECK dout1_9 vdout1_9ck45 = 0 time = 230
* CHECK dout1_10 vdout1_10ck45 = 0 time = 230
* CHECK dout1_11 vdout1_11ck45 = 0 time = 230
* CHECK dout1_12 vdout1_12ck45 = 0 time = 230
* CHECK dout1_13 vdout1_13ck45 = 1.0 time = 230
* CHECK dout1_14 vdout1_14ck45 = 1.0 time = 230
* CHECK dout1_15 vdout1_15ck45 = 0 time = 230
* CHECK dout1_16 vdout1_16ck45 = 1.0 time = 230
* CHECK dout1_17 vdout1_17ck45 = 0 time = 230
* CHECK dout1_18 vdout1_18ck45 = 0 time = 230
* CHECK dout1_19 vdout1_19ck45 = 1.0 time = 230
* CHECK dout1_20 vdout1_20ck45 = 0 time = 230
* CHECK dout1_21 vdout1_21ck45 = 0 time = 230
* CHECK dout1_22 vdout1_22ck45 = 1.0 time = 230
* CHECK dout1_23 vdout1_23ck45 = 1.0 time = 230
* CHECK dout1_24 vdout1_24ck45 = 1.0 time = 230
* CHECK dout1_25 vdout1_25ck45 = 1.0 time = 230
* CHECK dout1_26 vdout1_26ck45 = 1.0 time = 230
* CHECK dout1_27 vdout1_27ck45 = 0 time = 230
* CHECK dout1_28 vdout1_28ck45 = 1.0 time = 230
* CHECK dout1_29 vdout1_29ck45 = 1.0 time = 230
* CHECK dout1_30 vdout1_30ck45 = 0 time = 230
* CHECK dout1_31 vdout1_31ck45 = 1.0 time = 230
* CHECK dout1_0 vdout1_0ck46 = 1.0 time = 235
* CHECK dout1_1 vdout1_1ck46 = 1.0 time = 235
* CHECK dout1_2 vdout1_2ck46 = 0 time = 235
* CHECK dout1_3 vdout1_3ck46 = 0 time = 235
* CHECK dout1_4 vdout1_4ck46 = 0 time = 235
* CHECK dout1_5 vdout1_5ck46 = 1.0 time = 235
* CHECK dout1_6 vdout1_6ck46 = 0 time = 235
* CHECK dout1_7 vdout1_7ck46 = 1.0 time = 235
* CHECK dout1_8 vdout1_8ck46 = 1.0 time = 235
* CHECK dout1_9 vdout1_9ck46 = 0 time = 235
* CHECK dout1_10 vdout1_10ck46 = 1.0 time = 235
* CHECK dout1_11 vdout1_11ck46 = 1.0 time = 235
* CHECK dout1_12 vdout1_12ck46 = 0 time = 235
* CHECK dout1_13 vdout1_13ck46 = 1.0 time = 235
* CHECK dout1_14 vdout1_14ck46 = 1.0 time = 235
* CHECK dout1_15 vdout1_15ck46 = 1.0 time = 235
* CHECK dout1_16 vdout1_16ck46 = 1.0 time = 235
* CHECK dout1_17 vdout1_17ck46 = 1.0 time = 235
* CHECK dout1_18 vdout1_18ck46 = 0 time = 235
* CHECK dout1_19 vdout1_19ck46 = 1.0 time = 235
* CHECK dout1_20 vdout1_20ck46 = 1.0 time = 235
* CHECK dout1_21 vdout1_21ck46 = 0 time = 235
* CHECK dout1_22 vdout1_22ck46 = 0 time = 235
* CHECK dout1_23 vdout1_23ck46 = 0 time = 235
* CHECK dout1_24 vdout1_24ck46 = 0 time = 235
* CHECK dout1_25 vdout1_25ck46 = 1.0 time = 235
* CHECK dout1_26 vdout1_26ck46 = 1.0 time = 235
* CHECK dout1_27 vdout1_27ck46 = 0 time = 235
* CHECK dout1_28 vdout1_28ck46 = 0 time = 235
* CHECK dout1_29 vdout1_29ck46 = 0 time = 235
* CHECK dout1_30 vdout1_30ck46 = 0 time = 235
* CHECK dout1_31 vdout1_31ck46 = 1.0 time = 235
* CHECK dout1_0 vdout1_0ck49 = 1.0 time = 250
* CHECK dout1_1 vdout1_1ck49 = 1.0 time = 250
* CHECK dout1_2 vdout1_2ck49 = 1.0 time = 250
* CHECK dout1_3 vdout1_3ck49 = 1.0 time = 250
* CHECK dout1_4 vdout1_4ck49 = 1.0 time = 250
* CHECK dout1_5 vdout1_5ck49 = 1.0 time = 250
* CHECK dout1_6 vdout1_6ck49 = 1.0 time = 250
* CHECK dout1_7 vdout1_7ck49 = 1.0 time = 250
* CHECK dout1_8 vdout1_8ck49 = 1.0 time = 250
* CHECK dout1_9 vdout1_9ck49 = 0 time = 250
* CHECK dout1_10 vdout1_10ck49 = 0 time = 250
* CHECK dout1_11 vdout1_11ck49 = 0 time = 250
* CHECK dout1_12 vdout1_12ck49 = 1.0 time = 250
* CHECK dout1_13 vdout1_13ck49 = 1.0 time = 250
* CHECK dout1_14 vdout1_14ck49 = 0 time = 250
* CHECK dout1_15 vdout1_15ck49 = 0 time = 250
* CHECK dout1_16 vdout1_16ck49 = 0 time = 250
* CHECK dout1_17 vdout1_17ck49 = 1.0 time = 250
* CHECK dout1_18 vdout1_18ck49 = 1.0 time = 250
* CHECK dout1_19 vdout1_19ck49 = 1.0 time = 250
* CHECK dout1_20 vdout1_20ck49 = 0 time = 250
* CHECK dout1_21 vdout1_21ck49 = 0 time = 250
* CHECK dout1_22 vdout1_22ck49 = 1.0 time = 250
* CHECK dout1_23 vdout1_23ck49 = 0 time = 250
* CHECK dout1_24 vdout1_24ck49 = 0 time = 250
* CHECK dout1_25 vdout1_25ck49 = 0 time = 250
* CHECK dout1_26 vdout1_26ck49 = 1.0 time = 250
* CHECK dout1_27 vdout1_27ck49 = 0 time = 250
* CHECK dout1_28 vdout1_28ck49 = 0 time = 250
* CHECK dout1_29 vdout1_29ck49 = 1.0 time = 250
* CHECK dout1_30 vdout1_30ck49 = 0 time = 250
* CHECK dout1_31 vdout1_31ck49 = 0 time = 250
* CHECK dout0_0 vdout0_0ck51 = 1.0 time = 260
* CHECK dout0_1 vdout0_1ck51 = 1.0 time = 260
* CHECK dout0_2 vdout0_2ck51 = 0 time = 260
* CHECK dout0_3 vdout0_3ck51 = 0 time = 260
* CHECK dout0_4 vdout0_4ck51 = 0 time = 260
* CHECK dout0_5 vdout0_5ck51 = 1.0 time = 260
* CHECK dout0_6 vdout0_6ck51 = 0 time = 260
* CHECK dout0_7 vdout0_7ck51 = 1.0 time = 260
* CHECK dout0_8 vdout0_8ck51 = 1.0 time = 260
* CHECK dout0_9 vdout0_9ck51 = 0 time = 260
* CHECK dout0_10 vdout0_10ck51 = 1.0 time = 260
* CHECK dout0_11 vdout0_11ck51 = 1.0 time = 260
* CHECK dout0_12 vdout0_12ck51 = 0 time = 260
* CHECK dout0_13 vdout0_13ck51 = 1.0 time = 260
* CHECK dout0_14 vdout0_14ck51 = 1.0 time = 260
* CHECK dout0_15 vdout0_15ck51 = 1.0 time = 260
* CHECK dout0_16 vdout0_16ck51 = 1.0 time = 260
* CHECK dout0_17 vdout0_17ck51 = 1.0 time = 260
* CHECK dout0_18 vdout0_18ck51 = 0 time = 260
* CHECK dout0_19 vdout0_19ck51 = 1.0 time = 260
* CHECK dout0_20 vdout0_20ck51 = 1.0 time = 260
* CHECK dout0_21 vdout0_21ck51 = 0 time = 260
* CHECK dout0_22 vdout0_22ck51 = 0 time = 260
* CHECK dout0_23 vdout0_23ck51 = 0 time = 260
* CHECK dout0_24 vdout0_24ck51 = 0 time = 260
* CHECK dout0_25 vdout0_25ck51 = 1.0 time = 260
* CHECK dout0_26 vdout0_26ck51 = 1.0 time = 260
* CHECK dout0_27 vdout0_27ck51 = 0 time = 260
* CHECK dout0_28 vdout0_28ck51 = 0 time = 260
* CHECK dout0_29 vdout0_29ck51 = 0 time = 260
* CHECK dout0_30 vdout0_30ck51 = 0 time = 260
* CHECK dout0_31 vdout0_31ck51 = 1.0 time = 260
* CHECK dout1_0 vdout1_0ck51 = 1.0 time = 260
* CHECK dout1_1 vdout1_1ck51 = 0 time = 260
* CHECK dout1_2 vdout1_2ck51 = 0 time = 260
* CHECK dout1_3 vdout1_3ck51 = 0 time = 260
* CHECK dout1_4 vdout1_4ck51 = 0 time = 260
* CHECK dout1_5 vdout1_5ck51 = 1.0 time = 260
* CHECK dout1_6 vdout1_6ck51 = 1.0 time = 260
* CHECK dout1_7 vdout1_7ck51 = 0 time = 260
* CHECK dout1_8 vdout1_8ck51 = 1.0 time = 260
* CHECK dout1_9 vdout1_9ck51 = 0 time = 260
* CHECK dout1_10 vdout1_10ck51 = 0 time = 260
* CHECK dout1_11 vdout1_11ck51 = 0 time = 260
* CHECK dout1_12 vdout1_12ck51 = 1.0 time = 260
* CHECK dout1_13 vdout1_13ck51 = 1.0 time = 260
* CHECK dout1_14 vdout1_14ck51 = 0 time = 260
* CHECK dout1_15 vdout1_15ck51 = 1.0 time = 260
* CHECK dout1_16 vdout1_16ck51 = 0 time = 260
* CHECK dout1_17 vdout1_17ck51 = 1.0 time = 260
* CHECK dout1_18 vdout1_18ck51 = 1.0 time = 260
* CHECK dout1_19 vdout1_19ck51 = 1.0 time = 260
* CHECK dout1_20 vdout1_20ck51 = 1.0 time = 260
* CHECK dout1_21 vdout1_21ck51 = 0 time = 260
* CHECK dout1_22 vdout1_22ck51 = 1.0 time = 260
* CHECK dout1_23 vdout1_23ck51 = 0 time = 260
* CHECK dout1_24 vdout1_24ck51 = 0 time = 260
* CHECK dout1_25 vdout1_25ck51 = 1.0 time = 260
* CHECK dout1_26 vdout1_26ck51 = 1.0 time = 260
* CHECK dout1_27 vdout1_27ck51 = 1.0 time = 260
* CHECK dout1_28 vdout1_28ck51 = 0 time = 260
* CHECK dout1_29 vdout1_29ck51 = 0 time = 260
* CHECK dout1_30 vdout1_30ck51 = 0 time = 260
* CHECK dout1_31 vdout1_31ck51 = 0 time = 260
* CHECK dout0_0 vdout0_0ck52 = 0 time = 265
* CHECK dout0_1 vdout0_1ck52 = 0 time = 265
* CHECK dout0_2 vdout0_2ck52 = 1.0 time = 265
* CHECK dout0_3 vdout0_3ck52 = 1.0 time = 265
* CHECK dout0_4 vdout0_4ck52 = 0 time = 265
* CHECK dout0_5 vdout0_5ck52 = 0 time = 265
* CHECK dout0_6 vdout0_6ck52 = 0 time = 265
* CHECK dout0_7 vdout0_7ck52 = 1.0 time = 265
* CHECK dout0_8 vdout0_8ck52 = 0 time = 265
* CHECK dout0_9 vdout0_9ck52 = 1.0 time = 265
* CHECK dout0_10 vdout0_10ck52 = 1.0 time = 265
* CHECK dout0_11 vdout0_11ck52 = 0 time = 265
* CHECK dout0_12 vdout0_12ck52 = 0 time = 265
* CHECK dout0_13 vdout0_13ck52 = 0 time = 265
* CHECK dout0_14 vdout0_14ck52 = 0 time = 265
* CHECK dout0_15 vdout0_15ck52 = 1.0 time = 265
* CHECK dout0_16 vdout0_16ck52 = 1.0 time = 265
* CHECK dout0_17 vdout0_17ck52 = 0 time = 265
* CHECK dout0_18 vdout0_18ck52 = 0 time = 265
* CHECK dout0_19 vdout0_19ck52 = 0 time = 265
* CHECK dout0_20 vdout0_20ck52 = 1.0 time = 265
* CHECK dout0_21 vdout0_21ck52 = 1.0 time = 265
* CHECK dout0_22 vdout0_22ck52 = 1.0 time = 265
* CHECK dout0_23 vdout0_23ck52 = 1.0 time = 265
* CHECK dout0_24 vdout0_24ck52 = 0 time = 265
* CHECK dout0_25 vdout0_25ck52 = 1.0 time = 265
* CHECK dout0_26 vdout0_26ck52 = 0 time = 265
* CHECK dout0_27 vdout0_27ck52 = 1.0 time = 265
* CHECK dout0_28 vdout0_28ck52 = 0 time = 265
* CHECK dout0_29 vdout0_29ck52 = 1.0 time = 265
* CHECK dout0_30 vdout0_30ck52 = 0 time = 265
* CHECK dout0_31 vdout0_31ck52 = 0 time = 265
* CHECK dout1_0 vdout1_0ck53 = 0 time = 270
* CHECK dout1_1 vdout1_1ck53 = 0 time = 270
* CHECK dout1_2 vdout1_2ck53 = 0 time = 270
* CHECK dout1_3 vdout1_3ck53 = 0 time = 270
* CHECK dout1_4 vdout1_4ck53 = 0 time = 270
* CHECK dout1_5 vdout1_5ck53 = 1.0 time = 270
* CHECK dout1_6 vdout1_6ck53 = 1.0 time = 270
* CHECK dout1_7 vdout1_7ck53 = 0 time = 270
* CHECK dout1_8 vdout1_8ck53 = 0 time = 270
* CHECK dout1_9 vdout1_9ck53 = 1.0 time = 270
* CHECK dout1_10 vdout1_10ck53 = 0 time = 270
* CHECK dout1_11 vdout1_11ck53 = 1.0 time = 270
* CHECK dout1_12 vdout1_12ck53 = 0 time = 270
* CHECK dout1_13 vdout1_13ck53 = 0 time = 270
* CHECK dout1_14 vdout1_14ck53 = 0 time = 270
* CHECK dout1_15 vdout1_15ck53 = 0 time = 270
* CHECK dout1_16 vdout1_16ck53 = 1.0 time = 270
* CHECK dout1_17 vdout1_17ck53 = 0 time = 270
* CHECK dout1_18 vdout1_18ck53 = 1.0 time = 270
* CHECK dout1_19 vdout1_19ck53 = 0 time = 270
* CHECK dout1_20 vdout1_20ck53 = 0 time = 270
* CHECK dout1_21 vdout1_21ck53 = 0 time = 270
* CHECK dout1_22 vdout1_22ck53 = 1.0 time = 270
* CHECK dout1_23 vdout1_23ck53 = 0 time = 270
* CHECK dout1_24 vdout1_24ck53 = 0 time = 270
* CHECK dout1_25 vdout1_25ck53 = 1.0 time = 270
* CHECK dout1_26 vdout1_26ck53 = 0 time = 270
* CHECK dout1_27 vdout1_27ck53 = 1.0 time = 270
* CHECK dout1_28 vdout1_28ck53 = 0 time = 270
* CHECK dout1_29 vdout1_29ck53 = 0 time = 270
* CHECK dout1_30 vdout1_30ck53 = 1.0 time = 270
* CHECK dout1_31 vdout1_31ck53 = 1.0 time = 270
* CHECK dout0_0 vdout0_0ck54 = 1.0 time = 275
* CHECK dout0_1 vdout0_1ck54 = 1.0 time = 275
* CHECK dout0_2 vdout0_2ck54 = 0 time = 275
* CHECK dout0_3 vdout0_3ck54 = 0 time = 275
* CHECK dout0_4 vdout0_4ck54 = 0 time = 275
* CHECK dout0_5 vdout0_5ck54 = 1.0 time = 275
* CHECK dout0_6 vdout0_6ck54 = 0 time = 275
* CHECK dout0_7 vdout0_7ck54 = 1.0 time = 275
* CHECK dout0_8 vdout0_8ck54 = 1.0 time = 275
* CHECK dout0_9 vdout0_9ck54 = 0 time = 275
* CHECK dout0_10 vdout0_10ck54 = 1.0 time = 275
* CHECK dout0_11 vdout0_11ck54 = 1.0 time = 275
* CHECK dout0_12 vdout0_12ck54 = 0 time = 275
* CHECK dout0_13 vdout0_13ck54 = 1.0 time = 275
* CHECK dout0_14 vdout0_14ck54 = 1.0 time = 275
* CHECK dout0_15 vdout0_15ck54 = 1.0 time = 275
* CHECK dout0_16 vdout0_16ck54 = 1.0 time = 275
* CHECK dout0_17 vdout0_17ck54 = 1.0 time = 275
* CHECK dout0_18 vdout0_18ck54 = 0 time = 275
* CHECK dout0_19 vdout0_19ck54 = 1.0 time = 275
* CHECK dout0_20 vdout0_20ck54 = 1.0 time = 275
* CHECK dout0_21 vdout0_21ck54 = 0 time = 275
* CHECK dout0_22 vdout0_22ck54 = 0 time = 275
* CHECK dout0_23 vdout0_23ck54 = 0 time = 275
* CHECK dout0_24 vdout0_24ck54 = 0 time = 275
* CHECK dout0_25 vdout0_25ck54 = 1.0 time = 275
* CHECK dout0_26 vdout0_26ck54 = 1.0 time = 275
* CHECK dout0_27 vdout0_27ck54 = 0 time = 275
* CHECK dout0_28 vdout0_28ck54 = 0 time = 275
* CHECK dout0_29 vdout0_29ck54 = 0 time = 275
* CHECK dout0_30 vdout0_30ck54 = 0 time = 275
* CHECK dout0_31 vdout0_31ck54 = 1.0 time = 275
* CHECK dout1_0 vdout1_0ck54 = 0 time = 275
* CHECK dout1_1 vdout1_1ck54 = 0 time = 275
* CHECK dout1_2 vdout1_2ck54 = 0 time = 275
* CHECK dout1_3 vdout1_3ck54 = 0 time = 275
* CHECK dout1_4 vdout1_4ck54 = 0 time = 275
* CHECK dout1_5 vdout1_5ck54 = 0 time = 275
* CHECK dout1_6 vdout1_6ck54 = 1.0 time = 275
* CHECK dout1_7 vdout1_7ck54 = 1.0 time = 275
* CHECK dout1_8 vdout1_8ck54 = 0 time = 275
* CHECK dout1_9 vdout1_9ck54 = 1.0 time = 275
* CHECK dout1_10 vdout1_10ck54 = 0 time = 275
* CHECK dout1_11 vdout1_11ck54 = 0 time = 275
* CHECK dout1_12 vdout1_12ck54 = 0 time = 275
* CHECK dout1_13 vdout1_13ck54 = 1.0 time = 275
* CHECK dout1_14 vdout1_14ck54 = 0 time = 275
* CHECK dout1_15 vdout1_15ck54 = 1.0 time = 275
* CHECK dout1_16 vdout1_16ck54 = 1.0 time = 275
* CHECK dout1_17 vdout1_17ck54 = 0 time = 275
* CHECK dout1_18 vdout1_18ck54 = 0 time = 275
* CHECK dout1_19 vdout1_19ck54 = 0 time = 275
* CHECK dout1_20 vdout1_20ck54 = 0 time = 275
* CHECK dout1_21 vdout1_21ck54 = 1.0 time = 275
* CHECK dout1_22 vdout1_22ck54 = 1.0 time = 275
* CHECK dout1_23 vdout1_23ck54 = 1.0 time = 275
* CHECK dout1_24 vdout1_24ck54 = 0 time = 275
* CHECK dout1_25 vdout1_25ck54 = 0 time = 275
* CHECK dout1_26 vdout1_26ck54 = 1.0 time = 275
* CHECK dout1_27 vdout1_27ck54 = 1.0 time = 275
* CHECK dout1_28 vdout1_28ck54 = 1.0 time = 275
* CHECK dout1_29 vdout1_29ck54 = 0 time = 275
* CHECK dout1_30 vdout1_30ck54 = 0 time = 275
* CHECK dout1_31 vdout1_31ck54 = 1.0 time = 275
* CHECK dout0_0 vdout0_0ck56 = 1.0 time = 285
* CHECK dout0_1 vdout0_1ck56 = 1.0 time = 285
* CHECK dout0_2 vdout0_2ck56 = 1.0 time = 285
* CHECK dout0_3 vdout0_3ck56 = 1.0 time = 285
* CHECK dout0_4 vdout0_4ck56 = 1.0 time = 285
* CHECK dout0_5 vdout0_5ck56 = 1.0 time = 285
* CHECK dout0_6 vdout0_6ck56 = 1.0 time = 285
* CHECK dout0_7 vdout0_7ck56 = 1.0 time = 285
* CHECK dout0_8 vdout0_8ck56 = 1.0 time = 285
* CHECK dout0_9 vdout0_9ck56 = 0 time = 285
* CHECK dout0_10 vdout0_10ck56 = 0 time = 285
* CHECK dout0_11 vdout0_11ck56 = 0 time = 285
* CHECK dout0_12 vdout0_12ck56 = 1.0 time = 285
* CHECK dout0_13 vdout0_13ck56 = 1.0 time = 285
* CHECK dout0_14 vdout0_14ck56 = 0 time = 285
* CHECK dout0_15 vdout0_15ck56 = 0 time = 285
* CHECK dout0_16 vdout0_16ck56 = 0 time = 285
* CHECK dout0_17 vdout0_17ck56 = 1.0 time = 285
* CHECK dout0_18 vdout0_18ck56 = 1.0 time = 285
* CHECK dout0_19 vdout0_19ck56 = 1.0 time = 285
* CHECK dout0_20 vdout0_20ck56 = 0 time = 285
* CHECK dout0_21 vdout0_21ck56 = 0 time = 285
* CHECK dout0_22 vdout0_22ck56 = 1.0 time = 285
* CHECK dout0_23 vdout0_23ck56 = 0 time = 285
* CHECK dout0_24 vdout0_24ck56 = 0 time = 285
* CHECK dout0_25 vdout0_25ck56 = 0 time = 285
* CHECK dout0_26 vdout0_26ck56 = 1.0 time = 285
* CHECK dout0_27 vdout0_27ck56 = 0 time = 285
* CHECK dout0_28 vdout0_28ck56 = 0 time = 285
* CHECK dout0_29 vdout0_29ck56 = 1.0 time = 285
* CHECK dout0_30 vdout0_30ck56 = 0 time = 285
* CHECK dout0_31 vdout0_31ck56 = 0 time = 285
* CHECK dout1_0 vdout1_0ck56 = 0 time = 285
* CHECK dout1_1 vdout1_1ck56 = 0 time = 285
* CHECK dout1_2 vdout1_2ck56 = 0 time = 285
* CHECK dout1_3 vdout1_3ck56 = 0 time = 285
* CHECK dout1_4 vdout1_4ck56 = 0 time = 285
* CHECK dout1_5 vdout1_5ck56 = 1.0 time = 285
* CHECK dout1_6 vdout1_6ck56 = 1.0 time = 285
* CHECK dout1_7 vdout1_7ck56 = 0 time = 285
* CHECK dout1_8 vdout1_8ck56 = 0 time = 285
* CHECK dout1_9 vdout1_9ck56 = 1.0 time = 285
* CHECK dout1_10 vdout1_10ck56 = 0 time = 285
* CHECK dout1_11 vdout1_11ck56 = 1.0 time = 285
* CHECK dout1_12 vdout1_12ck56 = 0 time = 285
* CHECK dout1_13 vdout1_13ck56 = 0 time = 285
* CHECK dout1_14 vdout1_14ck56 = 0 time = 285
* CHECK dout1_15 vdout1_15ck56 = 0 time = 285
* CHECK dout1_16 vdout1_16ck56 = 1.0 time = 285
* CHECK dout1_17 vdout1_17ck56 = 0 time = 285
* CHECK dout1_18 vdout1_18ck56 = 1.0 time = 285
* CHECK dout1_19 vdout1_19ck56 = 0 time = 285
* CHECK dout1_20 vdout1_20ck56 = 0 time = 285
* CHECK dout1_21 vdout1_21ck56 = 0 time = 285
* CHECK dout1_22 vdout1_22ck56 = 1.0 time = 285
* CHECK dout1_23 vdout1_23ck56 = 0 time = 285
* CHECK dout1_24 vdout1_24ck56 = 0 time = 285
* CHECK dout1_25 vdout1_25ck56 = 1.0 time = 285
* CHECK dout1_26 vdout1_26ck56 = 0 time = 285
* CHECK dout1_27 vdout1_27ck56 = 1.0 time = 285
* CHECK dout1_28 vdout1_28ck56 = 0 time = 285
* CHECK dout1_29 vdout1_29ck56 = 0 time = 285
* CHECK dout1_30 vdout1_30ck56 = 1.0 time = 285
* CHECK dout1_31 vdout1_31ck56 = 1.0 time = 285
* CHECK dout1_0 vdout1_0ck57 = 1.0 time = 290
* CHECK dout1_1 vdout1_1ck57 = 0 time = 290
* CHECK dout1_2 vdout1_2ck57 = 0 time = 290
* CHECK dout1_3 vdout1_3ck57 = 0 time = 290
* CHECK dout1_4 vdout1_4ck57 = 0 time = 290
* CHECK dout1_5 vdout1_5ck57 = 1.0 time = 290
* CHECK dout1_6 vdout1_6ck57 = 1.0 time = 290
* CHECK dout1_7 vdout1_7ck57 = 0 time = 290
* CHECK dout1_8 vdout1_8ck57 = 1.0 time = 290
* CHECK dout1_9 vdout1_9ck57 = 0 time = 290
* CHECK dout1_10 vdout1_10ck57 = 0 time = 290
* CHECK dout1_11 vdout1_11ck57 = 0 time = 290
* CHECK dout1_12 vdout1_12ck57 = 1.0 time = 290
* CHECK dout1_13 vdout1_13ck57 = 1.0 time = 290
* CHECK dout1_14 vdout1_14ck57 = 0 time = 290
* CHECK dout1_15 vdout1_15ck57 = 1.0 time = 290
* CHECK dout1_16 vdout1_16ck57 = 0 time = 290
* CHECK dout1_17 vdout1_17ck57 = 1.0 time = 290
* CHECK dout1_18 vdout1_18ck57 = 1.0 time = 290
* CHECK dout1_19 vdout1_19ck57 = 1.0 time = 290
* CHECK dout1_20 vdout1_20ck57 = 1.0 time = 290
* CHECK dout1_21 vdout1_21ck57 = 0 time = 290
* CHECK dout1_22 vdout1_22ck57 = 1.0 time = 290
* CHECK dout1_23 vdout1_23ck57 = 0 time = 290
* CHECK dout1_24 vdout1_24ck57 = 0 time = 290
* CHECK dout1_25 vdout1_25ck57 = 1.0 time = 290
* CHECK dout1_26 vdout1_26ck57 = 1.0 time = 290
* CHECK dout1_27 vdout1_27ck57 = 1.0 time = 290
* CHECK dout1_28 vdout1_28ck57 = 0 time = 290
* CHECK dout1_29 vdout1_29ck57 = 0 time = 290
* CHECK dout1_30 vdout1_30ck57 = 0 time = 290
* CHECK dout1_31 vdout1_31ck57 = 0 time = 290
* CHECK dout0_0 vdout0_0ck58 = 0 time = 295
* CHECK dout0_1 vdout0_1ck58 = 0 time = 295
* CHECK dout0_2 vdout0_2ck58 = 0 time = 295
* CHECK dout0_3 vdout0_3ck58 = 0 time = 295
* CHECK dout0_4 vdout0_4ck58 = 0 time = 295
* CHECK dout0_5 vdout0_5ck58 = 0 time = 295
* CHECK dout0_6 vdout0_6ck58 = 1.0 time = 295
* CHECK dout0_7 vdout0_7ck58 = 1.0 time = 295
* CHECK dout0_8 vdout0_8ck58 = 0 time = 295
* CHECK dout0_9 vdout0_9ck58 = 1.0 time = 295
* CHECK dout0_10 vdout0_10ck58 = 0 time = 295
* CHECK dout0_11 vdout0_11ck58 = 0 time = 295
* CHECK dout0_12 vdout0_12ck58 = 0 time = 295
* CHECK dout0_13 vdout0_13ck58 = 1.0 time = 295
* CHECK dout0_14 vdout0_14ck58 = 0 time = 295
* CHECK dout0_15 vdout0_15ck58 = 1.0 time = 295
* CHECK dout0_16 vdout0_16ck58 = 1.0 time = 295
* CHECK dout0_17 vdout0_17ck58 = 0 time = 295
* CHECK dout0_18 vdout0_18ck58 = 0 time = 295
* CHECK dout0_19 vdout0_19ck58 = 0 time = 295
* CHECK dout0_20 vdout0_20ck58 = 0 time = 295
* CHECK dout0_21 vdout0_21ck58 = 1.0 time = 295
* CHECK dout0_22 vdout0_22ck58 = 1.0 time = 295
* CHECK dout0_23 vdout0_23ck58 = 1.0 time = 295
* CHECK dout0_24 vdout0_24ck58 = 0 time = 295
* CHECK dout0_25 vdout0_25ck58 = 0 time = 295
* CHECK dout0_26 vdout0_26ck58 = 1.0 time = 295
* CHECK dout0_27 vdout0_27ck58 = 1.0 time = 295
* CHECK dout0_28 vdout0_28ck58 = 1.0 time = 295
* CHECK dout0_29 vdout0_29ck58 = 0 time = 295
* CHECK dout0_30 vdout0_30ck58 = 0 time = 295
* CHECK dout0_31 vdout0_31ck58 = 1.0 time = 295
* CHECK dout0_0 vdout0_0ck59 = 0 time = 300
* CHECK dout0_1 vdout0_1ck59 = 0 time = 300
* CHECK dout0_2 vdout0_2ck59 = 0 time = 300
* CHECK dout0_3 vdout0_3ck59 = 0 time = 300
* CHECK dout0_4 vdout0_4ck59 = 0 time = 300
* CHECK dout0_5 vdout0_5ck59 = 1.0 time = 300
* CHECK dout0_6 vdout0_6ck59 = 1.0 time = 300
* CHECK dout0_7 vdout0_7ck59 = 0 time = 300
* CHECK dout0_8 vdout0_8ck59 = 0 time = 300
* CHECK dout0_9 vdout0_9ck59 = 1.0 time = 300
* CHECK dout0_10 vdout0_10ck59 = 0 time = 300
* CHECK dout0_11 vdout0_11ck59 = 1.0 time = 300
* CHECK dout0_12 vdout0_12ck59 = 0 time = 300
* CHECK dout0_13 vdout0_13ck59 = 0 time = 300
* CHECK dout0_14 vdout0_14ck59 = 0 time = 300
* CHECK dout0_15 vdout0_15ck59 = 0 time = 300
* CHECK dout0_16 vdout0_16ck59 = 1.0 time = 300
* CHECK dout0_17 vdout0_17ck59 = 0 time = 300
* CHECK dout0_18 vdout0_18ck59 = 1.0 time = 300
* CHECK dout0_19 vdout0_19ck59 = 0 time = 300
* CHECK dout0_20 vdout0_20ck59 = 0 time = 300
* CHECK dout0_21 vdout0_21ck59 = 0 time = 300
* CHECK dout0_22 vdout0_22ck59 = 1.0 time = 300
* CHECK dout0_23 vdout0_23ck59 = 0 time = 300
* CHECK dout0_24 vdout0_24ck59 = 0 time = 300
* CHECK dout0_25 vdout0_25ck59 = 1.0 time = 300
* CHECK dout0_26 vdout0_26ck59 = 0 time = 300
* CHECK dout0_27 vdout0_27ck59 = 1.0 time = 300
* CHECK dout0_28 vdout0_28ck59 = 0 time = 300
* CHECK dout0_29 vdout0_29ck59 = 0 time = 300
* CHECK dout0_30 vdout0_30ck59 = 1.0 time = 300
* CHECK dout0_31 vdout0_31ck59 = 1.0 time = 300
* CHECK dout1_0 vdout1_0ck59 = 0 time = 300
* CHECK dout1_1 vdout1_1ck59 = 0 time = 300
* CHECK dout1_2 vdout1_2ck59 = 0 time = 300
* CHECK dout1_3 vdout1_3ck59 = 0 time = 300
* CHECK dout1_4 vdout1_4ck59 = 0 time = 300
* CHECK dout1_5 vdout1_5ck59 = 0 time = 300
* CHECK dout1_6 vdout1_6ck59 = 1.0 time = 300
* CHECK dout1_7 vdout1_7ck59 = 1.0 time = 300
* CHECK dout1_8 vdout1_8ck59 = 0 time = 300
* CHECK dout1_9 vdout1_9ck59 = 1.0 time = 300
* CHECK dout1_10 vdout1_10ck59 = 0 time = 300
* CHECK dout1_11 vdout1_11ck59 = 0 time = 300
* CHECK dout1_12 vdout1_12ck59 = 0 time = 300
* CHECK dout1_13 vdout1_13ck59 = 1.0 time = 300
* CHECK dout1_14 vdout1_14ck59 = 0 time = 300
* CHECK dout1_15 vdout1_15ck59 = 1.0 time = 300
* CHECK dout1_16 vdout1_16ck59 = 1.0 time = 300
* CHECK dout1_17 vdout1_17ck59 = 0 time = 300
* CHECK dout1_18 vdout1_18ck59 = 0 time = 300
* CHECK dout1_19 vdout1_19ck59 = 0 time = 300
* CHECK dout1_20 vdout1_20ck59 = 0 time = 300
* CHECK dout1_21 vdout1_21ck59 = 1.0 time = 300
* CHECK dout1_22 vdout1_22ck59 = 1.0 time = 300
* CHECK dout1_23 vdout1_23ck59 = 1.0 time = 300
* CHECK dout1_24 vdout1_24ck59 = 0 time = 300
* CHECK dout1_25 vdout1_25ck59 = 0 time = 300
* CHECK dout1_26 vdout1_26ck59 = 1.0 time = 300
* CHECK dout1_27 vdout1_27ck59 = 1.0 time = 300
* CHECK dout1_28 vdout1_28ck59 = 1.0 time = 300
* CHECK dout1_29 vdout1_29ck59 = 0 time = 300
* CHECK dout1_30 vdout1_30ck59 = 0 time = 300
* CHECK dout1_31 vdout1_31ck59 = 1.0 time = 300
* CHECK dout1_0 vdout1_0ck60 = 1.0 time = 305
* CHECK dout1_1 vdout1_1ck60 = 0 time = 305
* CHECK dout1_2 vdout1_2ck60 = 1.0 time = 305
* CHECK dout1_3 vdout1_3ck60 = 1.0 time = 305
* CHECK dout1_4 vdout1_4ck60 = 1.0 time = 305
* CHECK dout1_5 vdout1_5ck60 = 1.0 time = 305
* CHECK dout1_6 vdout1_6ck60 = 1.0 time = 305
* CHECK dout1_7 vdout1_7ck60 = 1.0 time = 305
* CHECK dout1_8 vdout1_8ck60 = 1.0 time = 305
* CHECK dout1_9 vdout1_9ck60 = 0 time = 305
* CHECK dout1_10 vdout1_10ck60 = 1.0 time = 305
* CHECK dout1_11 vdout1_11ck60 = 0 time = 305
* CHECK dout1_12 vdout1_12ck60 = 0 time = 305
* CHECK dout1_13 vdout1_13ck60 = 0 time = 305
* CHECK dout1_14 vdout1_14ck60 = 0 time = 305
* CHECK dout1_15 vdout1_15ck60 = 1.0 time = 305
* CHECK dout1_16 vdout1_16ck60 = 0 time = 305
* CHECK dout1_17 vdout1_17ck60 = 1.0 time = 305
* CHECK dout1_18 vdout1_18ck60 = 0 time = 305
* CHECK dout1_19 vdout1_19ck60 = 0 time = 305
* CHECK dout1_20 vdout1_20ck60 = 0 time = 305
* CHECK dout1_21 vdout1_21ck60 = 0 time = 305
* CHECK dout1_22 vdout1_22ck60 = 0 time = 305
* CHECK dout1_23 vdout1_23ck60 = 0 time = 305
* CHECK dout1_24 vdout1_24ck60 = 0 time = 305
* CHECK dout1_25 vdout1_25ck60 = 1.0 time = 305
* CHECK dout1_26 vdout1_26ck60 = 1.0 time = 305
* CHECK dout1_27 vdout1_27ck60 = 0 time = 305
* CHECK dout1_28 vdout1_28ck60 = 0 time = 305
* CHECK dout1_29 vdout1_29ck60 = 1.0 time = 305
* CHECK dout1_30 vdout1_30ck60 = 1.0 time = 305
* CHECK dout1_31 vdout1_31ck60 = 1.0 time = 305
* CHECK dout0_0 vdout0_0ck61 = 1.0 time = 310
* CHECK dout0_1 vdout0_1ck61 = 0 time = 310
* CHECK dout0_2 vdout0_2ck61 = 1.0 time = 310
* CHECK dout0_3 vdout0_3ck61 = 1.0 time = 310
* CHECK dout0_4 vdout0_4ck61 = 1.0 time = 310
* CHECK dout0_5 vdout0_5ck61 = 1.0 time = 310
* CHECK dout0_6 vdout0_6ck61 = 1.0 time = 310
* CHECK dout0_7 vdout0_7ck61 = 1.0 time = 310
* CHECK dout0_8 vdout0_8ck61 = 1.0 time = 310
* CHECK dout0_9 vdout0_9ck61 = 0 time = 310
* CHECK dout0_10 vdout0_10ck61 = 1.0 time = 310
* CHECK dout0_11 vdout0_11ck61 = 0 time = 310
* CHECK dout0_12 vdout0_12ck61 = 0 time = 310
* CHECK dout0_13 vdout0_13ck61 = 0 time = 310
* CHECK dout0_14 vdout0_14ck61 = 0 time = 310
* CHECK dout0_15 vdout0_15ck61 = 1.0 time = 310
* CHECK dout0_16 vdout0_16ck61 = 0 time = 310
* CHECK dout0_17 vdout0_17ck61 = 1.0 time = 310
* CHECK dout0_18 vdout0_18ck61 = 0 time = 310
* CHECK dout0_19 vdout0_19ck61 = 0 time = 310
* CHECK dout0_20 vdout0_20ck61 = 0 time = 310
* CHECK dout0_21 vdout0_21ck61 = 0 time = 310
* CHECK dout0_22 vdout0_22ck61 = 0 time = 310
* CHECK dout0_23 vdout0_23ck61 = 0 time = 310
* CHECK dout0_24 vdout0_24ck61 = 0 time = 310
* CHECK dout0_25 vdout0_25ck61 = 1.0 time = 310
* CHECK dout0_26 vdout0_26ck61 = 1.0 time = 310
* CHECK dout0_27 vdout0_27ck61 = 0 time = 310
* CHECK dout0_28 vdout0_28ck61 = 0 time = 310
* CHECK dout0_29 vdout0_29ck61 = 1.0 time = 310
* CHECK dout0_30 vdout0_30ck61 = 1.0 time = 310
* CHECK dout0_31 vdout0_31ck61 = 1.0 time = 310
* CHECK dout1_0 vdout1_0ck61 = 1.0 time = 310
* CHECK dout1_1 vdout1_1ck61 = 1.0 time = 310
* CHECK dout1_2 vdout1_2ck61 = 1.0 time = 310
* CHECK dout1_3 vdout1_3ck61 = 1.0 time = 310
* CHECK dout1_4 vdout1_4ck61 = 1.0 time = 310
* CHECK dout1_5 vdout1_5ck61 = 1.0 time = 310
* CHECK dout1_6 vdout1_6ck61 = 1.0 time = 310
* CHECK dout1_7 vdout1_7ck61 = 1.0 time = 310
* CHECK dout1_8 vdout1_8ck61 = 1.0 time = 310
* CHECK dout1_9 vdout1_9ck61 = 0 time = 310
* CHECK dout1_10 vdout1_10ck61 = 0 time = 310
* CHECK dout1_11 vdout1_11ck61 = 0 time = 310
* CHECK dout1_12 vdout1_12ck61 = 1.0 time = 310
* CHECK dout1_13 vdout1_13ck61 = 1.0 time = 310
* CHECK dout1_14 vdout1_14ck61 = 0 time = 310
* CHECK dout1_15 vdout1_15ck61 = 0 time = 310
* CHECK dout1_16 vdout1_16ck61 = 0 time = 310
* CHECK dout1_17 vdout1_17ck61 = 1.0 time = 310
* CHECK dout1_18 vdout1_18ck61 = 1.0 time = 310
* CHECK dout1_19 vdout1_19ck61 = 1.0 time = 310
* CHECK dout1_20 vdout1_20ck61 = 0 time = 310
* CHECK dout1_21 vdout1_21ck61 = 0 time = 310
* CHECK dout1_22 vdout1_22ck61 = 1.0 time = 310
* CHECK dout1_23 vdout1_23ck61 = 0 time = 310
* CHECK dout1_24 vdout1_24ck61 = 0 time = 310
* CHECK dout1_25 vdout1_25ck61 = 0 time = 310
* CHECK dout1_26 vdout1_26ck61 = 1.0 time = 310
* CHECK dout1_27 vdout1_27ck61 = 0 time = 310
* CHECK dout1_28 vdout1_28ck61 = 0 time = 310
* CHECK dout1_29 vdout1_29ck61 = 1.0 time = 310
* CHECK dout1_30 vdout1_30ck61 = 0 time = 310
* CHECK dout1_31 vdout1_31ck61 = 0 time = 310
* CHECK dout0_0 vdout0_0ck63 = 1.0 time = 320
* CHECK dout0_1 vdout0_1ck63 = 0 time = 320
* CHECK dout0_2 vdout0_2ck63 = 0 time = 320
* CHECK dout0_3 vdout0_3ck63 = 0 time = 320
* CHECK dout0_4 vdout0_4ck63 = 0 time = 320
* CHECK dout0_5 vdout0_5ck63 = 0 time = 320
* CHECK dout0_6 vdout0_6ck63 = 1.0 time = 320
* CHECK dout0_7 vdout0_7ck63 = 0 time = 320
* CHECK dout0_8 vdout0_8ck63 = 0 time = 320
* CHECK dout0_9 vdout0_9ck63 = 0 time = 320
* CHECK dout0_10 vdout0_10ck63 = 0 time = 320
* CHECK dout0_11 vdout0_11ck63 = 1.0 time = 320
* CHECK dout0_12 vdout0_12ck63 = 0 time = 320
* CHECK dout0_13 vdout0_13ck63 = 0 time = 320
* CHECK dout0_14 vdout0_14ck63 = 0 time = 320
* CHECK dout0_15 vdout0_15ck63 = 1.0 time = 320
* CHECK dout0_16 vdout0_16ck63 = 1.0 time = 320
* CHECK dout0_17 vdout0_17ck63 = 1.0 time = 320
* CHECK dout0_18 vdout0_18ck63 = 1.0 time = 320
* CHECK dout0_19 vdout0_19ck63 = 0 time = 320
* CHECK dout0_20 vdout0_20ck63 = 0 time = 320
* CHECK dout0_21 vdout0_21ck63 = 0 time = 320
* CHECK dout0_22 vdout0_22ck63 = 1.0 time = 320
* CHECK dout0_23 vdout0_23ck63 = 1.0 time = 320
* CHECK dout0_24 vdout0_24ck63 = 0 time = 320
* CHECK dout0_25 vdout0_25ck63 = 1.0 time = 320
* CHECK dout0_26 vdout0_26ck63 = 1.0 time = 320
* CHECK dout0_27 vdout0_27ck63 = 0 time = 320
* CHECK dout0_28 vdout0_28ck63 = 1.0 time = 320
* CHECK dout0_29 vdout0_29ck63 = 0 time = 320
* CHECK dout0_30 vdout0_30ck63 = 0 time = 320
* CHECK dout0_31 vdout0_31ck63 = 0 time = 320
* CHECK dout1_0 vdout1_0ck63 = 1.0 time = 320
* CHECK dout1_1 vdout1_1ck63 = 1.0 time = 320
* CHECK dout1_2 vdout1_2ck63 = 1.0 time = 320
* CHECK dout1_3 vdout1_3ck63 = 1.0 time = 320
* CHECK dout1_4 vdout1_4ck63 = 0 time = 320
* CHECK dout1_5 vdout1_5ck63 = 0 time = 320
* CHECK dout1_6 vdout1_6ck63 = 1.0 time = 320
* CHECK dout1_7 vdout1_7ck63 = 1.0 time = 320
* CHECK dout1_8 vdout1_8ck63 = 0 time = 320
* CHECK dout1_9 vdout1_9ck63 = 0 time = 320
* CHECK dout1_10 vdout1_10ck63 = 1.0 time = 320
* CHECK dout1_11 vdout1_11ck63 = 0 time = 320
* CHECK dout1_12 vdout1_12ck63 = 1.0 time = 320
* CHECK dout1_13 vdout1_13ck63 = 0 time = 320
* CHECK dout1_14 vdout1_14ck63 = 1.0 time = 320
* CHECK dout1_15 vdout1_15ck63 = 0 time = 320
* CHECK dout1_16 vdout1_16ck63 = 1.0 time = 320
* CHECK dout1_17 vdout1_17ck63 = 1.0 time = 320
* CHECK dout1_18 vdout1_18ck63 = 0 time = 320
* CHECK dout1_19 vdout1_19ck63 = 0 time = 320
* CHECK dout1_20 vdout1_20ck63 = 1.0 time = 320
* CHECK dout1_21 vdout1_21ck63 = 1.0 time = 320
* CHECK dout1_22 vdout1_22ck63 = 1.0 time = 320
* CHECK dout1_23 vdout1_23ck63 = 1.0 time = 320
* CHECK dout1_24 vdout1_24ck63 = 0 time = 320
* CHECK dout1_25 vdout1_25ck63 = 0 time = 320
* CHECK dout1_26 vdout1_26ck63 = 0 time = 320
* CHECK dout1_27 vdout1_27ck63 = 0 time = 320
* CHECK dout1_28 vdout1_28ck63 = 1.0 time = 320
* CHECK dout1_29 vdout1_29ck63 = 1.0 time = 320
* CHECK dout1_30 vdout1_30ck63 = 1.0 time = 320
* CHECK dout1_31 vdout1_31ck63 = 0 time = 320
* CHECK dout0_0 vdout0_0ck64 = 1.0 time = 325
* CHECK dout0_1 vdout0_1ck64 = 1.0 time = 325
* CHECK dout0_2 vdout0_2ck64 = 1.0 time = 325
* CHECK dout0_3 vdout0_3ck64 = 1.0 time = 325
* CHECK dout0_4 vdout0_4ck64 = 1.0 time = 325
* CHECK dout0_5 vdout0_5ck64 = 1.0 time = 325
* CHECK dout0_6 vdout0_6ck64 = 1.0 time = 325
* CHECK dout0_7 vdout0_7ck64 = 1.0 time = 325
* CHECK dout0_8 vdout0_8ck64 = 1.0 time = 325
* CHECK dout0_9 vdout0_9ck64 = 0 time = 325
* CHECK dout0_10 vdout0_10ck64 = 0 time = 325
* CHECK dout0_11 vdout0_11ck64 = 0 time = 325
* CHECK dout0_12 vdout0_12ck64 = 1.0 time = 325
* CHECK dout0_13 vdout0_13ck64 = 1.0 time = 325
* CHECK dout0_14 vdout0_14ck64 = 0 time = 325
* CHECK dout0_15 vdout0_15ck64 = 0 time = 325
* CHECK dout0_16 vdout0_16ck64 = 0 time = 325
* CHECK dout0_17 vdout0_17ck64 = 1.0 time = 325
* CHECK dout0_18 vdout0_18ck64 = 1.0 time = 325
* CHECK dout0_19 vdout0_19ck64 = 1.0 time = 325
* CHECK dout0_20 vdout0_20ck64 = 0 time = 325
* CHECK dout0_21 vdout0_21ck64 = 0 time = 325
* CHECK dout0_22 vdout0_22ck64 = 1.0 time = 325
* CHECK dout0_23 vdout0_23ck64 = 0 time = 325
* CHECK dout0_24 vdout0_24ck64 = 0 time = 325
* CHECK dout0_25 vdout0_25ck64 = 0 time = 325
* CHECK dout0_26 vdout0_26ck64 = 1.0 time = 325
* CHECK dout0_27 vdout0_27ck64 = 0 time = 325
* CHECK dout0_28 vdout0_28ck64 = 0 time = 325
* CHECK dout0_29 vdout0_29ck64 = 1.0 time = 325
* CHECK dout0_30 vdout0_30ck64 = 0 time = 325
* CHECK dout0_31 vdout0_31ck64 = 0 time = 325
* CHECK dout1_0 vdout1_0ck64 = 1.0 time = 325
* CHECK dout1_1 vdout1_1ck64 = 1.0 time = 325
* CHECK dout1_2 vdout1_2ck64 = 1.0 time = 325
* CHECK dout1_3 vdout1_3ck64 = 1.0 time = 325
* CHECK dout1_4 vdout1_4ck64 = 1.0 time = 325
* CHECK dout1_5 vdout1_5ck64 = 1.0 time = 325
* CHECK dout1_6 vdout1_6ck64 = 1.0 time = 325
* CHECK dout1_7 vdout1_7ck64 = 1.0 time = 325
* CHECK dout1_8 vdout1_8ck64 = 1.0 time = 325
* CHECK dout1_9 vdout1_9ck64 = 0 time = 325
* CHECK dout1_10 vdout1_10ck64 = 0 time = 325
* CHECK dout1_11 vdout1_11ck64 = 0 time = 325
* CHECK dout1_12 vdout1_12ck64 = 1.0 time = 325
* CHECK dout1_13 vdout1_13ck64 = 1.0 time = 325
* CHECK dout1_14 vdout1_14ck64 = 0 time = 325
* CHECK dout1_15 vdout1_15ck64 = 0 time = 325
* CHECK dout1_16 vdout1_16ck64 = 0 time = 325
* CHECK dout1_17 vdout1_17ck64 = 1.0 time = 325
* CHECK dout1_18 vdout1_18ck64 = 1.0 time = 325
* CHECK dout1_19 vdout1_19ck64 = 1.0 time = 325
* CHECK dout1_20 vdout1_20ck64 = 0 time = 325
* CHECK dout1_21 vdout1_21ck64 = 0 time = 325
* CHECK dout1_22 vdout1_22ck64 = 1.0 time = 325
* CHECK dout1_23 vdout1_23ck64 = 0 time = 325
* CHECK dout1_24 vdout1_24ck64 = 0 time = 325
* CHECK dout1_25 vdout1_25ck64 = 0 time = 325
* CHECK dout1_26 vdout1_26ck64 = 1.0 time = 325
* CHECK dout1_27 vdout1_27ck64 = 0 time = 325
* CHECK dout1_28 vdout1_28ck64 = 0 time = 325
* CHECK dout1_29 vdout1_29ck64 = 1.0 time = 325
* CHECK dout1_30 vdout1_30ck64 = 0 time = 325
* CHECK dout1_31 vdout1_31ck64 = 0 time = 325
* CHECK dout1_0 vdout1_0ck66 = 1.0 time = 335
* CHECK dout1_1 vdout1_1ck66 = 1.0 time = 335
* CHECK dout1_2 vdout1_2ck66 = 0 time = 335
* CHECK dout1_3 vdout1_3ck66 = 1.0 time = 335
* CHECK dout1_4 vdout1_4ck66 = 0 time = 335
* CHECK dout1_5 vdout1_5ck66 = 1.0 time = 335
* CHECK dout1_6 vdout1_6ck66 = 1.0 time = 335
* CHECK dout1_7 vdout1_7ck66 = 0 time = 335
* CHECK dout1_8 vdout1_8ck66 = 0 time = 335
* CHECK dout1_9 vdout1_9ck66 = 0 time = 335
* CHECK dout1_10 vdout1_10ck66 = 0 time = 335
* CHECK dout1_11 vdout1_11ck66 = 1.0 time = 335
* CHECK dout1_12 vdout1_12ck66 = 0 time = 335
* CHECK dout1_13 vdout1_13ck66 = 1.0 time = 335
* CHECK dout1_14 vdout1_14ck66 = 0 time = 335
* CHECK dout1_15 vdout1_15ck66 = 0 time = 335
* CHECK dout1_16 vdout1_16ck66 = 1.0 time = 335
* CHECK dout1_17 vdout1_17ck66 = 1.0 time = 335
* CHECK dout1_18 vdout1_18ck66 = 1.0 time = 335
* CHECK dout1_19 vdout1_19ck66 = 0 time = 335
* CHECK dout1_20 vdout1_20ck66 = 0 time = 335
* CHECK dout1_21 vdout1_21ck66 = 1.0 time = 335
* CHECK dout1_22 vdout1_22ck66 = 1.0 time = 335
* CHECK dout1_23 vdout1_23ck66 = 0 time = 335
* CHECK dout1_24 vdout1_24ck66 = 1.0 time = 335
* CHECK dout1_25 vdout1_25ck66 = 0 time = 335
* CHECK dout1_26 vdout1_26ck66 = 0 time = 335
* CHECK dout1_27 vdout1_27ck66 = 1.0 time = 335
* CHECK dout1_28 vdout1_28ck66 = 0 time = 335
* CHECK dout1_29 vdout1_29ck66 = 1.0 time = 335
* CHECK dout1_30 vdout1_30ck66 = 1.0 time = 335
* CHECK dout1_31 vdout1_31ck66 = 0 time = 335
* CHECK dout0_0 vdout0_0ck67 = 1.0 time = 340
* CHECK dout0_1 vdout0_1ck67 = 0 time = 340
* CHECK dout0_2 vdout0_2ck67 = 1.0 time = 340
* CHECK dout0_3 vdout0_3ck67 = 1.0 time = 340
* CHECK dout0_4 vdout0_4ck67 = 1.0 time = 340
* CHECK dout0_5 vdout0_5ck67 = 1.0 time = 340
* CHECK dout0_6 vdout0_6ck67 = 1.0 time = 340
* CHECK dout0_7 vdout0_7ck67 = 1.0 time = 340
* CHECK dout0_8 vdout0_8ck67 = 1.0 time = 340
* CHECK dout0_9 vdout0_9ck67 = 0 time = 340
* CHECK dout0_10 vdout0_10ck67 = 1.0 time = 340
* CHECK dout0_11 vdout0_11ck67 = 0 time = 340
* CHECK dout0_12 vdout0_12ck67 = 0 time = 340
* CHECK dout0_13 vdout0_13ck67 = 0 time = 340
* CHECK dout0_14 vdout0_14ck67 = 0 time = 340
* CHECK dout0_15 vdout0_15ck67 = 1.0 time = 340
* CHECK dout0_16 vdout0_16ck67 = 0 time = 340
* CHECK dout0_17 vdout0_17ck67 = 1.0 time = 340
* CHECK dout0_18 vdout0_18ck67 = 0 time = 340
* CHECK dout0_19 vdout0_19ck67 = 0 time = 340
* CHECK dout0_20 vdout0_20ck67 = 0 time = 340
* CHECK dout0_21 vdout0_21ck67 = 0 time = 340
* CHECK dout0_22 vdout0_22ck67 = 0 time = 340
* CHECK dout0_23 vdout0_23ck67 = 0 time = 340
* CHECK dout0_24 vdout0_24ck67 = 0 time = 340
* CHECK dout0_25 vdout0_25ck67 = 1.0 time = 340
* CHECK dout0_26 vdout0_26ck67 = 1.0 time = 340
* CHECK dout0_27 vdout0_27ck67 = 0 time = 340
* CHECK dout0_28 vdout0_28ck67 = 0 time = 340
* CHECK dout0_29 vdout0_29ck67 = 1.0 time = 340
* CHECK dout0_30 vdout0_30ck67 = 1.0 time = 340
* CHECK dout0_31 vdout0_31ck67 = 1.0 time = 340
* CHECK dout1_0 vdout1_0ck67 = 0 time = 340
* CHECK dout1_1 vdout1_1ck67 = 0 time = 340
* CHECK dout1_2 vdout1_2ck67 = 0 time = 340
* CHECK dout1_3 vdout1_3ck67 = 0 time = 340
* CHECK dout1_4 vdout1_4ck67 = 0 time = 340
* CHECK dout1_5 vdout1_5ck67 = 0 time = 340
* CHECK dout1_6 vdout1_6ck67 = 1.0 time = 340
* CHECK dout1_7 vdout1_7ck67 = 1.0 time = 340
* CHECK dout1_8 vdout1_8ck67 = 0 time = 340
* CHECK dout1_9 vdout1_9ck67 = 1.0 time = 340
* CHECK dout1_10 vdout1_10ck67 = 0 time = 340
* CHECK dout1_11 vdout1_11ck67 = 0 time = 340
* CHECK dout1_12 vdout1_12ck67 = 0 time = 340
* CHECK dout1_13 vdout1_13ck67 = 1.0 time = 340
* CHECK dout1_14 vdout1_14ck67 = 0 time = 340
* CHECK dout1_15 vdout1_15ck67 = 1.0 time = 340
* CHECK dout1_16 vdout1_16ck67 = 1.0 time = 340
* CHECK dout1_17 vdout1_17ck67 = 0 time = 340
* CHECK dout1_18 vdout1_18ck67 = 0 time = 340
* CHECK dout1_19 vdout1_19ck67 = 0 time = 340
* CHECK dout1_20 vdout1_20ck67 = 0 time = 340
* CHECK dout1_21 vdout1_21ck67 = 1.0 time = 340
* CHECK dout1_22 vdout1_22ck67 = 1.0 time = 340
* CHECK dout1_23 vdout1_23ck67 = 1.0 time = 340
* CHECK dout1_24 vdout1_24ck67 = 0 time = 340
* CHECK dout1_25 vdout1_25ck67 = 0 time = 340
* CHECK dout1_26 vdout1_26ck67 = 1.0 time = 340
* CHECK dout1_27 vdout1_27ck67 = 1.0 time = 340
* CHECK dout1_28 vdout1_28ck67 = 1.0 time = 340
* CHECK dout1_29 vdout1_29ck67 = 0 time = 340
* CHECK dout1_30 vdout1_30ck67 = 0 time = 340
* CHECK dout1_31 vdout1_31ck67 = 1.0 time = 340
* CHECK dout1_0 vdout1_0ck71 = 1.0 time = 360
* CHECK dout1_1 vdout1_1ck71 = 1.0 time = 360
* CHECK dout1_2 vdout1_2ck71 = 1.0 time = 360
* CHECK dout1_3 vdout1_3ck71 = 1.0 time = 360
* CHECK dout1_4 vdout1_4ck71 = 0 time = 360
* CHECK dout1_5 vdout1_5ck71 = 0 time = 360
* CHECK dout1_6 vdout1_6ck71 = 1.0 time = 360
* CHECK dout1_7 vdout1_7ck71 = 1.0 time = 360
* CHECK dout1_8 vdout1_8ck71 = 0 time = 360
* CHECK dout1_9 vdout1_9ck71 = 0 time = 360
* CHECK dout1_10 vdout1_10ck71 = 1.0 time = 360
* CHECK dout1_11 vdout1_11ck71 = 0 time = 360
* CHECK dout1_12 vdout1_12ck71 = 1.0 time = 360
* CHECK dout1_13 vdout1_13ck71 = 0 time = 360
* CHECK dout1_14 vdout1_14ck71 = 1.0 time = 360
* CHECK dout1_15 vdout1_15ck71 = 0 time = 360
* CHECK dout1_16 vdout1_16ck71 = 1.0 time = 360
* CHECK dout1_17 vdout1_17ck71 = 1.0 time = 360
* CHECK dout1_18 vdout1_18ck71 = 0 time = 360
* CHECK dout1_19 vdout1_19ck71 = 0 time = 360
* CHECK dout1_20 vdout1_20ck71 = 1.0 time = 360
* CHECK dout1_21 vdout1_21ck71 = 1.0 time = 360
* CHECK dout1_22 vdout1_22ck71 = 1.0 time = 360
* CHECK dout1_23 vdout1_23ck71 = 1.0 time = 360
* CHECK dout1_24 vdout1_24ck71 = 0 time = 360
* CHECK dout1_25 vdout1_25ck71 = 0 time = 360
* CHECK dout1_26 vdout1_26ck71 = 0 time = 360
* CHECK dout1_27 vdout1_27ck71 = 0 time = 360
* CHECK dout1_28 vdout1_28ck71 = 1.0 time = 360
* CHECK dout1_29 vdout1_29ck71 = 1.0 time = 360
* CHECK dout1_30 vdout1_30ck71 = 1.0 time = 360
* CHECK dout1_31 vdout1_31ck71 = 0 time = 360
* CHECK dout0_0 vdout0_0ck72 = 1.0 time = 365
* CHECK dout0_1 vdout0_1ck72 = 1.0 time = 365
* CHECK dout0_2 vdout0_2ck72 = 1.0 time = 365
* CHECK dout0_3 vdout0_3ck72 = 1.0 time = 365
* CHECK dout0_4 vdout0_4ck72 = 0 time = 365
* CHECK dout0_5 vdout0_5ck72 = 0 time = 365
* CHECK dout0_6 vdout0_6ck72 = 1.0 time = 365
* CHECK dout0_7 vdout0_7ck72 = 1.0 time = 365
* CHECK dout0_8 vdout0_8ck72 = 0 time = 365
* CHECK dout0_9 vdout0_9ck72 = 0 time = 365
* CHECK dout0_10 vdout0_10ck72 = 1.0 time = 365
* CHECK dout0_11 vdout0_11ck72 = 0 time = 365
* CHECK dout0_12 vdout0_12ck72 = 1.0 time = 365
* CHECK dout0_13 vdout0_13ck72 = 0 time = 365
* CHECK dout0_14 vdout0_14ck72 = 1.0 time = 365
* CHECK dout0_15 vdout0_15ck72 = 0 time = 365
* CHECK dout0_16 vdout0_16ck72 = 1.0 time = 365
* CHECK dout0_17 vdout0_17ck72 = 1.0 time = 365
* CHECK dout0_18 vdout0_18ck72 = 0 time = 365
* CHECK dout0_19 vdout0_19ck72 = 0 time = 365
* CHECK dout0_20 vdout0_20ck72 = 1.0 time = 365
* CHECK dout0_21 vdout0_21ck72 = 1.0 time = 365
* CHECK dout0_22 vdout0_22ck72 = 1.0 time = 365
* CHECK dout0_23 vdout0_23ck72 = 1.0 time = 365
* CHECK dout0_24 vdout0_24ck72 = 0 time = 365
* CHECK dout0_25 vdout0_25ck72 = 0 time = 365
* CHECK dout0_26 vdout0_26ck72 = 0 time = 365
* CHECK dout0_27 vdout0_27ck72 = 0 time = 365
* CHECK dout0_28 vdout0_28ck72 = 1.0 time = 365
* CHECK dout0_29 vdout0_29ck72 = 1.0 time = 365
* CHECK dout0_30 vdout0_30ck72 = 1.0 time = 365
* CHECK dout0_31 vdout0_31ck72 = 0 time = 365
* CHECK dout0_0 vdout0_0ck73 = 0 time = 370
* CHECK dout0_1 vdout0_1ck73 = 0 time = 370
* CHECK dout0_2 vdout0_2ck73 = 0 time = 370
* CHECK dout0_3 vdout0_3ck73 = 0 time = 370
* CHECK dout0_4 vdout0_4ck73 = 1.0 time = 370
* CHECK dout0_5 vdout0_5ck73 = 0 time = 370
* CHECK dout0_6 vdout0_6ck73 = 1.0 time = 370
* CHECK dout0_7 vdout0_7ck73 = 0 time = 370
* CHECK dout0_8 vdout0_8ck73 = 0 time = 370
* CHECK dout0_9 vdout0_9ck73 = 1.0 time = 370
* CHECK dout0_10 vdout0_10ck73 = 1.0 time = 370
* CHECK dout0_11 vdout0_11ck73 = 1.0 time = 370
* CHECK dout0_12 vdout0_12ck73 = 0 time = 370
* CHECK dout0_13 vdout0_13ck73 = 0 time = 370
* CHECK dout0_14 vdout0_14ck73 = 0 time = 370
* CHECK dout0_15 vdout0_15ck73 = 1.0 time = 370
* CHECK dout0_16 vdout0_16ck73 = 0 time = 370
* CHECK dout0_17 vdout0_17ck73 = 1.0 time = 370
* CHECK dout0_18 vdout0_18ck73 = 1.0 time = 370
* CHECK dout0_19 vdout0_19ck73 = 0 time = 370
* CHECK dout0_20 vdout0_20ck73 = 0 time = 370
* CHECK dout0_21 vdout0_21ck73 = 1.0 time = 370
* CHECK dout0_22 vdout0_22ck73 = 1.0 time = 370
* CHECK dout0_23 vdout0_23ck73 = 1.0 time = 370
* CHECK dout0_24 vdout0_24ck73 = 0 time = 370
* CHECK dout0_25 vdout0_25ck73 = 1.0 time = 370
* CHECK dout0_26 vdout0_26ck73 = 0 time = 370
* CHECK dout0_27 vdout0_27ck73 = 0 time = 370
* CHECK dout0_28 vdout0_28ck73 = 1.0 time = 370
* CHECK dout0_29 vdout0_29ck73 = 0 time = 370
* CHECK dout0_30 vdout0_30ck73 = 1.0 time = 370
* CHECK dout0_31 vdout0_31ck73 = 1.0 time = 370
* CHECK dout1_0 vdout1_0ck73 = 0 time = 370
* CHECK dout1_1 vdout1_1ck73 = 1.0 time = 370
* CHECK dout1_2 vdout1_2ck73 = 0 time = 370
* CHECK dout1_3 vdout1_3ck73 = 0 time = 370
* CHECK dout1_4 vdout1_4ck73 = 1.0 time = 370
* CHECK dout1_5 vdout1_5ck73 = 0 time = 370
* CHECK dout1_6 vdout1_6ck73 = 1.0 time = 370
* CHECK dout1_7 vdout1_7ck73 = 0 time = 370
* CHECK dout1_8 vdout1_8ck73 = 0 time = 370
* CHECK dout1_9 vdout1_9ck73 = 1.0 time = 370
* CHECK dout1_10 vdout1_10ck73 = 0 time = 370
* CHECK dout1_11 vdout1_11ck73 = 0 time = 370
* CHECK dout1_12 vdout1_12ck73 = 0 time = 370
* CHECK dout1_13 vdout1_13ck73 = 1.0 time = 370
* CHECK dout1_14 vdout1_14ck73 = 0 time = 370
* CHECK dout1_15 vdout1_15ck73 = 0 time = 370
* CHECK dout1_16 vdout1_16ck73 = 1.0 time = 370
* CHECK dout1_17 vdout1_17ck73 = 0 time = 370
* CHECK dout1_18 vdout1_18ck73 = 0 time = 370
* CHECK dout1_19 vdout1_19ck73 = 1.0 time = 370
* CHECK dout1_20 vdout1_20ck73 = 1.0 time = 370
* CHECK dout1_21 vdout1_21ck73 = 1.0 time = 370
* CHECK dout1_22 vdout1_22ck73 = 1.0 time = 370
* CHECK dout1_23 vdout1_23ck73 = 1.0 time = 370
* CHECK dout1_24 vdout1_24ck73 = 1.0 time = 370
* CHECK dout1_25 vdout1_25ck73 = 0 time = 370
* CHECK dout1_26 vdout1_26ck73 = 0 time = 370
* CHECK dout1_27 vdout1_27ck73 = 1.0 time = 370
* CHECK dout1_28 vdout1_28ck73 = 1.0 time = 370
* CHECK dout1_29 vdout1_29ck73 = 0 time = 370
* CHECK dout1_30 vdout1_30ck73 = 0 time = 370
* CHECK dout1_31 vdout1_31ck73 = 0 time = 370
* CHECK dout1_0 vdout1_0ck74 = 1.0 time = 375
* CHECK dout1_1 vdout1_1ck74 = 0 time = 375
* CHECK dout1_2 vdout1_2ck74 = 1.0 time = 375
* CHECK dout1_3 vdout1_3ck74 = 1.0 time = 375
* CHECK dout1_4 vdout1_4ck74 = 1.0 time = 375
* CHECK dout1_5 vdout1_5ck74 = 1.0 time = 375
* CHECK dout1_6 vdout1_6ck74 = 1.0 time = 375
* CHECK dout1_7 vdout1_7ck74 = 1.0 time = 375
* CHECK dout1_8 vdout1_8ck74 = 1.0 time = 375
* CHECK dout1_9 vdout1_9ck74 = 0 time = 375
* CHECK dout1_10 vdout1_10ck74 = 1.0 time = 375
* CHECK dout1_11 vdout1_11ck74 = 0 time = 375
* CHECK dout1_12 vdout1_12ck74 = 0 time = 375
* CHECK dout1_13 vdout1_13ck74 = 0 time = 375
* CHECK dout1_14 vdout1_14ck74 = 0 time = 375
* CHECK dout1_15 vdout1_15ck74 = 1.0 time = 375
* CHECK dout1_16 vdout1_16ck74 = 0 time = 375
* CHECK dout1_17 vdout1_17ck74 = 1.0 time = 375
* CHECK dout1_18 vdout1_18ck74 = 0 time = 375
* CHECK dout1_19 vdout1_19ck74 = 0 time = 375
* CHECK dout1_20 vdout1_20ck74 = 0 time = 375
* CHECK dout1_21 vdout1_21ck74 = 0 time = 375
* CHECK dout1_22 vdout1_22ck74 = 0 time = 375
* CHECK dout1_23 vdout1_23ck74 = 0 time = 375
* CHECK dout1_24 vdout1_24ck74 = 0 time = 375
* CHECK dout1_25 vdout1_25ck74 = 1.0 time = 375
* CHECK dout1_26 vdout1_26ck74 = 1.0 time = 375
* CHECK dout1_27 vdout1_27ck74 = 0 time = 375
* CHECK dout1_28 vdout1_28ck74 = 0 time = 375
* CHECK dout1_29 vdout1_29ck74 = 1.0 time = 375
* CHECK dout1_30 vdout1_30ck74 = 1.0 time = 375
* CHECK dout1_31 vdout1_31ck74 = 1.0 time = 375
* CHECK dout0_0 vdout0_0ck75 = 1.0 time = 380
* CHECK dout0_1 vdout0_1ck75 = 0 time = 380
* CHECK dout0_2 vdout0_2ck75 = 0 time = 380
* CHECK dout0_3 vdout0_3ck75 = 1.0 time = 380
* CHECK dout0_4 vdout0_4ck75 = 0 time = 380
* CHECK dout0_5 vdout0_5ck75 = 0 time = 380
* CHECK dout0_6 vdout0_6ck75 = 1.0 time = 380
* CHECK dout0_7 vdout0_7ck75 = 0 time = 380
* CHECK dout0_8 vdout0_8ck75 = 1.0 time = 380
* CHECK dout0_9 vdout0_9ck75 = 0 time = 380
* CHECK dout0_10 vdout0_10ck75 = 0 time = 380
* CHECK dout0_11 vdout0_11ck75 = 1.0 time = 380
* CHECK dout0_12 vdout0_12ck75 = 0 time = 380
* CHECK dout0_13 vdout0_13ck75 = 1.0 time = 380
* CHECK dout0_14 vdout0_14ck75 = 1.0 time = 380
* CHECK dout0_15 vdout0_15ck75 = 0 time = 380
* CHECK dout0_16 vdout0_16ck75 = 1.0 time = 380
* CHECK dout0_17 vdout0_17ck75 = 1.0 time = 380
* CHECK dout0_18 vdout0_18ck75 = 1.0 time = 380
* CHECK dout0_19 vdout0_19ck75 = 0 time = 380
* CHECK dout0_20 vdout0_20ck75 = 0 time = 380
* CHECK dout0_21 vdout0_21ck75 = 0 time = 380
* CHECK dout0_22 vdout0_22ck75 = 1.0 time = 380
* CHECK dout0_23 vdout0_23ck75 = 0 time = 380
* CHECK dout0_24 vdout0_24ck75 = 0 time = 380
* CHECK dout0_25 vdout0_25ck75 = 1.0 time = 380
* CHECK dout0_26 vdout0_26ck75 = 1.0 time = 380
* CHECK dout0_27 vdout0_27ck75 = 1.0 time = 380
* CHECK dout0_28 vdout0_28ck75 = 1.0 time = 380
* CHECK dout0_29 vdout0_29ck75 = 0 time = 380
* CHECK dout0_30 vdout0_30ck75 = 0 time = 380
* CHECK dout0_31 vdout0_31ck75 = 0 time = 380
* CHECK dout1_0 vdout1_0ck75 = 1.0 time = 380
* CHECK dout1_1 vdout1_1ck75 = 1.0 time = 380
* CHECK dout1_2 vdout1_2ck75 = 1.0 time = 380
* CHECK dout1_3 vdout1_3ck75 = 1.0 time = 380
* CHECK dout1_4 vdout1_4ck75 = 0 time = 380
* CHECK dout1_5 vdout1_5ck75 = 0 time = 380
* CHECK dout1_6 vdout1_6ck75 = 1.0 time = 380
* CHECK dout1_7 vdout1_7ck75 = 0 time = 380
* CHECK dout1_8 vdout1_8ck75 = 1.0 time = 380
* CHECK dout1_9 vdout1_9ck75 = 0 time = 380
* CHECK dout1_10 vdout1_10ck75 = 1.0 time = 380
* CHECK dout1_11 vdout1_11ck75 = 1.0 time = 380
* CHECK dout1_12 vdout1_12ck75 = 1.0 time = 380
* CHECK dout1_13 vdout1_13ck75 = 1.0 time = 380
* CHECK dout1_14 vdout1_14ck75 = 0 time = 380
* CHECK dout1_15 vdout1_15ck75 = 1.0 time = 380
* CHECK dout1_16 vdout1_16ck75 = 0 time = 380
* CHECK dout1_17 vdout1_17ck75 = 1.0 time = 380
* CHECK dout1_18 vdout1_18ck75 = 1.0 time = 380
* CHECK dout1_19 vdout1_19ck75 = 0 time = 380
* CHECK dout1_20 vdout1_20ck75 = 1.0 time = 380
* CHECK dout1_21 vdout1_21ck75 = 0 time = 380
* CHECK dout1_22 vdout1_22ck75 = 1.0 time = 380
* CHECK dout1_23 vdout1_23ck75 = 0 time = 380
* CHECK dout1_24 vdout1_24ck75 = 1.0 time = 380
* CHECK dout1_25 vdout1_25ck75 = 0 time = 380
* CHECK dout1_26 vdout1_26ck75 = 1.0 time = 380
* CHECK dout1_27 vdout1_27ck75 = 0 time = 380
* CHECK dout1_28 vdout1_28ck75 = 0 time = 380
* CHECK dout1_29 vdout1_29ck75 = 1.0 time = 380
* CHECK dout1_30 vdout1_30ck75 = 0 time = 380
* CHECK dout1_31 vdout1_31ck75 = 1.0 time = 380
* CHECK dout0_0 vdout0_0ck76 = 1.0 time = 385
* CHECK dout0_1 vdout0_1ck76 = 1.0 time = 385
* CHECK dout0_2 vdout0_2ck76 = 0 time = 385
* CHECK dout0_3 vdout0_3ck76 = 0 time = 385
* CHECK dout0_4 vdout0_4ck76 = 0 time = 385
* CHECK dout0_5 vdout0_5ck76 = 1.0 time = 385
* CHECK dout0_6 vdout0_6ck76 = 0 time = 385
* CHECK dout0_7 vdout0_7ck76 = 0 time = 385
* CHECK dout0_8 vdout0_8ck76 = 1.0 time = 385
* CHECK dout0_9 vdout0_9ck76 = 0 time = 385
* CHECK dout0_10 vdout0_10ck76 = 0 time = 385
* CHECK dout0_11 vdout0_11ck76 = 0 time = 385
* CHECK dout0_12 vdout0_12ck76 = 1.0 time = 385
* CHECK dout0_13 vdout0_13ck76 = 0 time = 385
* CHECK dout0_14 vdout0_14ck76 = 1.0 time = 385
* CHECK dout0_15 vdout0_15ck76 = 1.0 time = 385
* CHECK dout0_16 vdout0_16ck76 = 1.0 time = 385
* CHECK dout0_17 vdout0_17ck76 = 1.0 time = 385
* CHECK dout0_18 vdout0_18ck76 = 0 time = 385
* CHECK dout0_19 vdout0_19ck76 = 1.0 time = 385
* CHECK dout0_20 vdout0_20ck76 = 0 time = 385
* CHECK dout0_21 vdout0_21ck76 = 1.0 time = 385
* CHECK dout0_22 vdout0_22ck76 = 0 time = 385
* CHECK dout0_23 vdout0_23ck76 = 1.0 time = 385
* CHECK dout0_24 vdout0_24ck76 = 0 time = 385
* CHECK dout0_25 vdout0_25ck76 = 1.0 time = 385
* CHECK dout0_26 vdout0_26ck76 = 0 time = 385
* CHECK dout0_27 vdout0_27ck76 = 0 time = 385
* CHECK dout0_28 vdout0_28ck76 = 1.0 time = 385
* CHECK dout0_29 vdout0_29ck76 = 0 time = 385
* CHECK dout0_30 vdout0_30ck76 = 0 time = 385
* CHECK dout0_31 vdout0_31ck76 = 1.0 time = 385
* CHECK dout1_0 vdout1_0ck78 = 1.0 time = 395
* CHECK dout1_1 vdout1_1ck78 = 1.0 time = 395
* CHECK dout1_2 vdout1_2ck78 = 1.0 time = 395
* CHECK dout1_3 vdout1_3ck78 = 1.0 time = 395
* CHECK dout1_4 vdout1_4ck78 = 0 time = 395
* CHECK dout1_5 vdout1_5ck78 = 0 time = 395
* CHECK dout1_6 vdout1_6ck78 = 1.0 time = 395
* CHECK dout1_7 vdout1_7ck78 = 1.0 time = 395
* CHECK dout1_8 vdout1_8ck78 = 0 time = 395
* CHECK dout1_9 vdout1_9ck78 = 0 time = 395
* CHECK dout1_10 vdout1_10ck78 = 1.0 time = 395
* CHECK dout1_11 vdout1_11ck78 = 0 time = 395
* CHECK dout1_12 vdout1_12ck78 = 1.0 time = 395
* CHECK dout1_13 vdout1_13ck78 = 0 time = 395
* CHECK dout1_14 vdout1_14ck78 = 1.0 time = 395
* CHECK dout1_15 vdout1_15ck78 = 0 time = 395
* CHECK dout1_16 vdout1_16ck78 = 1.0 time = 395
* CHECK dout1_17 vdout1_17ck78 = 1.0 time = 395
* CHECK dout1_18 vdout1_18ck78 = 0 time = 395
* CHECK dout1_19 vdout1_19ck78 = 0 time = 395
* CHECK dout1_20 vdout1_20ck78 = 1.0 time = 395
* CHECK dout1_21 vdout1_21ck78 = 1.0 time = 395
* CHECK dout1_22 vdout1_22ck78 = 1.0 time = 395
* CHECK dout1_23 vdout1_23ck78 = 1.0 time = 395
* CHECK dout1_24 vdout1_24ck78 = 0 time = 395
* CHECK dout1_25 vdout1_25ck78 = 0 time = 395
* CHECK dout1_26 vdout1_26ck78 = 0 time = 395
* CHECK dout1_27 vdout1_27ck78 = 0 time = 395
* CHECK dout1_28 vdout1_28ck78 = 1.0 time = 395
* CHECK dout1_29 vdout1_29ck78 = 1.0 time = 395
* CHECK dout1_30 vdout1_30ck78 = 1.0 time = 395
* CHECK dout1_31 vdout1_31ck78 = 0 time = 395
* CHECK dout0_0 vdout0_0ck79 = 0 time = 400
* CHECK dout0_1 vdout0_1ck79 = 1.0 time = 400
* CHECK dout0_2 vdout0_2ck79 = 0 time = 400
* CHECK dout0_3 vdout0_3ck79 = 0 time = 400
* CHECK dout0_4 vdout0_4ck79 = 1.0 time = 400
* CHECK dout0_5 vdout0_5ck79 = 0 time = 400
* CHECK dout0_6 vdout0_6ck79 = 1.0 time = 400
* CHECK dout0_7 vdout0_7ck79 = 0 time = 400
* CHECK dout0_8 vdout0_8ck79 = 0 time = 400
* CHECK dout0_9 vdout0_9ck79 = 1.0 time = 400
* CHECK dout0_10 vdout0_10ck79 = 0 time = 400
* CHECK dout0_11 vdout0_11ck79 = 0 time = 400
* CHECK dout0_12 vdout0_12ck79 = 0 time = 400
* CHECK dout0_13 vdout0_13ck79 = 1.0 time = 400
* CHECK dout0_14 vdout0_14ck79 = 0 time = 400
* CHECK dout0_15 vdout0_15ck79 = 0 time = 400
* CHECK dout0_16 vdout0_16ck79 = 1.0 time = 400
* CHECK dout0_17 vdout0_17ck79 = 0 time = 400
* CHECK dout0_18 vdout0_18ck79 = 0 time = 400
* CHECK dout0_19 vdout0_19ck79 = 1.0 time = 400
* CHECK dout0_20 vdout0_20ck79 = 1.0 time = 400
* CHECK dout0_21 vdout0_21ck79 = 1.0 time = 400
* CHECK dout0_22 vdout0_22ck79 = 1.0 time = 400
* CHECK dout0_23 vdout0_23ck79 = 1.0 time = 400
* CHECK dout0_24 vdout0_24ck79 = 1.0 time = 400
* CHECK dout0_25 vdout0_25ck79 = 0 time = 400
* CHECK dout0_26 vdout0_26ck79 = 0 time = 400
* CHECK dout0_27 vdout0_27ck79 = 1.0 time = 400
* CHECK dout0_28 vdout0_28ck79 = 1.0 time = 400
* CHECK dout0_29 vdout0_29ck79 = 0 time = 400
* CHECK dout0_30 vdout0_30ck79 = 0 time = 400
* CHECK dout0_31 vdout0_31ck79 = 0 time = 400
* CHECK dout1_0 vdout1_0ck79 = 0 time = 400
* CHECK dout1_1 vdout1_1ck79 = 0 time = 400
* CHECK dout1_2 vdout1_2ck79 = 0 time = 400
* CHECK dout1_3 vdout1_3ck79 = 0 time = 400
* CHECK dout1_4 vdout1_4ck79 = 1.0 time = 400
* CHECK dout1_5 vdout1_5ck79 = 0 time = 400
* CHECK dout1_6 vdout1_6ck79 = 1.0 time = 400
* CHECK dout1_7 vdout1_7ck79 = 0 time = 400
* CHECK dout1_8 vdout1_8ck79 = 0 time = 400
* CHECK dout1_9 vdout1_9ck79 = 1.0 time = 400
* CHECK dout1_10 vdout1_10ck79 = 1.0 time = 400
* CHECK dout1_11 vdout1_11ck79 = 1.0 time = 400
* CHECK dout1_12 vdout1_12ck79 = 0 time = 400
* CHECK dout1_13 vdout1_13ck79 = 0 time = 400
* CHECK dout1_14 vdout1_14ck79 = 0 time = 400
* CHECK dout1_15 vdout1_15ck79 = 1.0 time = 400
* CHECK dout1_16 vdout1_16ck79 = 0 time = 400
* CHECK dout1_17 vdout1_17ck79 = 1.0 time = 400
* CHECK dout1_18 vdout1_18ck79 = 1.0 time = 400
* CHECK dout1_19 vdout1_19ck79 = 0 time = 400
* CHECK dout1_20 vdout1_20ck79 = 0 time = 400
* CHECK dout1_21 vdout1_21ck79 = 1.0 time = 400
* CHECK dout1_22 vdout1_22ck79 = 1.0 time = 400
* CHECK dout1_23 vdout1_23ck79 = 1.0 time = 400
* CHECK dout1_24 vdout1_24ck79 = 0 time = 400
* CHECK dout1_25 vdout1_25ck79 = 1.0 time = 400
* CHECK dout1_26 vdout1_26ck79 = 0 time = 400
* CHECK dout1_27 vdout1_27ck79 = 0 time = 400
* CHECK dout1_28 vdout1_28ck79 = 1.0 time = 400
* CHECK dout1_29 vdout1_29ck79 = 0 time = 400
* CHECK dout1_30 vdout1_30ck79 = 1.0 time = 400
* CHECK dout1_31 vdout1_31ck79 = 1.0 time = 400
* CHECK dout0_0 vdout0_0ck80 = 0 time = 405
* CHECK dout0_1 vdout0_1ck80 = 0 time = 405
* CHECK dout0_2 vdout0_2ck80 = 0 time = 405
* CHECK dout0_3 vdout0_3ck80 = 0 time = 405
* CHECK dout0_4 vdout0_4ck80 = 1.0 time = 405
* CHECK dout0_5 vdout0_5ck80 = 0 time = 405
* CHECK dout0_6 vdout0_6ck80 = 1.0 time = 405
* CHECK dout0_7 vdout0_7ck80 = 0 time = 405
* CHECK dout0_8 vdout0_8ck80 = 0 time = 405
* CHECK dout0_9 vdout0_9ck80 = 1.0 time = 405
* CHECK dout0_10 vdout0_10ck80 = 1.0 time = 405
* CHECK dout0_11 vdout0_11ck80 = 1.0 time = 405
* CHECK dout0_12 vdout0_12ck80 = 0 time = 405
* CHECK dout0_13 vdout0_13ck80 = 0 time = 405
* CHECK dout0_14 vdout0_14ck80 = 0 time = 405
* CHECK dout0_15 vdout0_15ck80 = 1.0 time = 405
* CHECK dout0_16 vdout0_16ck80 = 0 time = 405
* CHECK dout0_17 vdout0_17ck80 = 1.0 time = 405
* CHECK dout0_18 vdout0_18ck80 = 1.0 time = 405
* CHECK dout0_19 vdout0_19ck80 = 0 time = 405
* CHECK dout0_20 vdout0_20ck80 = 0 time = 405
* CHECK dout0_21 vdout0_21ck80 = 1.0 time = 405
* CHECK dout0_22 vdout0_22ck80 = 1.0 time = 405
* CHECK dout0_23 vdout0_23ck80 = 1.0 time = 405
* CHECK dout0_24 vdout0_24ck80 = 0 time = 405
* CHECK dout0_25 vdout0_25ck80 = 1.0 time = 405
* CHECK dout0_26 vdout0_26ck80 = 0 time = 405
* CHECK dout0_27 vdout0_27ck80 = 0 time = 405
* CHECK dout0_28 vdout0_28ck80 = 1.0 time = 405
* CHECK dout0_29 vdout0_29ck80 = 0 time = 405
* CHECK dout0_30 vdout0_30ck80 = 1.0 time = 405
* CHECK dout0_31 vdout0_31ck80 = 1.0 time = 405
* CHECK dout0_0 vdout0_0ck81 = 1.0 time = 410
* CHECK dout0_1 vdout0_1ck81 = 1.0 time = 410
* CHECK dout0_2 vdout0_2ck81 = 1.0 time = 410
* CHECK dout0_3 vdout0_3ck81 = 1.0 time = 410
* CHECK dout0_4 vdout0_4ck81 = 0 time = 410
* CHECK dout0_5 vdout0_5ck81 = 0 time = 410
* CHECK dout0_6 vdout0_6ck81 = 1.0 time = 410
* CHECK dout0_7 vdout0_7ck81 = 1.0 time = 410
* CHECK dout0_8 vdout0_8ck81 = 0 time = 410
* CHECK dout0_9 vdout0_9ck81 = 0 time = 410
* CHECK dout0_10 vdout0_10ck81 = 1.0 time = 410
* CHECK dout0_11 vdout0_11ck81 = 0 time = 410
* CHECK dout0_12 vdout0_12ck81 = 1.0 time = 410
* CHECK dout0_13 vdout0_13ck81 = 0 time = 410
* CHECK dout0_14 vdout0_14ck81 = 1.0 time = 410
* CHECK dout0_15 vdout0_15ck81 = 0 time = 410
* CHECK dout0_16 vdout0_16ck81 = 1.0 time = 410
* CHECK dout0_17 vdout0_17ck81 = 1.0 time = 410
* CHECK dout0_18 vdout0_18ck81 = 0 time = 410
* CHECK dout0_19 vdout0_19ck81 = 0 time = 410
* CHECK dout0_20 vdout0_20ck81 = 1.0 time = 410
* CHECK dout0_21 vdout0_21ck81 = 1.0 time = 410
* CHECK dout0_22 vdout0_22ck81 = 1.0 time = 410
* CHECK dout0_23 vdout0_23ck81 = 1.0 time = 410
* CHECK dout0_24 vdout0_24ck81 = 0 time = 410
* CHECK dout0_25 vdout0_25ck81 = 0 time = 410
* CHECK dout0_26 vdout0_26ck81 = 0 time = 410
* CHECK dout0_27 vdout0_27ck81 = 0 time = 410
* CHECK dout0_28 vdout0_28ck81 = 1.0 time = 410
* CHECK dout0_29 vdout0_29ck81 = 1.0 time = 410
* CHECK dout0_30 vdout0_30ck81 = 1.0 time = 410
* CHECK dout0_31 vdout0_31ck81 = 0 time = 410
* CHECK dout1_0 vdout1_0ck82 = 0 time = 415
* CHECK dout1_1 vdout1_1ck82 = 0 time = 415
* CHECK dout1_2 vdout1_2ck82 = 0 time = 415
* CHECK dout1_3 vdout1_3ck82 = 0 time = 415
* CHECK dout1_4 vdout1_4ck82 = 1.0 time = 415
* CHECK dout1_5 vdout1_5ck82 = 0 time = 415
* CHECK dout1_6 vdout1_6ck82 = 1.0 time = 415
* CHECK dout1_7 vdout1_7ck82 = 0 time = 415
* CHECK dout1_8 vdout1_8ck82 = 0 time = 415
* CHECK dout1_9 vdout1_9ck82 = 1.0 time = 415
* CHECK dout1_10 vdout1_10ck82 = 1.0 time = 415
* CHECK dout1_11 vdout1_11ck82 = 1.0 time = 415
* CHECK dout1_12 vdout1_12ck82 = 0 time = 415
* CHECK dout1_13 vdout1_13ck82 = 0 time = 415
* CHECK dout1_14 vdout1_14ck82 = 0 time = 415
* CHECK dout1_15 vdout1_15ck82 = 1.0 time = 415
* CHECK dout1_16 vdout1_16ck82 = 0 time = 415
* CHECK dout1_17 vdout1_17ck82 = 1.0 time = 415
* CHECK dout1_18 vdout1_18ck82 = 1.0 time = 415
* CHECK dout1_19 vdout1_19ck82 = 0 time = 415
* CHECK dout1_20 vdout1_20ck82 = 0 time = 415
* CHECK dout1_21 vdout1_21ck82 = 1.0 time = 415
* CHECK dout1_22 vdout1_22ck82 = 1.0 time = 415
* CHECK dout1_23 vdout1_23ck82 = 1.0 time = 415
* CHECK dout1_24 vdout1_24ck82 = 0 time = 415
* CHECK dout1_25 vdout1_25ck82 = 1.0 time = 415
* CHECK dout1_26 vdout1_26ck82 = 0 time = 415
* CHECK dout1_27 vdout1_27ck82 = 0 time = 415
* CHECK dout1_28 vdout1_28ck82 = 1.0 time = 415
* CHECK dout1_29 vdout1_29ck82 = 0 time = 415
* CHECK dout1_30 vdout1_30ck82 = 1.0 time = 415
* CHECK dout1_31 vdout1_31ck82 = 1.0 time = 415
* CHECK dout0_0 vdout0_0ck83 = 0 time = 420
* CHECK dout0_1 vdout0_1ck83 = 1.0 time = 420
* CHECK dout0_2 vdout0_2ck83 = 0 time = 420
* CHECK dout0_3 vdout0_3ck83 = 0 time = 420
* CHECK dout0_4 vdout0_4ck83 = 1.0 time = 420
* CHECK dout0_5 vdout0_5ck83 = 0 time = 420
* CHECK dout0_6 vdout0_6ck83 = 1.0 time = 420
* CHECK dout0_7 vdout0_7ck83 = 0 time = 420
* CHECK dout0_8 vdout0_8ck83 = 0 time = 420
* CHECK dout0_9 vdout0_9ck83 = 1.0 time = 420
* CHECK dout0_10 vdout0_10ck83 = 0 time = 420
* CHECK dout0_11 vdout0_11ck83 = 0 time = 420
* CHECK dout0_12 vdout0_12ck83 = 0 time = 420
* CHECK dout0_13 vdout0_13ck83 = 1.0 time = 420
* CHECK dout0_14 vdout0_14ck83 = 0 time = 420
* CHECK dout0_15 vdout0_15ck83 = 0 time = 420
* CHECK dout0_16 vdout0_16ck83 = 1.0 time = 420
* CHECK dout0_17 vdout0_17ck83 = 0 time = 420
* CHECK dout0_18 vdout0_18ck83 = 0 time = 420
* CHECK dout0_19 vdout0_19ck83 = 1.0 time = 420
* CHECK dout0_20 vdout0_20ck83 = 1.0 time = 420
* CHECK dout0_21 vdout0_21ck83 = 1.0 time = 420
* CHECK dout0_22 vdout0_22ck83 = 1.0 time = 420
* CHECK dout0_23 vdout0_23ck83 = 1.0 time = 420
* CHECK dout0_24 vdout0_24ck83 = 1.0 time = 420
* CHECK dout0_25 vdout0_25ck83 = 0 time = 420
* CHECK dout0_26 vdout0_26ck83 = 0 time = 420
* CHECK dout0_27 vdout0_27ck83 = 1.0 time = 420
* CHECK dout0_28 vdout0_28ck83 = 1.0 time = 420
* CHECK dout0_29 vdout0_29ck83 = 0 time = 420
* CHECK dout0_30 vdout0_30ck83 = 0 time = 420
* CHECK dout0_31 vdout0_31ck83 = 0 time = 420
* CHECK dout0_0 vdout0_0ck84 = 0 time = 425
* CHECK dout0_1 vdout0_1ck84 = 1.0 time = 425
* CHECK dout0_2 vdout0_2ck84 = 0 time = 425
* CHECK dout0_3 vdout0_3ck84 = 0 time = 425
* CHECK dout0_4 vdout0_4ck84 = 1.0 time = 425
* CHECK dout0_5 vdout0_5ck84 = 0 time = 425
* CHECK dout0_6 vdout0_6ck84 = 1.0 time = 425
* CHECK dout0_7 vdout0_7ck84 = 0 time = 425
* CHECK dout0_8 vdout0_8ck84 = 0 time = 425
* CHECK dout0_9 vdout0_9ck84 = 1.0 time = 425
* CHECK dout0_10 vdout0_10ck84 = 0 time = 425
* CHECK dout0_11 vdout0_11ck84 = 0 time = 425
* CHECK dout0_12 vdout0_12ck84 = 0 time = 425
* CHECK dout0_13 vdout0_13ck84 = 1.0 time = 425
* CHECK dout0_14 vdout0_14ck84 = 0 time = 425
* CHECK dout0_15 vdout0_15ck84 = 0 time = 425
* CHECK dout0_16 vdout0_16ck84 = 1.0 time = 425
* CHECK dout0_17 vdout0_17ck84 = 0 time = 425
* CHECK dout0_18 vdout0_18ck84 = 0 time = 425
* CHECK dout0_19 vdout0_19ck84 = 1.0 time = 425
* CHECK dout0_20 vdout0_20ck84 = 1.0 time = 425
* CHECK dout0_21 vdout0_21ck84 = 1.0 time = 425
* CHECK dout0_22 vdout0_22ck84 = 1.0 time = 425
* CHECK dout0_23 vdout0_23ck84 = 1.0 time = 425
* CHECK dout0_24 vdout0_24ck84 = 1.0 time = 425
* CHECK dout0_25 vdout0_25ck84 = 0 time = 425
* CHECK dout0_26 vdout0_26ck84 = 0 time = 425
* CHECK dout0_27 vdout0_27ck84 = 1.0 time = 425
* CHECK dout0_28 vdout0_28ck84 = 1.0 time = 425
* CHECK dout0_29 vdout0_29ck84 = 0 time = 425
* CHECK dout0_30 vdout0_30ck84 = 0 time = 425
* CHECK dout0_31 vdout0_31ck84 = 0 time = 425
* CHECK dout0_0 vdout0_0ck85 = 0 time = 430
* CHECK dout0_1 vdout0_1ck85 = 0 time = 430
* CHECK dout0_2 vdout0_2ck85 = 1.0 time = 430
* CHECK dout0_3 vdout0_3ck85 = 1.0 time = 430
* CHECK dout0_4 vdout0_4ck85 = 1.0 time = 430
* CHECK dout0_5 vdout0_5ck85 = 0 time = 430
* CHECK dout0_6 vdout0_6ck85 = 0 time = 430
* CHECK dout0_7 vdout0_7ck85 = 1.0 time = 430
* CHECK dout0_8 vdout0_8ck85 = 0 time = 430
* CHECK dout0_9 vdout0_9ck85 = 0 time = 430
* CHECK dout0_10 vdout0_10ck85 = 0 time = 430
* CHECK dout0_11 vdout0_11ck85 = 1.0 time = 430
* CHECK dout0_12 vdout0_12ck85 = 0 time = 430
* CHECK dout0_13 vdout0_13ck85 = 0 time = 430
* CHECK dout0_14 vdout0_14ck85 = 0 time = 430
* CHECK dout0_15 vdout0_15ck85 = 0 time = 430
* CHECK dout0_16 vdout0_16ck85 = 1.0 time = 430
* CHECK dout0_17 vdout0_17ck85 = 1.0 time = 430
* CHECK dout0_18 vdout0_18ck85 = 0 time = 430
* CHECK dout0_19 vdout0_19ck85 = 1.0 time = 430
* CHECK dout0_20 vdout0_20ck85 = 1.0 time = 430
* CHECK dout0_21 vdout0_21ck85 = 1.0 time = 430
* CHECK dout0_22 vdout0_22ck85 = 0 time = 430
* CHECK dout0_23 vdout0_23ck85 = 1.0 time = 430
* CHECK dout0_24 vdout0_24ck85 = 1.0 time = 430
* CHECK dout0_25 vdout0_25ck85 = 1.0 time = 430
* CHECK dout0_26 vdout0_26ck85 = 1.0 time = 430
* CHECK dout0_27 vdout0_27ck85 = 0 time = 430
* CHECK dout0_28 vdout0_28ck85 = 0 time = 430
* CHECK dout0_29 vdout0_29ck85 = 0 time = 430
* CHECK dout0_30 vdout0_30ck85 = 0 time = 430
* CHECK dout0_31 vdout0_31ck85 = 0 time = 430
* CHECK dout1_0 vdout1_0ck85 = 1.0 time = 430
* CHECK dout1_1 vdout1_1ck85 = 1.0 time = 430
* CHECK dout1_2 vdout1_2ck85 = 1.0 time = 430
* CHECK dout1_3 vdout1_3ck85 = 1.0 time = 430
* CHECK dout1_4 vdout1_4ck85 = 0 time = 430
* CHECK dout1_5 vdout1_5ck85 = 0 time = 430
* CHECK dout1_6 vdout1_6ck85 = 1.0 time = 430
* CHECK dout1_7 vdout1_7ck85 = 0 time = 430
* CHECK dout1_8 vdout1_8ck85 = 1.0 time = 430
* CHECK dout1_9 vdout1_9ck85 = 0 time = 430
* CHECK dout1_10 vdout1_10ck85 = 1.0 time = 430
* CHECK dout1_11 vdout1_11ck85 = 1.0 time = 430
* CHECK dout1_12 vdout1_12ck85 = 1.0 time = 430
* CHECK dout1_13 vdout1_13ck85 = 1.0 time = 430
* CHECK dout1_14 vdout1_14ck85 = 0 time = 430
* CHECK dout1_15 vdout1_15ck85 = 1.0 time = 430
* CHECK dout1_16 vdout1_16ck85 = 0 time = 430
* CHECK dout1_17 vdout1_17ck85 = 1.0 time = 430
* CHECK dout1_18 vdout1_18ck85 = 1.0 time = 430
* CHECK dout1_19 vdout1_19ck85 = 0 time = 430
* CHECK dout1_20 vdout1_20ck85 = 1.0 time = 430
* CHECK dout1_21 vdout1_21ck85 = 0 time = 430
* CHECK dout1_22 vdout1_22ck85 = 1.0 time = 430
* CHECK dout1_23 vdout1_23ck85 = 0 time = 430
* CHECK dout1_24 vdout1_24ck85 = 1.0 time = 430
* CHECK dout1_25 vdout1_25ck85 = 0 time = 430
* CHECK dout1_26 vdout1_26ck85 = 1.0 time = 430
* CHECK dout1_27 vdout1_27ck85 = 0 time = 430
* CHECK dout1_28 vdout1_28ck85 = 0 time = 430
* CHECK dout1_29 vdout1_29ck85 = 1.0 time = 430
* CHECK dout1_30 vdout1_30ck85 = 0 time = 430
* CHECK dout1_31 vdout1_31ck85 = 1.0 time = 430
* CHECK dout1_0 vdout1_0ck86 = 1.0 time = 435
* CHECK dout1_1 vdout1_1ck86 = 1.0 time = 435
* CHECK dout1_2 vdout1_2ck86 = 1.0 time = 435
* CHECK dout1_3 vdout1_3ck86 = 1.0 time = 435
* CHECK dout1_4 vdout1_4ck86 = 0 time = 435
* CHECK dout1_5 vdout1_5ck86 = 0 time = 435
* CHECK dout1_6 vdout1_6ck86 = 1.0 time = 435
* CHECK dout1_7 vdout1_7ck86 = 1.0 time = 435
* CHECK dout1_8 vdout1_8ck86 = 0 time = 435
* CHECK dout1_9 vdout1_9ck86 = 0 time = 435
* CHECK dout1_10 vdout1_10ck86 = 1.0 time = 435
* CHECK dout1_11 vdout1_11ck86 = 0 time = 435
* CHECK dout1_12 vdout1_12ck86 = 1.0 time = 435
* CHECK dout1_13 vdout1_13ck86 = 0 time = 435
* CHECK dout1_14 vdout1_14ck86 = 1.0 time = 435
* CHECK dout1_15 vdout1_15ck86 = 0 time = 435
* CHECK dout1_16 vdout1_16ck86 = 1.0 time = 435
* CHECK dout1_17 vdout1_17ck86 = 1.0 time = 435
* CHECK dout1_18 vdout1_18ck86 = 0 time = 435
* CHECK dout1_19 vdout1_19ck86 = 0 time = 435
* CHECK dout1_20 vdout1_20ck86 = 1.0 time = 435
* CHECK dout1_21 vdout1_21ck86 = 1.0 time = 435
* CHECK dout1_22 vdout1_22ck86 = 1.0 time = 435
* CHECK dout1_23 vdout1_23ck86 = 1.0 time = 435
* CHECK dout1_24 vdout1_24ck86 = 0 time = 435
* CHECK dout1_25 vdout1_25ck86 = 0 time = 435
* CHECK dout1_26 vdout1_26ck86 = 0 time = 435
* CHECK dout1_27 vdout1_27ck86 = 0 time = 435
* CHECK dout1_28 vdout1_28ck86 = 1.0 time = 435
* CHECK dout1_29 vdout1_29ck86 = 1.0 time = 435
* CHECK dout1_30 vdout1_30ck86 = 1.0 time = 435
* CHECK dout1_31 vdout1_31ck86 = 0 time = 435
* CHECK dout1_0 vdout1_0ck89 = 0 time = 450
* CHECK dout1_1 vdout1_1ck89 = 1.0 time = 450
* CHECK dout1_2 vdout1_2ck89 = 0 time = 450
* CHECK dout1_3 vdout1_3ck89 = 0 time = 450
* CHECK dout1_4 vdout1_4ck89 = 1.0 time = 450
* CHECK dout1_5 vdout1_5ck89 = 0 time = 450
* CHECK dout1_6 vdout1_6ck89 = 1.0 time = 450
* CHECK dout1_7 vdout1_7ck89 = 0 time = 450
* CHECK dout1_8 vdout1_8ck89 = 0 time = 450
* CHECK dout1_9 vdout1_9ck89 = 1.0 time = 450
* CHECK dout1_10 vdout1_10ck89 = 0 time = 450
* CHECK dout1_11 vdout1_11ck89 = 0 time = 450
* CHECK dout1_12 vdout1_12ck89 = 0 time = 450
* CHECK dout1_13 vdout1_13ck89 = 1.0 time = 450
* CHECK dout1_14 vdout1_14ck89 = 0 time = 450
* CHECK dout1_15 vdout1_15ck89 = 0 time = 450
* CHECK dout1_16 vdout1_16ck89 = 1.0 time = 450
* CHECK dout1_17 vdout1_17ck89 = 0 time = 450
* CHECK dout1_18 vdout1_18ck89 = 0 time = 450
* CHECK dout1_19 vdout1_19ck89 = 1.0 time = 450
* CHECK dout1_20 vdout1_20ck89 = 1.0 time = 450
* CHECK dout1_21 vdout1_21ck89 = 1.0 time = 450
* CHECK dout1_22 vdout1_22ck89 = 1.0 time = 450
* CHECK dout1_23 vdout1_23ck89 = 1.0 time = 450
* CHECK dout1_24 vdout1_24ck89 = 1.0 time = 450
* CHECK dout1_25 vdout1_25ck89 = 0 time = 450
* CHECK dout1_26 vdout1_26ck89 = 0 time = 450
* CHECK dout1_27 vdout1_27ck89 = 1.0 time = 450
* CHECK dout1_28 vdout1_28ck89 = 1.0 time = 450
* CHECK dout1_29 vdout1_29ck89 = 0 time = 450
* CHECK dout1_30 vdout1_30ck89 = 0 time = 450
* CHECK dout1_31 vdout1_31ck89 = 0 time = 450
* CHECK dout0_0 vdout0_0ck90 = 0 time = 455
* CHECK dout0_1 vdout0_1ck90 = 0 time = 455
* CHECK dout0_2 vdout0_2ck90 = 0 time = 455
* CHECK dout0_3 vdout0_3ck90 = 0 time = 455
* CHECK dout0_4 vdout0_4ck90 = 1.0 time = 455
* CHECK dout0_5 vdout0_5ck90 = 0 time = 455
* CHECK dout0_6 vdout0_6ck90 = 1.0 time = 455
* CHECK dout0_7 vdout0_7ck90 = 0 time = 455
* CHECK dout0_8 vdout0_8ck90 = 0 time = 455
* CHECK dout0_9 vdout0_9ck90 = 1.0 time = 455
* CHECK dout0_10 vdout0_10ck90 = 1.0 time = 455
* CHECK dout0_11 vdout0_11ck90 = 1.0 time = 455
* CHECK dout0_12 vdout0_12ck90 = 0 time = 455
* CHECK dout0_13 vdout0_13ck90 = 0 time = 455
* CHECK dout0_14 vdout0_14ck90 = 0 time = 455
* CHECK dout0_15 vdout0_15ck90 = 1.0 time = 455
* CHECK dout0_16 vdout0_16ck90 = 0 time = 455
* CHECK dout0_17 vdout0_17ck90 = 1.0 time = 455
* CHECK dout0_18 vdout0_18ck90 = 1.0 time = 455
* CHECK dout0_19 vdout0_19ck90 = 0 time = 455
* CHECK dout0_20 vdout0_20ck90 = 0 time = 455
* CHECK dout0_21 vdout0_21ck90 = 1.0 time = 455
* CHECK dout0_22 vdout0_22ck90 = 1.0 time = 455
* CHECK dout0_23 vdout0_23ck90 = 1.0 time = 455
* CHECK dout0_24 vdout0_24ck90 = 0 time = 455
* CHECK dout0_25 vdout0_25ck90 = 1.0 time = 455
* CHECK dout0_26 vdout0_26ck90 = 0 time = 455
* CHECK dout0_27 vdout0_27ck90 = 0 time = 455
* CHECK dout0_28 vdout0_28ck90 = 1.0 time = 455
* CHECK dout0_29 vdout0_29ck90 = 0 time = 455
* CHECK dout0_30 vdout0_30ck90 = 1.0 time = 455
* CHECK dout0_31 vdout0_31ck90 = 1.0 time = 455
* CHECK dout1_0 vdout1_0ck90 = 1.0 time = 455
* CHECK dout1_1 vdout1_1ck90 = 0 time = 455
* CHECK dout1_2 vdout1_2ck90 = 0 time = 455
* CHECK dout1_3 vdout1_3ck90 = 1.0 time = 455
* CHECK dout1_4 vdout1_4ck90 = 0 time = 455
* CHECK dout1_5 vdout1_5ck90 = 0 time = 455
* CHECK dout1_6 vdout1_6ck90 = 1.0 time = 455
* CHECK dout1_7 vdout1_7ck90 = 0 time = 455
* CHECK dout1_8 vdout1_8ck90 = 1.0 time = 455
* CHECK dout1_9 vdout1_9ck90 = 0 time = 455
* CHECK dout1_10 vdout1_10ck90 = 0 time = 455
* CHECK dout1_11 vdout1_11ck90 = 1.0 time = 455
* CHECK dout1_12 vdout1_12ck90 = 0 time = 455
* CHECK dout1_13 vdout1_13ck90 = 1.0 time = 455
* CHECK dout1_14 vdout1_14ck90 = 1.0 time = 455
* CHECK dout1_15 vdout1_15ck90 = 0 time = 455
* CHECK dout1_16 vdout1_16ck90 = 1.0 time = 455
* CHECK dout1_17 vdout1_17ck90 = 1.0 time = 455
* CHECK dout1_18 vdout1_18ck90 = 1.0 time = 455
* CHECK dout1_19 vdout1_19ck90 = 0 time = 455
* CHECK dout1_20 vdout1_20ck90 = 0 time = 455
* CHECK dout1_21 vdout1_21ck90 = 0 time = 455
* CHECK dout1_22 vdout1_22ck90 = 1.0 time = 455
* CHECK dout1_23 vdout1_23ck90 = 0 time = 455
* CHECK dout1_24 vdout1_24ck90 = 0 time = 455
* CHECK dout1_25 vdout1_25ck90 = 1.0 time = 455
* CHECK dout1_26 vdout1_26ck90 = 1.0 time = 455
* CHECK dout1_27 vdout1_27ck90 = 1.0 time = 455
* CHECK dout1_28 vdout1_28ck90 = 1.0 time = 455
* CHECK dout1_29 vdout1_29ck90 = 0 time = 455
* CHECK dout1_30 vdout1_30ck90 = 0 time = 455
* CHECK dout1_31 vdout1_31ck90 = 0 time = 455
* CHECK dout1_0 vdout1_0ck94 = 0 time = 475
* CHECK dout1_1 vdout1_1ck94 = 0 time = 475
* CHECK dout1_2 vdout1_2ck94 = 1.0 time = 475
* CHECK dout1_3 vdout1_3ck94 = 1.0 time = 475
* CHECK dout1_4 vdout1_4ck94 = 1.0 time = 475
* CHECK dout1_5 vdout1_5ck94 = 0 time = 475
* CHECK dout1_6 vdout1_6ck94 = 0 time = 475
* CHECK dout1_7 vdout1_7ck94 = 1.0 time = 475
* CHECK dout1_8 vdout1_8ck94 = 0 time = 475
* CHECK dout1_9 vdout1_9ck94 = 0 time = 475
* CHECK dout1_10 vdout1_10ck94 = 0 time = 475
* CHECK dout1_11 vdout1_11ck94 = 1.0 time = 475
* CHECK dout1_12 vdout1_12ck94 = 0 time = 475
* CHECK dout1_13 vdout1_13ck94 = 0 time = 475
* CHECK dout1_14 vdout1_14ck94 = 0 time = 475
* CHECK dout1_15 vdout1_15ck94 = 0 time = 475
* CHECK dout1_16 vdout1_16ck94 = 1.0 time = 475
* CHECK dout1_17 vdout1_17ck94 = 1.0 time = 475
* CHECK dout1_18 vdout1_18ck94 = 0 time = 475
* CHECK dout1_19 vdout1_19ck94 = 1.0 time = 475
* CHECK dout1_20 vdout1_20ck94 = 1.0 time = 475
* CHECK dout1_21 vdout1_21ck94 = 1.0 time = 475
* CHECK dout1_22 vdout1_22ck94 = 0 time = 475
* CHECK dout1_23 vdout1_23ck94 = 1.0 time = 475
* CHECK dout1_24 vdout1_24ck94 = 1.0 time = 475
* CHECK dout1_25 vdout1_25ck94 = 1.0 time = 475
* CHECK dout1_26 vdout1_26ck94 = 1.0 time = 475
* CHECK dout1_27 vdout1_27ck94 = 0 time = 475
* CHECK dout1_28 vdout1_28ck94 = 0 time = 475
* CHECK dout1_29 vdout1_29ck94 = 0 time = 475
* CHECK dout1_30 vdout1_30ck94 = 0 time = 475
* CHECK dout1_31 vdout1_31ck94 = 0 time = 475
* CHECK dout0_0 vdout0_0ck95 = 0 time = 480
* CHECK dout0_1 vdout0_1ck95 = 1.0 time = 480
* CHECK dout0_2 vdout0_2ck95 = 1.0 time = 480
* CHECK dout0_3 vdout0_3ck95 = 1.0 time = 480
* CHECK dout0_4 vdout0_4ck95 = 1.0 time = 480
* CHECK dout0_5 vdout0_5ck95 = 0 time = 480
* CHECK dout0_6 vdout0_6ck95 = 0 time = 480
* CHECK dout0_7 vdout0_7ck95 = 0 time = 480
* CHECK dout0_8 vdout0_8ck95 = 1.0 time = 480
* CHECK dout0_9 vdout0_9ck95 = 1.0 time = 480
* CHECK dout0_10 vdout0_10ck95 = 0 time = 480
* CHECK dout0_11 vdout0_11ck95 = 1.0 time = 480
* CHECK dout0_12 vdout0_12ck95 = 0 time = 480
* CHECK dout0_13 vdout0_13ck95 = 1.0 time = 480
* CHECK dout0_14 vdout0_14ck95 = 1.0 time = 480
* CHECK dout0_15 vdout0_15ck95 = 1.0 time = 480
* CHECK dout0_16 vdout0_16ck95 = 1.0 time = 480
* CHECK dout0_17 vdout0_17ck95 = 0 time = 480
* CHECK dout0_18 vdout0_18ck95 = 1.0 time = 480
* CHECK dout0_19 vdout0_19ck95 = 0 time = 480
* CHECK dout0_20 vdout0_20ck95 = 0 time = 480
* CHECK dout0_21 vdout0_21ck95 = 1.0 time = 480
* CHECK dout0_22 vdout0_22ck95 = 1.0 time = 480
* CHECK dout0_23 vdout0_23ck95 = 0 time = 480
* CHECK dout0_24 vdout0_24ck95 = 0 time = 480
* CHECK dout0_25 vdout0_25ck95 = 0 time = 480
* CHECK dout0_26 vdout0_26ck95 = 1.0 time = 480
* CHECK dout0_27 vdout0_27ck95 = 0 time = 480
* CHECK dout0_28 vdout0_28ck95 = 0 time = 480
* CHECK dout0_29 vdout0_29ck95 = 1.0 time = 480
* CHECK dout0_30 vdout0_30ck95 = 1.0 time = 480
* CHECK dout0_31 vdout0_31ck95 = 1.0 time = 480
* CHECK dout1_0 vdout1_0ck95 = 1.0 time = 480
* CHECK dout1_1 vdout1_1ck95 = 0 time = 480
* CHECK dout1_2 vdout1_2ck95 = 0 time = 480
* CHECK dout1_3 vdout1_3ck95 = 1.0 time = 480
* CHECK dout1_4 vdout1_4ck95 = 0 time = 480
* CHECK dout1_5 vdout1_5ck95 = 0 time = 480
* CHECK dout1_6 vdout1_6ck95 = 1.0 time = 480
* CHECK dout1_7 vdout1_7ck95 = 0 time = 480
* CHECK dout1_8 vdout1_8ck95 = 1.0 time = 480
* CHECK dout1_9 vdout1_9ck95 = 0 time = 480
* CHECK dout1_10 vdout1_10ck95 = 0 time = 480
* CHECK dout1_11 vdout1_11ck95 = 1.0 time = 480
* CHECK dout1_12 vdout1_12ck95 = 0 time = 480
* CHECK dout1_13 vdout1_13ck95 = 1.0 time = 480
* CHECK dout1_14 vdout1_14ck95 = 1.0 time = 480
* CHECK dout1_15 vdout1_15ck95 = 0 time = 480
* CHECK dout1_16 vdout1_16ck95 = 1.0 time = 480
* CHECK dout1_17 vdout1_17ck95 = 1.0 time = 480
* CHECK dout1_18 vdout1_18ck95 = 1.0 time = 480
* CHECK dout1_19 vdout1_19ck95 = 0 time = 480
* CHECK dout1_20 vdout1_20ck95 = 0 time = 480
* CHECK dout1_21 vdout1_21ck95 = 0 time = 480
* CHECK dout1_22 vdout1_22ck95 = 1.0 time = 480
* CHECK dout1_23 vdout1_23ck95 = 0 time = 480
* CHECK dout1_24 vdout1_24ck95 = 0 time = 480
* CHECK dout1_25 vdout1_25ck95 = 1.0 time = 480
* CHECK dout1_26 vdout1_26ck95 = 1.0 time = 480
* CHECK dout1_27 vdout1_27ck95 = 1.0 time = 480
* CHECK dout1_28 vdout1_28ck95 = 1.0 time = 480
* CHECK dout1_29 vdout1_29ck95 = 0 time = 480
* CHECK dout1_30 vdout1_30ck95 = 0 time = 480
* CHECK dout1_31 vdout1_31ck95 = 0 time = 480
* CHECK dout0_0 vdout0_0ck96 = 1.0 time = 485
* CHECK dout0_1 vdout0_1ck96 = 0 time = 485
* CHECK dout0_2 vdout0_2ck96 = 0 time = 485
* CHECK dout0_3 vdout0_3ck96 = 0 time = 485
* CHECK dout0_4 vdout0_4ck96 = 1.0 time = 485
* CHECK dout0_5 vdout0_5ck96 = 1.0 time = 485
* CHECK dout0_6 vdout0_6ck96 = 1.0 time = 485
* CHECK dout0_7 vdout0_7ck96 = 0 time = 485
* CHECK dout0_8 vdout0_8ck96 = 1.0 time = 485
* CHECK dout0_9 vdout0_9ck96 = 0 time = 485
* CHECK dout0_10 vdout0_10ck96 = 0 time = 485
* CHECK dout0_11 vdout0_11ck96 = 1.0 time = 485
* CHECK dout0_12 vdout0_12ck96 = 1.0 time = 485
* CHECK dout0_13 vdout0_13ck96 = 0 time = 485
* CHECK dout0_14 vdout0_14ck96 = 1.0 time = 485
* CHECK dout0_15 vdout0_15ck96 = 1.0 time = 485
* CHECK dout0_16 vdout0_16ck96 = 0 time = 485
* CHECK dout0_17 vdout0_17ck96 = 1.0 time = 485
* CHECK dout0_18 vdout0_18ck96 = 0 time = 485
* CHECK dout0_19 vdout0_19ck96 = 1.0 time = 485
* CHECK dout0_20 vdout0_20ck96 = 0 time = 485
* CHECK dout0_21 vdout0_21ck96 = 1.0 time = 485
* CHECK dout0_22 vdout0_22ck96 = 0 time = 485
* CHECK dout0_23 vdout0_23ck96 = 0 time = 485
* CHECK dout0_24 vdout0_24ck96 = 0 time = 485
* CHECK dout0_25 vdout0_25ck96 = 1.0 time = 485
* CHECK dout0_26 vdout0_26ck96 = 0 time = 485
* CHECK dout0_27 vdout0_27ck96 = 0 time = 485
* CHECK dout0_28 vdout0_28ck96 = 0 time = 485
* CHECK dout0_29 vdout0_29ck96 = 0 time = 485
* CHECK dout0_30 vdout0_30ck96 = 1.0 time = 485
* CHECK dout0_31 vdout0_31ck96 = 1.0 time = 485
* CHECK dout0_0 vdout0_0ck97 = 1.0 time = 490
* CHECK dout0_1 vdout0_1ck97 = 1.0 time = 490
* CHECK dout0_2 vdout0_2ck97 = 1.0 time = 490
* CHECK dout0_3 vdout0_3ck97 = 1.0 time = 490
* CHECK dout0_4 vdout0_4ck97 = 0 time = 490
* CHECK dout0_5 vdout0_5ck97 = 0 time = 490
* CHECK dout0_6 vdout0_6ck97 = 1.0 time = 490
* CHECK dout0_7 vdout0_7ck97 = 0 time = 490
* CHECK dout0_8 vdout0_8ck97 = 1.0 time = 490
* CHECK dout0_9 vdout0_9ck97 = 0 time = 490
* CHECK dout0_10 vdout0_10ck97 = 1.0 time = 490
* CHECK dout0_11 vdout0_11ck97 = 1.0 time = 490
* CHECK dout0_12 vdout0_12ck97 = 1.0 time = 490
* CHECK dout0_13 vdout0_13ck97 = 1.0 time = 490
* CHECK dout0_14 vdout0_14ck97 = 0 time = 490
* CHECK dout0_15 vdout0_15ck97 = 1.0 time = 490
* CHECK dout0_16 vdout0_16ck97 = 0 time = 490
* CHECK dout0_17 vdout0_17ck97 = 1.0 time = 490
* CHECK dout0_18 vdout0_18ck97 = 1.0 time = 490
* CHECK dout0_19 vdout0_19ck97 = 0 time = 490
* CHECK dout0_20 vdout0_20ck97 = 1.0 time = 490
* CHECK dout0_21 vdout0_21ck97 = 0 time = 490
* CHECK dout0_22 vdout0_22ck97 = 1.0 time = 490
* CHECK dout0_23 vdout0_23ck97 = 0 time = 490
* CHECK dout0_24 vdout0_24ck97 = 1.0 time = 490
* CHECK dout0_25 vdout0_25ck97 = 0 time = 490
* CHECK dout0_26 vdout0_26ck97 = 1.0 time = 490
* CHECK dout0_27 vdout0_27ck97 = 0 time = 490
* CHECK dout0_28 vdout0_28ck97 = 0 time = 490
* CHECK dout0_29 vdout0_29ck97 = 1.0 time = 490
* CHECK dout0_30 vdout0_30ck97 = 0 time = 490
* CHECK dout0_31 vdout0_31ck97 = 1.0 time = 490
* CHECK dout1_0 vdout1_0ck97 = 1.0 time = 490
* CHECK dout1_1 vdout1_1ck97 = 1.0 time = 490
* CHECK dout1_2 vdout1_2ck97 = 1.0 time = 490
* CHECK dout1_3 vdout1_3ck97 = 1.0 time = 490
* CHECK dout1_4 vdout1_4ck97 = 0 time = 490
* CHECK dout1_5 vdout1_5ck97 = 0 time = 490
* CHECK dout1_6 vdout1_6ck97 = 0 time = 490
* CHECK dout1_7 vdout1_7ck97 = 0 time = 490
* CHECK dout1_8 vdout1_8ck97 = 1.0 time = 490
* CHECK dout1_9 vdout1_9ck97 = 1.0 time = 490
* CHECK dout1_10 vdout1_10ck97 = 1.0 time = 490
* CHECK dout1_11 vdout1_11ck97 = 1.0 time = 490
* CHECK dout1_12 vdout1_12ck97 = 1.0 time = 490
* CHECK dout1_13 vdout1_13ck97 = 1.0 time = 490
* CHECK dout1_14 vdout1_14ck97 = 1.0 time = 490
* CHECK dout1_15 vdout1_15ck97 = 1.0 time = 490
* CHECK dout1_16 vdout1_16ck97 = 1.0 time = 490
* CHECK dout1_17 vdout1_17ck97 = 0 time = 490
* CHECK dout1_18 vdout1_18ck97 = 1.0 time = 490
* CHECK dout1_19 vdout1_19ck97 = 0 time = 490
* CHECK dout1_20 vdout1_20ck97 = 1.0 time = 490
* CHECK dout1_21 vdout1_21ck97 = 0 time = 490
* CHECK dout1_22 vdout1_22ck97 = 0 time = 490
* CHECK dout1_23 vdout1_23ck97 = 0 time = 490
* CHECK dout1_24 vdout1_24ck97 = 0 time = 490
* CHECK dout1_25 vdout1_25ck97 = 0 time = 490
* CHECK dout1_26 vdout1_26ck97 = 1.0 time = 490
* CHECK dout1_27 vdout1_27ck97 = 1.0 time = 490
* CHECK dout1_28 vdout1_28ck97 = 1.0 time = 490
* CHECK dout1_29 vdout1_29ck97 = 1.0 time = 490
* CHECK dout1_30 vdout1_30ck97 = 1.0 time = 490
* CHECK dout1_31 vdout1_31ck97 = 0 time = 490
* CHECK dout0_0 vdout0_0ck98 = 0 time = 495
* CHECK dout0_1 vdout0_1ck98 = 0 time = 495
* CHECK dout0_2 vdout0_2ck98 = 0 time = 495
* CHECK dout0_3 vdout0_3ck98 = 0 time = 495
* CHECK dout0_4 vdout0_4ck98 = 1.0 time = 495
* CHECK dout0_5 vdout0_5ck98 = 0 time = 495
* CHECK dout0_6 vdout0_6ck98 = 0 time = 495
* CHECK dout0_7 vdout0_7ck98 = 1.0 time = 495
* CHECK dout0_8 vdout0_8ck98 = 1.0 time = 495
* CHECK dout0_9 vdout0_9ck98 = 1.0 time = 495
* CHECK dout0_10 vdout0_10ck98 = 1.0 time = 495
* CHECK dout0_11 vdout0_11ck98 = 1.0 time = 495
* CHECK dout0_12 vdout0_12ck98 = 1.0 time = 495
* CHECK dout0_13 vdout0_13ck98 = 0 time = 495
* CHECK dout0_14 vdout0_14ck98 = 1.0 time = 495
* CHECK dout0_15 vdout0_15ck98 = 0 time = 495
* CHECK dout0_16 vdout0_16ck98 = 0 time = 495
* CHECK dout0_17 vdout0_17ck98 = 0 time = 495
* CHECK dout0_18 vdout0_18ck98 = 0 time = 495
* CHECK dout0_19 vdout0_19ck98 = 0 time = 495
* CHECK dout0_20 vdout0_20ck98 = 0 time = 495
* CHECK dout0_21 vdout0_21ck98 = 0 time = 495
* CHECK dout0_22 vdout0_22ck98 = 0 time = 495
* CHECK dout0_23 vdout0_23ck98 = 1.0 time = 495
* CHECK dout0_24 vdout0_24ck98 = 0 time = 495
* CHECK dout0_25 vdout0_25ck98 = 1.0 time = 495
* CHECK dout0_26 vdout0_26ck98 = 0 time = 495
* CHECK dout0_27 vdout0_27ck98 = 1.0 time = 495
* CHECK dout0_28 vdout0_28ck98 = 1.0 time = 495
* CHECK dout0_29 vdout0_29ck98 = 0 time = 495
* CHECK dout0_30 vdout0_30ck98 = 0 time = 495
* CHECK dout0_31 vdout0_31ck98 = 0 time = 495
* CHECK dout1_0 vdout1_0ck98 = 1.0 time = 495
* CHECK dout1_1 vdout1_1ck98 = 0 time = 495
* CHECK dout1_2 vdout1_2ck98 = 0 time = 495
* CHECK dout1_3 vdout1_3ck98 = 0 time = 495
* CHECK dout1_4 vdout1_4ck98 = 1.0 time = 495
* CHECK dout1_5 vdout1_5ck98 = 1.0 time = 495
* CHECK dout1_6 vdout1_6ck98 = 1.0 time = 495
* CHECK dout1_7 vdout1_7ck98 = 0 time = 495
* CHECK dout1_8 vdout1_8ck98 = 1.0 time = 495
* CHECK dout1_9 vdout1_9ck98 = 0 time = 495
* CHECK dout1_10 vdout1_10ck98 = 0 time = 495
* CHECK dout1_11 vdout1_11ck98 = 1.0 time = 495
* CHECK dout1_12 vdout1_12ck98 = 1.0 time = 495
* CHECK dout1_13 vdout1_13ck98 = 0 time = 495
* CHECK dout1_14 vdout1_14ck98 = 1.0 time = 495
* CHECK dout1_15 vdout1_15ck98 = 1.0 time = 495
* CHECK dout1_16 vdout1_16ck98 = 0 time = 495
* CHECK dout1_17 vdout1_17ck98 = 1.0 time = 495
* CHECK dout1_18 vdout1_18ck98 = 0 time = 495
* CHECK dout1_19 vdout1_19ck98 = 1.0 time = 495
* CHECK dout1_20 vdout1_20ck98 = 0 time = 495
* CHECK dout1_21 vdout1_21ck98 = 1.0 time = 495
* CHECK dout1_22 vdout1_22ck98 = 0 time = 495
* CHECK dout1_23 vdout1_23ck98 = 0 time = 495
* CHECK dout1_24 vdout1_24ck98 = 0 time = 495
* CHECK dout1_25 vdout1_25ck98 = 1.0 time = 495
* CHECK dout1_26 vdout1_26ck98 = 0 time = 495
* CHECK dout1_27 vdout1_27ck98 = 0 time = 495
* CHECK dout1_28 vdout1_28ck98 = 0 time = 495
* CHECK dout1_29 vdout1_29ck98 = 0 time = 495
* CHECK dout1_30 vdout1_30ck98 = 1.0 time = 495
* CHECK dout1_31 vdout1_31ck98 = 1.0 time = 495
* CHECK dout1_0 vdout1_0ck99 = 1.0 time = 500
* CHECK dout1_1 vdout1_1ck99 = 0 time = 500
* CHECK dout1_2 vdout1_2ck99 = 0 time = 500
* CHECK dout1_3 vdout1_3ck99 = 1.0 time = 500
* CHECK dout1_4 vdout1_4ck99 = 0 time = 500
* CHECK dout1_5 vdout1_5ck99 = 0 time = 500
* CHECK dout1_6 vdout1_6ck99 = 1.0 time = 500
* CHECK dout1_7 vdout1_7ck99 = 0 time = 500
* CHECK dout1_8 vdout1_8ck99 = 1.0 time = 500
* CHECK dout1_9 vdout1_9ck99 = 0 time = 500
* CHECK dout1_10 vdout1_10ck99 = 0 time = 500
* CHECK dout1_11 vdout1_11ck99 = 1.0 time = 500
* CHECK dout1_12 vdout1_12ck99 = 0 time = 500
* CHECK dout1_13 vdout1_13ck99 = 1.0 time = 500
* CHECK dout1_14 vdout1_14ck99 = 1.0 time = 500
* CHECK dout1_15 vdout1_15ck99 = 0 time = 500
* CHECK dout1_16 vdout1_16ck99 = 1.0 time = 500
* CHECK dout1_17 vdout1_17ck99 = 1.0 time = 500
* CHECK dout1_18 vdout1_18ck99 = 1.0 time = 500
* CHECK dout1_19 vdout1_19ck99 = 0 time = 500
* CHECK dout1_20 vdout1_20ck99 = 0 time = 500
* CHECK dout1_21 vdout1_21ck99 = 0 time = 500
* CHECK dout1_22 vdout1_22ck99 = 1.0 time = 500
* CHECK dout1_23 vdout1_23ck99 = 0 time = 500
* CHECK dout1_24 vdout1_24ck99 = 0 time = 500
* CHECK dout1_25 vdout1_25ck99 = 1.0 time = 500
* CHECK dout1_26 vdout1_26ck99 = 1.0 time = 500
* CHECK dout1_27 vdout1_27ck99 = 1.0 time = 500
* CHECK dout1_28 vdout1_28ck99 = 1.0 time = 500
* CHECK dout1_29 vdout1_29ck99 = 0 time = 500
* CHECK dout1_30 vdout1_30ck99 = 0 time = 500
* CHECK dout1_31 vdout1_31ck99 = 0 time = 500
* CHECK dout0_0 vdout0_0ck100 = 1.0 time = 505
* CHECK dout0_1 vdout0_1ck100 = 1.0 time = 505
* CHECK dout0_2 vdout0_2ck100 = 1.0 time = 505
* CHECK dout0_3 vdout0_3ck100 = 1.0 time = 505
* CHECK dout0_4 vdout0_4ck100 = 0 time = 505
* CHECK dout0_5 vdout0_5ck100 = 0 time = 505
* CHECK dout0_6 vdout0_6ck100 = 1.0 time = 505
* CHECK dout0_7 vdout0_7ck100 = 0 time = 505
* CHECK dout0_8 vdout0_8ck100 = 1.0 time = 505
* CHECK dout0_9 vdout0_9ck100 = 0 time = 505
* CHECK dout0_10 vdout0_10ck100 = 1.0 time = 505
* CHECK dout0_11 vdout0_11ck100 = 1.0 time = 505
* CHECK dout0_12 vdout0_12ck100 = 1.0 time = 505
* CHECK dout0_13 vdout0_13ck100 = 1.0 time = 505
* CHECK dout0_14 vdout0_14ck100 = 0 time = 505
* CHECK dout0_15 vdout0_15ck100 = 1.0 time = 505
* CHECK dout0_16 vdout0_16ck100 = 0 time = 505
* CHECK dout0_17 vdout0_17ck100 = 1.0 time = 505
* CHECK dout0_18 vdout0_18ck100 = 1.0 time = 505
* CHECK dout0_19 vdout0_19ck100 = 0 time = 505
* CHECK dout0_20 vdout0_20ck100 = 1.0 time = 505
* CHECK dout0_21 vdout0_21ck100 = 0 time = 505
* CHECK dout0_22 vdout0_22ck100 = 1.0 time = 505
* CHECK dout0_23 vdout0_23ck100 = 0 time = 505
* CHECK dout0_24 vdout0_24ck100 = 1.0 time = 505
* CHECK dout0_25 vdout0_25ck100 = 0 time = 505
* CHECK dout0_26 vdout0_26ck100 = 1.0 time = 505
* CHECK dout0_27 vdout0_27ck100 = 0 time = 505
* CHECK dout0_28 vdout0_28ck100 = 0 time = 505
* CHECK dout0_29 vdout0_29ck100 = 1.0 time = 505
* CHECK dout0_30 vdout0_30ck100 = 0 time = 505
* CHECK dout0_31 vdout0_31ck100 = 1.0 time = 505
* CHECK dout0_0 vdout0_0ck101 = 1.0 time = 510
* CHECK dout0_1 vdout0_1ck101 = 1.0 time = 510
* CHECK dout0_2 vdout0_2ck101 = 1.0 time = 510
* CHECK dout0_3 vdout0_3ck101 = 1.0 time = 510
* CHECK dout0_4 vdout0_4ck101 = 0 time = 510
* CHECK dout0_5 vdout0_5ck101 = 0 time = 510
* CHECK dout0_6 vdout0_6ck101 = 0 time = 510
* CHECK dout0_7 vdout0_7ck101 = 0 time = 510
* CHECK dout0_8 vdout0_8ck101 = 1.0 time = 510
* CHECK dout0_9 vdout0_9ck101 = 1.0 time = 510
* CHECK dout0_10 vdout0_10ck101 = 1.0 time = 510
* CHECK dout0_11 vdout0_11ck101 = 1.0 time = 510
* CHECK dout0_12 vdout0_12ck101 = 1.0 time = 510
* CHECK dout0_13 vdout0_13ck101 = 1.0 time = 510
* CHECK dout0_14 vdout0_14ck101 = 1.0 time = 510
* CHECK dout0_15 vdout0_15ck101 = 1.0 time = 510
* CHECK dout0_16 vdout0_16ck101 = 1.0 time = 510
* CHECK dout0_17 vdout0_17ck101 = 0 time = 510
* CHECK dout0_18 vdout0_18ck101 = 1.0 time = 510
* CHECK dout0_19 vdout0_19ck101 = 0 time = 510
* CHECK dout0_20 vdout0_20ck101 = 1.0 time = 510
* CHECK dout0_21 vdout0_21ck101 = 0 time = 510
* CHECK dout0_22 vdout0_22ck101 = 0 time = 510
* CHECK dout0_23 vdout0_23ck101 = 0 time = 510
* CHECK dout0_24 vdout0_24ck101 = 0 time = 510
* CHECK dout0_25 vdout0_25ck101 = 0 time = 510
* CHECK dout0_26 vdout0_26ck101 = 1.0 time = 510
* CHECK dout0_27 vdout0_27ck101 = 1.0 time = 510
* CHECK dout0_28 vdout0_28ck101 = 1.0 time = 510
* CHECK dout0_29 vdout0_29ck101 = 1.0 time = 510
* CHECK dout0_30 vdout0_30ck101 = 1.0 time = 510
* CHECK dout0_31 vdout0_31ck101 = 0 time = 510
* CHECK dout0_0 vdout0_0ck103 = 1.0 time = 520
* CHECK dout0_1 vdout0_1ck103 = 0 time = 520
* CHECK dout0_2 vdout0_2ck103 = 0 time = 520
* CHECK dout0_3 vdout0_3ck103 = 0 time = 520
* CHECK dout0_4 vdout0_4ck103 = 1.0 time = 520
* CHECK dout0_5 vdout0_5ck103 = 1.0 time = 520
* CHECK dout0_6 vdout0_6ck103 = 1.0 time = 520
* CHECK dout0_7 vdout0_7ck103 = 0 time = 520
* CHECK dout0_8 vdout0_8ck103 = 1.0 time = 520
* CHECK dout0_9 vdout0_9ck103 = 0 time = 520
* CHECK dout0_10 vdout0_10ck103 = 0 time = 520
* CHECK dout0_11 vdout0_11ck103 = 1.0 time = 520
* CHECK dout0_12 vdout0_12ck103 = 1.0 time = 520
* CHECK dout0_13 vdout0_13ck103 = 0 time = 520
* CHECK dout0_14 vdout0_14ck103 = 1.0 time = 520
* CHECK dout0_15 vdout0_15ck103 = 1.0 time = 520
* CHECK dout0_16 vdout0_16ck103 = 0 time = 520
* CHECK dout0_17 vdout0_17ck103 = 1.0 time = 520
* CHECK dout0_18 vdout0_18ck103 = 0 time = 520
* CHECK dout0_19 vdout0_19ck103 = 1.0 time = 520
* CHECK dout0_20 vdout0_20ck103 = 0 time = 520
* CHECK dout0_21 vdout0_21ck103 = 1.0 time = 520
* CHECK dout0_22 vdout0_22ck103 = 0 time = 520
* CHECK dout0_23 vdout0_23ck103 = 0 time = 520
* CHECK dout0_24 vdout0_24ck103 = 0 time = 520
* CHECK dout0_25 vdout0_25ck103 = 1.0 time = 520
* CHECK dout0_26 vdout0_26ck103 = 0 time = 520
* CHECK dout0_27 vdout0_27ck103 = 0 time = 520
* CHECK dout0_28 vdout0_28ck103 = 0 time = 520
* CHECK dout0_29 vdout0_29ck103 = 0 time = 520
* CHECK dout0_30 vdout0_30ck103 = 1.0 time = 520
* CHECK dout0_31 vdout0_31ck103 = 1.0 time = 520
* CHECK dout1_0 vdout1_0ck103 = 1.0 time = 520
* CHECK dout1_1 vdout1_1ck103 = 1.0 time = 520
* CHECK dout1_2 vdout1_2ck103 = 1.0 time = 520
* CHECK dout1_3 vdout1_3ck103 = 1.0 time = 520
* CHECK dout1_4 vdout1_4ck103 = 0 time = 520
* CHECK dout1_5 vdout1_5ck103 = 0 time = 520
* CHECK dout1_6 vdout1_6ck103 = 0 time = 520
* CHECK dout1_7 vdout1_7ck103 = 0 time = 520
* CHECK dout1_8 vdout1_8ck103 = 1.0 time = 520
* CHECK dout1_9 vdout1_9ck103 = 1.0 time = 520
* CHECK dout1_10 vdout1_10ck103 = 1.0 time = 520
* CHECK dout1_11 vdout1_11ck103 = 1.0 time = 520
* CHECK dout1_12 vdout1_12ck103 = 1.0 time = 520
* CHECK dout1_13 vdout1_13ck103 = 1.0 time = 520
* CHECK dout1_14 vdout1_14ck103 = 1.0 time = 520
* CHECK dout1_15 vdout1_15ck103 = 1.0 time = 520
* CHECK dout1_16 vdout1_16ck103 = 1.0 time = 520
* CHECK dout1_17 vdout1_17ck103 = 0 time = 520
* CHECK dout1_18 vdout1_18ck103 = 1.0 time = 520
* CHECK dout1_19 vdout1_19ck103 = 0 time = 520
* CHECK dout1_20 vdout1_20ck103 = 1.0 time = 520
* CHECK dout1_21 vdout1_21ck103 = 0 time = 520
* CHECK dout1_22 vdout1_22ck103 = 0 time = 520
* CHECK dout1_23 vdout1_23ck103 = 0 time = 520
* CHECK dout1_24 vdout1_24ck103 = 0 time = 520
* CHECK dout1_25 vdout1_25ck103 = 0 time = 520
* CHECK dout1_26 vdout1_26ck103 = 1.0 time = 520
* CHECK dout1_27 vdout1_27ck103 = 1.0 time = 520
* CHECK dout1_28 vdout1_28ck103 = 1.0 time = 520
* CHECK dout1_29 vdout1_29ck103 = 1.0 time = 520
* CHECK dout1_30 vdout1_30ck103 = 1.0 time = 520
* CHECK dout1_31 vdout1_31ck103 = 0 time = 520
* CHECK dout1_0 vdout1_0ck104 = 1.0 time = 525
* CHECK dout1_1 vdout1_1ck104 = 0 time = 525
* CHECK dout1_2 vdout1_2ck104 = 1.0 time = 525
* CHECK dout1_3 vdout1_3ck104 = 0 time = 525
* CHECK dout1_4 vdout1_4ck104 = 1.0 time = 525
* CHECK dout1_5 vdout1_5ck104 = 0 time = 525
* CHECK dout1_6 vdout1_6ck104 = 1.0 time = 525
* CHECK dout1_7 vdout1_7ck104 = 1.0 time = 525
* CHECK dout1_8 vdout1_8ck104 = 1.0 time = 525
* CHECK dout1_9 vdout1_9ck104 = 0 time = 525
* CHECK dout1_10 vdout1_10ck104 = 0 time = 525
* CHECK dout1_11 vdout1_11ck104 = 0 time = 525
* CHECK dout1_12 vdout1_12ck104 = 1.0 time = 525
* CHECK dout1_13 vdout1_13ck104 = 1.0 time = 525
* CHECK dout1_14 vdout1_14ck104 = 1.0 time = 525
* CHECK dout1_15 vdout1_15ck104 = 1.0 time = 525
* CHECK dout1_16 vdout1_16ck104 = 0 time = 525
* CHECK dout1_17 vdout1_17ck104 = 0 time = 525
* CHECK dout1_18 vdout1_18ck104 = 0 time = 525
* CHECK dout1_19 vdout1_19ck104 = 0 time = 525
* CHECK dout1_20 vdout1_20ck104 = 0 time = 525
* CHECK dout1_21 vdout1_21ck104 = 1.0 time = 525
* CHECK dout1_22 vdout1_22ck104 = 0 time = 525
* CHECK dout1_23 vdout1_23ck104 = 1.0 time = 525
* CHECK dout1_24 vdout1_24ck104 = 1.0 time = 525
* CHECK dout1_25 vdout1_25ck104 = 0 time = 525
* CHECK dout1_26 vdout1_26ck104 = 0 time = 525
* CHECK dout1_27 vdout1_27ck104 = 0 time = 525
* CHECK dout1_28 vdout1_28ck104 = 1.0 time = 525
* CHECK dout1_29 vdout1_29ck104 = 1.0 time = 525
* CHECK dout1_30 vdout1_30ck104 = 1.0 time = 525
* CHECK dout1_31 vdout1_31ck104 = 1.0 time = 525
* CHECK dout0_0 vdout0_0ck105 = 1.0 time = 530
* CHECK dout0_1 vdout0_1ck105 = 0 time = 530
* CHECK dout0_2 vdout0_2ck105 = 0 time = 530
* CHECK dout0_3 vdout0_3ck105 = 0 time = 530
* CHECK dout0_4 vdout0_4ck105 = 1.0 time = 530
* CHECK dout0_5 vdout0_5ck105 = 1.0 time = 530
* CHECK dout0_6 vdout0_6ck105 = 1.0 time = 530
* CHECK dout0_7 vdout0_7ck105 = 0 time = 530
* CHECK dout0_8 vdout0_8ck105 = 1.0 time = 530
* CHECK dout0_9 vdout0_9ck105 = 0 time = 530
* CHECK dout0_10 vdout0_10ck105 = 0 time = 530
* CHECK dout0_11 vdout0_11ck105 = 1.0 time = 530
* CHECK dout0_12 vdout0_12ck105 = 1.0 time = 530
* CHECK dout0_13 vdout0_13ck105 = 0 time = 530
* CHECK dout0_14 vdout0_14ck105 = 1.0 time = 530
* CHECK dout0_15 vdout0_15ck105 = 1.0 time = 530
* CHECK dout0_16 vdout0_16ck105 = 0 time = 530
* CHECK dout0_17 vdout0_17ck105 = 1.0 time = 530
* CHECK dout0_18 vdout0_18ck105 = 0 time = 530
* CHECK dout0_19 vdout0_19ck105 = 1.0 time = 530
* CHECK dout0_20 vdout0_20ck105 = 0 time = 530
* CHECK dout0_21 vdout0_21ck105 = 1.0 time = 530
* CHECK dout0_22 vdout0_22ck105 = 0 time = 530
* CHECK dout0_23 vdout0_23ck105 = 0 time = 530
* CHECK dout0_24 vdout0_24ck105 = 0 time = 530
* CHECK dout0_25 vdout0_25ck105 = 1.0 time = 530
* CHECK dout0_26 vdout0_26ck105 = 0 time = 530
* CHECK dout0_27 vdout0_27ck105 = 0 time = 530
* CHECK dout0_28 vdout0_28ck105 = 0 time = 530
* CHECK dout0_29 vdout0_29ck105 = 0 time = 530
* CHECK dout0_30 vdout0_30ck105 = 1.0 time = 530
* CHECK dout0_31 vdout0_31ck105 = 1.0 time = 530
* CHECK dout0_0 vdout0_0ck106 = 1.0 time = 535
* CHECK dout0_1 vdout0_1ck106 = 0 time = 535
* CHECK dout0_2 vdout0_2ck106 = 1.0 time = 535
* CHECK dout0_3 vdout0_3ck106 = 0 time = 535
* CHECK dout0_4 vdout0_4ck106 = 1.0 time = 535
* CHECK dout0_5 vdout0_5ck106 = 0 time = 535
* CHECK dout0_6 vdout0_6ck106 = 1.0 time = 535
* CHECK dout0_7 vdout0_7ck106 = 1.0 time = 535
* CHECK dout0_8 vdout0_8ck106 = 1.0 time = 535
* CHECK dout0_9 vdout0_9ck106 = 0 time = 535
* CHECK dout0_10 vdout0_10ck106 = 0 time = 535
* CHECK dout0_11 vdout0_11ck106 = 0 time = 535
* CHECK dout0_12 vdout0_12ck106 = 1.0 time = 535
* CHECK dout0_13 vdout0_13ck106 = 1.0 time = 535
* CHECK dout0_14 vdout0_14ck106 = 1.0 time = 535
* CHECK dout0_15 vdout0_15ck106 = 1.0 time = 535
* CHECK dout0_16 vdout0_16ck106 = 0 time = 535
* CHECK dout0_17 vdout0_17ck106 = 0 time = 535
* CHECK dout0_18 vdout0_18ck106 = 0 time = 535
* CHECK dout0_19 vdout0_19ck106 = 0 time = 535
* CHECK dout0_20 vdout0_20ck106 = 0 time = 535
* CHECK dout0_21 vdout0_21ck106 = 1.0 time = 535
* CHECK dout0_22 vdout0_22ck106 = 0 time = 535
* CHECK dout0_23 vdout0_23ck106 = 1.0 time = 535
* CHECK dout0_24 vdout0_24ck106 = 1.0 time = 535
* CHECK dout0_25 vdout0_25ck106 = 0 time = 535
* CHECK dout0_26 vdout0_26ck106 = 0 time = 535
* CHECK dout0_27 vdout0_27ck106 = 0 time = 535
* CHECK dout0_28 vdout0_28ck106 = 1.0 time = 535
* CHECK dout0_29 vdout0_29ck106 = 1.0 time = 535
* CHECK dout0_30 vdout0_30ck106 = 1.0 time = 535
* CHECK dout0_31 vdout0_31ck106 = 1.0 time = 535
* CHECK dout1_0 vdout1_0ck106 = 0 time = 535
* CHECK dout1_1 vdout1_1ck106 = 1.0 time = 535
* CHECK dout1_2 vdout1_2ck106 = 0 time = 535
* CHECK dout1_3 vdout1_3ck106 = 0 time = 535
* CHECK dout1_4 vdout1_4ck106 = 1.0 time = 535
* CHECK dout1_5 vdout1_5ck106 = 0 time = 535
* CHECK dout1_6 vdout1_6ck106 = 1.0 time = 535
* CHECK dout1_7 vdout1_7ck106 = 0 time = 535
* CHECK dout1_8 vdout1_8ck106 = 0 time = 535
* CHECK dout1_9 vdout1_9ck106 = 1.0 time = 535
* CHECK dout1_10 vdout1_10ck106 = 0 time = 535
* CHECK dout1_11 vdout1_11ck106 = 0 time = 535
* CHECK dout1_12 vdout1_12ck106 = 0 time = 535
* CHECK dout1_13 vdout1_13ck106 = 1.0 time = 535
* CHECK dout1_14 vdout1_14ck106 = 0 time = 535
* CHECK dout1_15 vdout1_15ck106 = 0 time = 535
* CHECK dout1_16 vdout1_16ck106 = 1.0 time = 535
* CHECK dout1_17 vdout1_17ck106 = 0 time = 535
* CHECK dout1_18 vdout1_18ck106 = 0 time = 535
* CHECK dout1_19 vdout1_19ck106 = 1.0 time = 535
* CHECK dout1_20 vdout1_20ck106 = 1.0 time = 535
* CHECK dout1_21 vdout1_21ck106 = 1.0 time = 535
* CHECK dout1_22 vdout1_22ck106 = 1.0 time = 535
* CHECK dout1_23 vdout1_23ck106 = 1.0 time = 535
* CHECK dout1_24 vdout1_24ck106 = 1.0 time = 535
* CHECK dout1_25 vdout1_25ck106 = 0 time = 535
* CHECK dout1_26 vdout1_26ck106 = 0 time = 535
* CHECK dout1_27 vdout1_27ck106 = 1.0 time = 535
* CHECK dout1_28 vdout1_28ck106 = 1.0 time = 535
* CHECK dout1_29 vdout1_29ck106 = 0 time = 535
* CHECK dout1_30 vdout1_30ck106 = 0 time = 535
* CHECK dout1_31 vdout1_31ck106 = 0 time = 535
* CHECK dout0_0 vdout0_0ck107 = 0 time = 540
* CHECK dout0_1 vdout0_1ck107 = 1.0 time = 540
* CHECK dout0_2 vdout0_2ck107 = 0 time = 540
* CHECK dout0_3 vdout0_3ck107 = 0 time = 540
* CHECK dout0_4 vdout0_4ck107 = 1.0 time = 540
* CHECK dout0_5 vdout0_5ck107 = 0 time = 540
* CHECK dout0_6 vdout0_6ck107 = 1.0 time = 540
* CHECK dout0_7 vdout0_7ck107 = 0 time = 540
* CHECK dout0_8 vdout0_8ck107 = 0 time = 540
* CHECK dout0_9 vdout0_9ck107 = 1.0 time = 540
* CHECK dout0_10 vdout0_10ck107 = 0 time = 540
* CHECK dout0_11 vdout0_11ck107 = 0 time = 540
* CHECK dout0_12 vdout0_12ck107 = 0 time = 540
* CHECK dout0_13 vdout0_13ck107 = 1.0 time = 540
* CHECK dout0_14 vdout0_14ck107 = 0 time = 540
* CHECK dout0_15 vdout0_15ck107 = 0 time = 540
* CHECK dout0_16 vdout0_16ck107 = 1.0 time = 540
* CHECK dout0_17 vdout0_17ck107 = 0 time = 540
* CHECK dout0_18 vdout0_18ck107 = 0 time = 540
* CHECK dout0_19 vdout0_19ck107 = 1.0 time = 540
* CHECK dout0_20 vdout0_20ck107 = 1.0 time = 540
* CHECK dout0_21 vdout0_21ck107 = 1.0 time = 540
* CHECK dout0_22 vdout0_22ck107 = 1.0 time = 540
* CHECK dout0_23 vdout0_23ck107 = 1.0 time = 540
* CHECK dout0_24 vdout0_24ck107 = 1.0 time = 540
* CHECK dout0_25 vdout0_25ck107 = 0 time = 540
* CHECK dout0_26 vdout0_26ck107 = 0 time = 540
* CHECK dout0_27 vdout0_27ck107 = 1.0 time = 540
* CHECK dout0_28 vdout0_28ck107 = 1.0 time = 540
* CHECK dout0_29 vdout0_29ck107 = 0 time = 540
* CHECK dout0_30 vdout0_30ck107 = 0 time = 540
* CHECK dout0_31 vdout0_31ck107 = 0 time = 540
* CHECK dout0_0 vdout0_0ck108 = 1.0 time = 545
* CHECK dout0_1 vdout0_1ck108 = 1.0 time = 545
* CHECK dout0_2 vdout0_2ck108 = 1.0 time = 545
* CHECK dout0_3 vdout0_3ck108 = 1.0 time = 545
* CHECK dout0_4 vdout0_4ck108 = 0 time = 545
* CHECK dout0_5 vdout0_5ck108 = 0 time = 545
* CHECK dout0_6 vdout0_6ck108 = 0 time = 545
* CHECK dout0_7 vdout0_7ck108 = 0 time = 545
* CHECK dout0_8 vdout0_8ck108 = 1.0 time = 545
* CHECK dout0_9 vdout0_9ck108 = 1.0 time = 545
* CHECK dout0_10 vdout0_10ck108 = 1.0 time = 545
* CHECK dout0_11 vdout0_11ck108 = 1.0 time = 545
* CHECK dout0_12 vdout0_12ck108 = 1.0 time = 545
* CHECK dout0_13 vdout0_13ck108 = 1.0 time = 545
* CHECK dout0_14 vdout0_14ck108 = 1.0 time = 545
* CHECK dout0_15 vdout0_15ck108 = 1.0 time = 545
* CHECK dout0_16 vdout0_16ck108 = 1.0 time = 545
* CHECK dout0_17 vdout0_17ck108 = 0 time = 545
* CHECK dout0_18 vdout0_18ck108 = 1.0 time = 545
* CHECK dout0_19 vdout0_19ck108 = 0 time = 545
* CHECK dout0_20 vdout0_20ck108 = 1.0 time = 545
* CHECK dout0_21 vdout0_21ck108 = 0 time = 545
* CHECK dout0_22 vdout0_22ck108 = 0 time = 545
* CHECK dout0_23 vdout0_23ck108 = 0 time = 545
* CHECK dout0_24 vdout0_24ck108 = 0 time = 545
* CHECK dout0_25 vdout0_25ck108 = 0 time = 545
* CHECK dout0_26 vdout0_26ck108 = 1.0 time = 545
* CHECK dout0_27 vdout0_27ck108 = 1.0 time = 545
* CHECK dout0_28 vdout0_28ck108 = 1.0 time = 545
* CHECK dout0_29 vdout0_29ck108 = 1.0 time = 545
* CHECK dout0_30 vdout0_30ck108 = 1.0 time = 545
* CHECK dout0_31 vdout0_31ck108 = 0 time = 545
* CHECK dout0_0 vdout0_0ck110 = 0 time = 555
* CHECK dout0_1 vdout0_1ck110 = 0 time = 555
* CHECK dout0_2 vdout0_2ck110 = 0 time = 555
* CHECK dout0_3 vdout0_3ck110 = 1.0 time = 555
* CHECK dout0_4 vdout0_4ck110 = 1.0 time = 555
* CHECK dout0_5 vdout0_5ck110 = 1.0 time = 555
* CHECK dout0_6 vdout0_6ck110 = 0 time = 555
* CHECK dout0_7 vdout0_7ck110 = 1.0 time = 555
* CHECK dout0_8 vdout0_8ck110 = 1.0 time = 555
* CHECK dout0_9 vdout0_9ck110 = 0 time = 555
* CHECK dout0_10 vdout0_10ck110 = 1.0 time = 555
* CHECK dout0_11 vdout0_11ck110 = 1.0 time = 555
* CHECK dout0_12 vdout0_12ck110 = 0 time = 555
* CHECK dout0_13 vdout0_13ck110 = 0 time = 555
* CHECK dout0_14 vdout0_14ck110 = 0 time = 555
* CHECK dout0_15 vdout0_15ck110 = 0 time = 555
* CHECK dout0_16 vdout0_16ck110 = 1.0 time = 555
* CHECK dout0_17 vdout0_17ck110 = 1.0 time = 555
* CHECK dout0_18 vdout0_18ck110 = 0 time = 555
* CHECK dout0_19 vdout0_19ck110 = 1.0 time = 555
* CHECK dout0_20 vdout0_20ck110 = 0 time = 555
* CHECK dout0_21 vdout0_21ck110 = 0 time = 555
* CHECK dout0_22 vdout0_22ck110 = 1.0 time = 555
* CHECK dout0_23 vdout0_23ck110 = 0 time = 555
* CHECK dout0_24 vdout0_24ck110 = 1.0 time = 555
* CHECK dout0_25 vdout0_25ck110 = 0 time = 555
* CHECK dout0_26 vdout0_26ck110 = 0 time = 555
* CHECK dout0_27 vdout0_27ck110 = 1.0 time = 555
* CHECK dout0_28 vdout0_28ck110 = 0 time = 555
* CHECK dout0_29 vdout0_29ck110 = 1.0 time = 555
* CHECK dout0_30 vdout0_30ck110 = 0 time = 555
* CHECK dout0_31 vdout0_31ck110 = 1.0 time = 555
* CHECK dout1_0 vdout1_0ck110 = 1.0 time = 555
* CHECK dout1_1 vdout1_1ck110 = 0 time = 555
* CHECK dout1_2 vdout1_2ck110 = 0 time = 555
* CHECK dout1_3 vdout1_3ck110 = 0 time = 555
* CHECK dout1_4 vdout1_4ck110 = 1.0 time = 555
* CHECK dout1_5 vdout1_5ck110 = 1.0 time = 555
* CHECK dout1_6 vdout1_6ck110 = 1.0 time = 555
* CHECK dout1_7 vdout1_7ck110 = 0 time = 555
* CHECK dout1_8 vdout1_8ck110 = 1.0 time = 555
* CHECK dout1_9 vdout1_9ck110 = 0 time = 555
* CHECK dout1_10 vdout1_10ck110 = 0 time = 555
* CHECK dout1_11 vdout1_11ck110 = 1.0 time = 555
* CHECK dout1_12 vdout1_12ck110 = 1.0 time = 555
* CHECK dout1_13 vdout1_13ck110 = 0 time = 555
* CHECK dout1_14 vdout1_14ck110 = 1.0 time = 555
* CHECK dout1_15 vdout1_15ck110 = 1.0 time = 555
* CHECK dout1_16 vdout1_16ck110 = 0 time = 555
* CHECK dout1_17 vdout1_17ck110 = 1.0 time = 555
* CHECK dout1_18 vdout1_18ck110 = 0 time = 555
* CHECK dout1_19 vdout1_19ck110 = 1.0 time = 555
* CHECK dout1_20 vdout1_20ck110 = 0 time = 555
* CHECK dout1_21 vdout1_21ck110 = 1.0 time = 555
* CHECK dout1_22 vdout1_22ck110 = 0 time = 555
* CHECK dout1_23 vdout1_23ck110 = 0 time = 555
* CHECK dout1_24 vdout1_24ck110 = 0 time = 555
* CHECK dout1_25 vdout1_25ck110 = 1.0 time = 555
* CHECK dout1_26 vdout1_26ck110 = 0 time = 555
* CHECK dout1_27 vdout1_27ck110 = 0 time = 555
* CHECK dout1_28 vdout1_28ck110 = 0 time = 555
* CHECK dout1_29 vdout1_29ck110 = 0 time = 555
* CHECK dout1_30 vdout1_30ck110 = 1.0 time = 555
* CHECK dout1_31 vdout1_31ck110 = 1.0 time = 555
* CHECK dout1_0 vdout1_0ck111 = 1.0 time = 560
* CHECK dout1_1 vdout1_1ck111 = 0 time = 560
* CHECK dout1_2 vdout1_2ck111 = 0 time = 560
* CHECK dout1_3 vdout1_3ck111 = 1.0 time = 560
* CHECK dout1_4 vdout1_4ck111 = 0 time = 560
* CHECK dout1_5 vdout1_5ck111 = 0 time = 560
* CHECK dout1_6 vdout1_6ck111 = 1.0 time = 560
* CHECK dout1_7 vdout1_7ck111 = 0 time = 560
* CHECK dout1_8 vdout1_8ck111 = 1.0 time = 560
* CHECK dout1_9 vdout1_9ck111 = 0 time = 560
* CHECK dout1_10 vdout1_10ck111 = 0 time = 560
* CHECK dout1_11 vdout1_11ck111 = 1.0 time = 560
* CHECK dout1_12 vdout1_12ck111 = 0 time = 560
* CHECK dout1_13 vdout1_13ck111 = 1.0 time = 560
* CHECK dout1_14 vdout1_14ck111 = 1.0 time = 560
* CHECK dout1_15 vdout1_15ck111 = 0 time = 560
* CHECK dout1_16 vdout1_16ck111 = 1.0 time = 560
* CHECK dout1_17 vdout1_17ck111 = 1.0 time = 560
* CHECK dout1_18 vdout1_18ck111 = 1.0 time = 560
* CHECK dout1_19 vdout1_19ck111 = 0 time = 560
* CHECK dout1_20 vdout1_20ck111 = 0 time = 560
* CHECK dout1_21 vdout1_21ck111 = 0 time = 560
* CHECK dout1_22 vdout1_22ck111 = 1.0 time = 560
* CHECK dout1_23 vdout1_23ck111 = 0 time = 560
* CHECK dout1_24 vdout1_24ck111 = 0 time = 560
* CHECK dout1_25 vdout1_25ck111 = 1.0 time = 560
* CHECK dout1_26 vdout1_26ck111 = 1.0 time = 560
* CHECK dout1_27 vdout1_27ck111 = 1.0 time = 560
* CHECK dout1_28 vdout1_28ck111 = 1.0 time = 560
* CHECK dout1_29 vdout1_29ck111 = 0 time = 560
* CHECK dout1_30 vdout1_30ck111 = 0 time = 560
* CHECK dout1_31 vdout1_31ck111 = 0 time = 560
* CHECK dout1_0 vdout1_0ck112 = 1.0 time = 565
* CHECK dout1_1 vdout1_1ck112 = 0 time = 565
* CHECK dout1_2 vdout1_2ck112 = 0 time = 565
* CHECK dout1_3 vdout1_3ck112 = 1.0 time = 565
* CHECK dout1_4 vdout1_4ck112 = 0 time = 565
* CHECK dout1_5 vdout1_5ck112 = 0 time = 565
* CHECK dout1_6 vdout1_6ck112 = 1.0 time = 565
* CHECK dout1_7 vdout1_7ck112 = 0 time = 565
* CHECK dout1_8 vdout1_8ck112 = 1.0 time = 565
* CHECK dout1_9 vdout1_9ck112 = 0 time = 565
* CHECK dout1_10 vdout1_10ck112 = 0 time = 565
* CHECK dout1_11 vdout1_11ck112 = 1.0 time = 565
* CHECK dout1_12 vdout1_12ck112 = 0 time = 565
* CHECK dout1_13 vdout1_13ck112 = 1.0 time = 565
* CHECK dout1_14 vdout1_14ck112 = 1.0 time = 565
* CHECK dout1_15 vdout1_15ck112 = 0 time = 565
* CHECK dout1_16 vdout1_16ck112 = 1.0 time = 565
* CHECK dout1_17 vdout1_17ck112 = 1.0 time = 565
* CHECK dout1_18 vdout1_18ck112 = 1.0 time = 565
* CHECK dout1_19 vdout1_19ck112 = 0 time = 565
* CHECK dout1_20 vdout1_20ck112 = 0 time = 565
* CHECK dout1_21 vdout1_21ck112 = 0 time = 565
* CHECK dout1_22 vdout1_22ck112 = 1.0 time = 565
* CHECK dout1_23 vdout1_23ck112 = 0 time = 565
* CHECK dout1_24 vdout1_24ck112 = 0 time = 565
* CHECK dout1_25 vdout1_25ck112 = 1.0 time = 565
* CHECK dout1_26 vdout1_26ck112 = 1.0 time = 565
* CHECK dout1_27 vdout1_27ck112 = 1.0 time = 565
* CHECK dout1_28 vdout1_28ck112 = 1.0 time = 565
* CHECK dout1_29 vdout1_29ck112 = 0 time = 565
* CHECK dout1_30 vdout1_30ck112 = 0 time = 565
* CHECK dout1_31 vdout1_31ck112 = 0 time = 565
* CHECK dout1_0 vdout1_0ck113 = 1.0 time = 570
* CHECK dout1_1 vdout1_1ck113 = 0 time = 570
* CHECK dout1_2 vdout1_2ck113 = 1.0 time = 570
* CHECK dout1_3 vdout1_3ck113 = 0 time = 570
* CHECK dout1_4 vdout1_4ck113 = 0 time = 570
* CHECK dout1_5 vdout1_5ck113 = 1.0 time = 570
* CHECK dout1_6 vdout1_6ck113 = 0 time = 570
* CHECK dout1_7 vdout1_7ck113 = 0 time = 570
* CHECK dout1_8 vdout1_8ck113 = 0 time = 570
* CHECK dout1_9 vdout1_9ck113 = 1.0 time = 570
* CHECK dout1_10 vdout1_10ck113 = 0 time = 570
* CHECK dout1_11 vdout1_11ck113 = 1.0 time = 570
* CHECK dout1_12 vdout1_12ck113 = 1.0 time = 570
* CHECK dout1_13 vdout1_13ck113 = 1.0 time = 570
* CHECK dout1_14 vdout1_14ck113 = 1.0 time = 570
* CHECK dout1_15 vdout1_15ck113 = 0 time = 570
* CHECK dout1_16 vdout1_16ck113 = 1.0 time = 570
* CHECK dout1_17 vdout1_17ck113 = 1.0 time = 570
* CHECK dout1_18 vdout1_18ck113 = 0 time = 570
* CHECK dout1_19 vdout1_19ck113 = 0 time = 570
* CHECK dout1_20 vdout1_20ck113 = 1.0 time = 570
* CHECK dout1_21 vdout1_21ck113 = 1.0 time = 570
* CHECK dout1_22 vdout1_22ck113 = 0 time = 570
* CHECK dout1_23 vdout1_23ck113 = 1.0 time = 570
* CHECK dout1_24 vdout1_24ck113 = 0 time = 570
* CHECK dout1_25 vdout1_25ck113 = 0 time = 570
* CHECK dout1_26 vdout1_26ck113 = 0 time = 570
* CHECK dout1_27 vdout1_27ck113 = 0 time = 570
* CHECK dout1_28 vdout1_28ck113 = 1.0 time = 570
* CHECK dout1_29 vdout1_29ck113 = 1.0 time = 570
* CHECK dout1_30 vdout1_30ck113 = 0 time = 570
* CHECK dout1_31 vdout1_31ck113 = 1.0 time = 570
* CHECK dout0_0 vdout0_0ck114 = 0 time = 575
* CHECK dout0_1 vdout0_1ck114 = 0 time = 575
* CHECK dout0_2 vdout0_2ck114 = 0 time = 575
* CHECK dout0_3 vdout0_3ck114 = 1.0 time = 575
* CHECK dout0_4 vdout0_4ck114 = 1.0 time = 575
* CHECK dout0_5 vdout0_5ck114 = 1.0 time = 575
* CHECK dout0_6 vdout0_6ck114 = 0 time = 575
* CHECK dout0_7 vdout0_7ck114 = 1.0 time = 575
* CHECK dout0_8 vdout0_8ck114 = 1.0 time = 575
* CHECK dout0_9 vdout0_9ck114 = 0 time = 575
* CHECK dout0_10 vdout0_10ck114 = 1.0 time = 575
* CHECK dout0_11 vdout0_11ck114 = 1.0 time = 575
* CHECK dout0_12 vdout0_12ck114 = 0 time = 575
* CHECK dout0_13 vdout0_13ck114 = 0 time = 575
* CHECK dout0_14 vdout0_14ck114 = 0 time = 575
* CHECK dout0_15 vdout0_15ck114 = 0 time = 575
* CHECK dout0_16 vdout0_16ck114 = 1.0 time = 575
* CHECK dout0_17 vdout0_17ck114 = 1.0 time = 575
* CHECK dout0_18 vdout0_18ck114 = 0 time = 575
* CHECK dout0_19 vdout0_19ck114 = 1.0 time = 575
* CHECK dout0_20 vdout0_20ck114 = 0 time = 575
* CHECK dout0_21 vdout0_21ck114 = 0 time = 575
* CHECK dout0_22 vdout0_22ck114 = 1.0 time = 575
* CHECK dout0_23 vdout0_23ck114 = 0 time = 575
* CHECK dout0_24 vdout0_24ck114 = 1.0 time = 575
* CHECK dout0_25 vdout0_25ck114 = 0 time = 575
* CHECK dout0_26 vdout0_26ck114 = 0 time = 575
* CHECK dout0_27 vdout0_27ck114 = 1.0 time = 575
* CHECK dout0_28 vdout0_28ck114 = 0 time = 575
* CHECK dout0_29 vdout0_29ck114 = 1.0 time = 575
* CHECK dout0_30 vdout0_30ck114 = 0 time = 575
* CHECK dout0_31 vdout0_31ck114 = 1.0 time = 575
* CHECK dout0_0 vdout0_0ck115 = 1.0 time = 580
* CHECK dout0_1 vdout0_1ck115 = 0 time = 580
* CHECK dout0_2 vdout0_2ck115 = 1.0 time = 580
* CHECK dout0_3 vdout0_3ck115 = 0 time = 580
* CHECK dout0_4 vdout0_4ck115 = 0 time = 580
* CHECK dout0_5 vdout0_5ck115 = 1.0 time = 580
* CHECK dout0_6 vdout0_6ck115 = 0 time = 580
* CHECK dout0_7 vdout0_7ck115 = 0 time = 580
* CHECK dout0_8 vdout0_8ck115 = 0 time = 580
* CHECK dout0_9 vdout0_9ck115 = 1.0 time = 580
* CHECK dout0_10 vdout0_10ck115 = 0 time = 580
* CHECK dout0_11 vdout0_11ck115 = 1.0 time = 580
* CHECK dout0_12 vdout0_12ck115 = 1.0 time = 580
* CHECK dout0_13 vdout0_13ck115 = 1.0 time = 580
* CHECK dout0_14 vdout0_14ck115 = 1.0 time = 580
* CHECK dout0_15 vdout0_15ck115 = 0 time = 580
* CHECK dout0_16 vdout0_16ck115 = 1.0 time = 580
* CHECK dout0_17 vdout0_17ck115 = 1.0 time = 580
* CHECK dout0_18 vdout0_18ck115 = 0 time = 580
* CHECK dout0_19 vdout0_19ck115 = 0 time = 580
* CHECK dout0_20 vdout0_20ck115 = 1.0 time = 580
* CHECK dout0_21 vdout0_21ck115 = 1.0 time = 580
* CHECK dout0_22 vdout0_22ck115 = 0 time = 580
* CHECK dout0_23 vdout0_23ck115 = 1.0 time = 580
* CHECK dout0_24 vdout0_24ck115 = 0 time = 580
* CHECK dout0_25 vdout0_25ck115 = 0 time = 580
* CHECK dout0_26 vdout0_26ck115 = 0 time = 580
* CHECK dout0_27 vdout0_27ck115 = 0 time = 580
* CHECK dout0_28 vdout0_28ck115 = 1.0 time = 580
* CHECK dout0_29 vdout0_29ck115 = 1.0 time = 580
* CHECK dout0_30 vdout0_30ck115 = 0 time = 580
* CHECK dout0_31 vdout0_31ck115 = 1.0 time = 580
* CHECK dout1_0 vdout1_0ck115 = 0 time = 580
* CHECK dout1_1 vdout1_1ck115 = 0 time = 580
* CHECK dout1_2 vdout1_2ck115 = 0 time = 580
* CHECK dout1_3 vdout1_3ck115 = 1.0 time = 580
* CHECK dout1_4 vdout1_4ck115 = 1.0 time = 580
* CHECK dout1_5 vdout1_5ck115 = 1.0 time = 580
* CHECK dout1_6 vdout1_6ck115 = 0 time = 580
* CHECK dout1_7 vdout1_7ck115 = 1.0 time = 580
* CHECK dout1_8 vdout1_8ck115 = 0 time = 580
* CHECK dout1_9 vdout1_9ck115 = 1.0 time = 580
* CHECK dout1_10 vdout1_10ck115 = 0 time = 580
* CHECK dout1_11 vdout1_11ck115 = 0 time = 580
* CHECK dout1_12 vdout1_12ck115 = 0 time = 580
* CHECK dout1_13 vdout1_13ck115 = 0 time = 580
* CHECK dout1_14 vdout1_14ck115 = 1.0 time = 580
* CHECK dout1_15 vdout1_15ck115 = 0 time = 580
* CHECK dout1_16 vdout1_16ck115 = 1.0 time = 580
* CHECK dout1_17 vdout1_17ck115 = 1.0 time = 580
* CHECK dout1_18 vdout1_18ck115 = 0 time = 580
* CHECK dout1_19 vdout1_19ck115 = 0 time = 580
* CHECK dout1_20 vdout1_20ck115 = 1.0 time = 580
* CHECK dout1_21 vdout1_21ck115 = 0 time = 580
* CHECK dout1_22 vdout1_22ck115 = 0 time = 580
* CHECK dout1_23 vdout1_23ck115 = 1.0 time = 580
* CHECK dout1_24 vdout1_24ck115 = 0 time = 580
* CHECK dout1_25 vdout1_25ck115 = 1.0 time = 580
* CHECK dout1_26 vdout1_26ck115 = 1.0 time = 580
* CHECK dout1_27 vdout1_27ck115 = 0 time = 580
* CHECK dout1_28 vdout1_28ck115 = 1.0 time = 580
* CHECK dout1_29 vdout1_29ck115 = 0 time = 580
* CHECK dout1_30 vdout1_30ck115 = 0 time = 580
* CHECK dout1_31 vdout1_31ck115 = 1.0 time = 580
* CHECK dout1_0 vdout1_0ck116 = 1.0 time = 585
* CHECK dout1_1 vdout1_1ck116 = 1.0 time = 585
* CHECK dout1_2 vdout1_2ck116 = 1.0 time = 585
* CHECK dout1_3 vdout1_3ck116 = 1.0 time = 585
* CHECK dout1_4 vdout1_4ck116 = 0 time = 585
* CHECK dout1_5 vdout1_5ck116 = 0 time = 585
* CHECK dout1_6 vdout1_6ck116 = 0 time = 585
* CHECK dout1_7 vdout1_7ck116 = 0 time = 585
* CHECK dout1_8 vdout1_8ck116 = 1.0 time = 585
* CHECK dout1_9 vdout1_9ck116 = 1.0 time = 585
* CHECK dout1_10 vdout1_10ck116 = 1.0 time = 585
* CHECK dout1_11 vdout1_11ck116 = 1.0 time = 585
* CHECK dout1_12 vdout1_12ck116 = 1.0 time = 585
* CHECK dout1_13 vdout1_13ck116 = 1.0 time = 585
* CHECK dout1_14 vdout1_14ck116 = 1.0 time = 585
* CHECK dout1_15 vdout1_15ck116 = 1.0 time = 585
* CHECK dout1_16 vdout1_16ck116 = 1.0 time = 585
* CHECK dout1_17 vdout1_17ck116 = 0 time = 585
* CHECK dout1_18 vdout1_18ck116 = 1.0 time = 585
* CHECK dout1_19 vdout1_19ck116 = 0 time = 585
* CHECK dout1_20 vdout1_20ck116 = 1.0 time = 585
* CHECK dout1_21 vdout1_21ck116 = 0 time = 585
* CHECK dout1_22 vdout1_22ck116 = 0 time = 585
* CHECK dout1_23 vdout1_23ck116 = 0 time = 585
* CHECK dout1_24 vdout1_24ck116 = 0 time = 585
* CHECK dout1_25 vdout1_25ck116 = 0 time = 585
* CHECK dout1_26 vdout1_26ck116 = 1.0 time = 585
* CHECK dout1_27 vdout1_27ck116 = 1.0 time = 585
* CHECK dout1_28 vdout1_28ck116 = 1.0 time = 585
* CHECK dout1_29 vdout1_29ck116 = 1.0 time = 585
* CHECK dout1_30 vdout1_30ck116 = 1.0 time = 585
* CHECK dout1_31 vdout1_31ck116 = 0 time = 585
* CHECK dout0_0 vdout0_0ck117 = 1.0 time = 590
* CHECK dout0_1 vdout0_1ck117 = 1.0 time = 590
* CHECK dout0_2 vdout0_2ck117 = 1.0 time = 590
* CHECK dout0_3 vdout0_3ck117 = 1.0 time = 590
* CHECK dout0_4 vdout0_4ck117 = 0 time = 590
* CHECK dout0_5 vdout0_5ck117 = 0 time = 590
* CHECK dout0_6 vdout0_6ck117 = 0 time = 590
* CHECK dout0_7 vdout0_7ck117 = 0 time = 590
* CHECK dout0_8 vdout0_8ck117 = 1.0 time = 590
* CHECK dout0_9 vdout0_9ck117 = 1.0 time = 590
* CHECK dout0_10 vdout0_10ck117 = 1.0 time = 590
* CHECK dout0_11 vdout0_11ck117 = 1.0 time = 590
* CHECK dout0_12 vdout0_12ck117 = 1.0 time = 590
* CHECK dout0_13 vdout0_13ck117 = 1.0 time = 590
* CHECK dout0_14 vdout0_14ck117 = 1.0 time = 590
* CHECK dout0_15 vdout0_15ck117 = 1.0 time = 590
* CHECK dout0_16 vdout0_16ck117 = 1.0 time = 590
* CHECK dout0_17 vdout0_17ck117 = 0 time = 590
* CHECK dout0_18 vdout0_18ck117 = 1.0 time = 590
* CHECK dout0_19 vdout0_19ck117 = 0 time = 590
* CHECK dout0_20 vdout0_20ck117 = 1.0 time = 590
* CHECK dout0_21 vdout0_21ck117 = 0 time = 590
* CHECK dout0_22 vdout0_22ck117 = 0 time = 590
* CHECK dout0_23 vdout0_23ck117 = 0 time = 590
* CHECK dout0_24 vdout0_24ck117 = 0 time = 590
* CHECK dout0_25 vdout0_25ck117 = 0 time = 590
* CHECK dout0_26 vdout0_26ck117 = 1.0 time = 590
* CHECK dout0_27 vdout0_27ck117 = 1.0 time = 590
* CHECK dout0_28 vdout0_28ck117 = 1.0 time = 590
* CHECK dout0_29 vdout0_29ck117 = 1.0 time = 590
* CHECK dout0_30 vdout0_30ck117 = 1.0 time = 590
* CHECK dout0_31 vdout0_31ck117 = 0 time = 590
* CHECK dout0_0 vdout0_0ck118 = 1.0 time = 595
* CHECK dout0_1 vdout0_1ck118 = 1.0 time = 595
* CHECK dout0_2 vdout0_2ck118 = 1.0 time = 595
* CHECK dout0_3 vdout0_3ck118 = 1.0 time = 595
* CHECK dout0_4 vdout0_4ck118 = 0 time = 595
* CHECK dout0_5 vdout0_5ck118 = 0 time = 595
* CHECK dout0_6 vdout0_6ck118 = 0 time = 595
* CHECK dout0_7 vdout0_7ck118 = 0 time = 595
* CHECK dout0_8 vdout0_8ck118 = 1.0 time = 595
* CHECK dout0_9 vdout0_9ck118 = 1.0 time = 595
* CHECK dout0_10 vdout0_10ck118 = 1.0 time = 595
* CHECK dout0_11 vdout0_11ck118 = 1.0 time = 595
* CHECK dout0_12 vdout0_12ck118 = 1.0 time = 595
* CHECK dout0_13 vdout0_13ck118 = 1.0 time = 595
* CHECK dout0_14 vdout0_14ck118 = 1.0 time = 595
* CHECK dout0_15 vdout0_15ck118 = 1.0 time = 595
* CHECK dout0_16 vdout0_16ck118 = 1.0 time = 595
* CHECK dout0_17 vdout0_17ck118 = 0 time = 595
* CHECK dout0_18 vdout0_18ck118 = 1.0 time = 595
* CHECK dout0_19 vdout0_19ck118 = 0 time = 595
* CHECK dout0_20 vdout0_20ck118 = 1.0 time = 595
* CHECK dout0_21 vdout0_21ck118 = 0 time = 595
* CHECK dout0_22 vdout0_22ck118 = 0 time = 595
* CHECK dout0_23 vdout0_23ck118 = 0 time = 595
* CHECK dout0_24 vdout0_24ck118 = 0 time = 595
* CHECK dout0_25 vdout0_25ck118 = 0 time = 595
* CHECK dout0_26 vdout0_26ck118 = 1.0 time = 595
* CHECK dout0_27 vdout0_27ck118 = 1.0 time = 595
* CHECK dout0_28 vdout0_28ck118 = 1.0 time = 595
* CHECK dout0_29 vdout0_29ck118 = 1.0 time = 595
* CHECK dout0_30 vdout0_30ck118 = 1.0 time = 595
* CHECK dout0_31 vdout0_31ck118 = 0 time = 595
* CHECK dout0_0 vdout0_0ck119 = 1.0 time = 600
* CHECK dout0_1 vdout0_1ck119 = 1.0 time = 600
* CHECK dout0_2 vdout0_2ck119 = 1.0 time = 600
* CHECK dout0_3 vdout0_3ck119 = 1.0 time = 600
* CHECK dout0_4 vdout0_4ck119 = 0 time = 600
* CHECK dout0_5 vdout0_5ck119 = 0 time = 600
* CHECK dout0_6 vdout0_6ck119 = 1.0 time = 600
* CHECK dout0_7 vdout0_7ck119 = 0 time = 600
* CHECK dout0_8 vdout0_8ck119 = 1.0 time = 600
* CHECK dout0_9 vdout0_9ck119 = 0 time = 600
* CHECK dout0_10 vdout0_10ck119 = 1.0 time = 600
* CHECK dout0_11 vdout0_11ck119 = 1.0 time = 600
* CHECK dout0_12 vdout0_12ck119 = 1.0 time = 600
* CHECK dout0_13 vdout0_13ck119 = 1.0 time = 600
* CHECK dout0_14 vdout0_14ck119 = 0 time = 600
* CHECK dout0_15 vdout0_15ck119 = 1.0 time = 600
* CHECK dout0_16 vdout0_16ck119 = 0 time = 600
* CHECK dout0_17 vdout0_17ck119 = 1.0 time = 600
* CHECK dout0_18 vdout0_18ck119 = 1.0 time = 600
* CHECK dout0_19 vdout0_19ck119 = 0 time = 600
* CHECK dout0_20 vdout0_20ck119 = 1.0 time = 600
* CHECK dout0_21 vdout0_21ck119 = 0 time = 600
* CHECK dout0_22 vdout0_22ck119 = 1.0 time = 600
* CHECK dout0_23 vdout0_23ck119 = 0 time = 600
* CHECK dout0_24 vdout0_24ck119 = 1.0 time = 600
* CHECK dout0_25 vdout0_25ck119 = 0 time = 600
* CHECK dout0_26 vdout0_26ck119 = 1.0 time = 600
* CHECK dout0_27 vdout0_27ck119 = 0 time = 600
* CHECK dout0_28 vdout0_28ck119 = 0 time = 600
* CHECK dout0_29 vdout0_29ck119 = 1.0 time = 600
* CHECK dout0_30 vdout0_30ck119 = 0 time = 600
* CHECK dout0_31 vdout0_31ck119 = 1.0 time = 600
* CHECK dout1_0 vdout1_0ck119 = 0 time = 600
* CHECK dout1_1 vdout1_1ck119 = 0 time = 600
* CHECK dout1_2 vdout1_2ck119 = 0 time = 600
* CHECK dout1_3 vdout1_3ck119 = 1.0 time = 600
* CHECK dout1_4 vdout1_4ck119 = 1.0 time = 600
* CHECK dout1_5 vdout1_5ck119 = 1.0 time = 600
* CHECK dout1_6 vdout1_6ck119 = 0 time = 600
* CHECK dout1_7 vdout1_7ck119 = 1.0 time = 600
* CHECK dout1_8 vdout1_8ck119 = 0 time = 600
* CHECK dout1_9 vdout1_9ck119 = 1.0 time = 600
* CHECK dout1_10 vdout1_10ck119 = 0 time = 600
* CHECK dout1_11 vdout1_11ck119 = 0 time = 600
* CHECK dout1_12 vdout1_12ck119 = 0 time = 600
* CHECK dout1_13 vdout1_13ck119 = 0 time = 600
* CHECK dout1_14 vdout1_14ck119 = 1.0 time = 600
* CHECK dout1_15 vdout1_15ck119 = 0 time = 600
* CHECK dout1_16 vdout1_16ck119 = 1.0 time = 600
* CHECK dout1_17 vdout1_17ck119 = 1.0 time = 600
* CHECK dout1_18 vdout1_18ck119 = 0 time = 600
* CHECK dout1_19 vdout1_19ck119 = 0 time = 600
* CHECK dout1_20 vdout1_20ck119 = 1.0 time = 600
* CHECK dout1_21 vdout1_21ck119 = 0 time = 600
* CHECK dout1_22 vdout1_22ck119 = 0 time = 600
* CHECK dout1_23 vdout1_23ck119 = 1.0 time = 600
* CHECK dout1_24 vdout1_24ck119 = 0 time = 600
* CHECK dout1_25 vdout1_25ck119 = 1.0 time = 600
* CHECK dout1_26 vdout1_26ck119 = 1.0 time = 600
* CHECK dout1_27 vdout1_27ck119 = 0 time = 600
* CHECK dout1_28 vdout1_28ck119 = 1.0 time = 600
* CHECK dout1_29 vdout1_29ck119 = 0 time = 600
* CHECK dout1_30 vdout1_30ck119 = 0 time = 600
* CHECK dout1_31 vdout1_31ck119 = 1.0 time = 600
* CHECK dout1_0 vdout1_0ck120 = 0 time = 605
* CHECK dout1_1 vdout1_1ck120 = 0 time = 605
* CHECK dout1_2 vdout1_2ck120 = 0 time = 605
* CHECK dout1_3 vdout1_3ck120 = 1.0 time = 605
* CHECK dout1_4 vdout1_4ck120 = 1.0 time = 605
* CHECK dout1_5 vdout1_5ck120 = 1.0 time = 605
* CHECK dout1_6 vdout1_6ck120 = 0 time = 605
* CHECK dout1_7 vdout1_7ck120 = 1.0 time = 605
* CHECK dout1_8 vdout1_8ck120 = 1.0 time = 605
* CHECK dout1_9 vdout1_9ck120 = 0 time = 605
* CHECK dout1_10 vdout1_10ck120 = 1.0 time = 605
* CHECK dout1_11 vdout1_11ck120 = 1.0 time = 605
* CHECK dout1_12 vdout1_12ck120 = 0 time = 605
* CHECK dout1_13 vdout1_13ck120 = 0 time = 605
* CHECK dout1_14 vdout1_14ck120 = 0 time = 605
* CHECK dout1_15 vdout1_15ck120 = 0 time = 605
* CHECK dout1_16 vdout1_16ck120 = 1.0 time = 605
* CHECK dout1_17 vdout1_17ck120 = 1.0 time = 605
* CHECK dout1_18 vdout1_18ck120 = 0 time = 605
* CHECK dout1_19 vdout1_19ck120 = 1.0 time = 605
* CHECK dout1_20 vdout1_20ck120 = 0 time = 605
* CHECK dout1_21 vdout1_21ck120 = 0 time = 605
* CHECK dout1_22 vdout1_22ck120 = 1.0 time = 605
* CHECK dout1_23 vdout1_23ck120 = 0 time = 605
* CHECK dout1_24 vdout1_24ck120 = 1.0 time = 605
* CHECK dout1_25 vdout1_25ck120 = 0 time = 605
* CHECK dout1_26 vdout1_26ck120 = 0 time = 605
* CHECK dout1_27 vdout1_27ck120 = 1.0 time = 605
* CHECK dout1_28 vdout1_28ck120 = 0 time = 605
* CHECK dout1_29 vdout1_29ck120 = 1.0 time = 605
* CHECK dout1_30 vdout1_30ck120 = 0 time = 605
* CHECK dout1_31 vdout1_31ck120 = 1.0 time = 605
* CHECK dout0_0 vdout0_0ck121 = 1.0 time = 610
* CHECK dout0_1 vdout0_1ck121 = 1.0 time = 610
* CHECK dout0_2 vdout0_2ck121 = 0 time = 610
* CHECK dout0_3 vdout0_3ck121 = 1.0 time = 610
* CHECK dout0_4 vdout0_4ck121 = 1.0 time = 610
* CHECK dout0_5 vdout0_5ck121 = 0 time = 610
* CHECK dout0_6 vdout0_6ck121 = 1.0 time = 610
* CHECK dout0_7 vdout0_7ck121 = 0 time = 610
* CHECK dout0_8 vdout0_8ck121 = 0 time = 610
* CHECK dout0_9 vdout0_9ck121 = 0 time = 610
* CHECK dout0_10 vdout0_10ck121 = 1.0 time = 610
* CHECK dout0_11 vdout0_11ck121 = 1.0 time = 610
* CHECK dout0_12 vdout0_12ck121 = 1.0 time = 610
* CHECK dout0_13 vdout0_13ck121 = 0 time = 610
* CHECK dout0_14 vdout0_14ck121 = 0 time = 610
* CHECK dout0_15 vdout0_15ck121 = 0 time = 610
* CHECK dout0_16 vdout0_16ck121 = 0 time = 610
* CHECK dout0_17 vdout0_17ck121 = 0 time = 610
* CHECK dout0_18 vdout0_18ck121 = 0 time = 610
* CHECK dout0_19 vdout0_19ck121 = 0 time = 610
* CHECK dout0_20 vdout0_20ck121 = 0 time = 610
* CHECK dout0_21 vdout0_21ck121 = 1.0 time = 610
* CHECK dout0_22 vdout0_22ck121 = 1.0 time = 610
* CHECK dout0_23 vdout0_23ck121 = 0 time = 610
* CHECK dout0_24 vdout0_24ck121 = 0 time = 610
* CHECK dout0_25 vdout0_25ck121 = 0 time = 610
* CHECK dout0_26 vdout0_26ck121 = 1.0 time = 610
* CHECK dout0_27 vdout0_27ck121 = 1.0 time = 610
* CHECK dout0_28 vdout0_28ck121 = 1.0 time = 610
* CHECK dout0_29 vdout0_29ck121 = 0 time = 610
* CHECK dout0_30 vdout0_30ck121 = 1.0 time = 610
* CHECK dout0_31 vdout0_31ck121 = 0 time = 610
* CHECK dout0_0 vdout0_0ck122 = 1.0 time = 615
* CHECK dout0_1 vdout0_1ck122 = 0 time = 615
* CHECK dout0_2 vdout0_2ck122 = 0 time = 615
* CHECK dout0_3 vdout0_3ck122 = 1.0 time = 615
* CHECK dout0_4 vdout0_4ck122 = 0 time = 615
* CHECK dout0_5 vdout0_5ck122 = 0 time = 615
* CHECK dout0_6 vdout0_6ck122 = 1.0 time = 615
* CHECK dout0_7 vdout0_7ck122 = 0 time = 615
* CHECK dout0_8 vdout0_8ck122 = 1.0 time = 615
* CHECK dout0_9 vdout0_9ck122 = 0 time = 615
* CHECK dout0_10 vdout0_10ck122 = 0 time = 615
* CHECK dout0_11 vdout0_11ck122 = 1.0 time = 615
* CHECK dout0_12 vdout0_12ck122 = 0 time = 615
* CHECK dout0_13 vdout0_13ck122 = 1.0 time = 615
* CHECK dout0_14 vdout0_14ck122 = 1.0 time = 615
* CHECK dout0_15 vdout0_15ck122 = 0 time = 615
* CHECK dout0_16 vdout0_16ck122 = 1.0 time = 615
* CHECK dout0_17 vdout0_17ck122 = 1.0 time = 615
* CHECK dout0_18 vdout0_18ck122 = 1.0 time = 615
* CHECK dout0_19 vdout0_19ck122 = 0 time = 615
* CHECK dout0_20 vdout0_20ck122 = 0 time = 615
* CHECK dout0_21 vdout0_21ck122 = 0 time = 615
* CHECK dout0_22 vdout0_22ck122 = 1.0 time = 615
* CHECK dout0_23 vdout0_23ck122 = 0 time = 615
* CHECK dout0_24 vdout0_24ck122 = 0 time = 615
* CHECK dout0_25 vdout0_25ck122 = 1.0 time = 615
* CHECK dout0_26 vdout0_26ck122 = 1.0 time = 615
* CHECK dout0_27 vdout0_27ck122 = 1.0 time = 615
* CHECK dout0_28 vdout0_28ck122 = 1.0 time = 615
* CHECK dout0_29 vdout0_29ck122 = 0 time = 615
* CHECK dout0_30 vdout0_30ck122 = 0 time = 615
* CHECK dout0_31 vdout0_31ck122 = 0 time = 615
* CHECK dout1_0 vdout1_0ck122 = 1.0 time = 615
* CHECK dout1_1 vdout1_1ck122 = 1.0 time = 615
* CHECK dout1_2 vdout1_2ck122 = 1.0 time = 615
* CHECK dout1_3 vdout1_3ck122 = 1.0 time = 615
* CHECK dout1_4 vdout1_4ck122 = 0 time = 615
* CHECK dout1_5 vdout1_5ck122 = 0 time = 615
* CHECK dout1_6 vdout1_6ck122 = 1.0 time = 615
* CHECK dout1_7 vdout1_7ck122 = 0 time = 615
* CHECK dout1_8 vdout1_8ck122 = 1.0 time = 615
* CHECK dout1_9 vdout1_9ck122 = 0 time = 615
* CHECK dout1_10 vdout1_10ck122 = 1.0 time = 615
* CHECK dout1_11 vdout1_11ck122 = 1.0 time = 615
* CHECK dout1_12 vdout1_12ck122 = 1.0 time = 615
* CHECK dout1_13 vdout1_13ck122 = 1.0 time = 615
* CHECK dout1_14 vdout1_14ck122 = 0 time = 615
* CHECK dout1_15 vdout1_15ck122 = 1.0 time = 615
* CHECK dout1_16 vdout1_16ck122 = 0 time = 615
* CHECK dout1_17 vdout1_17ck122 = 1.0 time = 615
* CHECK dout1_18 vdout1_18ck122 = 1.0 time = 615
* CHECK dout1_19 vdout1_19ck122 = 0 time = 615
* CHECK dout1_20 vdout1_20ck122 = 1.0 time = 615
* CHECK dout1_21 vdout1_21ck122 = 0 time = 615
* CHECK dout1_22 vdout1_22ck122 = 1.0 time = 615
* CHECK dout1_23 vdout1_23ck122 = 0 time = 615
* CHECK dout1_24 vdout1_24ck122 = 1.0 time = 615
* CHECK dout1_25 vdout1_25ck122 = 0 time = 615
* CHECK dout1_26 vdout1_26ck122 = 1.0 time = 615
* CHECK dout1_27 vdout1_27ck122 = 0 time = 615
* CHECK dout1_28 vdout1_28ck122 = 0 time = 615
* CHECK dout1_29 vdout1_29ck122 = 1.0 time = 615
* CHECK dout1_30 vdout1_30ck122 = 0 time = 615
* CHECK dout1_31 vdout1_31ck122 = 1.0 time = 615
* CHECK dout1_0 vdout1_0ck125 = 0 time = 630
* CHECK dout1_1 vdout1_1ck125 = 0 time = 630
* CHECK dout1_2 vdout1_2ck125 = 0 time = 630
* CHECK dout1_3 vdout1_3ck125 = 1.0 time = 630
* CHECK dout1_4 vdout1_4ck125 = 1.0 time = 630
* CHECK dout1_5 vdout1_5ck125 = 1.0 time = 630
* CHECK dout1_6 vdout1_6ck125 = 0 time = 630
* CHECK dout1_7 vdout1_7ck125 = 1.0 time = 630
* CHECK dout1_8 vdout1_8ck125 = 1.0 time = 630
* CHECK dout1_9 vdout1_9ck125 = 0 time = 630
* CHECK dout1_10 vdout1_10ck125 = 1.0 time = 630
* CHECK dout1_11 vdout1_11ck125 = 1.0 time = 630
* CHECK dout1_12 vdout1_12ck125 = 0 time = 630
* CHECK dout1_13 vdout1_13ck125 = 0 time = 630
* CHECK dout1_14 vdout1_14ck125 = 0 time = 630
* CHECK dout1_15 vdout1_15ck125 = 0 time = 630
* CHECK dout1_16 vdout1_16ck125 = 1.0 time = 630
* CHECK dout1_17 vdout1_17ck125 = 1.0 time = 630
* CHECK dout1_18 vdout1_18ck125 = 0 time = 630
* CHECK dout1_19 vdout1_19ck125 = 1.0 time = 630
* CHECK dout1_20 vdout1_20ck125 = 0 time = 630
* CHECK dout1_21 vdout1_21ck125 = 0 time = 630
* CHECK dout1_22 vdout1_22ck125 = 1.0 time = 630
* CHECK dout1_23 vdout1_23ck125 = 0 time = 630
* CHECK dout1_24 vdout1_24ck125 = 1.0 time = 630
* CHECK dout1_25 vdout1_25ck125 = 0 time = 630
* CHECK dout1_26 vdout1_26ck125 = 0 time = 630
* CHECK dout1_27 vdout1_27ck125 = 1.0 time = 630
* CHECK dout1_28 vdout1_28ck125 = 0 time = 630
* CHECK dout1_29 vdout1_29ck125 = 1.0 time = 630
* CHECK dout1_30 vdout1_30ck125 = 0 time = 630
* CHECK dout1_31 vdout1_31ck125 = 1.0 time = 630
* CHECK dout1_0 vdout1_0ck126 = 1.0 time = 635
* CHECK dout1_1 vdout1_1ck126 = 1.0 time = 635
* CHECK dout1_2 vdout1_2ck126 = 1.0 time = 635
* CHECK dout1_3 vdout1_3ck126 = 1.0 time = 635
* CHECK dout1_4 vdout1_4ck126 = 0 time = 635
* CHECK dout1_5 vdout1_5ck126 = 0 time = 635
* CHECK dout1_6 vdout1_6ck126 = 1.0 time = 635
* CHECK dout1_7 vdout1_7ck126 = 0 time = 635
* CHECK dout1_8 vdout1_8ck126 = 1.0 time = 635
* CHECK dout1_9 vdout1_9ck126 = 0 time = 635
* CHECK dout1_10 vdout1_10ck126 = 1.0 time = 635
* CHECK dout1_11 vdout1_11ck126 = 1.0 time = 635
* CHECK dout1_12 vdout1_12ck126 = 1.0 time = 635
* CHECK dout1_13 vdout1_13ck126 = 1.0 time = 635
* CHECK dout1_14 vdout1_14ck126 = 0 time = 635
* CHECK dout1_15 vdout1_15ck126 = 1.0 time = 635
* CHECK dout1_16 vdout1_16ck126 = 0 time = 635
* CHECK dout1_17 vdout1_17ck126 = 1.0 time = 635
* CHECK dout1_18 vdout1_18ck126 = 1.0 time = 635
* CHECK dout1_19 vdout1_19ck126 = 0 time = 635
* CHECK dout1_20 vdout1_20ck126 = 1.0 time = 635
* CHECK dout1_21 vdout1_21ck126 = 0 time = 635
* CHECK dout1_22 vdout1_22ck126 = 1.0 time = 635
* CHECK dout1_23 vdout1_23ck126 = 0 time = 635
* CHECK dout1_24 vdout1_24ck126 = 1.0 time = 635
* CHECK dout1_25 vdout1_25ck126 = 0 time = 635
* CHECK dout1_26 vdout1_26ck126 = 1.0 time = 635
* CHECK dout1_27 vdout1_27ck126 = 0 time = 635
* CHECK dout1_28 vdout1_28ck126 = 0 time = 635
* CHECK dout1_29 vdout1_29ck126 = 1.0 time = 635
* CHECK dout1_30 vdout1_30ck126 = 0 time = 635
* CHECK dout1_31 vdout1_31ck126 = 1.0 time = 635
* CHECK dout0_0 vdout0_0ck127 = 1.0 time = 640
* CHECK dout0_1 vdout0_1ck127 = 0 time = 640
* CHECK dout0_2 vdout0_2ck127 = 0 time = 640
* CHECK dout0_3 vdout0_3ck127 = 0 time = 640
* CHECK dout0_4 vdout0_4ck127 = 1.0 time = 640
* CHECK dout0_5 vdout0_5ck127 = 1.0 time = 640
* CHECK dout0_6 vdout0_6ck127 = 1.0 time = 640
* CHECK dout0_7 vdout0_7ck127 = 0 time = 640
* CHECK dout0_8 vdout0_8ck127 = 1.0 time = 640
* CHECK dout0_9 vdout0_9ck127 = 0 time = 640
* CHECK dout0_10 vdout0_10ck127 = 0 time = 640
* CHECK dout0_11 vdout0_11ck127 = 1.0 time = 640
* CHECK dout0_12 vdout0_12ck127 = 1.0 time = 640
* CHECK dout0_13 vdout0_13ck127 = 0 time = 640
* CHECK dout0_14 vdout0_14ck127 = 1.0 time = 640
* CHECK dout0_15 vdout0_15ck127 = 1.0 time = 640
* CHECK dout0_16 vdout0_16ck127 = 0 time = 640
* CHECK dout0_17 vdout0_17ck127 = 1.0 time = 640
* CHECK dout0_18 vdout0_18ck127 = 0 time = 640
* CHECK dout0_19 vdout0_19ck127 = 1.0 time = 640
* CHECK dout0_20 vdout0_20ck127 = 0 time = 640
* CHECK dout0_21 vdout0_21ck127 = 1.0 time = 640
* CHECK dout0_22 vdout0_22ck127 = 0 time = 640
* CHECK dout0_23 vdout0_23ck127 = 0 time = 640
* CHECK dout0_24 vdout0_24ck127 = 0 time = 640
* CHECK dout0_25 vdout0_25ck127 = 1.0 time = 640
* CHECK dout0_26 vdout0_26ck127 = 0 time = 640
* CHECK dout0_27 vdout0_27ck127 = 0 time = 640
* CHECK dout0_28 vdout0_28ck127 = 0 time = 640
* CHECK dout0_29 vdout0_29ck127 = 0 time = 640
* CHECK dout0_30 vdout0_30ck127 = 1.0 time = 640
* CHECK dout0_31 vdout0_31ck127 = 1.0 time = 640
* CHECK dout0_0 vdout0_0ck128 = 0 time = 645
* CHECK dout0_1 vdout0_1ck128 = 0 time = 645
* CHECK dout0_2 vdout0_2ck128 = 0 time = 645
* CHECK dout0_3 vdout0_3ck128 = 1.0 time = 645
* CHECK dout0_4 vdout0_4ck128 = 1.0 time = 645
* CHECK dout0_5 vdout0_5ck128 = 1.0 time = 645
* CHECK dout0_6 vdout0_6ck128 = 0 time = 645
* CHECK dout0_7 vdout0_7ck128 = 1.0 time = 645
* CHECK dout0_8 vdout0_8ck128 = 0 time = 645
* CHECK dout0_9 vdout0_9ck128 = 1.0 time = 645
* CHECK dout0_10 vdout0_10ck128 = 0 time = 645
* CHECK dout0_11 vdout0_11ck128 = 0 time = 645
* CHECK dout0_12 vdout0_12ck128 = 0 time = 645
* CHECK dout0_13 vdout0_13ck128 = 0 time = 645
* CHECK dout0_14 vdout0_14ck128 = 1.0 time = 645
* CHECK dout0_15 vdout0_15ck128 = 0 time = 645
* CHECK dout0_16 vdout0_16ck128 = 1.0 time = 645
* CHECK dout0_17 vdout0_17ck128 = 1.0 time = 645
* CHECK dout0_18 vdout0_18ck128 = 0 time = 645
* CHECK dout0_19 vdout0_19ck128 = 0 time = 645
* CHECK dout0_20 vdout0_20ck128 = 1.0 time = 645
* CHECK dout0_21 vdout0_21ck128 = 0 time = 645
* CHECK dout0_22 vdout0_22ck128 = 0 time = 645
* CHECK dout0_23 vdout0_23ck128 = 1.0 time = 645
* CHECK dout0_24 vdout0_24ck128 = 0 time = 645
* CHECK dout0_25 vdout0_25ck128 = 1.0 time = 645
* CHECK dout0_26 vdout0_26ck128 = 1.0 time = 645
* CHECK dout0_27 vdout0_27ck128 = 0 time = 645
* CHECK dout0_28 vdout0_28ck128 = 1.0 time = 645
* CHECK dout0_29 vdout0_29ck128 = 0 time = 645
* CHECK dout0_30 vdout0_30ck128 = 0 time = 645
* CHECK dout0_31 vdout0_31ck128 = 1.0 time = 645
* CHECK dout1_0 vdout1_0ck129 = 1.0 time = 650
* CHECK dout1_1 vdout1_1ck129 = 0 time = 650
* CHECK dout1_2 vdout1_2ck129 = 0 time = 650
* CHECK dout1_3 vdout1_3ck129 = 1.0 time = 650
* CHECK dout1_4 vdout1_4ck129 = 0 time = 650
* CHECK dout1_5 vdout1_5ck129 = 0 time = 650
* CHECK dout1_6 vdout1_6ck129 = 1.0 time = 650
* CHECK dout1_7 vdout1_7ck129 = 0 time = 650
* CHECK dout1_8 vdout1_8ck129 = 1.0 time = 650
* CHECK dout1_9 vdout1_9ck129 = 0 time = 650
* CHECK dout1_10 vdout1_10ck129 = 0 time = 650
* CHECK dout1_11 vdout1_11ck129 = 1.0 time = 650
* CHECK dout1_12 vdout1_12ck129 = 0 time = 650
* CHECK dout1_13 vdout1_13ck129 = 1.0 time = 650
* CHECK dout1_14 vdout1_14ck129 = 1.0 time = 650
* CHECK dout1_15 vdout1_15ck129 = 0 time = 650
* CHECK dout1_16 vdout1_16ck129 = 1.0 time = 650
* CHECK dout1_17 vdout1_17ck129 = 1.0 time = 650
* CHECK dout1_18 vdout1_18ck129 = 1.0 time = 650
* CHECK dout1_19 vdout1_19ck129 = 0 time = 650
* CHECK dout1_20 vdout1_20ck129 = 0 time = 650
* CHECK dout1_21 vdout1_21ck129 = 0 time = 650
* CHECK dout1_22 vdout1_22ck129 = 1.0 time = 650
* CHECK dout1_23 vdout1_23ck129 = 0 time = 650
* CHECK dout1_24 vdout1_24ck129 = 0 time = 650
* CHECK dout1_25 vdout1_25ck129 = 1.0 time = 650
* CHECK dout1_26 vdout1_26ck129 = 1.0 time = 650
* CHECK dout1_27 vdout1_27ck129 = 1.0 time = 650
* CHECK dout1_28 vdout1_28ck129 = 1.0 time = 650
* CHECK dout1_29 vdout1_29ck129 = 0 time = 650
* CHECK dout1_30 vdout1_30ck129 = 0 time = 650
* CHECK dout1_31 vdout1_31ck129 = 0 time = 650
* CHECK dout1_0 vdout1_0ck130 = 1.0 time = 655
* CHECK dout1_1 vdout1_1ck130 = 1.0 time = 655
* CHECK dout1_2 vdout1_2ck130 = 1.0 time = 655
* CHECK dout1_3 vdout1_3ck130 = 1.0 time = 655
* CHECK dout1_4 vdout1_4ck130 = 0 time = 655
* CHECK dout1_5 vdout1_5ck130 = 0 time = 655
* CHECK dout1_6 vdout1_6ck130 = 1.0 time = 655
* CHECK dout1_7 vdout1_7ck130 = 0 time = 655
* CHECK dout1_8 vdout1_8ck130 = 1.0 time = 655
* CHECK dout1_9 vdout1_9ck130 = 0 time = 655
* CHECK dout1_10 vdout1_10ck130 = 1.0 time = 655
* CHECK dout1_11 vdout1_11ck130 = 1.0 time = 655
* CHECK dout1_12 vdout1_12ck130 = 1.0 time = 655
* CHECK dout1_13 vdout1_13ck130 = 1.0 time = 655
* CHECK dout1_14 vdout1_14ck130 = 0 time = 655
* CHECK dout1_15 vdout1_15ck130 = 1.0 time = 655
* CHECK dout1_16 vdout1_16ck130 = 0 time = 655
* CHECK dout1_17 vdout1_17ck130 = 1.0 time = 655
* CHECK dout1_18 vdout1_18ck130 = 1.0 time = 655
* CHECK dout1_19 vdout1_19ck130 = 0 time = 655
* CHECK dout1_20 vdout1_20ck130 = 1.0 time = 655
* CHECK dout1_21 vdout1_21ck130 = 0 time = 655
* CHECK dout1_22 vdout1_22ck130 = 1.0 time = 655
* CHECK dout1_23 vdout1_23ck130 = 0 time = 655
* CHECK dout1_24 vdout1_24ck130 = 1.0 time = 655
* CHECK dout1_25 vdout1_25ck130 = 0 time = 655
* CHECK dout1_26 vdout1_26ck130 = 1.0 time = 655
* CHECK dout1_27 vdout1_27ck130 = 0 time = 655
* CHECK dout1_28 vdout1_28ck130 = 0 time = 655
* CHECK dout1_29 vdout1_29ck130 = 1.0 time = 655
* CHECK dout1_30 vdout1_30ck130 = 0 time = 655
* CHECK dout1_31 vdout1_31ck130 = 1.0 time = 655
* CHECK dout0_0 vdout0_0ck131 = 1.0 time = 660
* CHECK dout0_1 vdout0_1ck131 = 1.0 time = 660
* CHECK dout0_2 vdout0_2ck131 = 0 time = 660
* CHECK dout0_3 vdout0_3ck131 = 1.0 time = 660
* CHECK dout0_4 vdout0_4ck131 = 1.0 time = 660
* CHECK dout0_5 vdout0_5ck131 = 0 time = 660
* CHECK dout0_6 vdout0_6ck131 = 1.0 time = 660
* CHECK dout0_7 vdout0_7ck131 = 0 time = 660
* CHECK dout0_8 vdout0_8ck131 = 0 time = 660
* CHECK dout0_9 vdout0_9ck131 = 0 time = 660
* CHECK dout0_10 vdout0_10ck131 = 1.0 time = 660
* CHECK dout0_11 vdout0_11ck131 = 1.0 time = 660
* CHECK dout0_12 vdout0_12ck131 = 1.0 time = 660
* CHECK dout0_13 vdout0_13ck131 = 0 time = 660
* CHECK dout0_14 vdout0_14ck131 = 0 time = 660
* CHECK dout0_15 vdout0_15ck131 = 0 time = 660
* CHECK dout0_16 vdout0_16ck131 = 0 time = 660
* CHECK dout0_17 vdout0_17ck131 = 0 time = 660
* CHECK dout0_18 vdout0_18ck131 = 0 time = 660
* CHECK dout0_19 vdout0_19ck131 = 0 time = 660
* CHECK dout0_20 vdout0_20ck131 = 0 time = 660
* CHECK dout0_21 vdout0_21ck131 = 1.0 time = 660
* CHECK dout0_22 vdout0_22ck131 = 1.0 time = 660
* CHECK dout0_23 vdout0_23ck131 = 0 time = 660
* CHECK dout0_24 vdout0_24ck131 = 0 time = 660
* CHECK dout0_25 vdout0_25ck131 = 0 time = 660
* CHECK dout0_26 vdout0_26ck131 = 1.0 time = 660
* CHECK dout0_27 vdout0_27ck131 = 1.0 time = 660
* CHECK dout0_28 vdout0_28ck131 = 1.0 time = 660
* CHECK dout0_29 vdout0_29ck131 = 0 time = 660
* CHECK dout0_30 vdout0_30ck131 = 1.0 time = 660
* CHECK dout0_31 vdout0_31ck131 = 0 time = 660
* CHECK dout0_0 vdout0_0ck132 = 1.0 time = 665
* CHECK dout0_1 vdout0_1ck132 = 1.0 time = 665
* CHECK dout0_2 vdout0_2ck132 = 0 time = 665
* CHECK dout0_3 vdout0_3ck132 = 1.0 time = 665
* CHECK dout0_4 vdout0_4ck132 = 1.0 time = 665
* CHECK dout0_5 vdout0_5ck132 = 0 time = 665
* CHECK dout0_6 vdout0_6ck132 = 1.0 time = 665
* CHECK dout0_7 vdout0_7ck132 = 0 time = 665
* CHECK dout0_8 vdout0_8ck132 = 0 time = 665
* CHECK dout0_9 vdout0_9ck132 = 0 time = 665
* CHECK dout0_10 vdout0_10ck132 = 1.0 time = 665
* CHECK dout0_11 vdout0_11ck132 = 1.0 time = 665
* CHECK dout0_12 vdout0_12ck132 = 1.0 time = 665
* CHECK dout0_13 vdout0_13ck132 = 0 time = 665
* CHECK dout0_14 vdout0_14ck132 = 0 time = 665
* CHECK dout0_15 vdout0_15ck132 = 0 time = 665
* CHECK dout0_16 vdout0_16ck132 = 0 time = 665
* CHECK dout0_17 vdout0_17ck132 = 0 time = 665
* CHECK dout0_18 vdout0_18ck132 = 0 time = 665
* CHECK dout0_19 vdout0_19ck132 = 0 time = 665
* CHECK dout0_20 vdout0_20ck132 = 0 time = 665
* CHECK dout0_21 vdout0_21ck132 = 1.0 time = 665
* CHECK dout0_22 vdout0_22ck132 = 1.0 time = 665
* CHECK dout0_23 vdout0_23ck132 = 0 time = 665
* CHECK dout0_24 vdout0_24ck132 = 0 time = 665
* CHECK dout0_25 vdout0_25ck132 = 0 time = 665
* CHECK dout0_26 vdout0_26ck132 = 1.0 time = 665
* CHECK dout0_27 vdout0_27ck132 = 1.0 time = 665
* CHECK dout0_28 vdout0_28ck132 = 1.0 time = 665
* CHECK dout0_29 vdout0_29ck132 = 0 time = 665
* CHECK dout0_30 vdout0_30ck132 = 1.0 time = 665
* CHECK dout0_31 vdout0_31ck132 = 0 time = 665
* CHECK dout1_0 vdout1_0ck132 = 1.0 time = 665
* CHECK dout1_1 vdout1_1ck132 = 1.0 time = 665
* CHECK dout1_2 vdout1_2ck132 = 1.0 time = 665
* CHECK dout1_3 vdout1_3ck132 = 1.0 time = 665
* CHECK dout1_4 vdout1_4ck132 = 0 time = 665
* CHECK dout1_5 vdout1_5ck132 = 0 time = 665
* CHECK dout1_6 vdout1_6ck132 = 1.0 time = 665
* CHECK dout1_7 vdout1_7ck132 = 0 time = 665
* CHECK dout1_8 vdout1_8ck132 = 1.0 time = 665
* CHECK dout1_9 vdout1_9ck132 = 0 time = 665
* CHECK dout1_10 vdout1_10ck132 = 1.0 time = 665
* CHECK dout1_11 vdout1_11ck132 = 1.0 time = 665
* CHECK dout1_12 vdout1_12ck132 = 1.0 time = 665
* CHECK dout1_13 vdout1_13ck132 = 1.0 time = 665
* CHECK dout1_14 vdout1_14ck132 = 0 time = 665
* CHECK dout1_15 vdout1_15ck132 = 1.0 time = 665
* CHECK dout1_16 vdout1_16ck132 = 0 time = 665
* CHECK dout1_17 vdout1_17ck132 = 1.0 time = 665
* CHECK dout1_18 vdout1_18ck132 = 1.0 time = 665
* CHECK dout1_19 vdout1_19ck132 = 0 time = 665
* CHECK dout1_20 vdout1_20ck132 = 1.0 time = 665
* CHECK dout1_21 vdout1_21ck132 = 0 time = 665
* CHECK dout1_22 vdout1_22ck132 = 1.0 time = 665
* CHECK dout1_23 vdout1_23ck132 = 0 time = 665
* CHECK dout1_24 vdout1_24ck132 = 1.0 time = 665
* CHECK dout1_25 vdout1_25ck132 = 0 time = 665
* CHECK dout1_26 vdout1_26ck132 = 1.0 time = 665
* CHECK dout1_27 vdout1_27ck132 = 0 time = 665
* CHECK dout1_28 vdout1_28ck132 = 0 time = 665
* CHECK dout1_29 vdout1_29ck132 = 1.0 time = 665
* CHECK dout1_30 vdout1_30ck132 = 0 time = 665
* CHECK dout1_31 vdout1_31ck132 = 1.0 time = 665
* CHECK dout0_0 vdout0_0ck133 = 0 time = 670
* CHECK dout0_1 vdout0_1ck133 = 0 time = 670
* CHECK dout0_2 vdout0_2ck133 = 0 time = 670
* CHECK dout0_3 vdout0_3ck133 = 1.0 time = 670
* CHECK dout0_4 vdout0_4ck133 = 1.0 time = 670
* CHECK dout0_5 vdout0_5ck133 = 1.0 time = 670
* CHECK dout0_6 vdout0_6ck133 = 0 time = 670
* CHECK dout0_7 vdout0_7ck133 = 1.0 time = 670
* CHECK dout0_8 vdout0_8ck133 = 1.0 time = 670
* CHECK dout0_9 vdout0_9ck133 = 0 time = 670
* CHECK dout0_10 vdout0_10ck133 = 1.0 time = 670
* CHECK dout0_11 vdout0_11ck133 = 1.0 time = 670
* CHECK dout0_12 vdout0_12ck133 = 0 time = 670
* CHECK dout0_13 vdout0_13ck133 = 0 time = 670
* CHECK dout0_14 vdout0_14ck133 = 0 time = 670
* CHECK dout0_15 vdout0_15ck133 = 0 time = 670
* CHECK dout0_16 vdout0_16ck133 = 1.0 time = 670
* CHECK dout0_17 vdout0_17ck133 = 1.0 time = 670
* CHECK dout0_18 vdout0_18ck133 = 0 time = 670
* CHECK dout0_19 vdout0_19ck133 = 1.0 time = 670
* CHECK dout0_20 vdout0_20ck133 = 0 time = 670
* CHECK dout0_21 vdout0_21ck133 = 0 time = 670
* CHECK dout0_22 vdout0_22ck133 = 1.0 time = 670
* CHECK dout0_23 vdout0_23ck133 = 0 time = 670
* CHECK dout0_24 vdout0_24ck133 = 1.0 time = 670
* CHECK dout0_25 vdout0_25ck133 = 0 time = 670
* CHECK dout0_26 vdout0_26ck133 = 0 time = 670
* CHECK dout0_27 vdout0_27ck133 = 1.0 time = 670
* CHECK dout0_28 vdout0_28ck133 = 0 time = 670
* CHECK dout0_29 vdout0_29ck133 = 1.0 time = 670
* CHECK dout0_30 vdout0_30ck133 = 0 time = 670
* CHECK dout0_31 vdout0_31ck133 = 1.0 time = 670
* CHECK dout1_0 vdout1_0ck133 = 0 time = 670
* CHECK dout1_1 vdout1_1ck133 = 0 time = 670
* CHECK dout1_2 vdout1_2ck133 = 1.0 time = 670
* CHECK dout1_3 vdout1_3ck133 = 1.0 time = 670
* CHECK dout1_4 vdout1_4ck133 = 0 time = 670
* CHECK dout1_5 vdout1_5ck133 = 0 time = 670
* CHECK dout1_6 vdout1_6ck133 = 1.0 time = 670
* CHECK dout1_7 vdout1_7ck133 = 1.0 time = 670
* CHECK dout1_8 vdout1_8ck133 = 0 time = 670
* CHECK dout1_9 vdout1_9ck133 = 0 time = 670
* CHECK dout1_10 vdout1_10ck133 = 0 time = 670
* CHECK dout1_11 vdout1_11ck133 = 0 time = 670
* CHECK dout1_12 vdout1_12ck133 = 0 time = 670
* CHECK dout1_13 vdout1_13ck133 = 1.0 time = 670
* CHECK dout1_14 vdout1_14ck133 = 0 time = 670
* CHECK dout1_15 vdout1_15ck133 = 0 time = 670
* CHECK dout1_16 vdout1_16ck133 = 0 time = 670
* CHECK dout1_17 vdout1_17ck133 = 1.0 time = 670
* CHECK dout1_18 vdout1_18ck133 = 0 time = 670
* CHECK dout1_19 vdout1_19ck133 = 0 time = 670
* CHECK dout1_20 vdout1_20ck133 = 0 time = 670
* CHECK dout1_21 vdout1_21ck133 = 1.0 time = 670
* CHECK dout1_22 vdout1_22ck133 = 0 time = 670
* CHECK dout1_23 vdout1_23ck133 = 1.0 time = 670
* CHECK dout1_24 vdout1_24ck133 = 1.0 time = 670
* CHECK dout1_25 vdout1_25ck133 = 0 time = 670
* CHECK dout1_26 vdout1_26ck133 = 1.0 time = 670
* CHECK dout1_27 vdout1_27ck133 = 0 time = 670
* CHECK dout1_28 vdout1_28ck133 = 1.0 time = 670
* CHECK dout1_29 vdout1_29ck133 = 1.0 time = 670
* CHECK dout1_30 vdout1_30ck133 = 0 time = 670
* CHECK dout1_31 vdout1_31ck133 = 0 time = 670
* CHECK dout0_0 vdout0_0ck134 = 0 time = 675
* CHECK dout0_1 vdout0_1ck134 = 0 time = 675
* CHECK dout0_2 vdout0_2ck134 = 0 time = 675
* CHECK dout0_3 vdout0_3ck134 = 0 time = 675
* CHECK dout0_4 vdout0_4ck134 = 0 time = 675
* CHECK dout0_5 vdout0_5ck134 = 0 time = 675
* CHECK dout0_6 vdout0_6ck134 = 1.0 time = 675
* CHECK dout0_7 vdout0_7ck134 = 1.0 time = 675
* CHECK dout0_8 vdout0_8ck134 = 0 time = 675
* CHECK dout0_9 vdout0_9ck134 = 1.0 time = 675
* CHECK dout0_10 vdout0_10ck134 = 0 time = 675
* CHECK dout0_11 vdout0_11ck134 = 1.0 time = 675
* CHECK dout0_12 vdout0_12ck134 = 1.0 time = 675
* CHECK dout0_13 vdout0_13ck134 = 0 time = 675
* CHECK dout0_14 vdout0_14ck134 = 1.0 time = 675
* CHECK dout0_15 vdout0_15ck134 = 1.0 time = 675
* CHECK dout0_16 vdout0_16ck134 = 1.0 time = 675
* CHECK dout0_17 vdout0_17ck134 = 1.0 time = 675
* CHECK dout0_18 vdout0_18ck134 = 0 time = 675
* CHECK dout0_19 vdout0_19ck134 = 0 time = 675
* CHECK dout0_20 vdout0_20ck134 = 1.0 time = 675
* CHECK dout0_21 vdout0_21ck134 = 1.0 time = 675
* CHECK dout0_22 vdout0_22ck134 = 0 time = 675
* CHECK dout0_23 vdout0_23ck134 = 1.0 time = 675
* CHECK dout0_24 vdout0_24ck134 = 0 time = 675
* CHECK dout0_25 vdout0_25ck134 = 0 time = 675
* CHECK dout0_26 vdout0_26ck134 = 1.0 time = 675
* CHECK dout0_27 vdout0_27ck134 = 1.0 time = 675
* CHECK dout0_28 vdout0_28ck134 = 1.0 time = 675
* CHECK dout0_29 vdout0_29ck134 = 1.0 time = 675
* CHECK dout0_30 vdout0_30ck134 = 1.0 time = 675
* CHECK dout0_31 vdout0_31ck134 = 0 time = 675
* CHECK dout1_0 vdout1_0ck134 = 1.0 time = 675
* CHECK dout1_1 vdout1_1ck134 = 0 time = 675
* CHECK dout1_2 vdout1_2ck134 = 0 time = 675
* CHECK dout1_3 vdout1_3ck134 = 0 time = 675
* CHECK dout1_4 vdout1_4ck134 = 1.0 time = 675
* CHECK dout1_5 vdout1_5ck134 = 1.0 time = 675
* CHECK dout1_6 vdout1_6ck134 = 1.0 time = 675
* CHECK dout1_7 vdout1_7ck134 = 0 time = 675
* CHECK dout1_8 vdout1_8ck134 = 1.0 time = 675
* CHECK dout1_9 vdout1_9ck134 = 0 time = 675
* CHECK dout1_10 vdout1_10ck134 = 0 time = 675
* CHECK dout1_11 vdout1_11ck134 = 1.0 time = 675
* CHECK dout1_12 vdout1_12ck134 = 1.0 time = 675
* CHECK dout1_13 vdout1_13ck134 = 0 time = 675
* CHECK dout1_14 vdout1_14ck134 = 1.0 time = 675
* CHECK dout1_15 vdout1_15ck134 = 1.0 time = 675
* CHECK dout1_16 vdout1_16ck134 = 0 time = 675
* CHECK dout1_17 vdout1_17ck134 = 1.0 time = 675
* CHECK dout1_18 vdout1_18ck134 = 0 time = 675
* CHECK dout1_19 vdout1_19ck134 = 1.0 time = 675
* CHECK dout1_20 vdout1_20ck134 = 0 time = 675
* CHECK dout1_21 vdout1_21ck134 = 1.0 time = 675
* CHECK dout1_22 vdout1_22ck134 = 0 time = 675
* CHECK dout1_23 vdout1_23ck134 = 0 time = 675
* CHECK dout1_24 vdout1_24ck134 = 0 time = 675
* CHECK dout1_25 vdout1_25ck134 = 1.0 time = 675
* CHECK dout1_26 vdout1_26ck134 = 0 time = 675
* CHECK dout1_27 vdout1_27ck134 = 0 time = 675
* CHECK dout1_28 vdout1_28ck134 = 0 time = 675
* CHECK dout1_29 vdout1_29ck134 = 0 time = 675
* CHECK dout1_30 vdout1_30ck134 = 1.0 time = 675
* CHECK dout1_31 vdout1_31ck134 = 1.0 time = 675
* CHECK dout0_0 vdout0_0ck135 = 1.0 time = 680
* CHECK dout0_1 vdout0_1ck135 = 0 time = 680
* CHECK dout0_2 vdout0_2ck135 = 0 time = 680
* CHECK dout0_3 vdout0_3ck135 = 1.0 time = 680
* CHECK dout0_4 vdout0_4ck135 = 0 time = 680
* CHECK dout0_5 vdout0_5ck135 = 0 time = 680
* CHECK dout0_6 vdout0_6ck135 = 1.0 time = 680
* CHECK dout0_7 vdout0_7ck135 = 0 time = 680
* CHECK dout0_8 vdout0_8ck135 = 1.0 time = 680
* CHECK dout0_9 vdout0_9ck135 = 0 time = 680
* CHECK dout0_10 vdout0_10ck135 = 0 time = 680
* CHECK dout0_11 vdout0_11ck135 = 1.0 time = 680
* CHECK dout0_12 vdout0_12ck135 = 0 time = 680
* CHECK dout0_13 vdout0_13ck135 = 1.0 time = 680
* CHECK dout0_14 vdout0_14ck135 = 1.0 time = 680
* CHECK dout0_15 vdout0_15ck135 = 0 time = 680
* CHECK dout0_16 vdout0_16ck135 = 1.0 time = 680
* CHECK dout0_17 vdout0_17ck135 = 1.0 time = 680
* CHECK dout0_18 vdout0_18ck135 = 1.0 time = 680
* CHECK dout0_19 vdout0_19ck135 = 0 time = 680
* CHECK dout0_20 vdout0_20ck135 = 0 time = 680
* CHECK dout0_21 vdout0_21ck135 = 0 time = 680
* CHECK dout0_22 vdout0_22ck135 = 1.0 time = 680
* CHECK dout0_23 vdout0_23ck135 = 0 time = 680
* CHECK dout0_24 vdout0_24ck135 = 0 time = 680
* CHECK dout0_25 vdout0_25ck135 = 1.0 time = 680
* CHECK dout0_26 vdout0_26ck135 = 1.0 time = 680
* CHECK dout0_27 vdout0_27ck135 = 1.0 time = 680
* CHECK dout0_28 vdout0_28ck135 = 1.0 time = 680
* CHECK dout0_29 vdout0_29ck135 = 0 time = 680
* CHECK dout0_30 vdout0_30ck135 = 0 time = 680
* CHECK dout0_31 vdout0_31ck135 = 0 time = 680
* CHECK dout0_0 vdout0_0ck137 = 1.0 time = 690
* CHECK dout0_1 vdout0_1ck137 = 1.0 time = 690
* CHECK dout0_2 vdout0_2ck137 = 0 time = 690
* CHECK dout0_3 vdout0_3ck137 = 1.0 time = 690
* CHECK dout0_4 vdout0_4ck137 = 1.0 time = 690
* CHECK dout0_5 vdout0_5ck137 = 0 time = 690
* CHECK dout0_6 vdout0_6ck137 = 1.0 time = 690
* CHECK dout0_7 vdout0_7ck137 = 0 time = 690
* CHECK dout0_8 vdout0_8ck137 = 0 time = 690
* CHECK dout0_9 vdout0_9ck137 = 0 time = 690
* CHECK dout0_10 vdout0_10ck137 = 1.0 time = 690
* CHECK dout0_11 vdout0_11ck137 = 1.0 time = 690
* CHECK dout0_12 vdout0_12ck137 = 1.0 time = 690
* CHECK dout0_13 vdout0_13ck137 = 0 time = 690
* CHECK dout0_14 vdout0_14ck137 = 0 time = 690
* CHECK dout0_15 vdout0_15ck137 = 0 time = 690
* CHECK dout0_16 vdout0_16ck137 = 0 time = 690
* CHECK dout0_17 vdout0_17ck137 = 0 time = 690
* CHECK dout0_18 vdout0_18ck137 = 0 time = 690
* CHECK dout0_19 vdout0_19ck137 = 0 time = 690
* CHECK dout0_20 vdout0_20ck137 = 0 time = 690
* CHECK dout0_21 vdout0_21ck137 = 1.0 time = 690
* CHECK dout0_22 vdout0_22ck137 = 1.0 time = 690
* CHECK dout0_23 vdout0_23ck137 = 0 time = 690
* CHECK dout0_24 vdout0_24ck137 = 0 time = 690
* CHECK dout0_25 vdout0_25ck137 = 0 time = 690
* CHECK dout0_26 vdout0_26ck137 = 1.0 time = 690
* CHECK dout0_27 vdout0_27ck137 = 1.0 time = 690
* CHECK dout0_28 vdout0_28ck137 = 1.0 time = 690
* CHECK dout0_29 vdout0_29ck137 = 0 time = 690
* CHECK dout0_30 vdout0_30ck137 = 1.0 time = 690
* CHECK dout0_31 vdout0_31ck137 = 0 time = 690
* CHECK dout1_0 vdout1_0ck137 = 1.0 time = 690
* CHECK dout1_1 vdout1_1ck137 = 0 time = 690
* CHECK dout1_2 vdout1_2ck137 = 1.0 time = 690
* CHECK dout1_3 vdout1_3ck137 = 0 time = 690
* CHECK dout1_4 vdout1_4ck137 = 0 time = 690
* CHECK dout1_5 vdout1_5ck137 = 0 time = 690
* CHECK dout1_6 vdout1_6ck137 = 0 time = 690
* CHECK dout1_7 vdout1_7ck137 = 1.0 time = 690
* CHECK dout1_8 vdout1_8ck137 = 0 time = 690
* CHECK dout1_9 vdout1_9ck137 = 1.0 time = 690
* CHECK dout1_10 vdout1_10ck137 = 0 time = 690
* CHECK dout1_11 vdout1_11ck137 = 1.0 time = 690
* CHECK dout1_12 vdout1_12ck137 = 0 time = 690
* CHECK dout1_13 vdout1_13ck137 = 1.0 time = 690
* CHECK dout1_14 vdout1_14ck137 = 0 time = 690
* CHECK dout1_15 vdout1_15ck137 = 1.0 time = 690
* CHECK dout1_16 vdout1_16ck137 = 1.0 time = 690
* CHECK dout1_17 vdout1_17ck137 = 0 time = 690
* CHECK dout1_18 vdout1_18ck137 = 1.0 time = 690
* CHECK dout1_19 vdout1_19ck137 = 1.0 time = 690
* CHECK dout1_20 vdout1_20ck137 = 1.0 time = 690
* CHECK dout1_21 vdout1_21ck137 = 1.0 time = 690
* CHECK dout1_22 vdout1_22ck137 = 0 time = 690
* CHECK dout1_23 vdout1_23ck137 = 1.0 time = 690
* CHECK dout1_24 vdout1_24ck137 = 0 time = 690
* CHECK dout1_25 vdout1_25ck137 = 1.0 time = 690
* CHECK dout1_26 vdout1_26ck137 = 0 time = 690
* CHECK dout1_27 vdout1_27ck137 = 0 time = 690
* CHECK dout1_28 vdout1_28ck137 = 1.0 time = 690
* CHECK dout1_29 vdout1_29ck137 = 1.0 time = 690
* CHECK dout1_30 vdout1_30ck137 = 1.0 time = 690
* CHECK dout1_31 vdout1_31ck137 = 0 time = 690
* CHECK dout1_0 vdout1_0ck138 = 1.0 time = 695
* CHECK dout1_1 vdout1_1ck138 = 0 time = 695
* CHECK dout1_2 vdout1_2ck138 = 0 time = 695
* CHECK dout1_3 vdout1_3ck138 = 0 time = 695
* CHECK dout1_4 vdout1_4ck138 = 1.0 time = 695
* CHECK dout1_5 vdout1_5ck138 = 1.0 time = 695
* CHECK dout1_6 vdout1_6ck138 = 1.0 time = 695
* CHECK dout1_7 vdout1_7ck138 = 0 time = 695
* CHECK dout1_8 vdout1_8ck138 = 1.0 time = 695
* CHECK dout1_9 vdout1_9ck138 = 0 time = 695
* CHECK dout1_10 vdout1_10ck138 = 0 time = 695
* CHECK dout1_11 vdout1_11ck138 = 1.0 time = 695
* CHECK dout1_12 vdout1_12ck138 = 1.0 time = 695
* CHECK dout1_13 vdout1_13ck138 = 0 time = 695
* CHECK dout1_14 vdout1_14ck138 = 1.0 time = 695
* CHECK dout1_15 vdout1_15ck138 = 1.0 time = 695
* CHECK dout1_16 vdout1_16ck138 = 0 time = 695
* CHECK dout1_17 vdout1_17ck138 = 1.0 time = 695
* CHECK dout1_18 vdout1_18ck138 = 0 time = 695
* CHECK dout1_19 vdout1_19ck138 = 1.0 time = 695
* CHECK dout1_20 vdout1_20ck138 = 0 time = 695
* CHECK dout1_21 vdout1_21ck138 = 1.0 time = 695
* CHECK dout1_22 vdout1_22ck138 = 0 time = 695
* CHECK dout1_23 vdout1_23ck138 = 0 time = 695
* CHECK dout1_24 vdout1_24ck138 = 0 time = 695
* CHECK dout1_25 vdout1_25ck138 = 1.0 time = 695
* CHECK dout1_26 vdout1_26ck138 = 0 time = 695
* CHECK dout1_27 vdout1_27ck138 = 0 time = 695
* CHECK dout1_28 vdout1_28ck138 = 0 time = 695
* CHECK dout1_29 vdout1_29ck138 = 0 time = 695
* CHECK dout1_30 vdout1_30ck138 = 1.0 time = 695
* CHECK dout1_31 vdout1_31ck138 = 1.0 time = 695
* CHECK dout0_0 vdout0_0ck139 = 1.0 time = 700
* CHECK dout0_1 vdout0_1ck139 = 1.0 time = 700
* CHECK dout0_2 vdout0_2ck139 = 0 time = 700
* CHECK dout0_3 vdout0_3ck139 = 1.0 time = 700
* CHECK dout0_4 vdout0_4ck139 = 1.0 time = 700
* CHECK dout0_5 vdout0_5ck139 = 0 time = 700
* CHECK dout0_6 vdout0_6ck139 = 1.0 time = 700
* CHECK dout0_7 vdout0_7ck139 = 0 time = 700
* CHECK dout0_8 vdout0_8ck139 = 0 time = 700
* CHECK dout0_9 vdout0_9ck139 = 0 time = 700
* CHECK dout0_10 vdout0_10ck139 = 1.0 time = 700
* CHECK dout0_11 vdout0_11ck139 = 1.0 time = 700
* CHECK dout0_12 vdout0_12ck139 = 1.0 time = 700
* CHECK dout0_13 vdout0_13ck139 = 0 time = 700
* CHECK dout0_14 vdout0_14ck139 = 0 time = 700
* CHECK dout0_15 vdout0_15ck139 = 0 time = 700
* CHECK dout0_16 vdout0_16ck139 = 0 time = 700
* CHECK dout0_17 vdout0_17ck139 = 0 time = 700
* CHECK dout0_18 vdout0_18ck139 = 0 time = 700
* CHECK dout0_19 vdout0_19ck139 = 0 time = 700
* CHECK dout0_20 vdout0_20ck139 = 0 time = 700
* CHECK dout0_21 vdout0_21ck139 = 1.0 time = 700
* CHECK dout0_22 vdout0_22ck139 = 1.0 time = 700
* CHECK dout0_23 vdout0_23ck139 = 0 time = 700
* CHECK dout0_24 vdout0_24ck139 = 0 time = 700
* CHECK dout0_25 vdout0_25ck139 = 0 time = 700
* CHECK dout0_26 vdout0_26ck139 = 1.0 time = 700
* CHECK dout0_27 vdout0_27ck139 = 1.0 time = 700
* CHECK dout0_28 vdout0_28ck139 = 1.0 time = 700
* CHECK dout0_29 vdout0_29ck139 = 0 time = 700
* CHECK dout0_30 vdout0_30ck139 = 1.0 time = 700
* CHECK dout0_31 vdout0_31ck139 = 0 time = 700
* CHECK dout1_0 vdout1_0ck140 = 0 time = 705
* CHECK dout1_1 vdout1_1ck140 = 0 time = 705
* CHECK dout1_2 vdout1_2ck140 = 1.0 time = 705
* CHECK dout1_3 vdout1_3ck140 = 1.0 time = 705
* CHECK dout1_4 vdout1_4ck140 = 0 time = 705
* CHECK dout1_5 vdout1_5ck140 = 0 time = 705
* CHECK dout1_6 vdout1_6ck140 = 1.0 time = 705
* CHECK dout1_7 vdout1_7ck140 = 1.0 time = 705
* CHECK dout1_8 vdout1_8ck140 = 0 time = 705
* CHECK dout1_9 vdout1_9ck140 = 0 time = 705
* CHECK dout1_10 vdout1_10ck140 = 0 time = 705
* CHECK dout1_11 vdout1_11ck140 = 0 time = 705
* CHECK dout1_12 vdout1_12ck140 = 0 time = 705
* CHECK dout1_13 vdout1_13ck140 = 1.0 time = 705
* CHECK dout1_14 vdout1_14ck140 = 0 time = 705
* CHECK dout1_15 vdout1_15ck140 = 0 time = 705
* CHECK dout1_16 vdout1_16ck140 = 0 time = 705
* CHECK dout1_17 vdout1_17ck140 = 1.0 time = 705
* CHECK dout1_18 vdout1_18ck140 = 0 time = 705
* CHECK dout1_19 vdout1_19ck140 = 0 time = 705
* CHECK dout1_20 vdout1_20ck140 = 0 time = 705
* CHECK dout1_21 vdout1_21ck140 = 1.0 time = 705
* CHECK dout1_22 vdout1_22ck140 = 0 time = 705
* CHECK dout1_23 vdout1_23ck140 = 1.0 time = 705
* CHECK dout1_24 vdout1_24ck140 = 1.0 time = 705
* CHECK dout1_25 vdout1_25ck140 = 0 time = 705
* CHECK dout1_26 vdout1_26ck140 = 1.0 time = 705
* CHECK dout1_27 vdout1_27ck140 = 0 time = 705
* CHECK dout1_28 vdout1_28ck140 = 1.0 time = 705
* CHECK dout1_29 vdout1_29ck140 = 1.0 time = 705
* CHECK dout1_30 vdout1_30ck140 = 0 time = 705
* CHECK dout1_31 vdout1_31ck140 = 0 time = 705
* CHECK dout0_0 vdout0_0ck141 = 1.0 time = 710
* CHECK dout0_1 vdout0_1ck141 = 0 time = 710
* CHECK dout0_2 vdout0_2ck141 = 1.0 time = 710
* CHECK dout0_3 vdout0_3ck141 = 0 time = 710
* CHECK dout0_4 vdout0_4ck141 = 0 time = 710
* CHECK dout0_5 vdout0_5ck141 = 0 time = 710
* CHECK dout0_6 vdout0_6ck141 = 0 time = 710
* CHECK dout0_7 vdout0_7ck141 = 1.0 time = 710
* CHECK dout0_8 vdout0_8ck141 = 0 time = 710
* CHECK dout0_9 vdout0_9ck141 = 1.0 time = 710
* CHECK dout0_10 vdout0_10ck141 = 0 time = 710
* CHECK dout0_11 vdout0_11ck141 = 1.0 time = 710
* CHECK dout0_12 vdout0_12ck141 = 0 time = 710
* CHECK dout0_13 vdout0_13ck141 = 1.0 time = 710
* CHECK dout0_14 vdout0_14ck141 = 0 time = 710
* CHECK dout0_15 vdout0_15ck141 = 1.0 time = 710
* CHECK dout0_16 vdout0_16ck141 = 1.0 time = 710
* CHECK dout0_17 vdout0_17ck141 = 0 time = 710
* CHECK dout0_18 vdout0_18ck141 = 1.0 time = 710
* CHECK dout0_19 vdout0_19ck141 = 1.0 time = 710
* CHECK dout0_20 vdout0_20ck141 = 1.0 time = 710
* CHECK dout0_21 vdout0_21ck141 = 1.0 time = 710
* CHECK dout0_22 vdout0_22ck141 = 0 time = 710
* CHECK dout0_23 vdout0_23ck141 = 1.0 time = 710
* CHECK dout0_24 vdout0_24ck141 = 0 time = 710
* CHECK dout0_25 vdout0_25ck141 = 1.0 time = 710
* CHECK dout0_26 vdout0_26ck141 = 0 time = 710
* CHECK dout0_27 vdout0_27ck141 = 0 time = 710
* CHECK dout0_28 vdout0_28ck141 = 1.0 time = 710
* CHECK dout0_29 vdout0_29ck141 = 1.0 time = 710
* CHECK dout0_30 vdout0_30ck141 = 1.0 time = 710
* CHECK dout0_31 vdout0_31ck141 = 0 time = 710
* CHECK dout1_0 vdout1_0ck143 = 0 time = 720
* CHECK dout1_1 vdout1_1ck143 = 0 time = 720
* CHECK dout1_2 vdout1_2ck143 = 1.0 time = 720
* CHECK dout1_3 vdout1_3ck143 = 1.0 time = 720
* CHECK dout1_4 vdout1_4ck143 = 0 time = 720
* CHECK dout1_5 vdout1_5ck143 = 0 time = 720
* CHECK dout1_6 vdout1_6ck143 = 1.0 time = 720
* CHECK dout1_7 vdout1_7ck143 = 1.0 time = 720
* CHECK dout1_8 vdout1_8ck143 = 0 time = 720
* CHECK dout1_9 vdout1_9ck143 = 0 time = 720
* CHECK dout1_10 vdout1_10ck143 = 0 time = 720
* CHECK dout1_11 vdout1_11ck143 = 0 time = 720
* CHECK dout1_12 vdout1_12ck143 = 0 time = 720
* CHECK dout1_13 vdout1_13ck143 = 1.0 time = 720
* CHECK dout1_14 vdout1_14ck143 = 0 time = 720
* CHECK dout1_15 vdout1_15ck143 = 0 time = 720
* CHECK dout1_16 vdout1_16ck143 = 0 time = 720
* CHECK dout1_17 vdout1_17ck143 = 1.0 time = 720
* CHECK dout1_18 vdout1_18ck143 = 0 time = 720
* CHECK dout1_19 vdout1_19ck143 = 0 time = 720
* CHECK dout1_20 vdout1_20ck143 = 0 time = 720
* CHECK dout1_21 vdout1_21ck143 = 1.0 time = 720
* CHECK dout1_22 vdout1_22ck143 = 0 time = 720
* CHECK dout1_23 vdout1_23ck143 = 1.0 time = 720
* CHECK dout1_24 vdout1_24ck143 = 1.0 time = 720
* CHECK dout1_25 vdout1_25ck143 = 0 time = 720
* CHECK dout1_26 vdout1_26ck143 = 1.0 time = 720
* CHECK dout1_27 vdout1_27ck143 = 0 time = 720
* CHECK dout1_28 vdout1_28ck143 = 1.0 time = 720
* CHECK dout1_29 vdout1_29ck143 = 1.0 time = 720
* CHECK dout1_30 vdout1_30ck143 = 0 time = 720
* CHECK dout1_31 vdout1_31ck143 = 0 time = 720
* CHECK dout0_0 vdout0_0ck145 = 0 time = 730
* CHECK dout0_1 vdout0_1ck145 = 0 time = 730
* CHECK dout0_2 vdout0_2ck145 = 0 time = 730
* CHECK dout0_3 vdout0_3ck145 = 0 time = 730
* CHECK dout0_4 vdout0_4ck145 = 0 time = 730
* CHECK dout0_5 vdout0_5ck145 = 0 time = 730
* CHECK dout0_6 vdout0_6ck145 = 1.0 time = 730
* CHECK dout0_7 vdout0_7ck145 = 1.0 time = 730
* CHECK dout0_8 vdout0_8ck145 = 0 time = 730
* CHECK dout0_9 vdout0_9ck145 = 1.0 time = 730
* CHECK dout0_10 vdout0_10ck145 = 0 time = 730
* CHECK dout0_11 vdout0_11ck145 = 1.0 time = 730
* CHECK dout0_12 vdout0_12ck145 = 1.0 time = 730
* CHECK dout0_13 vdout0_13ck145 = 0 time = 730
* CHECK dout0_14 vdout0_14ck145 = 1.0 time = 730
* CHECK dout0_15 vdout0_15ck145 = 1.0 time = 730
* CHECK dout0_16 vdout0_16ck145 = 1.0 time = 730
* CHECK dout0_17 vdout0_17ck145 = 1.0 time = 730
* CHECK dout0_18 vdout0_18ck145 = 0 time = 730
* CHECK dout0_19 vdout0_19ck145 = 0 time = 730
* CHECK dout0_20 vdout0_20ck145 = 1.0 time = 730
* CHECK dout0_21 vdout0_21ck145 = 1.0 time = 730
* CHECK dout0_22 vdout0_22ck145 = 0 time = 730
* CHECK dout0_23 vdout0_23ck145 = 1.0 time = 730
* CHECK dout0_24 vdout0_24ck145 = 0 time = 730
* CHECK dout0_25 vdout0_25ck145 = 0 time = 730
* CHECK dout0_26 vdout0_26ck145 = 1.0 time = 730
* CHECK dout0_27 vdout0_27ck145 = 1.0 time = 730
* CHECK dout0_28 vdout0_28ck145 = 1.0 time = 730
* CHECK dout0_29 vdout0_29ck145 = 1.0 time = 730
* CHECK dout0_30 vdout0_30ck145 = 1.0 time = 730
* CHECK dout0_31 vdout0_31ck145 = 0 time = 730
* CHECK dout1_0 vdout1_0ck145 = 0 time = 730
* CHECK dout1_1 vdout1_1ck145 = 0 time = 730
* CHECK dout1_2 vdout1_2ck145 = 0 time = 730
* CHECK dout1_3 vdout1_3ck145 = 1.0 time = 730
* CHECK dout1_4 vdout1_4ck145 = 1.0 time = 730
* CHECK dout1_5 vdout1_5ck145 = 1.0 time = 730
* CHECK dout1_6 vdout1_6ck145 = 0 time = 730
* CHECK dout1_7 vdout1_7ck145 = 1.0 time = 730
* CHECK dout1_8 vdout1_8ck145 = 0 time = 730
* CHECK dout1_9 vdout1_9ck145 = 1.0 time = 730
* CHECK dout1_10 vdout1_10ck145 = 0 time = 730
* CHECK dout1_11 vdout1_11ck145 = 0 time = 730
* CHECK dout1_12 vdout1_12ck145 = 0 time = 730
* CHECK dout1_13 vdout1_13ck145 = 0 time = 730
* CHECK dout1_14 vdout1_14ck145 = 1.0 time = 730
* CHECK dout1_15 vdout1_15ck145 = 0 time = 730
* CHECK dout1_16 vdout1_16ck145 = 1.0 time = 730
* CHECK dout1_17 vdout1_17ck145 = 1.0 time = 730
* CHECK dout1_18 vdout1_18ck145 = 0 time = 730
* CHECK dout1_19 vdout1_19ck145 = 0 time = 730
* CHECK dout1_20 vdout1_20ck145 = 1.0 time = 730
* CHECK dout1_21 vdout1_21ck145 = 0 time = 730
* CHECK dout1_22 vdout1_22ck145 = 0 time = 730
* CHECK dout1_23 vdout1_23ck145 = 1.0 time = 730
* CHECK dout1_24 vdout1_24ck145 = 0 time = 730
* CHECK dout1_25 vdout1_25ck145 = 1.0 time = 730
* CHECK dout1_26 vdout1_26ck145 = 1.0 time = 730
* CHECK dout1_27 vdout1_27ck145 = 0 time = 730
* CHECK dout1_28 vdout1_28ck145 = 1.0 time = 730
* CHECK dout1_29 vdout1_29ck145 = 0 time = 730
* CHECK dout1_30 vdout1_30ck145 = 0 time = 730
* CHECK dout1_31 vdout1_31ck145 = 1.0 time = 730
* CHECK dout0_0 vdout0_0ck146 = 0 time = 735
* CHECK dout0_1 vdout0_1ck146 = 0 time = 735
* CHECK dout0_2 vdout0_2ck146 = 0 time = 735
* CHECK dout0_3 vdout0_3ck146 = 0 time = 735
* CHECK dout0_4 vdout0_4ck146 = 0 time = 735
* CHECK dout0_5 vdout0_5ck146 = 1.0 time = 735
* CHECK dout0_6 vdout0_6ck146 = 0 time = 735
* CHECK dout0_7 vdout0_7ck146 = 0 time = 735
* CHECK dout0_8 vdout0_8ck146 = 1.0 time = 735
* CHECK dout0_9 vdout0_9ck146 = 1.0 time = 735
* CHECK dout0_10 vdout0_10ck146 = 0 time = 735
* CHECK dout0_11 vdout0_11ck146 = 0 time = 735
* CHECK dout0_12 vdout0_12ck146 = 0 time = 735
* CHECK dout0_13 vdout0_13ck146 = 1.0 time = 735
* CHECK dout0_14 vdout0_14ck146 = 1.0 time = 735
* CHECK dout0_15 vdout0_15ck146 = 1.0 time = 735
* CHECK dout0_16 vdout0_16ck146 = 1.0 time = 735
* CHECK dout0_17 vdout0_17ck146 = 0 time = 735
* CHECK dout0_18 vdout0_18ck146 = 1.0 time = 735
* CHECK dout0_19 vdout0_19ck146 = 0 time = 735
* CHECK dout0_20 vdout0_20ck146 = 1.0 time = 735
* CHECK dout0_21 vdout0_21ck146 = 0 time = 735
* CHECK dout0_22 vdout0_22ck146 = 0 time = 735
* CHECK dout0_23 vdout0_23ck146 = 0 time = 735
* CHECK dout0_24 vdout0_24ck146 = 0 time = 735
* CHECK dout0_25 vdout0_25ck146 = 0 time = 735
* CHECK dout0_26 vdout0_26ck146 = 1.0 time = 735
* CHECK dout0_27 vdout0_27ck146 = 0 time = 735
* CHECK dout0_28 vdout0_28ck146 = 1.0 time = 735
* CHECK dout0_29 vdout0_29ck146 = 1.0 time = 735
* CHECK dout0_30 vdout0_30ck146 = 0 time = 735
* CHECK dout0_31 vdout0_31ck146 = 1.0 time = 735
* CHECK dout1_0 vdout1_0ck146 = 0 time = 735
* CHECK dout1_1 vdout1_1ck146 = 0 time = 735
* CHECK dout1_2 vdout1_2ck146 = 0 time = 735
* CHECK dout1_3 vdout1_3ck146 = 1.0 time = 735
* CHECK dout1_4 vdout1_4ck146 = 1.0 time = 735
* CHECK dout1_5 vdout1_5ck146 = 1.0 time = 735
* CHECK dout1_6 vdout1_6ck146 = 0 time = 735
* CHECK dout1_7 vdout1_7ck146 = 1.0 time = 735
* CHECK dout1_8 vdout1_8ck146 = 0 time = 735
* CHECK dout1_9 vdout1_9ck146 = 1.0 time = 735
* CHECK dout1_10 vdout1_10ck146 = 0 time = 735
* CHECK dout1_11 vdout1_11ck146 = 0 time = 735
* CHECK dout1_12 vdout1_12ck146 = 0 time = 735
* CHECK dout1_13 vdout1_13ck146 = 0 time = 735
* CHECK dout1_14 vdout1_14ck146 = 1.0 time = 735
* CHECK dout1_15 vdout1_15ck146 = 0 time = 735
* CHECK dout1_16 vdout1_16ck146 = 1.0 time = 735
* CHECK dout1_17 vdout1_17ck146 = 1.0 time = 735
* CHECK dout1_18 vdout1_18ck146 = 0 time = 735
* CHECK dout1_19 vdout1_19ck146 = 0 time = 735
* CHECK dout1_20 vdout1_20ck146 = 1.0 time = 735
* CHECK dout1_21 vdout1_21ck146 = 0 time = 735
* CHECK dout1_22 vdout1_22ck146 = 0 time = 735
* CHECK dout1_23 vdout1_23ck146 = 1.0 time = 735
* CHECK dout1_24 vdout1_24ck146 = 0 time = 735
* CHECK dout1_25 vdout1_25ck146 = 1.0 time = 735
* CHECK dout1_26 vdout1_26ck146 = 1.0 time = 735
* CHECK dout1_27 vdout1_27ck146 = 0 time = 735
* CHECK dout1_28 vdout1_28ck146 = 1.0 time = 735
* CHECK dout1_29 vdout1_29ck146 = 0 time = 735
* CHECK dout1_30 vdout1_30ck146 = 0 time = 735
* CHECK dout1_31 vdout1_31ck146 = 1.0 time = 735
* CHECK dout1_0 vdout1_0ck149 = 1.0 time = 750
* CHECK dout1_1 vdout1_1ck149 = 0 time = 750
* CHECK dout1_2 vdout1_2ck149 = 1.0 time = 750
* CHECK dout1_3 vdout1_3ck149 = 0 time = 750
* CHECK dout1_4 vdout1_4ck149 = 0 time = 750
* CHECK dout1_5 vdout1_5ck149 = 0 time = 750
* CHECK dout1_6 vdout1_6ck149 = 0 time = 750
* CHECK dout1_7 vdout1_7ck149 = 0 time = 750
* CHECK dout1_8 vdout1_8ck149 = 0 time = 750
* CHECK dout1_9 vdout1_9ck149 = 0 time = 750
* CHECK dout1_10 vdout1_10ck149 = 0 time = 750
* CHECK dout1_11 vdout1_11ck149 = 1.0 time = 750
* CHECK dout1_12 vdout1_12ck149 = 0 time = 750
* CHECK dout1_13 vdout1_13ck149 = 1.0 time = 750
* CHECK dout1_14 vdout1_14ck149 = 1.0 time = 750
* CHECK dout1_15 vdout1_15ck149 = 0 time = 750
* CHECK dout1_16 vdout1_16ck149 = 0 time = 750
* CHECK dout1_17 vdout1_17ck149 = 1.0 time = 750
* CHECK dout1_18 vdout1_18ck149 = 1.0 time = 750
* CHECK dout1_19 vdout1_19ck149 = 1.0 time = 750
* CHECK dout1_20 vdout1_20ck149 = 0 time = 750
* CHECK dout1_21 vdout1_21ck149 = 1.0 time = 750
* CHECK dout1_22 vdout1_22ck149 = 1.0 time = 750
* CHECK dout1_23 vdout1_23ck149 = 0 time = 750
* CHECK dout1_24 vdout1_24ck149 = 0 time = 750
* CHECK dout1_25 vdout1_25ck149 = 1.0 time = 750
* CHECK dout1_26 vdout1_26ck149 = 0 time = 750
* CHECK dout1_27 vdout1_27ck149 = 1.0 time = 750
* CHECK dout1_28 vdout1_28ck149 = 0 time = 750
* CHECK dout1_29 vdout1_29ck149 = 1.0 time = 750
* CHECK dout1_30 vdout1_30ck149 = 0 time = 750
* CHECK dout1_31 vdout1_31ck149 = 0 time = 750
* CHECK dout0_0 vdout0_0ck151 = 1.0 time = 760
* CHECK dout0_1 vdout0_1ck151 = 1.0 time = 760
* CHECK dout0_2 vdout0_2ck151 = 1.0 time = 760
* CHECK dout0_3 vdout0_3ck151 = 1.0 time = 760
* CHECK dout0_4 vdout0_4ck151 = 0 time = 760
* CHECK dout0_5 vdout0_5ck151 = 0 time = 760
* CHECK dout0_6 vdout0_6ck151 = 1.0 time = 760
* CHECK dout0_7 vdout0_7ck151 = 0 time = 760
* CHECK dout0_8 vdout0_8ck151 = 1.0 time = 760
* CHECK dout0_9 vdout0_9ck151 = 0 time = 760
* CHECK dout0_10 vdout0_10ck151 = 1.0 time = 760
* CHECK dout0_11 vdout0_11ck151 = 1.0 time = 760
* CHECK dout0_12 vdout0_12ck151 = 1.0 time = 760
* CHECK dout0_13 vdout0_13ck151 = 1.0 time = 760
* CHECK dout0_14 vdout0_14ck151 = 0 time = 760
* CHECK dout0_15 vdout0_15ck151 = 1.0 time = 760
* CHECK dout0_16 vdout0_16ck151 = 0 time = 760
* CHECK dout0_17 vdout0_17ck151 = 1.0 time = 760
* CHECK dout0_18 vdout0_18ck151 = 1.0 time = 760
* CHECK dout0_19 vdout0_19ck151 = 0 time = 760
* CHECK dout0_20 vdout0_20ck151 = 1.0 time = 760
* CHECK dout0_21 vdout0_21ck151 = 0 time = 760
* CHECK dout0_22 vdout0_22ck151 = 1.0 time = 760
* CHECK dout0_23 vdout0_23ck151 = 0 time = 760
* CHECK dout0_24 vdout0_24ck151 = 1.0 time = 760
* CHECK dout0_25 vdout0_25ck151 = 0 time = 760
* CHECK dout0_26 vdout0_26ck151 = 1.0 time = 760
* CHECK dout0_27 vdout0_27ck151 = 0 time = 760
* CHECK dout0_28 vdout0_28ck151 = 0 time = 760
* CHECK dout0_29 vdout0_29ck151 = 1.0 time = 760
* CHECK dout0_30 vdout0_30ck151 = 0 time = 760
* CHECK dout0_31 vdout0_31ck151 = 1.0 time = 760
* CHECK dout1_0 vdout1_0ck151 = 0 time = 760
* CHECK dout1_1 vdout1_1ck151 = 0 time = 760
* CHECK dout1_2 vdout1_2ck151 = 1.0 time = 760
* CHECK dout1_3 vdout1_3ck151 = 0 time = 760
* CHECK dout1_4 vdout1_4ck151 = 1.0 time = 760
* CHECK dout1_5 vdout1_5ck151 = 1.0 time = 760
* CHECK dout1_6 vdout1_6ck151 = 0 time = 760
* CHECK dout1_7 vdout1_7ck151 = 1.0 time = 760
* CHECK dout1_8 vdout1_8ck151 = 1.0 time = 760
* CHECK dout1_9 vdout1_9ck151 = 0 time = 760
* CHECK dout1_10 vdout1_10ck151 = 0 time = 760
* CHECK dout1_11 vdout1_11ck151 = 0 time = 760
* CHECK dout1_12 vdout1_12ck151 = 0 time = 760
* CHECK dout1_13 vdout1_13ck151 = 1.0 time = 760
* CHECK dout1_14 vdout1_14ck151 = 1.0 time = 760
* CHECK dout1_15 vdout1_15ck151 = 1.0 time = 760
* CHECK dout1_16 vdout1_16ck151 = 0 time = 760
* CHECK dout1_17 vdout1_17ck151 = 0 time = 760
* CHECK dout1_18 vdout1_18ck151 = 0 time = 760
* CHECK dout1_19 vdout1_19ck151 = 0 time = 760
* CHECK dout1_20 vdout1_20ck151 = 1.0 time = 760
* CHECK dout1_21 vdout1_21ck151 = 1.0 time = 760
* CHECK dout1_22 vdout1_22ck151 = 1.0 time = 760
* CHECK dout1_23 vdout1_23ck151 = 1.0 time = 760
* CHECK dout1_24 vdout1_24ck151 = 1.0 time = 760
* CHECK dout1_25 vdout1_25ck151 = 0 time = 760
* CHECK dout1_26 vdout1_26ck151 = 1.0 time = 760
* CHECK dout1_27 vdout1_27ck151 = 0 time = 760
* CHECK dout1_28 vdout1_28ck151 = 1.0 time = 760
* CHECK dout1_29 vdout1_29ck151 = 0 time = 760
* CHECK dout1_30 vdout1_30ck151 = 0 time = 760
* CHECK dout1_31 vdout1_31ck151 = 1.0 time = 760
* CHECK dout0_0 vdout0_0ck152 = 0 time = 765
* CHECK dout0_1 vdout0_1ck152 = 0 time = 765
* CHECK dout0_2 vdout0_2ck152 = 1.0 time = 765
* CHECK dout0_3 vdout0_3ck152 = 1.0 time = 765
* CHECK dout0_4 vdout0_4ck152 = 0 time = 765
* CHECK dout0_5 vdout0_5ck152 = 0 time = 765
* CHECK dout0_6 vdout0_6ck152 = 1.0 time = 765
* CHECK dout0_7 vdout0_7ck152 = 1.0 time = 765
* CHECK dout0_8 vdout0_8ck152 = 0 time = 765
* CHECK dout0_9 vdout0_9ck152 = 0 time = 765
* CHECK dout0_10 vdout0_10ck152 = 0 time = 765
* CHECK dout0_11 vdout0_11ck152 = 0 time = 765
* CHECK dout0_12 vdout0_12ck152 = 0 time = 765
* CHECK dout0_13 vdout0_13ck152 = 1.0 time = 765
* CHECK dout0_14 vdout0_14ck152 = 0 time = 765
* CHECK dout0_15 vdout0_15ck152 = 0 time = 765
* CHECK dout0_16 vdout0_16ck152 = 0 time = 765
* CHECK dout0_17 vdout0_17ck152 = 1.0 time = 765
* CHECK dout0_18 vdout0_18ck152 = 0 time = 765
* CHECK dout0_19 vdout0_19ck152 = 0 time = 765
* CHECK dout0_20 vdout0_20ck152 = 0 time = 765
* CHECK dout0_21 vdout0_21ck152 = 1.0 time = 765
* CHECK dout0_22 vdout0_22ck152 = 0 time = 765
* CHECK dout0_23 vdout0_23ck152 = 1.0 time = 765
* CHECK dout0_24 vdout0_24ck152 = 1.0 time = 765
* CHECK dout0_25 vdout0_25ck152 = 0 time = 765
* CHECK dout0_26 vdout0_26ck152 = 1.0 time = 765
* CHECK dout0_27 vdout0_27ck152 = 0 time = 765
* CHECK dout0_28 vdout0_28ck152 = 1.0 time = 765
* CHECK dout0_29 vdout0_29ck152 = 1.0 time = 765
* CHECK dout0_30 vdout0_30ck152 = 0 time = 765
* CHECK dout0_31 vdout0_31ck152 = 0 time = 765
* CHECK dout0_0 vdout0_0ck153 = 1.0 time = 770
* CHECK dout0_1 vdout0_1ck153 = 0 time = 770
* CHECK dout0_2 vdout0_2ck153 = 1.0 time = 770
* CHECK dout0_3 vdout0_3ck153 = 0 time = 770
* CHECK dout0_4 vdout0_4ck153 = 0 time = 770
* CHECK dout0_5 vdout0_5ck153 = 0 time = 770
* CHECK dout0_6 vdout0_6ck153 = 0 time = 770
* CHECK dout0_7 vdout0_7ck153 = 0 time = 770
* CHECK dout0_8 vdout0_8ck153 = 0 time = 770
* CHECK dout0_9 vdout0_9ck153 = 0 time = 770
* CHECK dout0_10 vdout0_10ck153 = 0 time = 770
* CHECK dout0_11 vdout0_11ck153 = 1.0 time = 770
* CHECK dout0_12 vdout0_12ck153 = 0 time = 770
* CHECK dout0_13 vdout0_13ck153 = 1.0 time = 770
* CHECK dout0_14 vdout0_14ck153 = 1.0 time = 770
* CHECK dout0_15 vdout0_15ck153 = 0 time = 770
* CHECK dout0_16 vdout0_16ck153 = 0 time = 770
* CHECK dout0_17 vdout0_17ck153 = 1.0 time = 770
* CHECK dout0_18 vdout0_18ck153 = 1.0 time = 770
* CHECK dout0_19 vdout0_19ck153 = 1.0 time = 770
* CHECK dout0_20 vdout0_20ck153 = 0 time = 770
* CHECK dout0_21 vdout0_21ck153 = 1.0 time = 770
* CHECK dout0_22 vdout0_22ck153 = 1.0 time = 770
* CHECK dout0_23 vdout0_23ck153 = 0 time = 770
* CHECK dout0_24 vdout0_24ck153 = 0 time = 770
* CHECK dout0_25 vdout0_25ck153 = 1.0 time = 770
* CHECK dout0_26 vdout0_26ck153 = 0 time = 770
* CHECK dout0_27 vdout0_27ck153 = 1.0 time = 770
* CHECK dout0_28 vdout0_28ck153 = 0 time = 770
* CHECK dout0_29 vdout0_29ck153 = 1.0 time = 770
* CHECK dout0_30 vdout0_30ck153 = 0 time = 770
* CHECK dout0_31 vdout0_31ck153 = 0 time = 770
* CHECK dout1_0 vdout1_0ck155 = 1.0 time = 780
* CHECK dout1_1 vdout1_1ck155 = 1.0 time = 780
* CHECK dout1_2 vdout1_2ck155 = 1.0 time = 780
* CHECK dout1_3 vdout1_3ck155 = 1.0 time = 780
* CHECK dout1_4 vdout1_4ck155 = 0 time = 780
* CHECK dout1_5 vdout1_5ck155 = 0 time = 780
* CHECK dout1_6 vdout1_6ck155 = 1.0 time = 780
* CHECK dout1_7 vdout1_7ck155 = 0 time = 780
* CHECK dout1_8 vdout1_8ck155 = 1.0 time = 780
* CHECK dout1_9 vdout1_9ck155 = 0 time = 780
* CHECK dout1_10 vdout1_10ck155 = 1.0 time = 780
* CHECK dout1_11 vdout1_11ck155 = 1.0 time = 780
* CHECK dout1_12 vdout1_12ck155 = 1.0 time = 780
* CHECK dout1_13 vdout1_13ck155 = 1.0 time = 780
* CHECK dout1_14 vdout1_14ck155 = 0 time = 780
* CHECK dout1_15 vdout1_15ck155 = 1.0 time = 780
* CHECK dout1_16 vdout1_16ck155 = 0 time = 780
* CHECK dout1_17 vdout1_17ck155 = 1.0 time = 780
* CHECK dout1_18 vdout1_18ck155 = 1.0 time = 780
* CHECK dout1_19 vdout1_19ck155 = 0 time = 780
* CHECK dout1_20 vdout1_20ck155 = 1.0 time = 780
* CHECK dout1_21 vdout1_21ck155 = 0 time = 780
* CHECK dout1_22 vdout1_22ck155 = 1.0 time = 780
* CHECK dout1_23 vdout1_23ck155 = 0 time = 780
* CHECK dout1_24 vdout1_24ck155 = 1.0 time = 780
* CHECK dout1_25 vdout1_25ck155 = 0 time = 780
* CHECK dout1_26 vdout1_26ck155 = 1.0 time = 780
* CHECK dout1_27 vdout1_27ck155 = 0 time = 780
* CHECK dout1_28 vdout1_28ck155 = 0 time = 780
* CHECK dout1_29 vdout1_29ck155 = 1.0 time = 780
* CHECK dout1_30 vdout1_30ck155 = 0 time = 780
* CHECK dout1_31 vdout1_31ck155 = 1.0 time = 780
* CHECK dout1_0 vdout1_0ck157 = 1.0 time = 790
* CHECK dout1_1 vdout1_1ck157 = 0 time = 790
* CHECK dout1_2 vdout1_2ck157 = 1.0 time = 790
* CHECK dout1_3 vdout1_3ck157 = 0 time = 790
* CHECK dout1_4 vdout1_4ck157 = 0 time = 790
* CHECK dout1_5 vdout1_5ck157 = 0 time = 790
* CHECK dout1_6 vdout1_6ck157 = 0 time = 790
* CHECK dout1_7 vdout1_7ck157 = 0 time = 790
* CHECK dout1_8 vdout1_8ck157 = 0 time = 790
* CHECK dout1_9 vdout1_9ck157 = 0 time = 790
* CHECK dout1_10 vdout1_10ck157 = 0 time = 790
* CHECK dout1_11 vdout1_11ck157 = 1.0 time = 790
* CHECK dout1_12 vdout1_12ck157 = 0 time = 790
* CHECK dout1_13 vdout1_13ck157 = 1.0 time = 790
* CHECK dout1_14 vdout1_14ck157 = 1.0 time = 790
* CHECK dout1_15 vdout1_15ck157 = 0 time = 790
* CHECK dout1_16 vdout1_16ck157 = 0 time = 790
* CHECK dout1_17 vdout1_17ck157 = 1.0 time = 790
* CHECK dout1_18 vdout1_18ck157 = 1.0 time = 790
* CHECK dout1_19 vdout1_19ck157 = 1.0 time = 790
* CHECK dout1_20 vdout1_20ck157 = 0 time = 790
* CHECK dout1_21 vdout1_21ck157 = 1.0 time = 790
* CHECK dout1_22 vdout1_22ck157 = 1.0 time = 790
* CHECK dout1_23 vdout1_23ck157 = 0 time = 790
* CHECK dout1_24 vdout1_24ck157 = 0 time = 790
* CHECK dout1_25 vdout1_25ck157 = 1.0 time = 790
* CHECK dout1_26 vdout1_26ck157 = 0 time = 790
* CHECK dout1_27 vdout1_27ck157 = 1.0 time = 790
* CHECK dout1_28 vdout1_28ck157 = 0 time = 790
* CHECK dout1_29 vdout1_29ck157 = 1.0 time = 790
* CHECK dout1_30 vdout1_30ck157 = 0 time = 790
* CHECK dout1_31 vdout1_31ck157 = 0 time = 790
* CHECK dout0_0 vdout0_0ck158 = 1.0 time = 795
* CHECK dout0_1 vdout0_1ck158 = 0 time = 795
* CHECK dout0_2 vdout0_2ck158 = 1.0 time = 795
* CHECK dout0_3 vdout0_3ck158 = 0 time = 795
* CHECK dout0_4 vdout0_4ck158 = 0 time = 795
* CHECK dout0_5 vdout0_5ck158 = 1.0 time = 795
* CHECK dout0_6 vdout0_6ck158 = 0 time = 795
* CHECK dout0_7 vdout0_7ck158 = 0 time = 795
* CHECK dout0_8 vdout0_8ck158 = 0 time = 795
* CHECK dout0_9 vdout0_9ck158 = 0 time = 795
* CHECK dout0_10 vdout0_10ck158 = 1.0 time = 795
* CHECK dout0_11 vdout0_11ck158 = 1.0 time = 795
* CHECK dout0_12 vdout0_12ck158 = 0 time = 795
* CHECK dout0_13 vdout0_13ck158 = 1.0 time = 795
* CHECK dout0_14 vdout0_14ck158 = 0 time = 795
* CHECK dout0_15 vdout0_15ck158 = 1.0 time = 795
* CHECK dout0_16 vdout0_16ck158 = 1.0 time = 795
* CHECK dout0_17 vdout0_17ck158 = 0 time = 795
* CHECK dout0_18 vdout0_18ck158 = 0 time = 795
* CHECK dout0_19 vdout0_19ck158 = 1.0 time = 795
* CHECK dout0_20 vdout0_20ck158 = 1.0 time = 795
* CHECK dout0_21 vdout0_21ck158 = 0 time = 795
* CHECK dout0_22 vdout0_22ck158 = 1.0 time = 795
* CHECK dout0_23 vdout0_23ck158 = 1.0 time = 795
* CHECK dout0_24 vdout0_24ck158 = 0 time = 795
* CHECK dout0_25 vdout0_25ck158 = 0 time = 795
* CHECK dout0_26 vdout0_26ck158 = 0 time = 795
* CHECK dout0_27 vdout0_27ck158 = 0 time = 795
* CHECK dout0_28 vdout0_28ck158 = 0 time = 795
* CHECK dout0_29 vdout0_29ck158 = 0 time = 795
* CHECK dout0_30 vdout0_30ck158 = 1.0 time = 795
* CHECK dout0_31 vdout0_31ck158 = 0 time = 795
* CHECK dout0_0 vdout0_0ck160 = 1.0 time = 805
* CHECK dout0_1 vdout0_1ck160 = 1.0 time = 805
* CHECK dout0_2 vdout0_2ck160 = 1.0 time = 805
* CHECK dout0_3 vdout0_3ck160 = 1.0 time = 805
* CHECK dout0_4 vdout0_4ck160 = 1.0 time = 805
* CHECK dout0_5 vdout0_5ck160 = 1.0 time = 805
* CHECK dout0_6 vdout0_6ck160 = 1.0 time = 805
* CHECK dout0_7 vdout0_7ck160 = 1.0 time = 805
* CHECK dout0_8 vdout0_8ck160 = 1.0 time = 805
* CHECK dout0_9 vdout0_9ck160 = 1.0 time = 805
* CHECK dout0_10 vdout0_10ck160 = 1.0 time = 805
* CHECK dout0_11 vdout0_11ck160 = 0 time = 805
* CHECK dout0_12 vdout0_12ck160 = 1.0 time = 805
* CHECK dout0_13 vdout0_13ck160 = 0 time = 805
* CHECK dout0_14 vdout0_14ck160 = 0 time = 805
* CHECK dout0_15 vdout0_15ck160 = 1.0 time = 805
* CHECK dout0_16 vdout0_16ck160 = 1.0 time = 805
* CHECK dout0_17 vdout0_17ck160 = 1.0 time = 805
* CHECK dout0_18 vdout0_18ck160 = 1.0 time = 805
* CHECK dout0_19 vdout0_19ck160 = 1.0 time = 805
* CHECK dout0_20 vdout0_20ck160 = 1.0 time = 805
* CHECK dout0_21 vdout0_21ck160 = 0 time = 805
* CHECK dout0_22 vdout0_22ck160 = 0 time = 805
* CHECK dout0_23 vdout0_23ck160 = 1.0 time = 805
* CHECK dout0_24 vdout0_24ck160 = 0 time = 805
* CHECK dout0_25 vdout0_25ck160 = 0 time = 805
* CHECK dout0_26 vdout0_26ck160 = 0 time = 805
* CHECK dout0_27 vdout0_27ck160 = 0 time = 805
* CHECK dout0_28 vdout0_28ck160 = 1.0 time = 805
* CHECK dout0_29 vdout0_29ck160 = 1.0 time = 805
* CHECK dout0_30 vdout0_30ck160 = 0 time = 805
* CHECK dout0_31 vdout0_31ck160 = 0 time = 805
* CHECK dout1_0 vdout1_0ck160 = 1.0 time = 805
* CHECK dout1_1 vdout1_1ck160 = 1.0 time = 805
* CHECK dout1_2 vdout1_2ck160 = 1.0 time = 805
* CHECK dout1_3 vdout1_3ck160 = 1.0 time = 805
* CHECK dout1_4 vdout1_4ck160 = 0 time = 805
* CHECK dout1_5 vdout1_5ck160 = 0 time = 805
* CHECK dout1_6 vdout1_6ck160 = 1.0 time = 805
* CHECK dout1_7 vdout1_7ck160 = 0 time = 805
* CHECK dout1_8 vdout1_8ck160 = 1.0 time = 805
* CHECK dout1_9 vdout1_9ck160 = 0 time = 805
* CHECK dout1_10 vdout1_10ck160 = 1.0 time = 805
* CHECK dout1_11 vdout1_11ck160 = 1.0 time = 805
* CHECK dout1_12 vdout1_12ck160 = 1.0 time = 805
* CHECK dout1_13 vdout1_13ck160 = 1.0 time = 805
* CHECK dout1_14 vdout1_14ck160 = 0 time = 805
* CHECK dout1_15 vdout1_15ck160 = 1.0 time = 805
* CHECK dout1_16 vdout1_16ck160 = 0 time = 805
* CHECK dout1_17 vdout1_17ck160 = 1.0 time = 805
* CHECK dout1_18 vdout1_18ck160 = 1.0 time = 805
* CHECK dout1_19 vdout1_19ck160 = 0 time = 805
* CHECK dout1_20 vdout1_20ck160 = 1.0 time = 805
* CHECK dout1_21 vdout1_21ck160 = 0 time = 805
* CHECK dout1_22 vdout1_22ck160 = 1.0 time = 805
* CHECK dout1_23 vdout1_23ck160 = 0 time = 805
* CHECK dout1_24 vdout1_24ck160 = 1.0 time = 805
* CHECK dout1_25 vdout1_25ck160 = 0 time = 805
* CHECK dout1_26 vdout1_26ck160 = 1.0 time = 805
* CHECK dout1_27 vdout1_27ck160 = 0 time = 805
* CHECK dout1_28 vdout1_28ck160 = 0 time = 805
* CHECK dout1_29 vdout1_29ck160 = 1.0 time = 805
* CHECK dout1_30 vdout1_30ck160 = 0 time = 805
* CHECK dout1_31 vdout1_31ck160 = 1.0 time = 805
* CHECK dout0_0 vdout0_0ck161 = 1.0 time = 810
* CHECK dout0_1 vdout0_1ck161 = 1.0 time = 810
* CHECK dout0_2 vdout0_2ck161 = 1.0 time = 810
* CHECK dout0_3 vdout0_3ck161 = 1.0 time = 810
* CHECK dout0_4 vdout0_4ck161 = 1.0 time = 810
* CHECK dout0_5 vdout0_5ck161 = 1.0 time = 810
* CHECK dout0_6 vdout0_6ck161 = 1.0 time = 810
* CHECK dout0_7 vdout0_7ck161 = 1.0 time = 810
* CHECK dout0_8 vdout0_8ck161 = 1.0 time = 810
* CHECK dout0_9 vdout0_9ck161 = 1.0 time = 810
* CHECK dout0_10 vdout0_10ck161 = 1.0 time = 810
* CHECK dout0_11 vdout0_11ck161 = 0 time = 810
* CHECK dout0_12 vdout0_12ck161 = 1.0 time = 810
* CHECK dout0_13 vdout0_13ck161 = 0 time = 810
* CHECK dout0_14 vdout0_14ck161 = 0 time = 810
* CHECK dout0_15 vdout0_15ck161 = 1.0 time = 810
* CHECK dout0_16 vdout0_16ck161 = 1.0 time = 810
* CHECK dout0_17 vdout0_17ck161 = 1.0 time = 810
* CHECK dout0_18 vdout0_18ck161 = 1.0 time = 810
* CHECK dout0_19 vdout0_19ck161 = 1.0 time = 810
* CHECK dout0_20 vdout0_20ck161 = 1.0 time = 810
* CHECK dout0_21 vdout0_21ck161 = 0 time = 810
* CHECK dout0_22 vdout0_22ck161 = 0 time = 810
* CHECK dout0_23 vdout0_23ck161 = 1.0 time = 810
* CHECK dout0_24 vdout0_24ck161 = 0 time = 810
* CHECK dout0_25 vdout0_25ck161 = 0 time = 810
* CHECK dout0_26 vdout0_26ck161 = 0 time = 810
* CHECK dout0_27 vdout0_27ck161 = 0 time = 810
* CHECK dout0_28 vdout0_28ck161 = 1.0 time = 810
* CHECK dout0_29 vdout0_29ck161 = 1.0 time = 810
* CHECK dout0_30 vdout0_30ck161 = 0 time = 810
* CHECK dout0_31 vdout0_31ck161 = 0 time = 810
* CHECK dout1_0 vdout1_0ck161 = 0 time = 810
* CHECK dout1_1 vdout1_1ck161 = 1.0 time = 810
* CHECK dout1_2 vdout1_2ck161 = 0 time = 810
* CHECK dout1_3 vdout1_3ck161 = 0 time = 810
* CHECK dout1_4 vdout1_4ck161 = 1.0 time = 810
* CHECK dout1_5 vdout1_5ck161 = 1.0 time = 810
* CHECK dout1_6 vdout1_6ck161 = 1.0 time = 810
* CHECK dout1_7 vdout1_7ck161 = 1.0 time = 810
* CHECK dout1_8 vdout1_8ck161 = 1.0 time = 810
* CHECK dout1_9 vdout1_9ck161 = 0 time = 810
* CHECK dout1_10 vdout1_10ck161 = 0 time = 810
* CHECK dout1_11 vdout1_11ck161 = 1.0 time = 810
* CHECK dout1_12 vdout1_12ck161 = 1.0 time = 810
* CHECK dout1_13 vdout1_13ck161 = 0 time = 810
* CHECK dout1_14 vdout1_14ck161 = 0 time = 810
* CHECK dout1_15 vdout1_15ck161 = 1.0 time = 810
* CHECK dout1_16 vdout1_16ck161 = 1.0 time = 810
* CHECK dout1_17 vdout1_17ck161 = 1.0 time = 810
* CHECK dout1_18 vdout1_18ck161 = 1.0 time = 810
* CHECK dout1_19 vdout1_19ck161 = 0 time = 810
* CHECK dout1_20 vdout1_20ck161 = 0 time = 810
* CHECK dout1_21 vdout1_21ck161 = 0 time = 810
* CHECK dout1_22 vdout1_22ck161 = 1.0 time = 810
* CHECK dout1_23 vdout1_23ck161 = 1.0 time = 810
* CHECK dout1_24 vdout1_24ck161 = 1.0 time = 810
* CHECK dout1_25 vdout1_25ck161 = 1.0 time = 810
* CHECK dout1_26 vdout1_26ck161 = 0 time = 810
* CHECK dout1_27 vdout1_27ck161 = 0 time = 810
* CHECK dout1_28 vdout1_28ck161 = 0 time = 810
* CHECK dout1_29 vdout1_29ck161 = 0 time = 810
* CHECK dout1_30 vdout1_30ck161 = 0 time = 810
* CHECK dout1_31 vdout1_31ck161 = 1.0 time = 810
* CHECK dout0_0 vdout0_0ck165 = 1.0 time = 830
* CHECK dout0_1 vdout0_1ck165 = 1.0 time = 830
* CHECK dout0_2 vdout0_2ck165 = 0 time = 830
* CHECK dout0_3 vdout0_3ck165 = 0 time = 830
* CHECK dout0_4 vdout0_4ck165 = 0 time = 830
* CHECK dout0_5 vdout0_5ck165 = 1.0 time = 830
* CHECK dout0_6 vdout0_6ck165 = 0 time = 830
* CHECK dout0_7 vdout0_7ck165 = 1.0 time = 830
* CHECK dout0_8 vdout0_8ck165 = 0 time = 830
* CHECK dout0_9 vdout0_9ck165 = 1.0 time = 830
* CHECK dout0_10 vdout0_10ck165 = 0 time = 830
* CHECK dout0_11 vdout0_11ck165 = 1.0 time = 830
* CHECK dout0_12 vdout0_12ck165 = 0 time = 830
* CHECK dout0_13 vdout0_13ck165 = 1.0 time = 830
* CHECK dout0_14 vdout0_14ck165 = 0 time = 830
* CHECK dout0_15 vdout0_15ck165 = 0 time = 830
* CHECK dout0_16 vdout0_16ck165 = 1.0 time = 830
* CHECK dout0_17 vdout0_17ck165 = 0 time = 830
* CHECK dout0_18 vdout0_18ck165 = 0 time = 830
* CHECK dout0_19 vdout0_19ck165 = 0 time = 830
* CHECK dout0_20 vdout0_20ck165 = 1.0 time = 830
* CHECK dout0_21 vdout0_21ck165 = 1.0 time = 830
* CHECK dout0_22 vdout0_22ck165 = 0 time = 830
* CHECK dout0_23 vdout0_23ck165 = 1.0 time = 830
* CHECK dout0_24 vdout0_24ck165 = 0 time = 830
* CHECK dout0_25 vdout0_25ck165 = 0 time = 830
* CHECK dout0_26 vdout0_26ck165 = 1.0 time = 830
* CHECK dout0_27 vdout0_27ck165 = 0 time = 830
* CHECK dout0_28 vdout0_28ck165 = 0 time = 830
* CHECK dout0_29 vdout0_29ck165 = 0 time = 830
* CHECK dout0_30 vdout0_30ck165 = 1.0 time = 830
* CHECK dout0_31 vdout0_31ck165 = 1.0 time = 830
* CHECK dout1_0 vdout1_0ck165 = 0 time = 830
* CHECK dout1_1 vdout1_1ck165 = 1.0 time = 830
* CHECK dout1_2 vdout1_2ck165 = 0 time = 830
* CHECK dout1_3 vdout1_3ck165 = 0 time = 830
* CHECK dout1_4 vdout1_4ck165 = 1.0 time = 830
* CHECK dout1_5 vdout1_5ck165 = 1.0 time = 830
* CHECK dout1_6 vdout1_6ck165 = 1.0 time = 830
* CHECK dout1_7 vdout1_7ck165 = 1.0 time = 830
* CHECK dout1_8 vdout1_8ck165 = 1.0 time = 830
* CHECK dout1_9 vdout1_9ck165 = 0 time = 830
* CHECK dout1_10 vdout1_10ck165 = 0 time = 830
* CHECK dout1_11 vdout1_11ck165 = 1.0 time = 830
* CHECK dout1_12 vdout1_12ck165 = 1.0 time = 830
* CHECK dout1_13 vdout1_13ck165 = 0 time = 830
* CHECK dout1_14 vdout1_14ck165 = 0 time = 830
* CHECK dout1_15 vdout1_15ck165 = 1.0 time = 830
* CHECK dout1_16 vdout1_16ck165 = 1.0 time = 830
* CHECK dout1_17 vdout1_17ck165 = 1.0 time = 830
* CHECK dout1_18 vdout1_18ck165 = 1.0 time = 830
* CHECK dout1_19 vdout1_19ck165 = 0 time = 830
* CHECK dout1_20 vdout1_20ck165 = 0 time = 830
* CHECK dout1_21 vdout1_21ck165 = 0 time = 830
* CHECK dout1_22 vdout1_22ck165 = 1.0 time = 830
* CHECK dout1_23 vdout1_23ck165 = 1.0 time = 830
* CHECK dout1_24 vdout1_24ck165 = 1.0 time = 830
* CHECK dout1_25 vdout1_25ck165 = 1.0 time = 830
* CHECK dout1_26 vdout1_26ck165 = 0 time = 830
* CHECK dout1_27 vdout1_27ck165 = 0 time = 830
* CHECK dout1_28 vdout1_28ck165 = 0 time = 830
* CHECK dout1_29 vdout1_29ck165 = 0 time = 830
* CHECK dout1_30 vdout1_30ck165 = 0 time = 830
* CHECK dout1_31 vdout1_31ck165 = 1.0 time = 830
* CHECK dout0_0 vdout0_0ck166 = 0 time = 835
* CHECK dout0_1 vdout0_1ck166 = 0 time = 835
* CHECK dout0_2 vdout0_2ck166 = 0 time = 835
* CHECK dout0_3 vdout0_3ck166 = 1.0 time = 835
* CHECK dout0_4 vdout0_4ck166 = 1.0 time = 835
* CHECK dout0_5 vdout0_5ck166 = 1.0 time = 835
* CHECK dout0_6 vdout0_6ck166 = 0 time = 835
* CHECK dout0_7 vdout0_7ck166 = 1.0 time = 835
* CHECK dout0_8 vdout0_8ck166 = 0 time = 835
* CHECK dout0_9 vdout0_9ck166 = 1.0 time = 835
* CHECK dout0_10 vdout0_10ck166 = 0 time = 835
* CHECK dout0_11 vdout0_11ck166 = 0 time = 835
* CHECK dout0_12 vdout0_12ck166 = 0 time = 835
* CHECK dout0_13 vdout0_13ck166 = 0 time = 835
* CHECK dout0_14 vdout0_14ck166 = 1.0 time = 835
* CHECK dout0_15 vdout0_15ck166 = 0 time = 835
* CHECK dout0_16 vdout0_16ck166 = 1.0 time = 835
* CHECK dout0_17 vdout0_17ck166 = 1.0 time = 835
* CHECK dout0_18 vdout0_18ck166 = 0 time = 835
* CHECK dout0_19 vdout0_19ck166 = 0 time = 835
* CHECK dout0_20 vdout0_20ck166 = 1.0 time = 835
* CHECK dout0_21 vdout0_21ck166 = 0 time = 835
* CHECK dout0_22 vdout0_22ck166 = 0 time = 835
* CHECK dout0_23 vdout0_23ck166 = 1.0 time = 835
* CHECK dout0_24 vdout0_24ck166 = 0 time = 835
* CHECK dout0_25 vdout0_25ck166 = 1.0 time = 835
* CHECK dout0_26 vdout0_26ck166 = 1.0 time = 835
* CHECK dout0_27 vdout0_27ck166 = 0 time = 835
* CHECK dout0_28 vdout0_28ck166 = 1.0 time = 835
* CHECK dout0_29 vdout0_29ck166 = 0 time = 835
* CHECK dout0_30 vdout0_30ck166 = 0 time = 835
* CHECK dout0_31 vdout0_31ck166 = 1.0 time = 835
* CHECK dout1_0 vdout1_0ck166 = 1.0 time = 835
* CHECK dout1_1 vdout1_1ck166 = 0 time = 835
* CHECK dout1_2 vdout1_2ck166 = 1.0 time = 835
* CHECK dout1_3 vdout1_3ck166 = 0 time = 835
* CHECK dout1_4 vdout1_4ck166 = 0 time = 835
* CHECK dout1_5 vdout1_5ck166 = 1.0 time = 835
* CHECK dout1_6 vdout1_6ck166 = 0 time = 835
* CHECK dout1_7 vdout1_7ck166 = 0 time = 835
* CHECK dout1_8 vdout1_8ck166 = 0 time = 835
* CHECK dout1_9 vdout1_9ck166 = 0 time = 835
* CHECK dout1_10 vdout1_10ck166 = 1.0 time = 835
* CHECK dout1_11 vdout1_11ck166 = 1.0 time = 835
* CHECK dout1_12 vdout1_12ck166 = 0 time = 835
* CHECK dout1_13 vdout1_13ck166 = 1.0 time = 835
* CHECK dout1_14 vdout1_14ck166 = 0 time = 835
* CHECK dout1_15 vdout1_15ck166 = 1.0 time = 835
* CHECK dout1_16 vdout1_16ck166 = 1.0 time = 835
* CHECK dout1_17 vdout1_17ck166 = 0 time = 835
* CHECK dout1_18 vdout1_18ck166 = 0 time = 835
* CHECK dout1_19 vdout1_19ck166 = 1.0 time = 835
* CHECK dout1_20 vdout1_20ck166 = 1.0 time = 835
* CHECK dout1_21 vdout1_21ck166 = 0 time = 835
* CHECK dout1_22 vdout1_22ck166 = 1.0 time = 835
* CHECK dout1_23 vdout1_23ck166 = 1.0 time = 835
* CHECK dout1_24 vdout1_24ck166 = 0 time = 835
* CHECK dout1_25 vdout1_25ck166 = 0 time = 835
* CHECK dout1_26 vdout1_26ck166 = 0 time = 835
* CHECK dout1_27 vdout1_27ck166 = 0 time = 835
* CHECK dout1_28 vdout1_28ck166 = 0 time = 835
* CHECK dout1_29 vdout1_29ck166 = 0 time = 835
* CHECK dout1_30 vdout1_30ck166 = 1.0 time = 835
* CHECK dout1_31 vdout1_31ck166 = 0 time = 835
* CHECK dout0_0 vdout0_0ck167 = 1.0 time = 840
* CHECK dout0_1 vdout0_1ck167 = 0 time = 840
* CHECK dout0_2 vdout0_2ck167 = 1.0 time = 840
* CHECK dout0_3 vdout0_3ck167 = 0 time = 840
* CHECK dout0_4 vdout0_4ck167 = 0 time = 840
* CHECK dout0_5 vdout0_5ck167 = 0 time = 840
* CHECK dout0_6 vdout0_6ck167 = 0 time = 840
* CHECK dout0_7 vdout0_7ck167 = 1.0 time = 840
* CHECK dout0_8 vdout0_8ck167 = 0 time = 840
* CHECK dout0_9 vdout0_9ck167 = 1.0 time = 840
* CHECK dout0_10 vdout0_10ck167 = 0 time = 840
* CHECK dout0_11 vdout0_11ck167 = 1.0 time = 840
* CHECK dout0_12 vdout0_12ck167 = 0 time = 840
* CHECK dout0_13 vdout0_13ck167 = 1.0 time = 840
* CHECK dout0_14 vdout0_14ck167 = 0 time = 840
* CHECK dout0_15 vdout0_15ck167 = 1.0 time = 840
* CHECK dout0_16 vdout0_16ck167 = 1.0 time = 840
* CHECK dout0_17 vdout0_17ck167 = 0 time = 840
* CHECK dout0_18 vdout0_18ck167 = 1.0 time = 840
* CHECK dout0_19 vdout0_19ck167 = 1.0 time = 840
* CHECK dout0_20 vdout0_20ck167 = 1.0 time = 840
* CHECK dout0_21 vdout0_21ck167 = 1.0 time = 840
* CHECK dout0_22 vdout0_22ck167 = 0 time = 840
* CHECK dout0_23 vdout0_23ck167 = 1.0 time = 840
* CHECK dout0_24 vdout0_24ck167 = 0 time = 840
* CHECK dout0_25 vdout0_25ck167 = 1.0 time = 840
* CHECK dout0_26 vdout0_26ck167 = 0 time = 840
* CHECK dout0_27 vdout0_27ck167 = 0 time = 840
* CHECK dout0_28 vdout0_28ck167 = 1.0 time = 840
* CHECK dout0_29 vdout0_29ck167 = 1.0 time = 840
* CHECK dout0_30 vdout0_30ck167 = 1.0 time = 840
* CHECK dout0_31 vdout0_31ck167 = 0 time = 840
* CHECK dout1_0 vdout1_0ck167 = 1.0 time = 840
* CHECK dout1_1 vdout1_1ck167 = 1.0 time = 840
* CHECK dout1_2 vdout1_2ck167 = 0 time = 840
* CHECK dout1_3 vdout1_3ck167 = 1.0 time = 840
* CHECK dout1_4 vdout1_4ck167 = 1.0 time = 840
* CHECK dout1_5 vdout1_5ck167 = 1.0 time = 840
* CHECK dout1_6 vdout1_6ck167 = 0 time = 840
* CHECK dout1_7 vdout1_7ck167 = 1.0 time = 840
* CHECK dout1_8 vdout1_8ck167 = 0 time = 840
* CHECK dout1_9 vdout1_9ck167 = 0 time = 840
* CHECK dout1_10 vdout1_10ck167 = 1.0 time = 840
* CHECK dout1_11 vdout1_11ck167 = 0 time = 840
* CHECK dout1_12 vdout1_12ck167 = 1.0 time = 840
* CHECK dout1_13 vdout1_13ck167 = 0 time = 840
* CHECK dout1_14 vdout1_14ck167 = 1.0 time = 840
* CHECK dout1_15 vdout1_15ck167 = 0 time = 840
* CHECK dout1_16 vdout1_16ck167 = 1.0 time = 840
* CHECK dout1_17 vdout1_17ck167 = 0 time = 840
* CHECK dout1_18 vdout1_18ck167 = 1.0 time = 840
* CHECK dout1_19 vdout1_19ck167 = 0 time = 840
* CHECK dout1_20 vdout1_20ck167 = 1.0 time = 840
* CHECK dout1_21 vdout1_21ck167 = 1.0 time = 840
* CHECK dout1_22 vdout1_22ck167 = 0 time = 840
* CHECK dout1_23 vdout1_23ck167 = 0 time = 840
* CHECK dout1_24 vdout1_24ck167 = 0 time = 840
* CHECK dout1_25 vdout1_25ck167 = 0 time = 840
* CHECK dout1_26 vdout1_26ck167 = 0 time = 840
* CHECK dout1_27 vdout1_27ck167 = 0 time = 840
* CHECK dout1_28 vdout1_28ck167 = 1.0 time = 840
* CHECK dout1_29 vdout1_29ck167 = 0 time = 840
* CHECK dout1_30 vdout1_30ck167 = 0 time = 840
* CHECK dout1_31 vdout1_31ck167 = 0 time = 840
* CHECK dout0_0 vdout0_0ck168 = 1.0 time = 845
* CHECK dout0_1 vdout0_1ck168 = 1.0 time = 845
* CHECK dout0_2 vdout0_2ck168 = 0 time = 845
* CHECK dout0_3 vdout0_3ck168 = 0 time = 845
* CHECK dout0_4 vdout0_4ck168 = 0 time = 845
* CHECK dout0_5 vdout0_5ck168 = 1.0 time = 845
* CHECK dout0_6 vdout0_6ck168 = 0 time = 845
* CHECK dout0_7 vdout0_7ck168 = 1.0 time = 845
* CHECK dout0_8 vdout0_8ck168 = 0 time = 845
* CHECK dout0_9 vdout0_9ck168 = 1.0 time = 845
* CHECK dout0_10 vdout0_10ck168 = 0 time = 845
* CHECK dout0_11 vdout0_11ck168 = 1.0 time = 845
* CHECK dout0_12 vdout0_12ck168 = 0 time = 845
* CHECK dout0_13 vdout0_13ck168 = 1.0 time = 845
* CHECK dout0_14 vdout0_14ck168 = 0 time = 845
* CHECK dout0_15 vdout0_15ck168 = 0 time = 845
* CHECK dout0_16 vdout0_16ck168 = 1.0 time = 845
* CHECK dout0_17 vdout0_17ck168 = 0 time = 845
* CHECK dout0_18 vdout0_18ck168 = 0 time = 845
* CHECK dout0_19 vdout0_19ck168 = 0 time = 845
* CHECK dout0_20 vdout0_20ck168 = 1.0 time = 845
* CHECK dout0_21 vdout0_21ck168 = 1.0 time = 845
* CHECK dout0_22 vdout0_22ck168 = 0 time = 845
* CHECK dout0_23 vdout0_23ck168 = 1.0 time = 845
* CHECK dout0_24 vdout0_24ck168 = 0 time = 845
* CHECK dout0_25 vdout0_25ck168 = 0 time = 845
* CHECK dout0_26 vdout0_26ck168 = 1.0 time = 845
* CHECK dout0_27 vdout0_27ck168 = 0 time = 845
* CHECK dout0_28 vdout0_28ck168 = 0 time = 845
* CHECK dout0_29 vdout0_29ck168 = 0 time = 845
* CHECK dout0_30 vdout0_30ck168 = 1.0 time = 845
* CHECK dout0_31 vdout0_31ck168 = 1.0 time = 845
* CHECK dout1_0 vdout1_0ck168 = 0 time = 845
* CHECK dout1_1 vdout1_1ck168 = 1.0 time = 845
* CHECK dout1_2 vdout1_2ck168 = 0 time = 845
* CHECK dout1_3 vdout1_3ck168 = 0 time = 845
* CHECK dout1_4 vdout1_4ck168 = 1.0 time = 845
* CHECK dout1_5 vdout1_5ck168 = 1.0 time = 845
* CHECK dout1_6 vdout1_6ck168 = 1.0 time = 845
* CHECK dout1_7 vdout1_7ck168 = 1.0 time = 845
* CHECK dout1_8 vdout1_8ck168 = 1.0 time = 845
* CHECK dout1_9 vdout1_9ck168 = 0 time = 845
* CHECK dout1_10 vdout1_10ck168 = 0 time = 845
* CHECK dout1_11 vdout1_11ck168 = 1.0 time = 845
* CHECK dout1_12 vdout1_12ck168 = 1.0 time = 845
* CHECK dout1_13 vdout1_13ck168 = 0 time = 845
* CHECK dout1_14 vdout1_14ck168 = 0 time = 845
* CHECK dout1_15 vdout1_15ck168 = 1.0 time = 845
* CHECK dout1_16 vdout1_16ck168 = 1.0 time = 845
* CHECK dout1_17 vdout1_17ck168 = 1.0 time = 845
* CHECK dout1_18 vdout1_18ck168 = 1.0 time = 845
* CHECK dout1_19 vdout1_19ck168 = 0 time = 845
* CHECK dout1_20 vdout1_20ck168 = 0 time = 845
* CHECK dout1_21 vdout1_21ck168 = 0 time = 845
* CHECK dout1_22 vdout1_22ck168 = 1.0 time = 845
* CHECK dout1_23 vdout1_23ck168 = 1.0 time = 845
* CHECK dout1_24 vdout1_24ck168 = 1.0 time = 845
* CHECK dout1_25 vdout1_25ck168 = 1.0 time = 845
* CHECK dout1_26 vdout1_26ck168 = 0 time = 845
* CHECK dout1_27 vdout1_27ck168 = 0 time = 845
* CHECK dout1_28 vdout1_28ck168 = 0 time = 845
* CHECK dout1_29 vdout1_29ck168 = 0 time = 845
* CHECK dout1_30 vdout1_30ck168 = 0 time = 845
* CHECK dout1_31 vdout1_31ck168 = 1.0 time = 845
* CHECK dout0_0 vdout0_0ck169 = 1.0 time = 850
* CHECK dout0_1 vdout0_1ck169 = 1.0 time = 850
* CHECK dout0_2 vdout0_2ck169 = 0 time = 850
* CHECK dout0_3 vdout0_3ck169 = 0 time = 850
* CHECK dout0_4 vdout0_4ck169 = 0 time = 850
* CHECK dout0_5 vdout0_5ck169 = 1.0 time = 850
* CHECK dout0_6 vdout0_6ck169 = 0 time = 850
* CHECK dout0_7 vdout0_7ck169 = 1.0 time = 850
* CHECK dout0_8 vdout0_8ck169 = 0 time = 850
* CHECK dout0_9 vdout0_9ck169 = 1.0 time = 850
* CHECK dout0_10 vdout0_10ck169 = 0 time = 850
* CHECK dout0_11 vdout0_11ck169 = 1.0 time = 850
* CHECK dout0_12 vdout0_12ck169 = 0 time = 850
* CHECK dout0_13 vdout0_13ck169 = 1.0 time = 850
* CHECK dout0_14 vdout0_14ck169 = 0 time = 850
* CHECK dout0_15 vdout0_15ck169 = 0 time = 850
* CHECK dout0_16 vdout0_16ck169 = 1.0 time = 850
* CHECK dout0_17 vdout0_17ck169 = 0 time = 850
* CHECK dout0_18 vdout0_18ck169 = 0 time = 850
* CHECK dout0_19 vdout0_19ck169 = 0 time = 850
* CHECK dout0_20 vdout0_20ck169 = 1.0 time = 850
* CHECK dout0_21 vdout0_21ck169 = 1.0 time = 850
* CHECK dout0_22 vdout0_22ck169 = 0 time = 850
* CHECK dout0_23 vdout0_23ck169 = 1.0 time = 850
* CHECK dout0_24 vdout0_24ck169 = 0 time = 850
* CHECK dout0_25 vdout0_25ck169 = 0 time = 850
* CHECK dout0_26 vdout0_26ck169 = 1.0 time = 850
* CHECK dout0_27 vdout0_27ck169 = 0 time = 850
* CHECK dout0_28 vdout0_28ck169 = 0 time = 850
* CHECK dout0_29 vdout0_29ck169 = 0 time = 850
* CHECK dout0_30 vdout0_30ck169 = 1.0 time = 850
* CHECK dout0_31 vdout0_31ck169 = 1.0 time = 850
* CHECK dout1_0 vdout1_0ck169 = 1.0 time = 850
* CHECK dout1_1 vdout1_1ck169 = 0 time = 850
* CHECK dout1_2 vdout1_2ck169 = 1.0 time = 850
* CHECK dout1_3 vdout1_3ck169 = 0 time = 850
* CHECK dout1_4 vdout1_4ck169 = 0 time = 850
* CHECK dout1_5 vdout1_5ck169 = 0 time = 850
* CHECK dout1_6 vdout1_6ck169 = 0 time = 850
* CHECK dout1_7 vdout1_7ck169 = 1.0 time = 850
* CHECK dout1_8 vdout1_8ck169 = 0 time = 850
* CHECK dout1_9 vdout1_9ck169 = 1.0 time = 850
* CHECK dout1_10 vdout1_10ck169 = 0 time = 850
* CHECK dout1_11 vdout1_11ck169 = 1.0 time = 850
* CHECK dout1_12 vdout1_12ck169 = 0 time = 850
* CHECK dout1_13 vdout1_13ck169 = 1.0 time = 850
* CHECK dout1_14 vdout1_14ck169 = 0 time = 850
* CHECK dout1_15 vdout1_15ck169 = 1.0 time = 850
* CHECK dout1_16 vdout1_16ck169 = 1.0 time = 850
* CHECK dout1_17 vdout1_17ck169 = 0 time = 850
* CHECK dout1_18 vdout1_18ck169 = 1.0 time = 850
* CHECK dout1_19 vdout1_19ck169 = 1.0 time = 850
* CHECK dout1_20 vdout1_20ck169 = 1.0 time = 850
* CHECK dout1_21 vdout1_21ck169 = 1.0 time = 850
* CHECK dout1_22 vdout1_22ck169 = 0 time = 850
* CHECK dout1_23 vdout1_23ck169 = 1.0 time = 850
* CHECK dout1_24 vdout1_24ck169 = 0 time = 850
* CHECK dout1_25 vdout1_25ck169 = 1.0 time = 850
* CHECK dout1_26 vdout1_26ck169 = 0 time = 850
* CHECK dout1_27 vdout1_27ck169 = 0 time = 850
* CHECK dout1_28 vdout1_28ck169 = 1.0 time = 850
* CHECK dout1_29 vdout1_29ck169 = 1.0 time = 850
* CHECK dout1_30 vdout1_30ck169 = 1.0 time = 850
* CHECK dout1_31 vdout1_31ck169 = 0 time = 850
* CHECK dout1_0 vdout1_0ck170 = 0 time = 855
* CHECK dout1_1 vdout1_1ck170 = 0 time = 855
* CHECK dout1_2 vdout1_2ck170 = 0 time = 855
* CHECK dout1_3 vdout1_3ck170 = 1.0 time = 855
* CHECK dout1_4 vdout1_4ck170 = 1.0 time = 855
* CHECK dout1_5 vdout1_5ck170 = 0 time = 855
* CHECK dout1_6 vdout1_6ck170 = 0 time = 855
* CHECK dout1_7 vdout1_7ck170 = 1.0 time = 855
* CHECK dout1_8 vdout1_8ck170 = 0 time = 855
* CHECK dout1_9 vdout1_9ck170 = 1.0 time = 855
* CHECK dout1_10 vdout1_10ck170 = 1.0 time = 855
* CHECK dout1_11 vdout1_11ck170 = 0 time = 855
* CHECK dout1_12 vdout1_12ck170 = 0 time = 855
* CHECK dout1_13 vdout1_13ck170 = 1.0 time = 855
* CHECK dout1_14 vdout1_14ck170 = 0 time = 855
* CHECK dout1_15 vdout1_15ck170 = 1.0 time = 855
* CHECK dout1_16 vdout1_16ck170 = 1.0 time = 855
* CHECK dout1_17 vdout1_17ck170 = 1.0 time = 855
* CHECK dout1_18 vdout1_18ck170 = 0 time = 855
* CHECK dout1_19 vdout1_19ck170 = 1.0 time = 855
* CHECK dout1_20 vdout1_20ck170 = 1.0 time = 855
* CHECK dout1_21 vdout1_21ck170 = 0 time = 855
* CHECK dout1_22 vdout1_22ck170 = 1.0 time = 855
* CHECK dout1_23 vdout1_23ck170 = 0 time = 855
* CHECK dout1_24 vdout1_24ck170 = 1.0 time = 855
* CHECK dout1_25 vdout1_25ck170 = 1.0 time = 855
* CHECK dout1_26 vdout1_26ck170 = 1.0 time = 855
* CHECK dout1_27 vdout1_27ck170 = 0 time = 855
* CHECK dout1_28 vdout1_28ck170 = 1.0 time = 855
* CHECK dout1_29 vdout1_29ck170 = 0 time = 855
* CHECK dout1_30 vdout1_30ck170 = 0 time = 855
* CHECK dout1_31 vdout1_31ck170 = 1.0 time = 855
* CHECK dout0_0 vdout0_0ck173 = 1.0 time = 870
* CHECK dout0_1 vdout0_1ck173 = 0 time = 870
* CHECK dout0_2 vdout0_2ck173 = 1.0 time = 870
* CHECK dout0_3 vdout0_3ck173 = 0 time = 870
* CHECK dout0_4 vdout0_4ck173 = 0 time = 870
* CHECK dout0_5 vdout0_5ck173 = 1.0 time = 870
* CHECK dout0_6 vdout0_6ck173 = 0 time = 870
* CHECK dout0_7 vdout0_7ck173 = 0 time = 870
* CHECK dout0_8 vdout0_8ck173 = 0 time = 870
* CHECK dout0_9 vdout0_9ck173 = 0 time = 870
* CHECK dout0_10 vdout0_10ck173 = 1.0 time = 870
* CHECK dout0_11 vdout0_11ck173 = 1.0 time = 870
* CHECK dout0_12 vdout0_12ck173 = 0 time = 870
* CHECK dout0_13 vdout0_13ck173 = 1.0 time = 870
* CHECK dout0_14 vdout0_14ck173 = 0 time = 870
* CHECK dout0_15 vdout0_15ck173 = 1.0 time = 870
* CHECK dout0_16 vdout0_16ck173 = 1.0 time = 870
* CHECK dout0_17 vdout0_17ck173 = 0 time = 870
* CHECK dout0_18 vdout0_18ck173 = 0 time = 870
* CHECK dout0_19 vdout0_19ck173 = 1.0 time = 870
* CHECK dout0_20 vdout0_20ck173 = 1.0 time = 870
* CHECK dout0_21 vdout0_21ck173 = 0 time = 870
* CHECK dout0_22 vdout0_22ck173 = 1.0 time = 870
* CHECK dout0_23 vdout0_23ck173 = 1.0 time = 870
* CHECK dout0_24 vdout0_24ck173 = 0 time = 870
* CHECK dout0_25 vdout0_25ck173 = 0 time = 870
* CHECK dout0_26 vdout0_26ck173 = 0 time = 870
* CHECK dout0_27 vdout0_27ck173 = 0 time = 870
* CHECK dout0_28 vdout0_28ck173 = 0 time = 870
* CHECK dout0_29 vdout0_29ck173 = 0 time = 870
* CHECK dout0_30 vdout0_30ck173 = 1.0 time = 870
* CHECK dout0_31 vdout0_31ck173 = 0 time = 870
* CHECK dout1_0 vdout1_0ck173 = 0 time = 870
* CHECK dout1_1 vdout1_1ck173 = 0 time = 870
* CHECK dout1_2 vdout1_2ck173 = 0 time = 870
* CHECK dout1_3 vdout1_3ck173 = 1.0 time = 870
* CHECK dout1_4 vdout1_4ck173 = 1.0 time = 870
* CHECK dout1_5 vdout1_5ck173 = 1.0 time = 870
* CHECK dout1_6 vdout1_6ck173 = 0 time = 870
* CHECK dout1_7 vdout1_7ck173 = 1.0 time = 870
* CHECK dout1_8 vdout1_8ck173 = 0 time = 870
* CHECK dout1_9 vdout1_9ck173 = 1.0 time = 870
* CHECK dout1_10 vdout1_10ck173 = 0 time = 870
* CHECK dout1_11 vdout1_11ck173 = 0 time = 870
* CHECK dout1_12 vdout1_12ck173 = 0 time = 870
* CHECK dout1_13 vdout1_13ck173 = 0 time = 870
* CHECK dout1_14 vdout1_14ck173 = 1.0 time = 870
* CHECK dout1_15 vdout1_15ck173 = 0 time = 870
* CHECK dout1_16 vdout1_16ck173 = 1.0 time = 870
* CHECK dout1_17 vdout1_17ck173 = 1.0 time = 870
* CHECK dout1_18 vdout1_18ck173 = 0 time = 870
* CHECK dout1_19 vdout1_19ck173 = 0 time = 870
* CHECK dout1_20 vdout1_20ck173 = 1.0 time = 870
* CHECK dout1_21 vdout1_21ck173 = 0 time = 870
* CHECK dout1_22 vdout1_22ck173 = 0 time = 870
* CHECK dout1_23 vdout1_23ck173 = 1.0 time = 870
* CHECK dout1_24 vdout1_24ck173 = 0 time = 870
* CHECK dout1_25 vdout1_25ck173 = 1.0 time = 870
* CHECK dout1_26 vdout1_26ck173 = 1.0 time = 870
* CHECK dout1_27 vdout1_27ck173 = 0 time = 870
* CHECK dout1_28 vdout1_28ck173 = 1.0 time = 870
* CHECK dout1_29 vdout1_29ck173 = 0 time = 870
* CHECK dout1_30 vdout1_30ck173 = 0 time = 870
* CHECK dout1_31 vdout1_31ck173 = 1.0 time = 870
* CHECK dout1_0 vdout1_0ck174 = 1.0 time = 875
* CHECK dout1_1 vdout1_1ck174 = 1.0 time = 875
* CHECK dout1_2 vdout1_2ck174 = 0 time = 875
* CHECK dout1_3 vdout1_3ck174 = 0 time = 875
* CHECK dout1_4 vdout1_4ck174 = 0 time = 875
* CHECK dout1_5 vdout1_5ck174 = 1.0 time = 875
* CHECK dout1_6 vdout1_6ck174 = 0 time = 875
* CHECK dout1_7 vdout1_7ck174 = 1.0 time = 875
* CHECK dout1_8 vdout1_8ck174 = 0 time = 875
* CHECK dout1_9 vdout1_9ck174 = 1.0 time = 875
* CHECK dout1_10 vdout1_10ck174 = 0 time = 875
* CHECK dout1_11 vdout1_11ck174 = 1.0 time = 875
* CHECK dout1_12 vdout1_12ck174 = 0 time = 875
* CHECK dout1_13 vdout1_13ck174 = 1.0 time = 875
* CHECK dout1_14 vdout1_14ck174 = 0 time = 875
* CHECK dout1_15 vdout1_15ck174 = 0 time = 875
* CHECK dout1_16 vdout1_16ck174 = 1.0 time = 875
* CHECK dout1_17 vdout1_17ck174 = 0 time = 875
* CHECK dout1_18 vdout1_18ck174 = 0 time = 875
* CHECK dout1_19 vdout1_19ck174 = 0 time = 875
* CHECK dout1_20 vdout1_20ck174 = 1.0 time = 875
* CHECK dout1_21 vdout1_21ck174 = 1.0 time = 875
* CHECK dout1_22 vdout1_22ck174 = 0 time = 875
* CHECK dout1_23 vdout1_23ck174 = 1.0 time = 875
* CHECK dout1_24 vdout1_24ck174 = 0 time = 875
* CHECK dout1_25 vdout1_25ck174 = 0 time = 875
* CHECK dout1_26 vdout1_26ck174 = 1.0 time = 875
* CHECK dout1_27 vdout1_27ck174 = 0 time = 875
* CHECK dout1_28 vdout1_28ck174 = 0 time = 875
* CHECK dout1_29 vdout1_29ck174 = 0 time = 875
* CHECK dout1_30 vdout1_30ck174 = 1.0 time = 875
* CHECK dout1_31 vdout1_31ck174 = 1.0 time = 875
* CHECK dout0_0 vdout0_0ck175 = 0 time = 880
* CHECK dout0_1 vdout0_1ck175 = 0 time = 880
* CHECK dout0_2 vdout0_2ck175 = 0 time = 880
* CHECK dout0_3 vdout0_3ck175 = 1.0 time = 880
* CHECK dout0_4 vdout0_4ck175 = 1.0 time = 880
* CHECK dout0_5 vdout0_5ck175 = 1.0 time = 880
* CHECK dout0_6 vdout0_6ck175 = 0 time = 880
* CHECK dout0_7 vdout0_7ck175 = 1.0 time = 880
* CHECK dout0_8 vdout0_8ck175 = 0 time = 880
* CHECK dout0_9 vdout0_9ck175 = 1.0 time = 880
* CHECK dout0_10 vdout0_10ck175 = 0 time = 880
* CHECK dout0_11 vdout0_11ck175 = 0 time = 880
* CHECK dout0_12 vdout0_12ck175 = 0 time = 880
* CHECK dout0_13 vdout0_13ck175 = 0 time = 880
* CHECK dout0_14 vdout0_14ck175 = 1.0 time = 880
* CHECK dout0_15 vdout0_15ck175 = 0 time = 880
* CHECK dout0_16 vdout0_16ck175 = 1.0 time = 880
* CHECK dout0_17 vdout0_17ck175 = 1.0 time = 880
* CHECK dout0_18 vdout0_18ck175 = 0 time = 880
* CHECK dout0_19 vdout0_19ck175 = 0 time = 880
* CHECK dout0_20 vdout0_20ck175 = 1.0 time = 880
* CHECK dout0_21 vdout0_21ck175 = 0 time = 880
* CHECK dout0_22 vdout0_22ck175 = 0 time = 880
* CHECK dout0_23 vdout0_23ck175 = 1.0 time = 880
* CHECK dout0_24 vdout0_24ck175 = 0 time = 880
* CHECK dout0_25 vdout0_25ck175 = 1.0 time = 880
* CHECK dout0_26 vdout0_26ck175 = 1.0 time = 880
* CHECK dout0_27 vdout0_27ck175 = 0 time = 880
* CHECK dout0_28 vdout0_28ck175 = 1.0 time = 880
* CHECK dout0_29 vdout0_29ck175 = 0 time = 880
* CHECK dout0_30 vdout0_30ck175 = 0 time = 880
* CHECK dout0_31 vdout0_31ck175 = 1.0 time = 880
* CHECK dout1_0 vdout1_0ck175 = 0 time = 880
* CHECK dout1_1 vdout1_1ck175 = 1.0 time = 880
* CHECK dout1_2 vdout1_2ck175 = 0 time = 880
* CHECK dout1_3 vdout1_3ck175 = 1.0 time = 880
* CHECK dout1_4 vdout1_4ck175 = 1.0 time = 880
* CHECK dout1_5 vdout1_5ck175 = 1.0 time = 880
* CHECK dout1_6 vdout1_6ck175 = 0 time = 880
* CHECK dout1_7 vdout1_7ck175 = 1.0 time = 880
* CHECK dout1_8 vdout1_8ck175 = 0 time = 880
* CHECK dout1_9 vdout1_9ck175 = 1.0 time = 880
* CHECK dout1_10 vdout1_10ck175 = 1.0 time = 880
* CHECK dout1_11 vdout1_11ck175 = 0 time = 880
* CHECK dout1_12 vdout1_12ck175 = 1.0 time = 880
* CHECK dout1_13 vdout1_13ck175 = 1.0 time = 880
* CHECK dout1_14 vdout1_14ck175 = 0 time = 880
* CHECK dout1_15 vdout1_15ck175 = 0 time = 880
* CHECK dout1_16 vdout1_16ck175 = 0 time = 880
* CHECK dout1_17 vdout1_17ck175 = 1.0 time = 880
* CHECK dout1_18 vdout1_18ck175 = 0 time = 880
* CHECK dout1_19 vdout1_19ck175 = 0 time = 880
* CHECK dout1_20 vdout1_20ck175 = 1.0 time = 880
* CHECK dout1_21 vdout1_21ck175 = 0 time = 880
* CHECK dout1_22 vdout1_22ck175 = 0 time = 880
* CHECK dout1_23 vdout1_23ck175 = 0 time = 880
* CHECK dout1_24 vdout1_24ck175 = 0 time = 880
* CHECK dout1_25 vdout1_25ck175 = 1.0 time = 880
* CHECK dout1_26 vdout1_26ck175 = 1.0 time = 880
* CHECK dout1_27 vdout1_27ck175 = 1.0 time = 880
* CHECK dout1_28 vdout1_28ck175 = 0 time = 880
* CHECK dout1_29 vdout1_29ck175 = 0 time = 880
* CHECK dout1_30 vdout1_30ck175 = 0 time = 880
* CHECK dout1_31 vdout1_31ck175 = 0 time = 880
* CHECK dout0_0 vdout0_0ck176 = 1.0 time = 885
* CHECK dout0_1 vdout0_1ck176 = 0 time = 885
* CHECK dout0_2 vdout0_2ck176 = 1.0 time = 885
* CHECK dout0_3 vdout0_3ck176 = 0 time = 885
* CHECK dout0_4 vdout0_4ck176 = 0 time = 885
* CHECK dout0_5 vdout0_5ck176 = 1.0 time = 885
* CHECK dout0_6 vdout0_6ck176 = 0 time = 885
* CHECK dout0_7 vdout0_7ck176 = 0 time = 885
* CHECK dout0_8 vdout0_8ck176 = 0 time = 885
* CHECK dout0_9 vdout0_9ck176 = 0 time = 885
* CHECK dout0_10 vdout0_10ck176 = 1.0 time = 885
* CHECK dout0_11 vdout0_11ck176 = 1.0 time = 885
* CHECK dout0_12 vdout0_12ck176 = 0 time = 885
* CHECK dout0_13 vdout0_13ck176 = 1.0 time = 885
* CHECK dout0_14 vdout0_14ck176 = 0 time = 885
* CHECK dout0_15 vdout0_15ck176 = 1.0 time = 885
* CHECK dout0_16 vdout0_16ck176 = 1.0 time = 885
* CHECK dout0_17 vdout0_17ck176 = 0 time = 885
* CHECK dout0_18 vdout0_18ck176 = 0 time = 885
* CHECK dout0_19 vdout0_19ck176 = 1.0 time = 885
* CHECK dout0_20 vdout0_20ck176 = 1.0 time = 885
* CHECK dout0_21 vdout0_21ck176 = 0 time = 885
* CHECK dout0_22 vdout0_22ck176 = 1.0 time = 885
* CHECK dout0_23 vdout0_23ck176 = 1.0 time = 885
* CHECK dout0_24 vdout0_24ck176 = 0 time = 885
* CHECK dout0_25 vdout0_25ck176 = 0 time = 885
* CHECK dout0_26 vdout0_26ck176 = 0 time = 885
* CHECK dout0_27 vdout0_27ck176 = 0 time = 885
* CHECK dout0_28 vdout0_28ck176 = 0 time = 885
* CHECK dout0_29 vdout0_29ck176 = 0 time = 885
* CHECK dout0_30 vdout0_30ck176 = 1.0 time = 885
* CHECK dout0_31 vdout0_31ck176 = 0 time = 885
* CHECK dout0_0 vdout0_0ck177 = 0 time = 890
* CHECK dout0_1 vdout0_1ck177 = 0 time = 890
* CHECK dout0_2 vdout0_2ck177 = 0 time = 890
* CHECK dout0_3 vdout0_3ck177 = 1.0 time = 890
* CHECK dout0_4 vdout0_4ck177 = 0 time = 890
* CHECK dout0_5 vdout0_5ck177 = 1.0 time = 890
* CHECK dout0_6 vdout0_6ck177 = 1.0 time = 890
* CHECK dout0_7 vdout0_7ck177 = 1.0 time = 890
* CHECK dout0_8 vdout0_8ck177 = 1.0 time = 890
* CHECK dout0_9 vdout0_9ck177 = 0 time = 890
* CHECK dout0_10 vdout0_10ck177 = 1.0 time = 890
* CHECK dout0_11 vdout0_11ck177 = 1.0 time = 890
* CHECK dout0_12 vdout0_12ck177 = 1.0 time = 890
* CHECK dout0_13 vdout0_13ck177 = 1.0 time = 890
* CHECK dout0_14 vdout0_14ck177 = 0 time = 890
* CHECK dout0_15 vdout0_15ck177 = 0 time = 890
* CHECK dout0_16 vdout0_16ck177 = 1.0 time = 890
* CHECK dout0_17 vdout0_17ck177 = 0 time = 890
* CHECK dout0_18 vdout0_18ck177 = 1.0 time = 890
* CHECK dout0_19 vdout0_19ck177 = 0 time = 890
* CHECK dout0_20 vdout0_20ck177 = 1.0 time = 890
* CHECK dout0_21 vdout0_21ck177 = 0 time = 890
* CHECK dout0_22 vdout0_22ck177 = 1.0 time = 890
* CHECK dout0_23 vdout0_23ck177 = 1.0 time = 890
* CHECK dout0_24 vdout0_24ck177 = 0 time = 890
* CHECK dout0_25 vdout0_25ck177 = 1.0 time = 890
* CHECK dout0_26 vdout0_26ck177 = 0 time = 890
* CHECK dout0_27 vdout0_27ck177 = 1.0 time = 890
* CHECK dout0_28 vdout0_28ck177 = 0 time = 890
* CHECK dout0_29 vdout0_29ck177 = 1.0 time = 890
* CHECK dout0_30 vdout0_30ck177 = 1.0 time = 890
* CHECK dout0_31 vdout0_31ck177 = 0 time = 890
* CHECK dout1_0 vdout1_0ck177 = 0 time = 890
* CHECK dout1_1 vdout1_1ck177 = 1.0 time = 890
* CHECK dout1_2 vdout1_2ck177 = 0 time = 890
* CHECK dout1_3 vdout1_3ck177 = 0 time = 890
* CHECK dout1_4 vdout1_4ck177 = 1.0 time = 890
* CHECK dout1_5 vdout1_5ck177 = 1.0 time = 890
* CHECK dout1_6 vdout1_6ck177 = 1.0 time = 890
* CHECK dout1_7 vdout1_7ck177 = 1.0 time = 890
* CHECK dout1_8 vdout1_8ck177 = 1.0 time = 890
* CHECK dout1_9 vdout1_9ck177 = 0 time = 890
* CHECK dout1_10 vdout1_10ck177 = 0 time = 890
* CHECK dout1_11 vdout1_11ck177 = 1.0 time = 890
* CHECK dout1_12 vdout1_12ck177 = 1.0 time = 890
* CHECK dout1_13 vdout1_13ck177 = 0 time = 890
* CHECK dout1_14 vdout1_14ck177 = 0 time = 890
* CHECK dout1_15 vdout1_15ck177 = 1.0 time = 890
* CHECK dout1_16 vdout1_16ck177 = 1.0 time = 890
* CHECK dout1_17 vdout1_17ck177 = 1.0 time = 890
* CHECK dout1_18 vdout1_18ck177 = 1.0 time = 890
* CHECK dout1_19 vdout1_19ck177 = 0 time = 890
* CHECK dout1_20 vdout1_20ck177 = 0 time = 890
* CHECK dout1_21 vdout1_21ck177 = 0 time = 890
* CHECK dout1_22 vdout1_22ck177 = 1.0 time = 890
* CHECK dout1_23 vdout1_23ck177 = 1.0 time = 890
* CHECK dout1_24 vdout1_24ck177 = 1.0 time = 890
* CHECK dout1_25 vdout1_25ck177 = 1.0 time = 890
* CHECK dout1_26 vdout1_26ck177 = 0 time = 890
* CHECK dout1_27 vdout1_27ck177 = 0 time = 890
* CHECK dout1_28 vdout1_28ck177 = 0 time = 890
* CHECK dout1_29 vdout1_29ck177 = 0 time = 890
* CHECK dout1_30 vdout1_30ck177 = 0 time = 890
* CHECK dout1_31 vdout1_31ck177 = 1.0 time = 890
* CHECK dout0_0 vdout0_0ck178 = 0 time = 895
* CHECK dout0_1 vdout0_1ck178 = 0 time = 895
* CHECK dout0_2 vdout0_2ck178 = 0 time = 895
* CHECK dout0_3 vdout0_3ck178 = 1.0 time = 895
* CHECK dout0_4 vdout0_4ck178 = 0 time = 895
* CHECK dout0_5 vdout0_5ck178 = 1.0 time = 895
* CHECK dout0_6 vdout0_6ck178 = 1.0 time = 895
* CHECK dout0_7 vdout0_7ck178 = 1.0 time = 895
* CHECK dout0_8 vdout0_8ck178 = 1.0 time = 895
* CHECK dout0_9 vdout0_9ck178 = 0 time = 895
* CHECK dout0_10 vdout0_10ck178 = 1.0 time = 895
* CHECK dout0_11 vdout0_11ck178 = 1.0 time = 895
* CHECK dout0_12 vdout0_12ck178 = 1.0 time = 895
* CHECK dout0_13 vdout0_13ck178 = 1.0 time = 895
* CHECK dout0_14 vdout0_14ck178 = 0 time = 895
* CHECK dout0_15 vdout0_15ck178 = 0 time = 895
* CHECK dout0_16 vdout0_16ck178 = 1.0 time = 895
* CHECK dout0_17 vdout0_17ck178 = 0 time = 895
* CHECK dout0_18 vdout0_18ck178 = 1.0 time = 895
* CHECK dout0_19 vdout0_19ck178 = 0 time = 895
* CHECK dout0_20 vdout0_20ck178 = 1.0 time = 895
* CHECK dout0_21 vdout0_21ck178 = 0 time = 895
* CHECK dout0_22 vdout0_22ck178 = 1.0 time = 895
* CHECK dout0_23 vdout0_23ck178 = 1.0 time = 895
* CHECK dout0_24 vdout0_24ck178 = 0 time = 895
* CHECK dout0_25 vdout0_25ck178 = 1.0 time = 895
* CHECK dout0_26 vdout0_26ck178 = 0 time = 895
* CHECK dout0_27 vdout0_27ck178 = 1.0 time = 895
* CHECK dout0_28 vdout0_28ck178 = 0 time = 895
* CHECK dout0_29 vdout0_29ck178 = 1.0 time = 895
* CHECK dout0_30 vdout0_30ck178 = 1.0 time = 895
* CHECK dout0_31 vdout0_31ck178 = 0 time = 895
* CHECK dout0_0 vdout0_0ck179 = 0 time = 900
* CHECK dout0_1 vdout0_1ck179 = 1.0 time = 900
* CHECK dout0_2 vdout0_2ck179 = 0 time = 900
* CHECK dout0_3 vdout0_3ck179 = 0 time = 900
* CHECK dout0_4 vdout0_4ck179 = 1.0 time = 900
* CHECK dout0_5 vdout0_5ck179 = 1.0 time = 900
* CHECK dout0_6 vdout0_6ck179 = 1.0 time = 900
* CHECK dout0_7 vdout0_7ck179 = 1.0 time = 900
* CHECK dout0_8 vdout0_8ck179 = 1.0 time = 900
* CHECK dout0_9 vdout0_9ck179 = 0 time = 900
* CHECK dout0_10 vdout0_10ck179 = 0 time = 900
* CHECK dout0_11 vdout0_11ck179 = 1.0 time = 900
* CHECK dout0_12 vdout0_12ck179 = 1.0 time = 900
* CHECK dout0_13 vdout0_13ck179 = 0 time = 900
* CHECK dout0_14 vdout0_14ck179 = 0 time = 900
* CHECK dout0_15 vdout0_15ck179 = 1.0 time = 900
* CHECK dout0_16 vdout0_16ck179 = 1.0 time = 900
* CHECK dout0_17 vdout0_17ck179 = 1.0 time = 900
* CHECK dout0_18 vdout0_18ck179 = 1.0 time = 900
* CHECK dout0_19 vdout0_19ck179 = 0 time = 900
* CHECK dout0_20 vdout0_20ck179 = 0 time = 900
* CHECK dout0_21 vdout0_21ck179 = 0 time = 900
* CHECK dout0_22 vdout0_22ck179 = 1.0 time = 900
* CHECK dout0_23 vdout0_23ck179 = 1.0 time = 900
* CHECK dout0_24 vdout0_24ck179 = 1.0 time = 900
* CHECK dout0_25 vdout0_25ck179 = 1.0 time = 900
* CHECK dout0_26 vdout0_26ck179 = 0 time = 900
* CHECK dout0_27 vdout0_27ck179 = 0 time = 900
* CHECK dout0_28 vdout0_28ck179 = 0 time = 900
* CHECK dout0_29 vdout0_29ck179 = 0 time = 900
* CHECK dout0_30 vdout0_30ck179 = 0 time = 900
* CHECK dout0_31 vdout0_31ck179 = 1.0 time = 900
* CHECK dout1_0 vdout1_0ck180 = 1.0 time = 905
* CHECK dout1_1 vdout1_1ck180 = 1.0 time = 905
* CHECK dout1_2 vdout1_2ck180 = 1.0 time = 905
* CHECK dout1_3 vdout1_3ck180 = 1.0 time = 905
* CHECK dout1_4 vdout1_4ck180 = 0 time = 905
* CHECK dout1_5 vdout1_5ck180 = 1.0 time = 905
* CHECK dout1_6 vdout1_6ck180 = 0 time = 905
* CHECK dout1_7 vdout1_7ck180 = 0 time = 905
* CHECK dout1_8 vdout1_8ck180 = 0 time = 905
* CHECK dout1_9 vdout1_9ck180 = 0 time = 905
* CHECK dout1_10 vdout1_10ck180 = 0 time = 905
* CHECK dout1_11 vdout1_11ck180 = 1.0 time = 905
* CHECK dout1_12 vdout1_12ck180 = 1.0 time = 905
* CHECK dout1_13 vdout1_13ck180 = 1.0 time = 905
* CHECK dout1_14 vdout1_14ck180 = 0 time = 905
* CHECK dout1_15 vdout1_15ck180 = 0 time = 905
* CHECK dout1_16 vdout1_16ck180 = 1.0 time = 905
* CHECK dout1_17 vdout1_17ck180 = 0 time = 905
* CHECK dout1_18 vdout1_18ck180 = 1.0 time = 905
* CHECK dout1_19 vdout1_19ck180 = 1.0 time = 905
* CHECK dout1_20 vdout1_20ck180 = 0 time = 905
* CHECK dout1_21 vdout1_21ck180 = 0 time = 905
* CHECK dout1_22 vdout1_22ck180 = 1.0 time = 905
* CHECK dout1_23 vdout1_23ck180 = 0 time = 905
* CHECK dout1_24 vdout1_24ck180 = 1.0 time = 905
* CHECK dout1_25 vdout1_25ck180 = 1.0 time = 905
* CHECK dout1_26 vdout1_26ck180 = 0 time = 905
* CHECK dout1_27 vdout1_27ck180 = 1.0 time = 905
* CHECK dout1_28 vdout1_28ck180 = 1.0 time = 905
* CHECK dout1_29 vdout1_29ck180 = 1.0 time = 905
* CHECK dout1_30 vdout1_30ck180 = 0 time = 905
* CHECK dout1_31 vdout1_31ck180 = 0 time = 905
* CHECK dout1_0 vdout1_0ck181 = 1.0 time = 910
* CHECK dout1_1 vdout1_1ck181 = 1.0 time = 910
* CHECK dout1_2 vdout1_2ck181 = 1.0 time = 910
* CHECK dout1_3 vdout1_3ck181 = 1.0 time = 910
* CHECK dout1_4 vdout1_4ck181 = 0 time = 910
* CHECK dout1_5 vdout1_5ck181 = 1.0 time = 910
* CHECK dout1_6 vdout1_6ck181 = 0 time = 910
* CHECK dout1_7 vdout1_7ck181 = 0 time = 910
* CHECK dout1_8 vdout1_8ck181 = 0 time = 910
* CHECK dout1_9 vdout1_9ck181 = 0 time = 910
* CHECK dout1_10 vdout1_10ck181 = 0 time = 910
* CHECK dout1_11 vdout1_11ck181 = 1.0 time = 910
* CHECK dout1_12 vdout1_12ck181 = 1.0 time = 910
* CHECK dout1_13 vdout1_13ck181 = 1.0 time = 910
* CHECK dout1_14 vdout1_14ck181 = 0 time = 910
* CHECK dout1_15 vdout1_15ck181 = 0 time = 910
* CHECK dout1_16 vdout1_16ck181 = 1.0 time = 910
* CHECK dout1_17 vdout1_17ck181 = 0 time = 910
* CHECK dout1_18 vdout1_18ck181 = 1.0 time = 910
* CHECK dout1_19 vdout1_19ck181 = 1.0 time = 910
* CHECK dout1_20 vdout1_20ck181 = 0 time = 910
* CHECK dout1_21 vdout1_21ck181 = 0 time = 910
* CHECK dout1_22 vdout1_22ck181 = 1.0 time = 910
* CHECK dout1_23 vdout1_23ck181 = 0 time = 910
* CHECK dout1_24 vdout1_24ck181 = 1.0 time = 910
* CHECK dout1_25 vdout1_25ck181 = 1.0 time = 910
* CHECK dout1_26 vdout1_26ck181 = 0 time = 910
* CHECK dout1_27 vdout1_27ck181 = 1.0 time = 910
* CHECK dout1_28 vdout1_28ck181 = 1.0 time = 910
* CHECK dout1_29 vdout1_29ck181 = 1.0 time = 910
* CHECK dout1_30 vdout1_30ck181 = 0 time = 910
* CHECK dout1_31 vdout1_31ck181 = 0 time = 910
* CHECK dout0_0 vdout0_0ck183 = 1.0 time = 920
* CHECK dout0_1 vdout0_1ck183 = 1.0 time = 920
* CHECK dout0_2 vdout0_2ck183 = 0 time = 920
* CHECK dout0_3 vdout0_3ck183 = 1.0 time = 920
* CHECK dout0_4 vdout0_4ck183 = 1.0 time = 920
* CHECK dout0_5 vdout0_5ck183 = 1.0 time = 920
* CHECK dout0_6 vdout0_6ck183 = 0 time = 920
* CHECK dout0_7 vdout0_7ck183 = 1.0 time = 920
* CHECK dout0_8 vdout0_8ck183 = 0 time = 920
* CHECK dout0_9 vdout0_9ck183 = 0 time = 920
* CHECK dout0_10 vdout0_10ck183 = 1.0 time = 920
* CHECK dout0_11 vdout0_11ck183 = 0 time = 920
* CHECK dout0_12 vdout0_12ck183 = 1.0 time = 920
* CHECK dout0_13 vdout0_13ck183 = 0 time = 920
* CHECK dout0_14 vdout0_14ck183 = 1.0 time = 920
* CHECK dout0_15 vdout0_15ck183 = 0 time = 920
* CHECK dout0_16 vdout0_16ck183 = 1.0 time = 920
* CHECK dout0_17 vdout0_17ck183 = 0 time = 920
* CHECK dout0_18 vdout0_18ck183 = 1.0 time = 920
* CHECK dout0_19 vdout0_19ck183 = 0 time = 920
* CHECK dout0_20 vdout0_20ck183 = 1.0 time = 920
* CHECK dout0_21 vdout0_21ck183 = 1.0 time = 920
* CHECK dout0_22 vdout0_22ck183 = 0 time = 920
* CHECK dout0_23 vdout0_23ck183 = 0 time = 920
* CHECK dout0_24 vdout0_24ck183 = 0 time = 920
* CHECK dout0_25 vdout0_25ck183 = 0 time = 920
* CHECK dout0_26 vdout0_26ck183 = 0 time = 920
* CHECK dout0_27 vdout0_27ck183 = 0 time = 920
* CHECK dout0_28 vdout0_28ck183 = 1.0 time = 920
* CHECK dout0_29 vdout0_29ck183 = 0 time = 920
* CHECK dout0_30 vdout0_30ck183 = 0 time = 920
* CHECK dout0_31 vdout0_31ck183 = 0 time = 920
* CHECK dout1_0 vdout1_0ck183 = 0 time = 920
* CHECK dout1_1 vdout1_1ck183 = 1.0 time = 920
* CHECK dout1_2 vdout1_2ck183 = 0 time = 920
* CHECK dout1_3 vdout1_3ck183 = 1.0 time = 920
* CHECK dout1_4 vdout1_4ck183 = 1.0 time = 920
* CHECK dout1_5 vdout1_5ck183 = 0 time = 920
* CHECK dout1_6 vdout1_6ck183 = 1.0 time = 920
* CHECK dout1_7 vdout1_7ck183 = 1.0 time = 920
* CHECK dout1_8 vdout1_8ck183 = 1.0 time = 920
* CHECK dout1_9 vdout1_9ck183 = 1.0 time = 920
* CHECK dout1_10 vdout1_10ck183 = 0 time = 920
* CHECK dout1_11 vdout1_11ck183 = 1.0 time = 920
* CHECK dout1_12 vdout1_12ck183 = 0 time = 920
* CHECK dout1_13 vdout1_13ck183 = 1.0 time = 920
* CHECK dout1_14 vdout1_14ck183 = 1.0 time = 920
* CHECK dout1_15 vdout1_15ck183 = 0 time = 920
* CHECK dout1_16 vdout1_16ck183 = 1.0 time = 920
* CHECK dout1_17 vdout1_17ck183 = 1.0 time = 920
* CHECK dout1_18 vdout1_18ck183 = 1.0 time = 920
* CHECK dout1_19 vdout1_19ck183 = 0 time = 920
* CHECK dout1_20 vdout1_20ck183 = 0 time = 920
* CHECK dout1_21 vdout1_21ck183 = 1.0 time = 920
* CHECK dout1_22 vdout1_22ck183 = 0 time = 920
* CHECK dout1_23 vdout1_23ck183 = 0 time = 920
* CHECK dout1_24 vdout1_24ck183 = 1.0 time = 920
* CHECK dout1_25 vdout1_25ck183 = 1.0 time = 920
* CHECK dout1_26 vdout1_26ck183 = 0 time = 920
* CHECK dout1_27 vdout1_27ck183 = 0 time = 920
* CHECK dout1_28 vdout1_28ck183 = 0 time = 920
* CHECK dout1_29 vdout1_29ck183 = 0 time = 920
* CHECK dout1_30 vdout1_30ck183 = 0 time = 920
* CHECK dout1_31 vdout1_31ck183 = 1.0 time = 920
* CHECK dout0_0 vdout0_0ck186 = 1.0 time = 935
* CHECK dout0_1 vdout0_1ck186 = 1.0 time = 935
* CHECK dout0_2 vdout0_2ck186 = 0 time = 935
* CHECK dout0_3 vdout0_3ck186 = 0 time = 935
* CHECK dout0_4 vdout0_4ck186 = 1.0 time = 935
* CHECK dout0_5 vdout0_5ck186 = 0 time = 935
* CHECK dout0_6 vdout0_6ck186 = 1.0 time = 935
* CHECK dout0_7 vdout0_7ck186 = 0 time = 935
* CHECK dout0_8 vdout0_8ck186 = 0 time = 935
* CHECK dout0_9 vdout0_9ck186 = 1.0 time = 935
* CHECK dout0_10 vdout0_10ck186 = 1.0 time = 935
* CHECK dout0_11 vdout0_11ck186 = 1.0 time = 935
* CHECK dout0_12 vdout0_12ck186 = 0 time = 935
* CHECK dout0_13 vdout0_13ck186 = 1.0 time = 935
* CHECK dout0_14 vdout0_14ck186 = 0 time = 935
* CHECK dout0_15 vdout0_15ck186 = 1.0 time = 935
* CHECK dout0_16 vdout0_16ck186 = 1.0 time = 935
* CHECK dout0_17 vdout0_17ck186 = 1.0 time = 935
* CHECK dout0_18 vdout0_18ck186 = 0 time = 935
* CHECK dout0_19 vdout0_19ck186 = 0 time = 935
* CHECK dout0_20 vdout0_20ck186 = 0 time = 935
* CHECK dout0_21 vdout0_21ck186 = 0 time = 935
* CHECK dout0_22 vdout0_22ck186 = 0 time = 935
* CHECK dout0_23 vdout0_23ck186 = 0 time = 935
* CHECK dout0_24 vdout0_24ck186 = 1.0 time = 935
* CHECK dout0_25 vdout0_25ck186 = 0 time = 935
* CHECK dout0_26 vdout0_26ck186 = 1.0 time = 935
* CHECK dout0_27 vdout0_27ck186 = 1.0 time = 935
* CHECK dout0_28 vdout0_28ck186 = 0 time = 935
* CHECK dout0_29 vdout0_29ck186 = 1.0 time = 935
* CHECK dout0_30 vdout0_30ck186 = 1.0 time = 935
* CHECK dout0_31 vdout0_31ck186 = 0 time = 935
* CHECK dout0_0 vdout0_0ck188 = 1.0 time = 945
* CHECK dout0_1 vdout0_1ck188 = 1.0 time = 945
* CHECK dout0_2 vdout0_2ck188 = 1.0 time = 945
* CHECK dout0_3 vdout0_3ck188 = 1.0 time = 945
* CHECK dout0_4 vdout0_4ck188 = 0 time = 945
* CHECK dout0_5 vdout0_5ck188 = 1.0 time = 945
* CHECK dout0_6 vdout0_6ck188 = 0 time = 945
* CHECK dout0_7 vdout0_7ck188 = 0 time = 945
* CHECK dout0_8 vdout0_8ck188 = 0 time = 945
* CHECK dout0_9 vdout0_9ck188 = 0 time = 945
* CHECK dout0_10 vdout0_10ck188 = 0 time = 945
* CHECK dout0_11 vdout0_11ck188 = 1.0 time = 945
* CHECK dout0_12 vdout0_12ck188 = 1.0 time = 945
* CHECK dout0_13 vdout0_13ck188 = 1.0 time = 945
* CHECK dout0_14 vdout0_14ck188 = 0 time = 945
* CHECK dout0_15 vdout0_15ck188 = 0 time = 945
* CHECK dout0_16 vdout0_16ck188 = 1.0 time = 945
* CHECK dout0_17 vdout0_17ck188 = 0 time = 945
* CHECK dout0_18 vdout0_18ck188 = 1.0 time = 945
* CHECK dout0_19 vdout0_19ck188 = 1.0 time = 945
* CHECK dout0_20 vdout0_20ck188 = 0 time = 945
* CHECK dout0_21 vdout0_21ck188 = 0 time = 945
* CHECK dout0_22 vdout0_22ck188 = 1.0 time = 945
* CHECK dout0_23 vdout0_23ck188 = 0 time = 945
* CHECK dout0_24 vdout0_24ck188 = 1.0 time = 945
* CHECK dout0_25 vdout0_25ck188 = 1.0 time = 945
* CHECK dout0_26 vdout0_26ck188 = 0 time = 945
* CHECK dout0_27 vdout0_27ck188 = 1.0 time = 945
* CHECK dout0_28 vdout0_28ck188 = 1.0 time = 945
* CHECK dout0_29 vdout0_29ck188 = 1.0 time = 945
* CHECK dout0_30 vdout0_30ck188 = 0 time = 945
* CHECK dout0_31 vdout0_31ck188 = 0 time = 945
* CHECK dout1_0 vdout1_0ck188 = 0 time = 945
* CHECK dout1_1 vdout1_1ck188 = 1.0 time = 945
* CHECK dout1_2 vdout1_2ck188 = 1.0 time = 945
* CHECK dout1_3 vdout1_3ck188 = 1.0 time = 945
* CHECK dout1_4 vdout1_4ck188 = 1.0 time = 945
* CHECK dout1_5 vdout1_5ck188 = 0 time = 945
* CHECK dout1_6 vdout1_6ck188 = 1.0 time = 945
* CHECK dout1_7 vdout1_7ck188 = 0 time = 945
* CHECK dout1_8 vdout1_8ck188 = 0 time = 945
* CHECK dout1_9 vdout1_9ck188 = 1.0 time = 945
* CHECK dout1_10 vdout1_10ck188 = 1.0 time = 945
* CHECK dout1_11 vdout1_11ck188 = 1.0 time = 945
* CHECK dout1_12 vdout1_12ck188 = 0 time = 945
* CHECK dout1_13 vdout1_13ck188 = 1.0 time = 945
* CHECK dout1_14 vdout1_14ck188 = 0 time = 945
* CHECK dout1_15 vdout1_15ck188 = 1.0 time = 945
* CHECK dout1_16 vdout1_16ck188 = 0 time = 945
* CHECK dout1_17 vdout1_17ck188 = 1.0 time = 945
* CHECK dout1_18 vdout1_18ck188 = 0 time = 945
* CHECK dout1_19 vdout1_19ck188 = 1.0 time = 945
* CHECK dout1_20 vdout1_20ck188 = 1.0 time = 945
* CHECK dout1_21 vdout1_21ck188 = 0 time = 945
* CHECK dout1_22 vdout1_22ck188 = 1.0 time = 945
* CHECK dout1_23 vdout1_23ck188 = 1.0 time = 945
* CHECK dout1_24 vdout1_24ck188 = 0 time = 945
* CHECK dout1_25 vdout1_25ck188 = 0 time = 945
* CHECK dout1_26 vdout1_26ck188 = 1.0 time = 945
* CHECK dout1_27 vdout1_27ck188 = 1.0 time = 945
* CHECK dout1_28 vdout1_28ck188 = 1.0 time = 945
* CHECK dout1_29 vdout1_29ck188 = 0 time = 945
* CHECK dout1_30 vdout1_30ck188 = 1.0 time = 945
* CHECK dout1_31 vdout1_31ck188 = 0 time = 945
* CHECK dout1_0 vdout1_0ck189 = 0 time = 950
* CHECK dout1_1 vdout1_1ck189 = 0 time = 950
* CHECK dout1_2 vdout1_2ck189 = 0 time = 950
* CHECK dout1_3 vdout1_3ck189 = 0 time = 950
* CHECK dout1_4 vdout1_4ck189 = 1.0 time = 950
* CHECK dout1_5 vdout1_5ck189 = 0 time = 950
* CHECK dout1_6 vdout1_6ck189 = 0 time = 950
* CHECK dout1_7 vdout1_7ck189 = 1.0 time = 950
* CHECK dout1_8 vdout1_8ck189 = 0 time = 950
* CHECK dout1_9 vdout1_9ck189 = 1.0 time = 950
* CHECK dout1_10 vdout1_10ck189 = 0 time = 950
* CHECK dout1_11 vdout1_11ck189 = 1.0 time = 950
* CHECK dout1_12 vdout1_12ck189 = 1.0 time = 950
* CHECK dout1_13 vdout1_13ck189 = 0 time = 950
* CHECK dout1_14 vdout1_14ck189 = 1.0 time = 950
* CHECK dout1_15 vdout1_15ck189 = 0 time = 950
* CHECK dout1_16 vdout1_16ck189 = 1.0 time = 950
* CHECK dout1_17 vdout1_17ck189 = 0 time = 950
* CHECK dout1_18 vdout1_18ck189 = 1.0 time = 950
* CHECK dout1_19 vdout1_19ck189 = 0 time = 950
* CHECK dout1_20 vdout1_20ck189 = 0 time = 950
* CHECK dout1_21 vdout1_21ck189 = 0 time = 950
* CHECK dout1_22 vdout1_22ck189 = 1.0 time = 950
* CHECK dout1_23 vdout1_23ck189 = 1.0 time = 950
* CHECK dout1_24 vdout1_24ck189 = 0 time = 950
* CHECK dout1_25 vdout1_25ck189 = 1.0 time = 950
* CHECK dout1_26 vdout1_26ck189 = 0 time = 950
* CHECK dout1_27 vdout1_27ck189 = 0 time = 950
* CHECK dout1_28 vdout1_28ck189 = 1.0 time = 950
* CHECK dout1_29 vdout1_29ck189 = 1.0 time = 950
* CHECK dout1_30 vdout1_30ck189 = 1.0 time = 950
* CHECK dout1_31 vdout1_31ck189 = 0 time = 950
* CHECK dout0_0 vdout0_0ck190 = 1.0 time = 955
* CHECK dout0_1 vdout0_1ck190 = 1.0 time = 955
* CHECK dout0_2 vdout0_2ck190 = 1.0 time = 955
* CHECK dout0_3 vdout0_3ck190 = 0 time = 955
* CHECK dout0_4 vdout0_4ck190 = 0 time = 955
* CHECK dout0_5 vdout0_5ck190 = 0 time = 955
* CHECK dout0_6 vdout0_6ck190 = 1.0 time = 955
* CHECK dout0_7 vdout0_7ck190 = 1.0 time = 955
* CHECK dout0_8 vdout0_8ck190 = 1.0 time = 955
* CHECK dout0_9 vdout0_9ck190 = 0 time = 955
* CHECK dout0_10 vdout0_10ck190 = 0 time = 955
* CHECK dout0_11 vdout0_11ck190 = 0 time = 955
* CHECK dout0_12 vdout0_12ck190 = 0 time = 955
* CHECK dout0_13 vdout0_13ck190 = 1.0 time = 955
* CHECK dout0_14 vdout0_14ck190 = 1.0 time = 955
* CHECK dout0_15 vdout0_15ck190 = 1.0 time = 955
* CHECK dout0_16 vdout0_16ck190 = 0 time = 955
* CHECK dout0_17 vdout0_17ck190 = 1.0 time = 955
* CHECK dout0_18 vdout0_18ck190 = 1.0 time = 955
* CHECK dout0_19 vdout0_19ck190 = 0 time = 955
* CHECK dout0_20 vdout0_20ck190 = 1.0 time = 955
* CHECK dout0_21 vdout0_21ck190 = 0 time = 955
* CHECK dout0_22 vdout0_22ck190 = 0 time = 955
* CHECK dout0_23 vdout0_23ck190 = 1.0 time = 955
* CHECK dout0_24 vdout0_24ck190 = 1.0 time = 955
* CHECK dout0_25 vdout0_25ck190 = 0 time = 955
* CHECK dout0_26 vdout0_26ck190 = 0 time = 955
* CHECK dout0_27 vdout0_27ck190 = 0 time = 955
* CHECK dout0_28 vdout0_28ck190 = 1.0 time = 955
* CHECK dout0_29 vdout0_29ck190 = 0 time = 955
* CHECK dout0_30 vdout0_30ck190 = 0 time = 955
* CHECK dout0_31 vdout0_31ck190 = 1.0 time = 955
* CHECK dout0_0 vdout0_0ck193 = 0 time = 970
* CHECK dout0_1 vdout0_1ck193 = 0 time = 970
* CHECK dout0_2 vdout0_2ck193 = 0 time = 970
* CHECK dout0_3 vdout0_3ck193 = 0 time = 970
* CHECK dout0_4 vdout0_4ck193 = 1.0 time = 970
* CHECK dout0_5 vdout0_5ck193 = 1.0 time = 970
* CHECK dout0_6 vdout0_6ck193 = 0 time = 970
* CHECK dout0_7 vdout0_7ck193 = 1.0 time = 970
* CHECK dout0_8 vdout0_8ck193 = 1.0 time = 970
* CHECK dout0_9 vdout0_9ck193 = 1.0 time = 970
* CHECK dout0_10 vdout0_10ck193 = 1.0 time = 970
* CHECK dout0_11 vdout0_11ck193 = 0 time = 970
* CHECK dout0_12 vdout0_12ck193 = 1.0 time = 970
* CHECK dout0_13 vdout0_13ck193 = 0 time = 970
* CHECK dout0_14 vdout0_14ck193 = 0 time = 970
* CHECK dout0_15 vdout0_15ck193 = 1.0 time = 970
* CHECK dout0_16 vdout0_16ck193 = 1.0 time = 970
* CHECK dout0_17 vdout0_17ck193 = 1.0 time = 970
* CHECK dout0_18 vdout0_18ck193 = 1.0 time = 970
* CHECK dout0_19 vdout0_19ck193 = 0 time = 970
* CHECK dout0_20 vdout0_20ck193 = 0 time = 970
* CHECK dout0_21 vdout0_21ck193 = 0 time = 970
* CHECK dout0_22 vdout0_22ck193 = 1.0 time = 970
* CHECK dout0_23 vdout0_23ck193 = 1.0 time = 970
* CHECK dout0_24 vdout0_24ck193 = 1.0 time = 970
* CHECK dout0_25 vdout0_25ck193 = 1.0 time = 970
* CHECK dout0_26 vdout0_26ck193 = 0 time = 970
* CHECK dout0_27 vdout0_27ck193 = 1.0 time = 970
* CHECK dout0_28 vdout0_28ck193 = 0 time = 970
* CHECK dout0_29 vdout0_29ck193 = 1.0 time = 970
* CHECK dout0_30 vdout0_30ck193 = 0 time = 970
* CHECK dout0_31 vdout0_31ck193 = 0 time = 970
* CHECK dout1_0 vdout1_0ck193 = 0 time = 970
* CHECK dout1_1 vdout1_1ck193 = 1.0 time = 970
* CHECK dout1_2 vdout1_2ck193 = 0 time = 970
* CHECK dout1_3 vdout1_3ck193 = 1.0 time = 970
* CHECK dout1_4 vdout1_4ck193 = 1.0 time = 970
* CHECK dout1_5 vdout1_5ck193 = 1.0 time = 970
* CHECK dout1_6 vdout1_6ck193 = 1.0 time = 970
* CHECK dout1_7 vdout1_7ck193 = 1.0 time = 970
* CHECK dout1_8 vdout1_8ck193 = 1.0 time = 970
* CHECK dout1_9 vdout1_9ck193 = 0 time = 970
* CHECK dout1_10 vdout1_10ck193 = 1.0 time = 970
* CHECK dout1_11 vdout1_11ck193 = 1.0 time = 970
* CHECK dout1_12 vdout1_12ck193 = 1.0 time = 970
* CHECK dout1_13 vdout1_13ck193 = 1.0 time = 970
* CHECK dout1_14 vdout1_14ck193 = 0 time = 970
* CHECK dout1_15 vdout1_15ck193 = 1.0 time = 970
* CHECK dout1_16 vdout1_16ck193 = 1.0 time = 970
* CHECK dout1_17 vdout1_17ck193 = 1.0 time = 970
* CHECK dout1_18 vdout1_18ck193 = 0 time = 970
* CHECK dout1_19 vdout1_19ck193 = 0 time = 970
* CHECK dout1_20 vdout1_20ck193 = 1.0 time = 970
* CHECK dout1_21 vdout1_21ck193 = 1.0 time = 970
* CHECK dout1_22 vdout1_22ck193 = 0 time = 970
* CHECK dout1_23 vdout1_23ck193 = 1.0 time = 970
* CHECK dout1_24 vdout1_24ck193 = 0 time = 970
* CHECK dout1_25 vdout1_25ck193 = 0 time = 970
* CHECK dout1_26 vdout1_26ck193 = 0 time = 970
* CHECK dout1_27 vdout1_27ck193 = 1.0 time = 970
* CHECK dout1_28 vdout1_28ck193 = 0 time = 970
* CHECK dout1_29 vdout1_29ck193 = 0 time = 970
* CHECK dout1_30 vdout1_30ck193 = 0 time = 970
* CHECK dout1_31 vdout1_31ck193 = 0 time = 970
* CHECK dout1_0 vdout1_0ck194 = 0 time = 975
* CHECK dout1_1 vdout1_1ck194 = 1.0 time = 975
* CHECK dout1_2 vdout1_2ck194 = 0 time = 975
* CHECK dout1_3 vdout1_3ck194 = 1.0 time = 975
* CHECK dout1_4 vdout1_4ck194 = 1.0 time = 975
* CHECK dout1_5 vdout1_5ck194 = 1.0 time = 975
* CHECK dout1_6 vdout1_6ck194 = 1.0 time = 975
* CHECK dout1_7 vdout1_7ck194 = 1.0 time = 975
* CHECK dout1_8 vdout1_8ck194 = 1.0 time = 975
* CHECK dout1_9 vdout1_9ck194 = 0 time = 975
* CHECK dout1_10 vdout1_10ck194 = 1.0 time = 975
* CHECK dout1_11 vdout1_11ck194 = 1.0 time = 975
* CHECK dout1_12 vdout1_12ck194 = 1.0 time = 975
* CHECK dout1_13 vdout1_13ck194 = 1.0 time = 975
* CHECK dout1_14 vdout1_14ck194 = 0 time = 975
* CHECK dout1_15 vdout1_15ck194 = 1.0 time = 975
* CHECK dout1_16 vdout1_16ck194 = 1.0 time = 975
* CHECK dout1_17 vdout1_17ck194 = 1.0 time = 975
* CHECK dout1_18 vdout1_18ck194 = 0 time = 975
* CHECK dout1_19 vdout1_19ck194 = 0 time = 975
* CHECK dout1_20 vdout1_20ck194 = 1.0 time = 975
* CHECK dout1_21 vdout1_21ck194 = 1.0 time = 975
* CHECK dout1_22 vdout1_22ck194 = 0 time = 975
* CHECK dout1_23 vdout1_23ck194 = 1.0 time = 975
* CHECK dout1_24 vdout1_24ck194 = 0 time = 975
* CHECK dout1_25 vdout1_25ck194 = 0 time = 975
* CHECK dout1_26 vdout1_26ck194 = 0 time = 975
* CHECK dout1_27 vdout1_27ck194 = 1.0 time = 975
* CHECK dout1_28 vdout1_28ck194 = 0 time = 975
* CHECK dout1_29 vdout1_29ck194 = 0 time = 975
* CHECK dout1_30 vdout1_30ck194 = 0 time = 975
* CHECK dout1_31 vdout1_31ck194 = 0 time = 975
* CHECK dout0_0 vdout0_0ck195 = 0 time = 980
* CHECK dout0_1 vdout0_1ck195 = 0 time = 980
* CHECK dout0_2 vdout0_2ck195 = 0 time = 980
* CHECK dout0_3 vdout0_3ck195 = 0 time = 980
* CHECK dout0_4 vdout0_4ck195 = 1.0 time = 980
* CHECK dout0_5 vdout0_5ck195 = 1.0 time = 980
* CHECK dout0_6 vdout0_6ck195 = 0 time = 980
* CHECK dout0_7 vdout0_7ck195 = 1.0 time = 980
* CHECK dout0_8 vdout0_8ck195 = 1.0 time = 980
* CHECK dout0_9 vdout0_9ck195 = 1.0 time = 980
* CHECK dout0_10 vdout0_10ck195 = 1.0 time = 980
* CHECK dout0_11 vdout0_11ck195 = 0 time = 980
* CHECK dout0_12 vdout0_12ck195 = 1.0 time = 980
* CHECK dout0_13 vdout0_13ck195 = 0 time = 980
* CHECK dout0_14 vdout0_14ck195 = 0 time = 980
* CHECK dout0_15 vdout0_15ck195 = 1.0 time = 980
* CHECK dout0_16 vdout0_16ck195 = 1.0 time = 980
* CHECK dout0_17 vdout0_17ck195 = 1.0 time = 980
* CHECK dout0_18 vdout0_18ck195 = 1.0 time = 980
* CHECK dout0_19 vdout0_19ck195 = 0 time = 980
* CHECK dout0_20 vdout0_20ck195 = 0 time = 980
* CHECK dout0_21 vdout0_21ck195 = 0 time = 980
* CHECK dout0_22 vdout0_22ck195 = 1.0 time = 980
* CHECK dout0_23 vdout0_23ck195 = 1.0 time = 980
* CHECK dout0_24 vdout0_24ck195 = 1.0 time = 980
* CHECK dout0_25 vdout0_25ck195 = 1.0 time = 980
* CHECK dout0_26 vdout0_26ck195 = 0 time = 980
* CHECK dout0_27 vdout0_27ck195 = 1.0 time = 980
* CHECK dout0_28 vdout0_28ck195 = 0 time = 980
* CHECK dout0_29 vdout0_29ck195 = 1.0 time = 980
* CHECK dout0_30 vdout0_30ck195 = 0 time = 980
* CHECK dout0_31 vdout0_31ck195 = 0 time = 980
* CHECK dout1_0 vdout1_0ck195 = 1.0 time = 980
* CHECK dout1_1 vdout1_1ck195 = 1.0 time = 980
* CHECK dout1_2 vdout1_2ck195 = 0 time = 980
* CHECK dout1_3 vdout1_3ck195 = 0 time = 980
* CHECK dout1_4 vdout1_4ck195 = 0 time = 980
* CHECK dout1_5 vdout1_5ck195 = 1.0 time = 980
* CHECK dout1_6 vdout1_6ck195 = 1.0 time = 980
* CHECK dout1_7 vdout1_7ck195 = 0 time = 980
* CHECK dout1_8 vdout1_8ck195 = 1.0 time = 980
* CHECK dout1_9 vdout1_9ck195 = 1.0 time = 980
* CHECK dout1_10 vdout1_10ck195 = 1.0 time = 980
* CHECK dout1_11 vdout1_11ck195 = 0 time = 980
* CHECK dout1_12 vdout1_12ck195 = 1.0 time = 980
* CHECK dout1_13 vdout1_13ck195 = 0 time = 980
* CHECK dout1_14 vdout1_14ck195 = 0 time = 980
* CHECK dout1_15 vdout1_15ck195 = 1.0 time = 980
* CHECK dout1_16 vdout1_16ck195 = 1.0 time = 980
* CHECK dout1_17 vdout1_17ck195 = 1.0 time = 980
* CHECK dout1_18 vdout1_18ck195 = 1.0 time = 980
* CHECK dout1_19 vdout1_19ck195 = 1.0 time = 980
* CHECK dout1_20 vdout1_20ck195 = 1.0 time = 980
* CHECK dout1_21 vdout1_21ck195 = 0 time = 980
* CHECK dout1_22 vdout1_22ck195 = 0 time = 980
* CHECK dout1_23 vdout1_23ck195 = 0 time = 980
* CHECK dout1_24 vdout1_24ck195 = 1.0 time = 980
* CHECK dout1_25 vdout1_25ck195 = 0 time = 980
* CHECK dout1_26 vdout1_26ck195 = 0 time = 980
* CHECK dout1_27 vdout1_27ck195 = 1.0 time = 980
* CHECK dout1_28 vdout1_28ck195 = 0 time = 980
* CHECK dout1_29 vdout1_29ck195 = 1.0 time = 980
* CHECK dout1_30 vdout1_30ck195 = 1.0 time = 980
* CHECK dout1_31 vdout1_31ck195 = 1.0 time = 980
* CHECK dout0_0 vdout0_0ck196 = 0 time = 985
* CHECK dout0_1 vdout0_1ck196 = 1.0 time = 985
* CHECK dout0_2 vdout0_2ck196 = 0 time = 985
* CHECK dout0_3 vdout0_3ck196 = 1.0 time = 985
* CHECK dout0_4 vdout0_4ck196 = 1.0 time = 985
* CHECK dout0_5 vdout0_5ck196 = 1.0 time = 985
* CHECK dout0_6 vdout0_6ck196 = 1.0 time = 985
* CHECK dout0_7 vdout0_7ck196 = 1.0 time = 985
* CHECK dout0_8 vdout0_8ck196 = 1.0 time = 985
* CHECK dout0_9 vdout0_9ck196 = 0 time = 985
* CHECK dout0_10 vdout0_10ck196 = 1.0 time = 985
* CHECK dout0_11 vdout0_11ck196 = 1.0 time = 985
* CHECK dout0_12 vdout0_12ck196 = 1.0 time = 985
* CHECK dout0_13 vdout0_13ck196 = 1.0 time = 985
* CHECK dout0_14 vdout0_14ck196 = 0 time = 985
* CHECK dout0_15 vdout0_15ck196 = 1.0 time = 985
* CHECK dout0_16 vdout0_16ck196 = 1.0 time = 985
* CHECK dout0_17 vdout0_17ck196 = 1.0 time = 985
* CHECK dout0_18 vdout0_18ck196 = 0 time = 985
* CHECK dout0_19 vdout0_19ck196 = 0 time = 985
* CHECK dout0_20 vdout0_20ck196 = 1.0 time = 985
* CHECK dout0_21 vdout0_21ck196 = 1.0 time = 985
* CHECK dout0_22 vdout0_22ck196 = 0 time = 985
* CHECK dout0_23 vdout0_23ck196 = 1.0 time = 985
* CHECK dout0_24 vdout0_24ck196 = 0 time = 985
* CHECK dout0_25 vdout0_25ck196 = 0 time = 985
* CHECK dout0_26 vdout0_26ck196 = 0 time = 985
* CHECK dout0_27 vdout0_27ck196 = 1.0 time = 985
* CHECK dout0_28 vdout0_28ck196 = 0 time = 985
* CHECK dout0_29 vdout0_29ck196 = 0 time = 985
* CHECK dout0_30 vdout0_30ck196 = 0 time = 985
* CHECK dout0_31 vdout0_31ck196 = 0 time = 985
* CHECK dout1_0 vdout1_0ck196 = 1.0 time = 985
* CHECK dout1_1 vdout1_1ck196 = 0 time = 985
* CHECK dout1_2 vdout1_2ck196 = 1.0 time = 985
* CHECK dout1_3 vdout1_3ck196 = 0 time = 985
* CHECK dout1_4 vdout1_4ck196 = 0 time = 985
* CHECK dout1_5 vdout1_5ck196 = 0 time = 985
* CHECK dout1_6 vdout1_6ck196 = 1.0 time = 985
* CHECK dout1_7 vdout1_7ck196 = 0 time = 985
* CHECK dout1_8 vdout1_8ck196 = 0 time = 985
* CHECK dout1_9 vdout1_9ck196 = 0 time = 985
* CHECK dout1_10 vdout1_10ck196 = 1.0 time = 985
* CHECK dout1_11 vdout1_11ck196 = 0 time = 985
* CHECK dout1_12 vdout1_12ck196 = 1.0 time = 985
* CHECK dout1_13 vdout1_13ck196 = 1.0 time = 985
* CHECK dout1_14 vdout1_14ck196 = 1.0 time = 985
* CHECK dout1_15 vdout1_15ck196 = 1.0 time = 985
* CHECK dout1_16 vdout1_16ck196 = 0 time = 985
* CHECK dout1_17 vdout1_17ck196 = 1.0 time = 985
* CHECK dout1_18 vdout1_18ck196 = 1.0 time = 985
* CHECK dout1_19 vdout1_19ck196 = 1.0 time = 985
* CHECK dout1_20 vdout1_20ck196 = 0 time = 985
* CHECK dout1_21 vdout1_21ck196 = 1.0 time = 985
* CHECK dout1_22 vdout1_22ck196 = 0 time = 985
* CHECK dout1_23 vdout1_23ck196 = 0 time = 985
* CHECK dout1_24 vdout1_24ck196 = 0 time = 985
* CHECK dout1_25 vdout1_25ck196 = 0 time = 985
* CHECK dout1_26 vdout1_26ck196 = 0 time = 985
* CHECK dout1_27 vdout1_27ck196 = 1.0 time = 985
* CHECK dout1_28 vdout1_28ck196 = 0 time = 985
* CHECK dout1_29 vdout1_29ck196 = 1.0 time = 985
* CHECK dout1_30 vdout1_30ck196 = 1.0 time = 985
* CHECK dout1_31 vdout1_31ck196 = 1.0 time = 985
* CHECK dout0_0 vdout0_0ck197 = 0 time = 990
* CHECK dout0_1 vdout0_1ck197 = 0 time = 990
* CHECK dout0_2 vdout0_2ck197 = 0 time = 990
* CHECK dout0_3 vdout0_3ck197 = 1.0 time = 990
* CHECK dout0_4 vdout0_4ck197 = 1.0 time = 990
* CHECK dout0_5 vdout0_5ck197 = 0 time = 990
* CHECK dout0_6 vdout0_6ck197 = 1.0 time = 990
* CHECK dout0_7 vdout0_7ck197 = 1.0 time = 990
* CHECK dout0_8 vdout0_8ck197 = 0 time = 990
* CHECK dout0_9 vdout0_9ck197 = 1.0 time = 990
* CHECK dout0_10 vdout0_10ck197 = 0 time = 990
* CHECK dout0_11 vdout0_11ck197 = 1.0 time = 990
* CHECK dout0_12 vdout0_12ck197 = 1.0 time = 990
* CHECK dout0_13 vdout0_13ck197 = 0 time = 990
* CHECK dout0_14 vdout0_14ck197 = 1.0 time = 990
* CHECK dout0_15 vdout0_15ck197 = 0 time = 990
* CHECK dout0_16 vdout0_16ck197 = 0 time = 990
* CHECK dout0_17 vdout0_17ck197 = 1.0 time = 990
* CHECK dout0_18 vdout0_18ck197 = 1.0 time = 990
* CHECK dout0_19 vdout0_19ck197 = 1.0 time = 990
* CHECK dout0_20 vdout0_20ck197 = 1.0 time = 990
* CHECK dout0_21 vdout0_21ck197 = 0 time = 990
* CHECK dout0_22 vdout0_22ck197 = 0 time = 990
* CHECK dout0_23 vdout0_23ck197 = 0 time = 990
* CHECK dout0_24 vdout0_24ck197 = 0 time = 990
* CHECK dout0_25 vdout0_25ck197 = 1.0 time = 990
* CHECK dout0_26 vdout0_26ck197 = 1.0 time = 990
* CHECK dout0_27 vdout0_27ck197 = 0 time = 990
* CHECK dout0_28 vdout0_28ck197 = 0 time = 990
* CHECK dout0_29 vdout0_29ck197 = 1.0 time = 990
* CHECK dout0_30 vdout0_30ck197 = 0 time = 990
* CHECK dout0_31 vdout0_31ck197 = 1.0 time = 990
* CHECK dout0_0 vdout0_0ck199 = 0 time = 1000
* CHECK dout0_1 vdout0_1ck199 = 1.0 time = 1000
* CHECK dout0_2 vdout0_2ck199 = 0 time = 1000
* CHECK dout0_3 vdout0_3ck199 = 1.0 time = 1000
* CHECK dout0_4 vdout0_4ck199 = 1.0 time = 1000
* CHECK dout0_5 vdout0_5ck199 = 1.0 time = 1000
* CHECK dout0_6 vdout0_6ck199 = 1.0 time = 1000
* CHECK dout0_7 vdout0_7ck199 = 1.0 time = 1000
* CHECK dout0_8 vdout0_8ck199 = 1.0 time = 1000
* CHECK dout0_9 vdout0_9ck199 = 0 time = 1000
* CHECK dout0_10 vdout0_10ck199 = 1.0 time = 1000
* CHECK dout0_11 vdout0_11ck199 = 1.0 time = 1000
* CHECK dout0_12 vdout0_12ck199 = 1.0 time = 1000
* CHECK dout0_13 vdout0_13ck199 = 1.0 time = 1000
* CHECK dout0_14 vdout0_14ck199 = 0 time = 1000
* CHECK dout0_15 vdout0_15ck199 = 1.0 time = 1000
* CHECK dout0_16 vdout0_16ck199 = 1.0 time = 1000
* CHECK dout0_17 vdout0_17ck199 = 1.0 time = 1000
* CHECK dout0_18 vdout0_18ck199 = 0 time = 1000
* CHECK dout0_19 vdout0_19ck199 = 0 time = 1000
* CHECK dout0_20 vdout0_20ck199 = 1.0 time = 1000
* CHECK dout0_21 vdout0_21ck199 = 1.0 time = 1000
* CHECK dout0_22 vdout0_22ck199 = 0 time = 1000
* CHECK dout0_23 vdout0_23ck199 = 1.0 time = 1000
* CHECK dout0_24 vdout0_24ck199 = 0 time = 1000
* CHECK dout0_25 vdout0_25ck199 = 0 time = 1000
* CHECK dout0_26 vdout0_26ck199 = 0 time = 1000
* CHECK dout0_27 vdout0_27ck199 = 1.0 time = 1000
* CHECK dout0_28 vdout0_28ck199 = 0 time = 1000
* CHECK dout0_29 vdout0_29ck199 = 0 time = 1000
* CHECK dout0_30 vdout0_30ck199 = 0 time = 1000
* CHECK dout0_31 vdout0_31ck199 = 0 time = 1000
* CHECK dout0_0 vdout0_0ck200 = 1.0 time = 1005
* CHECK dout0_1 vdout0_1ck200 = 1.0 time = 1005
* CHECK dout0_2 vdout0_2ck200 = 1.0 time = 1005
* CHECK dout0_3 vdout0_3ck200 = 1.0 time = 1005
* CHECK dout0_4 vdout0_4ck200 = 0 time = 1005
* CHECK dout0_5 vdout0_5ck200 = 1.0 time = 1005
* CHECK dout0_6 vdout0_6ck200 = 0 time = 1005
* CHECK dout0_7 vdout0_7ck200 = 0 time = 1005
* CHECK dout0_8 vdout0_8ck200 = 0 time = 1005
* CHECK dout0_9 vdout0_9ck200 = 0 time = 1005
* CHECK dout0_10 vdout0_10ck200 = 0 time = 1005
* CHECK dout0_11 vdout0_11ck200 = 1.0 time = 1005
* CHECK dout0_12 vdout0_12ck200 = 1.0 time = 1005
* CHECK dout0_13 vdout0_13ck200 = 1.0 time = 1005
* CHECK dout0_14 vdout0_14ck200 = 0 time = 1005
* CHECK dout0_15 vdout0_15ck200 = 0 time = 1005
* CHECK dout0_16 vdout0_16ck200 = 1.0 time = 1005
* CHECK dout0_17 vdout0_17ck200 = 0 time = 1005
* CHECK dout0_18 vdout0_18ck200 = 1.0 time = 1005
* CHECK dout0_19 vdout0_19ck200 = 1.0 time = 1005
* CHECK dout0_20 vdout0_20ck200 = 0 time = 1005
* CHECK dout0_21 vdout0_21ck200 = 0 time = 1005
* CHECK dout0_22 vdout0_22ck200 = 1.0 time = 1005
* CHECK dout0_23 vdout0_23ck200 = 0 time = 1005
* CHECK dout0_24 vdout0_24ck200 = 1.0 time = 1005
* CHECK dout0_25 vdout0_25ck200 = 1.0 time = 1005
* CHECK dout0_26 vdout0_26ck200 = 0 time = 1005
* CHECK dout0_27 vdout0_27ck200 = 1.0 time = 1005
* CHECK dout0_28 vdout0_28ck200 = 1.0 time = 1005
* CHECK dout0_29 vdout0_29ck200 = 1.0 time = 1005
* CHECK dout0_30 vdout0_30ck200 = 0 time = 1005
* CHECK dout0_31 vdout0_31ck200 = 0 time = 1005
* CHECK dout0_0 vdout0_0ck201 = 0 time = 1010
* CHECK dout0_1 vdout0_1ck201 = 1.0 time = 1010
* CHECK dout0_2 vdout0_2ck201 = 0 time = 1010
* CHECK dout0_3 vdout0_3ck201 = 0 time = 1010
* CHECK dout0_4 vdout0_4ck201 = 1.0 time = 1010
* CHECK dout0_5 vdout0_5ck201 = 1.0 time = 1010
* CHECK dout0_6 vdout0_6ck201 = 1.0 time = 1010
* CHECK dout0_7 vdout0_7ck201 = 1.0 time = 1010
* CHECK dout0_8 vdout0_8ck201 = 1.0 time = 1010
* CHECK dout0_9 vdout0_9ck201 = 0 time = 1010
* CHECK dout0_10 vdout0_10ck201 = 0 time = 1010
* CHECK dout0_11 vdout0_11ck201 = 1.0 time = 1010
* CHECK dout0_12 vdout0_12ck201 = 1.0 time = 1010
* CHECK dout0_13 vdout0_13ck201 = 0 time = 1010
* CHECK dout0_14 vdout0_14ck201 = 0 time = 1010
* CHECK dout0_15 vdout0_15ck201 = 1.0 time = 1010
* CHECK dout0_16 vdout0_16ck201 = 1.0 time = 1010
* CHECK dout0_17 vdout0_17ck201 = 1.0 time = 1010
* CHECK dout0_18 vdout0_18ck201 = 1.0 time = 1010
* CHECK dout0_19 vdout0_19ck201 = 0 time = 1010
* CHECK dout0_20 vdout0_20ck201 = 0 time = 1010
* CHECK dout0_21 vdout0_21ck201 = 0 time = 1010
* CHECK dout0_22 vdout0_22ck201 = 1.0 time = 1010
* CHECK dout0_23 vdout0_23ck201 = 1.0 time = 1010
* CHECK dout0_24 vdout0_24ck201 = 1.0 time = 1010
* CHECK dout0_25 vdout0_25ck201 = 1.0 time = 1010
* CHECK dout0_26 vdout0_26ck201 = 0 time = 1010
* CHECK dout0_27 vdout0_27ck201 = 0 time = 1010
* CHECK dout0_28 vdout0_28ck201 = 0 time = 1010
* CHECK dout0_29 vdout0_29ck201 = 0 time = 1010
* CHECK dout0_30 vdout0_30ck201 = 0 time = 1010
* CHECK dout0_31 vdout0_31ck201 = 1.0 time = 1010
* CHECK dout0_0 vdout0_0ck202 = 0 time = 1015
* CHECK dout0_1 vdout0_1ck202 = 1.0 time = 1015
* CHECK dout0_2 vdout0_2ck202 = 0 time = 1015
* CHECK dout0_3 vdout0_3ck202 = 1.0 time = 1015
* CHECK dout0_4 vdout0_4ck202 = 1.0 time = 1015
* CHECK dout0_5 vdout0_5ck202 = 1.0 time = 1015
* CHECK dout0_6 vdout0_6ck202 = 1.0 time = 1015
* CHECK dout0_7 vdout0_7ck202 = 1.0 time = 1015
* CHECK dout0_8 vdout0_8ck202 = 1.0 time = 1015
* CHECK dout0_9 vdout0_9ck202 = 0 time = 1015
* CHECK dout0_10 vdout0_10ck202 = 1.0 time = 1015
* CHECK dout0_11 vdout0_11ck202 = 1.0 time = 1015
* CHECK dout0_12 vdout0_12ck202 = 1.0 time = 1015
* CHECK dout0_13 vdout0_13ck202 = 1.0 time = 1015
* CHECK dout0_14 vdout0_14ck202 = 0 time = 1015
* CHECK dout0_15 vdout0_15ck202 = 1.0 time = 1015
* CHECK dout0_16 vdout0_16ck202 = 1.0 time = 1015
* CHECK dout0_17 vdout0_17ck202 = 1.0 time = 1015
* CHECK dout0_18 vdout0_18ck202 = 0 time = 1015
* CHECK dout0_19 vdout0_19ck202 = 0 time = 1015
* CHECK dout0_20 vdout0_20ck202 = 1.0 time = 1015
* CHECK dout0_21 vdout0_21ck202 = 1.0 time = 1015
* CHECK dout0_22 vdout0_22ck202 = 0 time = 1015
* CHECK dout0_23 vdout0_23ck202 = 1.0 time = 1015
* CHECK dout0_24 vdout0_24ck202 = 0 time = 1015
* CHECK dout0_25 vdout0_25ck202 = 0 time = 1015
* CHECK dout0_26 vdout0_26ck202 = 0 time = 1015
* CHECK dout0_27 vdout0_27ck202 = 1.0 time = 1015
* CHECK dout0_28 vdout0_28ck202 = 0 time = 1015
* CHECK dout0_29 vdout0_29ck202 = 0 time = 1015
* CHECK dout0_30 vdout0_30ck202 = 0 time = 1015
* CHECK dout0_31 vdout0_31ck202 = 0 time = 1015
* CHECK dout1_0 vdout1_0ck203 = 0 time = 1020
* CHECK dout1_1 vdout1_1ck203 = 0 time = 1020
* CHECK dout1_2 vdout1_2ck203 = 0 time = 1020
* CHECK dout1_3 vdout1_3ck203 = 1.0 time = 1020
* CHECK dout1_4 vdout1_4ck203 = 1.0 time = 1020
* CHECK dout1_5 vdout1_5ck203 = 0 time = 1020
* CHECK dout1_6 vdout1_6ck203 = 1.0 time = 1020
* CHECK dout1_7 vdout1_7ck203 = 1.0 time = 1020
* CHECK dout1_8 vdout1_8ck203 = 0 time = 1020
* CHECK dout1_9 vdout1_9ck203 = 1.0 time = 1020
* CHECK dout1_10 vdout1_10ck203 = 0 time = 1020
* CHECK dout1_11 vdout1_11ck203 = 1.0 time = 1020
* CHECK dout1_12 vdout1_12ck203 = 1.0 time = 1020
* CHECK dout1_13 vdout1_13ck203 = 0 time = 1020
* CHECK dout1_14 vdout1_14ck203 = 1.0 time = 1020
* CHECK dout1_15 vdout1_15ck203 = 0 time = 1020
* CHECK dout1_16 vdout1_16ck203 = 0 time = 1020
* CHECK dout1_17 vdout1_17ck203 = 1.0 time = 1020
* CHECK dout1_18 vdout1_18ck203 = 1.0 time = 1020
* CHECK dout1_19 vdout1_19ck203 = 1.0 time = 1020
* CHECK dout1_20 vdout1_20ck203 = 1.0 time = 1020
* CHECK dout1_21 vdout1_21ck203 = 0 time = 1020
* CHECK dout1_22 vdout1_22ck203 = 0 time = 1020
* CHECK dout1_23 vdout1_23ck203 = 0 time = 1020
* CHECK dout1_24 vdout1_24ck203 = 0 time = 1020
* CHECK dout1_25 vdout1_25ck203 = 1.0 time = 1020
* CHECK dout1_26 vdout1_26ck203 = 1.0 time = 1020
* CHECK dout1_27 vdout1_27ck203 = 0 time = 1020
* CHECK dout1_28 vdout1_28ck203 = 0 time = 1020
* CHECK dout1_29 vdout1_29ck203 = 1.0 time = 1020
* CHECK dout1_30 vdout1_30ck203 = 0 time = 1020
* CHECK dout1_31 vdout1_31ck203 = 1.0 time = 1020
* CHECK dout0_0 vdout0_0ck204 = 1.0 time = 1025
* CHECK dout0_1 vdout0_1ck204 = 1.0 time = 1025
* CHECK dout0_2 vdout0_2ck204 = 1.0 time = 1025
* CHECK dout0_3 vdout0_3ck204 = 1.0 time = 1025
* CHECK dout0_4 vdout0_4ck204 = 0 time = 1025
* CHECK dout0_5 vdout0_5ck204 = 1.0 time = 1025
* CHECK dout0_6 vdout0_6ck204 = 0 time = 1025
* CHECK dout0_7 vdout0_7ck204 = 0 time = 1025
* CHECK dout0_8 vdout0_8ck204 = 0 time = 1025
* CHECK dout0_9 vdout0_9ck204 = 0 time = 1025
* CHECK dout0_10 vdout0_10ck204 = 0 time = 1025
* CHECK dout0_11 vdout0_11ck204 = 1.0 time = 1025
* CHECK dout0_12 vdout0_12ck204 = 1.0 time = 1025
* CHECK dout0_13 vdout0_13ck204 = 1.0 time = 1025
* CHECK dout0_14 vdout0_14ck204 = 0 time = 1025
* CHECK dout0_15 vdout0_15ck204 = 0 time = 1025
* CHECK dout0_16 vdout0_16ck204 = 1.0 time = 1025
* CHECK dout0_17 vdout0_17ck204 = 0 time = 1025
* CHECK dout0_18 vdout0_18ck204 = 1.0 time = 1025
* CHECK dout0_19 vdout0_19ck204 = 1.0 time = 1025
* CHECK dout0_20 vdout0_20ck204 = 0 time = 1025
* CHECK dout0_21 vdout0_21ck204 = 0 time = 1025
* CHECK dout0_22 vdout0_22ck204 = 1.0 time = 1025
* CHECK dout0_23 vdout0_23ck204 = 0 time = 1025
* CHECK dout0_24 vdout0_24ck204 = 1.0 time = 1025
* CHECK dout0_25 vdout0_25ck204 = 1.0 time = 1025
* CHECK dout0_26 vdout0_26ck204 = 0 time = 1025
* CHECK dout0_27 vdout0_27ck204 = 1.0 time = 1025
* CHECK dout0_28 vdout0_28ck204 = 1.0 time = 1025
* CHECK dout0_29 vdout0_29ck204 = 1.0 time = 1025
* CHECK dout0_30 vdout0_30ck204 = 0 time = 1025
* CHECK dout0_31 vdout0_31ck204 = 0 time = 1025
.include /home/ihs24/OpenRAM/openram_outputs/fp16_SRAM_MACROS/functional_meas.sp
* probe is used for hspice/xa, while plot is used in ngspice
*.probe V(*)
*.plot V(*)
.end
