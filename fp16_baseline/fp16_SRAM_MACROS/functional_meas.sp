.meas tran vdout0_0ck40 FIND v(dout0_0) AT=25.025n

.meas tran vdout0_1ck40 FIND v(dout0_1) AT=25.025n

.meas tran vdout0_2ck40 FIND v(dout0_2) AT=25.025n

.meas tran vdout0_3ck40 FIND v(dout0_3) AT=25.025n

.meas tran vdout0_4ck40 FIND v(dout0_4) AT=25.025n

.meas tran vdout0_5ck40 FIND v(dout0_5) AT=25.025n

.meas tran vdout0_6ck40 FIND v(dout0_6) AT=25.025n

.meas tran vdout0_7ck40 FIND v(dout0_7) AT=25.025n

.meas tran vdout0_8ck40 FIND v(dout0_8) AT=25.025n

.meas tran vdout0_9ck40 FIND v(dout0_9) AT=25.025n

.meas tran vdout0_10ck40 FIND v(dout0_10) AT=25.025n

.meas tran vdout0_11ck40 FIND v(dout0_11) AT=25.025n

.meas tran vdout0_12ck40 FIND v(dout0_12) AT=25.025n

.meas tran vdout0_13ck40 FIND v(dout0_13) AT=25.025n

.meas tran vdout0_14ck40 FIND v(dout0_14) AT=25.025n

.meas tran vdout0_15ck40 FIND v(dout0_15) AT=25.025n

.meas tran vdout0_16ck40 FIND v(dout0_16) AT=25.025n

.meas tran vdout0_17ck40 FIND v(dout0_17) AT=25.025n

.meas tran vdout0_18ck40 FIND v(dout0_18) AT=25.025n

.meas tran vdout0_19ck40 FIND v(dout0_19) AT=25.025n

.meas tran vdout0_20ck40 FIND v(dout0_20) AT=25.025n

.meas tran vdout0_21ck40 FIND v(dout0_21) AT=25.025n

.meas tran vdout0_22ck40 FIND v(dout0_22) AT=25.025n

.meas tran vdout0_23ck40 FIND v(dout0_23) AT=25.025n

.meas tran vdout0_24ck40 FIND v(dout0_24) AT=25.025n

.meas tran vdout0_25ck40 FIND v(dout0_25) AT=25.025n

.meas tran vdout0_26ck40 FIND v(dout0_26) AT=25.025n

.meas tran vdout0_27ck40 FIND v(dout0_27) AT=25.025n

.meas tran vdout0_28ck40 FIND v(dout0_28) AT=25.025n

.meas tran vdout0_29ck40 FIND v(dout0_29) AT=25.025n

.meas tran vdout0_30ck40 FIND v(dout0_30) AT=25.025n

.meas tran vdout0_31ck40 FIND v(dout0_31) AT=25.025n

.meas tran vdout1_0ck40 FIND v(dout1_0) AT=25.025n

.meas tran vdout1_1ck40 FIND v(dout1_1) AT=25.025n

.meas tran vdout1_2ck40 FIND v(dout1_2) AT=25.025n

.meas tran vdout1_3ck40 FIND v(dout1_3) AT=25.025n

.meas tran vdout1_4ck40 FIND v(dout1_4) AT=25.025n

.meas tran vdout1_5ck40 FIND v(dout1_5) AT=25.025n

.meas tran vdout1_6ck40 FIND v(dout1_6) AT=25.025n

.meas tran vdout1_7ck40 FIND v(dout1_7) AT=25.025n

.meas tran vdout1_8ck40 FIND v(dout1_8) AT=25.025n

.meas tran vdout1_9ck40 FIND v(dout1_9) AT=25.025n

.meas tran vdout1_10ck40 FIND v(dout1_10) AT=25.025n

.meas tran vdout1_11ck40 FIND v(dout1_11) AT=25.025n

.meas tran vdout1_12ck40 FIND v(dout1_12) AT=25.025n

.meas tran vdout1_13ck40 FIND v(dout1_13) AT=25.025n

.meas tran vdout1_14ck40 FIND v(dout1_14) AT=25.025n

.meas tran vdout1_15ck40 FIND v(dout1_15) AT=25.025n

.meas tran vdout1_16ck40 FIND v(dout1_16) AT=25.025n

.meas tran vdout1_17ck40 FIND v(dout1_17) AT=25.025n

.meas tran vdout1_18ck40 FIND v(dout1_18) AT=25.025n

.meas tran vdout1_19ck40 FIND v(dout1_19) AT=25.025n

.meas tran vdout1_20ck40 FIND v(dout1_20) AT=25.025n

.meas tran vdout1_21ck40 FIND v(dout1_21) AT=25.025n

.meas tran vdout1_22ck40 FIND v(dout1_22) AT=25.025n

.meas tran vdout1_23ck40 FIND v(dout1_23) AT=25.025n

.meas tran vdout1_24ck40 FIND v(dout1_24) AT=25.025n

.meas tran vdout1_25ck40 FIND v(dout1_25) AT=25.025n

.meas tran vdout1_26ck40 FIND v(dout1_26) AT=25.025n

.meas tran vdout1_27ck40 FIND v(dout1_27) AT=25.025n

.meas tran vdout1_28ck40 FIND v(dout1_28) AT=25.025n

.meas tran vdout1_29ck40 FIND v(dout1_29) AT=25.025n

.meas tran vdout1_30ck40 FIND v(dout1_30) AT=25.025n

.meas tran vdout1_31ck40 FIND v(dout1_31) AT=25.025n

.meas tran vdout0_0ck50 FIND v(dout0_0) AT=30.025n

.meas tran vdout0_1ck50 FIND v(dout0_1) AT=30.025n

.meas tran vdout0_2ck50 FIND v(dout0_2) AT=30.025n

.meas tran vdout0_3ck50 FIND v(dout0_3) AT=30.025n

.meas tran vdout0_4ck50 FIND v(dout0_4) AT=30.025n

.meas tran vdout0_5ck50 FIND v(dout0_5) AT=30.025n

.meas tran vdout0_6ck50 FIND v(dout0_6) AT=30.025n

.meas tran vdout0_7ck50 FIND v(dout0_7) AT=30.025n

.meas tran vdout0_8ck50 FIND v(dout0_8) AT=30.025n

.meas tran vdout0_9ck50 FIND v(dout0_9) AT=30.025n

.meas tran vdout0_10ck50 FIND v(dout0_10) AT=30.025n

.meas tran vdout0_11ck50 FIND v(dout0_11) AT=30.025n

.meas tran vdout0_12ck50 FIND v(dout0_12) AT=30.025n

.meas tran vdout0_13ck50 FIND v(dout0_13) AT=30.025n

.meas tran vdout0_14ck50 FIND v(dout0_14) AT=30.025n

.meas tran vdout0_15ck50 FIND v(dout0_15) AT=30.025n

.meas tran vdout0_16ck50 FIND v(dout0_16) AT=30.025n

.meas tran vdout0_17ck50 FIND v(dout0_17) AT=30.025n

.meas tran vdout0_18ck50 FIND v(dout0_18) AT=30.025n

.meas tran vdout0_19ck50 FIND v(dout0_19) AT=30.025n

.meas tran vdout0_20ck50 FIND v(dout0_20) AT=30.025n

.meas tran vdout0_21ck50 FIND v(dout0_21) AT=30.025n

.meas tran vdout0_22ck50 FIND v(dout0_22) AT=30.025n

.meas tran vdout0_23ck50 FIND v(dout0_23) AT=30.025n

.meas tran vdout0_24ck50 FIND v(dout0_24) AT=30.025n

.meas tran vdout0_25ck50 FIND v(dout0_25) AT=30.025n

.meas tran vdout0_26ck50 FIND v(dout0_26) AT=30.025n

.meas tran vdout0_27ck50 FIND v(dout0_27) AT=30.025n

.meas tran vdout0_28ck50 FIND v(dout0_28) AT=30.025n

.meas tran vdout0_29ck50 FIND v(dout0_29) AT=30.025n

.meas tran vdout0_30ck50 FIND v(dout0_30) AT=30.025n

.meas tran vdout0_31ck50 FIND v(dout0_31) AT=30.025n

.meas tran vdout1_0ck80 FIND v(dout1_0) AT=45.025n

.meas tran vdout1_1ck80 FIND v(dout1_1) AT=45.025n

.meas tran vdout1_2ck80 FIND v(dout1_2) AT=45.025n

.meas tran vdout1_3ck80 FIND v(dout1_3) AT=45.025n

.meas tran vdout1_4ck80 FIND v(dout1_4) AT=45.025n

.meas tran vdout1_5ck80 FIND v(dout1_5) AT=45.025n

.meas tran vdout1_6ck80 FIND v(dout1_6) AT=45.025n

.meas tran vdout1_7ck80 FIND v(dout1_7) AT=45.025n

.meas tran vdout1_8ck80 FIND v(dout1_8) AT=45.025n

.meas tran vdout1_9ck80 FIND v(dout1_9) AT=45.025n

.meas tran vdout1_10ck80 FIND v(dout1_10) AT=45.025n

.meas tran vdout1_11ck80 FIND v(dout1_11) AT=45.025n

.meas tran vdout1_12ck80 FIND v(dout1_12) AT=45.025n

.meas tran vdout1_13ck80 FIND v(dout1_13) AT=45.025n

.meas tran vdout1_14ck80 FIND v(dout1_14) AT=45.025n

.meas tran vdout1_15ck80 FIND v(dout1_15) AT=45.025n

.meas tran vdout1_16ck80 FIND v(dout1_16) AT=45.025n

.meas tran vdout1_17ck80 FIND v(dout1_17) AT=45.025n

.meas tran vdout1_18ck80 FIND v(dout1_18) AT=45.025n

.meas tran vdout1_19ck80 FIND v(dout1_19) AT=45.025n

.meas tran vdout1_20ck80 FIND v(dout1_20) AT=45.025n

.meas tran vdout1_21ck80 FIND v(dout1_21) AT=45.025n

.meas tran vdout1_22ck80 FIND v(dout1_22) AT=45.025n

.meas tran vdout1_23ck80 FIND v(dout1_23) AT=45.025n

.meas tran vdout1_24ck80 FIND v(dout1_24) AT=45.025n

.meas tran vdout1_25ck80 FIND v(dout1_25) AT=45.025n

.meas tran vdout1_26ck80 FIND v(dout1_26) AT=45.025n

.meas tran vdout1_27ck80 FIND v(dout1_27) AT=45.025n

.meas tran vdout1_28ck80 FIND v(dout1_28) AT=45.025n

.meas tran vdout1_29ck80 FIND v(dout1_29) AT=45.025n

.meas tran vdout1_30ck80 FIND v(dout1_30) AT=45.025n

.meas tran vdout1_31ck80 FIND v(dout1_31) AT=45.025n

.meas tran vdout1_0ck90 FIND v(dout1_0) AT=50.025n

.meas tran vdout1_1ck90 FIND v(dout1_1) AT=50.025n

.meas tran vdout1_2ck90 FIND v(dout1_2) AT=50.025n

.meas tran vdout1_3ck90 FIND v(dout1_3) AT=50.025n

.meas tran vdout1_4ck90 FIND v(dout1_4) AT=50.025n

.meas tran vdout1_5ck90 FIND v(dout1_5) AT=50.025n

.meas tran vdout1_6ck90 FIND v(dout1_6) AT=50.025n

.meas tran vdout1_7ck90 FIND v(dout1_7) AT=50.025n

.meas tran vdout1_8ck90 FIND v(dout1_8) AT=50.025n

.meas tran vdout1_9ck90 FIND v(dout1_9) AT=50.025n

.meas tran vdout1_10ck90 FIND v(dout1_10) AT=50.025n

.meas tran vdout1_11ck90 FIND v(dout1_11) AT=50.025n

.meas tran vdout1_12ck90 FIND v(dout1_12) AT=50.025n

.meas tran vdout1_13ck90 FIND v(dout1_13) AT=50.025n

.meas tran vdout1_14ck90 FIND v(dout1_14) AT=50.025n

.meas tran vdout1_15ck90 FIND v(dout1_15) AT=50.025n

.meas tran vdout1_16ck90 FIND v(dout1_16) AT=50.025n

.meas tran vdout1_17ck90 FIND v(dout1_17) AT=50.025n

.meas tran vdout1_18ck90 FIND v(dout1_18) AT=50.025n

.meas tran vdout1_19ck90 FIND v(dout1_19) AT=50.025n

.meas tran vdout1_20ck90 FIND v(dout1_20) AT=50.025n

.meas tran vdout1_21ck90 FIND v(dout1_21) AT=50.025n

.meas tran vdout1_22ck90 FIND v(dout1_22) AT=50.025n

.meas tran vdout1_23ck90 FIND v(dout1_23) AT=50.025n

.meas tran vdout1_24ck90 FIND v(dout1_24) AT=50.025n

.meas tran vdout1_25ck90 FIND v(dout1_25) AT=50.025n

.meas tran vdout1_26ck90 FIND v(dout1_26) AT=50.025n

.meas tran vdout1_27ck90 FIND v(dout1_27) AT=50.025n

.meas tran vdout1_28ck90 FIND v(dout1_28) AT=50.025n

.meas tran vdout1_29ck90 FIND v(dout1_29) AT=50.025n

.meas tran vdout1_30ck90 FIND v(dout1_30) AT=50.025n

.meas tran vdout1_31ck90 FIND v(dout1_31) AT=50.025n

.meas tran vdout0_0ck110 FIND v(dout0_0) AT=60.025n

.meas tran vdout0_1ck110 FIND v(dout0_1) AT=60.025n

.meas tran vdout0_2ck110 FIND v(dout0_2) AT=60.025n

.meas tran vdout0_3ck110 FIND v(dout0_3) AT=60.025n

.meas tran vdout0_4ck110 FIND v(dout0_4) AT=60.025n

.meas tran vdout0_5ck110 FIND v(dout0_5) AT=60.025n

.meas tran vdout0_6ck110 FIND v(dout0_6) AT=60.025n

.meas tran vdout0_7ck110 FIND v(dout0_7) AT=60.025n

.meas tran vdout0_8ck110 FIND v(dout0_8) AT=60.025n

.meas tran vdout0_9ck110 FIND v(dout0_9) AT=60.025n

.meas tran vdout0_10ck110 FIND v(dout0_10) AT=60.025n

.meas tran vdout0_11ck110 FIND v(dout0_11) AT=60.025n

.meas tran vdout0_12ck110 FIND v(dout0_12) AT=60.025n

.meas tran vdout0_13ck110 FIND v(dout0_13) AT=60.025n

.meas tran vdout0_14ck110 FIND v(dout0_14) AT=60.025n

.meas tran vdout0_15ck110 FIND v(dout0_15) AT=60.025n

.meas tran vdout0_16ck110 FIND v(dout0_16) AT=60.025n

.meas tran vdout0_17ck110 FIND v(dout0_17) AT=60.025n

.meas tran vdout0_18ck110 FIND v(dout0_18) AT=60.025n

.meas tran vdout0_19ck110 FIND v(dout0_19) AT=60.025n

.meas tran vdout0_20ck110 FIND v(dout0_20) AT=60.025n

.meas tran vdout0_21ck110 FIND v(dout0_21) AT=60.025n

.meas tran vdout0_22ck110 FIND v(dout0_22) AT=60.025n

.meas tran vdout0_23ck110 FIND v(dout0_23) AT=60.025n

.meas tran vdout0_24ck110 FIND v(dout0_24) AT=60.025n

.meas tran vdout0_25ck110 FIND v(dout0_25) AT=60.025n

.meas tran vdout0_26ck110 FIND v(dout0_26) AT=60.025n

.meas tran vdout0_27ck110 FIND v(dout0_27) AT=60.025n

.meas tran vdout0_28ck110 FIND v(dout0_28) AT=60.025n

.meas tran vdout0_29ck110 FIND v(dout0_29) AT=60.025n

.meas tran vdout0_30ck110 FIND v(dout0_30) AT=60.025n

.meas tran vdout0_31ck110 FIND v(dout0_31) AT=60.025n

.meas tran vdout1_0ck110 FIND v(dout1_0) AT=60.025n

.meas tran vdout1_1ck110 FIND v(dout1_1) AT=60.025n

.meas tran vdout1_2ck110 FIND v(dout1_2) AT=60.025n

.meas tran vdout1_3ck110 FIND v(dout1_3) AT=60.025n

.meas tran vdout1_4ck110 FIND v(dout1_4) AT=60.025n

.meas tran vdout1_5ck110 FIND v(dout1_5) AT=60.025n

.meas tran vdout1_6ck110 FIND v(dout1_6) AT=60.025n

.meas tran vdout1_7ck110 FIND v(dout1_7) AT=60.025n

.meas tran vdout1_8ck110 FIND v(dout1_8) AT=60.025n

.meas tran vdout1_9ck110 FIND v(dout1_9) AT=60.025n

.meas tran vdout1_10ck110 FIND v(dout1_10) AT=60.025n

.meas tran vdout1_11ck110 FIND v(dout1_11) AT=60.025n

.meas tran vdout1_12ck110 FIND v(dout1_12) AT=60.025n

.meas tran vdout1_13ck110 FIND v(dout1_13) AT=60.025n

.meas tran vdout1_14ck110 FIND v(dout1_14) AT=60.025n

.meas tran vdout1_15ck110 FIND v(dout1_15) AT=60.025n

.meas tran vdout1_16ck110 FIND v(dout1_16) AT=60.025n

.meas tran vdout1_17ck110 FIND v(dout1_17) AT=60.025n

.meas tran vdout1_18ck110 FIND v(dout1_18) AT=60.025n

.meas tran vdout1_19ck110 FIND v(dout1_19) AT=60.025n

.meas tran vdout1_20ck110 FIND v(dout1_20) AT=60.025n

.meas tran vdout1_21ck110 FIND v(dout1_21) AT=60.025n

.meas tran vdout1_22ck110 FIND v(dout1_22) AT=60.025n

.meas tran vdout1_23ck110 FIND v(dout1_23) AT=60.025n

.meas tran vdout1_24ck110 FIND v(dout1_24) AT=60.025n

.meas tran vdout1_25ck110 FIND v(dout1_25) AT=60.025n

.meas tran vdout1_26ck110 FIND v(dout1_26) AT=60.025n

.meas tran vdout1_27ck110 FIND v(dout1_27) AT=60.025n

.meas tran vdout1_28ck110 FIND v(dout1_28) AT=60.025n

.meas tran vdout1_29ck110 FIND v(dout1_29) AT=60.025n

.meas tran vdout1_30ck110 FIND v(dout1_30) AT=60.025n

.meas tran vdout1_31ck110 FIND v(dout1_31) AT=60.025n

.meas tran vdout1_0ck120 FIND v(dout1_0) AT=65.025n

.meas tran vdout1_1ck120 FIND v(dout1_1) AT=65.025n

.meas tran vdout1_2ck120 FIND v(dout1_2) AT=65.025n

.meas tran vdout1_3ck120 FIND v(dout1_3) AT=65.025n

.meas tran vdout1_4ck120 FIND v(dout1_4) AT=65.025n

.meas tran vdout1_5ck120 FIND v(dout1_5) AT=65.025n

.meas tran vdout1_6ck120 FIND v(dout1_6) AT=65.025n

.meas tran vdout1_7ck120 FIND v(dout1_7) AT=65.025n

.meas tran vdout1_8ck120 FIND v(dout1_8) AT=65.025n

.meas tran vdout1_9ck120 FIND v(dout1_9) AT=65.025n

.meas tran vdout1_10ck120 FIND v(dout1_10) AT=65.025n

.meas tran vdout1_11ck120 FIND v(dout1_11) AT=65.025n

.meas tran vdout1_12ck120 FIND v(dout1_12) AT=65.025n

.meas tran vdout1_13ck120 FIND v(dout1_13) AT=65.025n

.meas tran vdout1_14ck120 FIND v(dout1_14) AT=65.025n

.meas tran vdout1_15ck120 FIND v(dout1_15) AT=65.025n

.meas tran vdout1_16ck120 FIND v(dout1_16) AT=65.025n

.meas tran vdout1_17ck120 FIND v(dout1_17) AT=65.025n

.meas tran vdout1_18ck120 FIND v(dout1_18) AT=65.025n

.meas tran vdout1_19ck120 FIND v(dout1_19) AT=65.025n

.meas tran vdout1_20ck120 FIND v(dout1_20) AT=65.025n

.meas tran vdout1_21ck120 FIND v(dout1_21) AT=65.025n

.meas tran vdout1_22ck120 FIND v(dout1_22) AT=65.025n

.meas tran vdout1_23ck120 FIND v(dout1_23) AT=65.025n

.meas tran vdout1_24ck120 FIND v(dout1_24) AT=65.025n

.meas tran vdout1_25ck120 FIND v(dout1_25) AT=65.025n

.meas tran vdout1_26ck120 FIND v(dout1_26) AT=65.025n

.meas tran vdout1_27ck120 FIND v(dout1_27) AT=65.025n

.meas tran vdout1_28ck120 FIND v(dout1_28) AT=65.025n

.meas tran vdout1_29ck120 FIND v(dout1_29) AT=65.025n

.meas tran vdout1_30ck120 FIND v(dout1_30) AT=65.025n

.meas tran vdout1_31ck120 FIND v(dout1_31) AT=65.025n

.meas tran vdout1_0ck130 FIND v(dout1_0) AT=70.025n

.meas tran vdout1_1ck130 FIND v(dout1_1) AT=70.025n

.meas tran vdout1_2ck130 FIND v(dout1_2) AT=70.025n

.meas tran vdout1_3ck130 FIND v(dout1_3) AT=70.025n

.meas tran vdout1_4ck130 FIND v(dout1_4) AT=70.025n

.meas tran vdout1_5ck130 FIND v(dout1_5) AT=70.025n

.meas tran vdout1_6ck130 FIND v(dout1_6) AT=70.025n

.meas tran vdout1_7ck130 FIND v(dout1_7) AT=70.025n

.meas tran vdout1_8ck130 FIND v(dout1_8) AT=70.025n

.meas tran vdout1_9ck130 FIND v(dout1_9) AT=70.025n

.meas tran vdout1_10ck130 FIND v(dout1_10) AT=70.025n

.meas tran vdout1_11ck130 FIND v(dout1_11) AT=70.025n

.meas tran vdout1_12ck130 FIND v(dout1_12) AT=70.025n

.meas tran vdout1_13ck130 FIND v(dout1_13) AT=70.025n

.meas tran vdout1_14ck130 FIND v(dout1_14) AT=70.025n

.meas tran vdout1_15ck130 FIND v(dout1_15) AT=70.025n

.meas tran vdout1_16ck130 FIND v(dout1_16) AT=70.025n

.meas tran vdout1_17ck130 FIND v(dout1_17) AT=70.025n

.meas tran vdout1_18ck130 FIND v(dout1_18) AT=70.025n

.meas tran vdout1_19ck130 FIND v(dout1_19) AT=70.025n

.meas tran vdout1_20ck130 FIND v(dout1_20) AT=70.025n

.meas tran vdout1_21ck130 FIND v(dout1_21) AT=70.025n

.meas tran vdout1_22ck130 FIND v(dout1_22) AT=70.025n

.meas tran vdout1_23ck130 FIND v(dout1_23) AT=70.025n

.meas tran vdout1_24ck130 FIND v(dout1_24) AT=70.025n

.meas tran vdout1_25ck130 FIND v(dout1_25) AT=70.025n

.meas tran vdout1_26ck130 FIND v(dout1_26) AT=70.025n

.meas tran vdout1_27ck130 FIND v(dout1_27) AT=70.025n

.meas tran vdout1_28ck130 FIND v(dout1_28) AT=70.025n

.meas tran vdout1_29ck130 FIND v(dout1_29) AT=70.025n

.meas tran vdout1_30ck130 FIND v(dout1_30) AT=70.025n

.meas tran vdout1_31ck130 FIND v(dout1_31) AT=70.025n

.meas tran vdout0_0ck140 FIND v(dout0_0) AT=75.025n

.meas tran vdout0_1ck140 FIND v(dout0_1) AT=75.025n

.meas tran vdout0_2ck140 FIND v(dout0_2) AT=75.025n

.meas tran vdout0_3ck140 FIND v(dout0_3) AT=75.025n

.meas tran vdout0_4ck140 FIND v(dout0_4) AT=75.025n

.meas tran vdout0_5ck140 FIND v(dout0_5) AT=75.025n

.meas tran vdout0_6ck140 FIND v(dout0_6) AT=75.025n

.meas tran vdout0_7ck140 FIND v(dout0_7) AT=75.025n

.meas tran vdout0_8ck140 FIND v(dout0_8) AT=75.025n

.meas tran vdout0_9ck140 FIND v(dout0_9) AT=75.025n

.meas tran vdout0_10ck140 FIND v(dout0_10) AT=75.025n

.meas tran vdout0_11ck140 FIND v(dout0_11) AT=75.025n

.meas tran vdout0_12ck140 FIND v(dout0_12) AT=75.025n

.meas tran vdout0_13ck140 FIND v(dout0_13) AT=75.025n

.meas tran vdout0_14ck140 FIND v(dout0_14) AT=75.025n

.meas tran vdout0_15ck140 FIND v(dout0_15) AT=75.025n

.meas tran vdout0_16ck140 FIND v(dout0_16) AT=75.025n

.meas tran vdout0_17ck140 FIND v(dout0_17) AT=75.025n

.meas tran vdout0_18ck140 FIND v(dout0_18) AT=75.025n

.meas tran vdout0_19ck140 FIND v(dout0_19) AT=75.025n

.meas tran vdout0_20ck140 FIND v(dout0_20) AT=75.025n

.meas tran vdout0_21ck140 FIND v(dout0_21) AT=75.025n

.meas tran vdout0_22ck140 FIND v(dout0_22) AT=75.025n

.meas tran vdout0_23ck140 FIND v(dout0_23) AT=75.025n

.meas tran vdout0_24ck140 FIND v(dout0_24) AT=75.025n

.meas tran vdout0_25ck140 FIND v(dout0_25) AT=75.025n

.meas tran vdout0_26ck140 FIND v(dout0_26) AT=75.025n

.meas tran vdout0_27ck140 FIND v(dout0_27) AT=75.025n

.meas tran vdout0_28ck140 FIND v(dout0_28) AT=75.025n

.meas tran vdout0_29ck140 FIND v(dout0_29) AT=75.025n

.meas tran vdout0_30ck140 FIND v(dout0_30) AT=75.025n

.meas tran vdout0_31ck140 FIND v(dout0_31) AT=75.025n

.meas tran vdout1_0ck150 FIND v(dout1_0) AT=80.025n

.meas tran vdout1_1ck150 FIND v(dout1_1) AT=80.025n

.meas tran vdout1_2ck150 FIND v(dout1_2) AT=80.025n

.meas tran vdout1_3ck150 FIND v(dout1_3) AT=80.025n

.meas tran vdout1_4ck150 FIND v(dout1_4) AT=80.025n

.meas tran vdout1_5ck150 FIND v(dout1_5) AT=80.025n

.meas tran vdout1_6ck150 FIND v(dout1_6) AT=80.025n

.meas tran vdout1_7ck150 FIND v(dout1_7) AT=80.025n

.meas tran vdout1_8ck150 FIND v(dout1_8) AT=80.025n

.meas tran vdout1_9ck150 FIND v(dout1_9) AT=80.025n

.meas tran vdout1_10ck150 FIND v(dout1_10) AT=80.025n

.meas tran vdout1_11ck150 FIND v(dout1_11) AT=80.025n

.meas tran vdout1_12ck150 FIND v(dout1_12) AT=80.025n

.meas tran vdout1_13ck150 FIND v(dout1_13) AT=80.025n

.meas tran vdout1_14ck150 FIND v(dout1_14) AT=80.025n

.meas tran vdout1_15ck150 FIND v(dout1_15) AT=80.025n

.meas tran vdout1_16ck150 FIND v(dout1_16) AT=80.025n

.meas tran vdout1_17ck150 FIND v(dout1_17) AT=80.025n

.meas tran vdout1_18ck150 FIND v(dout1_18) AT=80.025n

.meas tran vdout1_19ck150 FIND v(dout1_19) AT=80.025n

.meas tran vdout1_20ck150 FIND v(dout1_20) AT=80.025n

.meas tran vdout1_21ck150 FIND v(dout1_21) AT=80.025n

.meas tran vdout1_22ck150 FIND v(dout1_22) AT=80.025n

.meas tran vdout1_23ck150 FIND v(dout1_23) AT=80.025n

.meas tran vdout1_24ck150 FIND v(dout1_24) AT=80.025n

.meas tran vdout1_25ck150 FIND v(dout1_25) AT=80.025n

.meas tran vdout1_26ck150 FIND v(dout1_26) AT=80.025n

.meas tran vdout1_27ck150 FIND v(dout1_27) AT=80.025n

.meas tran vdout1_28ck150 FIND v(dout1_28) AT=80.025n

.meas tran vdout1_29ck150 FIND v(dout1_29) AT=80.025n

.meas tran vdout1_30ck150 FIND v(dout1_30) AT=80.025n

.meas tran vdout1_31ck150 FIND v(dout1_31) AT=80.025n

.meas tran vdout1_0ck160 FIND v(dout1_0) AT=85.025n

.meas tran vdout1_1ck160 FIND v(dout1_1) AT=85.025n

.meas tran vdout1_2ck160 FIND v(dout1_2) AT=85.025n

.meas tran vdout1_3ck160 FIND v(dout1_3) AT=85.025n

.meas tran vdout1_4ck160 FIND v(dout1_4) AT=85.025n

.meas tran vdout1_5ck160 FIND v(dout1_5) AT=85.025n

.meas tran vdout1_6ck160 FIND v(dout1_6) AT=85.025n

.meas tran vdout1_7ck160 FIND v(dout1_7) AT=85.025n

.meas tran vdout1_8ck160 FIND v(dout1_8) AT=85.025n

.meas tran vdout1_9ck160 FIND v(dout1_9) AT=85.025n

.meas tran vdout1_10ck160 FIND v(dout1_10) AT=85.025n

.meas tran vdout1_11ck160 FIND v(dout1_11) AT=85.025n

.meas tran vdout1_12ck160 FIND v(dout1_12) AT=85.025n

.meas tran vdout1_13ck160 FIND v(dout1_13) AT=85.025n

.meas tran vdout1_14ck160 FIND v(dout1_14) AT=85.025n

.meas tran vdout1_15ck160 FIND v(dout1_15) AT=85.025n

.meas tran vdout1_16ck160 FIND v(dout1_16) AT=85.025n

.meas tran vdout1_17ck160 FIND v(dout1_17) AT=85.025n

.meas tran vdout1_18ck160 FIND v(dout1_18) AT=85.025n

.meas tran vdout1_19ck160 FIND v(dout1_19) AT=85.025n

.meas tran vdout1_20ck160 FIND v(dout1_20) AT=85.025n

.meas tran vdout1_21ck160 FIND v(dout1_21) AT=85.025n

.meas tran vdout1_22ck160 FIND v(dout1_22) AT=85.025n

.meas tran vdout1_23ck160 FIND v(dout1_23) AT=85.025n

.meas tran vdout1_24ck160 FIND v(dout1_24) AT=85.025n

.meas tran vdout1_25ck160 FIND v(dout1_25) AT=85.025n

.meas tran vdout1_26ck160 FIND v(dout1_26) AT=85.025n

.meas tran vdout1_27ck160 FIND v(dout1_27) AT=85.025n

.meas tran vdout1_28ck160 FIND v(dout1_28) AT=85.025n

.meas tran vdout1_29ck160 FIND v(dout1_29) AT=85.025n

.meas tran vdout1_30ck160 FIND v(dout1_30) AT=85.025n

.meas tran vdout1_31ck160 FIND v(dout1_31) AT=85.025n

.meas tran vdout1_0ck180 FIND v(dout1_0) AT=95.025n

.meas tran vdout1_1ck180 FIND v(dout1_1) AT=95.025n

.meas tran vdout1_2ck180 FIND v(dout1_2) AT=95.025n

.meas tran vdout1_3ck180 FIND v(dout1_3) AT=95.025n

.meas tran vdout1_4ck180 FIND v(dout1_4) AT=95.025n

.meas tran vdout1_5ck180 FIND v(dout1_5) AT=95.025n

.meas tran vdout1_6ck180 FIND v(dout1_6) AT=95.025n

.meas tran vdout1_7ck180 FIND v(dout1_7) AT=95.025n

.meas tran vdout1_8ck180 FIND v(dout1_8) AT=95.025n

.meas tran vdout1_9ck180 FIND v(dout1_9) AT=95.025n

.meas tran vdout1_10ck180 FIND v(dout1_10) AT=95.025n

.meas tran vdout1_11ck180 FIND v(dout1_11) AT=95.025n

.meas tran vdout1_12ck180 FIND v(dout1_12) AT=95.025n

.meas tran vdout1_13ck180 FIND v(dout1_13) AT=95.025n

.meas tran vdout1_14ck180 FIND v(dout1_14) AT=95.025n

.meas tran vdout1_15ck180 FIND v(dout1_15) AT=95.025n

.meas tran vdout1_16ck180 FIND v(dout1_16) AT=95.025n

.meas tran vdout1_17ck180 FIND v(dout1_17) AT=95.025n

.meas tran vdout1_18ck180 FIND v(dout1_18) AT=95.025n

.meas tran vdout1_19ck180 FIND v(dout1_19) AT=95.025n

.meas tran vdout1_20ck180 FIND v(dout1_20) AT=95.025n

.meas tran vdout1_21ck180 FIND v(dout1_21) AT=95.025n

.meas tran vdout1_22ck180 FIND v(dout1_22) AT=95.025n

.meas tran vdout1_23ck180 FIND v(dout1_23) AT=95.025n

.meas tran vdout1_24ck180 FIND v(dout1_24) AT=95.025n

.meas tran vdout1_25ck180 FIND v(dout1_25) AT=95.025n

.meas tran vdout1_26ck180 FIND v(dout1_26) AT=95.025n

.meas tran vdout1_27ck180 FIND v(dout1_27) AT=95.025n

.meas tran vdout1_28ck180 FIND v(dout1_28) AT=95.025n

.meas tran vdout1_29ck180 FIND v(dout1_29) AT=95.025n

.meas tran vdout1_30ck180 FIND v(dout1_30) AT=95.025n

.meas tran vdout1_31ck180 FIND v(dout1_31) AT=95.025n

.meas tran vdout0_0ck190 FIND v(dout0_0) AT=100.025n

.meas tran vdout0_1ck190 FIND v(dout0_1) AT=100.025n

.meas tran vdout0_2ck190 FIND v(dout0_2) AT=100.025n

.meas tran vdout0_3ck190 FIND v(dout0_3) AT=100.025n

.meas tran vdout0_4ck190 FIND v(dout0_4) AT=100.025n

.meas tran vdout0_5ck190 FIND v(dout0_5) AT=100.025n

.meas tran vdout0_6ck190 FIND v(dout0_6) AT=100.025n

.meas tran vdout0_7ck190 FIND v(dout0_7) AT=100.025n

.meas tran vdout0_8ck190 FIND v(dout0_8) AT=100.025n

.meas tran vdout0_9ck190 FIND v(dout0_9) AT=100.025n

.meas tran vdout0_10ck190 FIND v(dout0_10) AT=100.025n

.meas tran vdout0_11ck190 FIND v(dout0_11) AT=100.025n

.meas tran vdout0_12ck190 FIND v(dout0_12) AT=100.025n

.meas tran vdout0_13ck190 FIND v(dout0_13) AT=100.025n

.meas tran vdout0_14ck190 FIND v(dout0_14) AT=100.025n

.meas tran vdout0_15ck190 FIND v(dout0_15) AT=100.025n

.meas tran vdout0_16ck190 FIND v(dout0_16) AT=100.025n

.meas tran vdout0_17ck190 FIND v(dout0_17) AT=100.025n

.meas tran vdout0_18ck190 FIND v(dout0_18) AT=100.025n

.meas tran vdout0_19ck190 FIND v(dout0_19) AT=100.025n

.meas tran vdout0_20ck190 FIND v(dout0_20) AT=100.025n

.meas tran vdout0_21ck190 FIND v(dout0_21) AT=100.025n

.meas tran vdout0_22ck190 FIND v(dout0_22) AT=100.025n

.meas tran vdout0_23ck190 FIND v(dout0_23) AT=100.025n

.meas tran vdout0_24ck190 FIND v(dout0_24) AT=100.025n

.meas tran vdout0_25ck190 FIND v(dout0_25) AT=100.025n

.meas tran vdout0_26ck190 FIND v(dout0_26) AT=100.025n

.meas tran vdout0_27ck190 FIND v(dout0_27) AT=100.025n

.meas tran vdout0_28ck190 FIND v(dout0_28) AT=100.025n

.meas tran vdout0_29ck190 FIND v(dout0_29) AT=100.025n

.meas tran vdout0_30ck190 FIND v(dout0_30) AT=100.025n

.meas tran vdout0_31ck190 FIND v(dout0_31) AT=100.025n

.meas tran vdout1_0ck190 FIND v(dout1_0) AT=100.025n

.meas tran vdout1_1ck190 FIND v(dout1_1) AT=100.025n

.meas tran vdout1_2ck190 FIND v(dout1_2) AT=100.025n

.meas tran vdout1_3ck190 FIND v(dout1_3) AT=100.025n

.meas tran vdout1_4ck190 FIND v(dout1_4) AT=100.025n

.meas tran vdout1_5ck190 FIND v(dout1_5) AT=100.025n

.meas tran vdout1_6ck190 FIND v(dout1_6) AT=100.025n

.meas tran vdout1_7ck190 FIND v(dout1_7) AT=100.025n

.meas tran vdout1_8ck190 FIND v(dout1_8) AT=100.025n

.meas tran vdout1_9ck190 FIND v(dout1_9) AT=100.025n

.meas tran vdout1_10ck190 FIND v(dout1_10) AT=100.025n

.meas tran vdout1_11ck190 FIND v(dout1_11) AT=100.025n

.meas tran vdout1_12ck190 FIND v(dout1_12) AT=100.025n

.meas tran vdout1_13ck190 FIND v(dout1_13) AT=100.025n

.meas tran vdout1_14ck190 FIND v(dout1_14) AT=100.025n

.meas tran vdout1_15ck190 FIND v(dout1_15) AT=100.025n

.meas tran vdout1_16ck190 FIND v(dout1_16) AT=100.025n

.meas tran vdout1_17ck190 FIND v(dout1_17) AT=100.025n

.meas tran vdout1_18ck190 FIND v(dout1_18) AT=100.025n

.meas tran vdout1_19ck190 FIND v(dout1_19) AT=100.025n

.meas tran vdout1_20ck190 FIND v(dout1_20) AT=100.025n

.meas tran vdout1_21ck190 FIND v(dout1_21) AT=100.025n

.meas tran vdout1_22ck190 FIND v(dout1_22) AT=100.025n

.meas tran vdout1_23ck190 FIND v(dout1_23) AT=100.025n

.meas tran vdout1_24ck190 FIND v(dout1_24) AT=100.025n

.meas tran vdout1_25ck190 FIND v(dout1_25) AT=100.025n

.meas tran vdout1_26ck190 FIND v(dout1_26) AT=100.025n

.meas tran vdout1_27ck190 FIND v(dout1_27) AT=100.025n

.meas tran vdout1_28ck190 FIND v(dout1_28) AT=100.025n

.meas tran vdout1_29ck190 FIND v(dout1_29) AT=100.025n

.meas tran vdout1_30ck190 FIND v(dout1_30) AT=100.025n

.meas tran vdout1_31ck190 FIND v(dout1_31) AT=100.025n

.meas tran vdout0_0ck210 FIND v(dout0_0) AT=110.025n

.meas tran vdout0_1ck210 FIND v(dout0_1) AT=110.025n

.meas tran vdout0_2ck210 FIND v(dout0_2) AT=110.025n

.meas tran vdout0_3ck210 FIND v(dout0_3) AT=110.025n

.meas tran vdout0_4ck210 FIND v(dout0_4) AT=110.025n

.meas tran vdout0_5ck210 FIND v(dout0_5) AT=110.025n

.meas tran vdout0_6ck210 FIND v(dout0_6) AT=110.025n

.meas tran vdout0_7ck210 FIND v(dout0_7) AT=110.025n

.meas tran vdout0_8ck210 FIND v(dout0_8) AT=110.025n

.meas tran vdout0_9ck210 FIND v(dout0_9) AT=110.025n

.meas tran vdout0_10ck210 FIND v(dout0_10) AT=110.025n

.meas tran vdout0_11ck210 FIND v(dout0_11) AT=110.025n

.meas tran vdout0_12ck210 FIND v(dout0_12) AT=110.025n

.meas tran vdout0_13ck210 FIND v(dout0_13) AT=110.025n

.meas tran vdout0_14ck210 FIND v(dout0_14) AT=110.025n

.meas tran vdout0_15ck210 FIND v(dout0_15) AT=110.025n

.meas tran vdout0_16ck210 FIND v(dout0_16) AT=110.025n

.meas tran vdout0_17ck210 FIND v(dout0_17) AT=110.025n

.meas tran vdout0_18ck210 FIND v(dout0_18) AT=110.025n

.meas tran vdout0_19ck210 FIND v(dout0_19) AT=110.025n

.meas tran vdout0_20ck210 FIND v(dout0_20) AT=110.025n

.meas tran vdout0_21ck210 FIND v(dout0_21) AT=110.025n

.meas tran vdout0_22ck210 FIND v(dout0_22) AT=110.025n

.meas tran vdout0_23ck210 FIND v(dout0_23) AT=110.025n

.meas tran vdout0_24ck210 FIND v(dout0_24) AT=110.025n

.meas tran vdout0_25ck210 FIND v(dout0_25) AT=110.025n

.meas tran vdout0_26ck210 FIND v(dout0_26) AT=110.025n

.meas tran vdout0_27ck210 FIND v(dout0_27) AT=110.025n

.meas tran vdout0_28ck210 FIND v(dout0_28) AT=110.025n

.meas tran vdout0_29ck210 FIND v(dout0_29) AT=110.025n

.meas tran vdout0_30ck210 FIND v(dout0_30) AT=110.025n

.meas tran vdout0_31ck210 FIND v(dout0_31) AT=110.025n

.meas tran vdout1_0ck210 FIND v(dout1_0) AT=110.025n

.meas tran vdout1_1ck210 FIND v(dout1_1) AT=110.025n

.meas tran vdout1_2ck210 FIND v(dout1_2) AT=110.025n

.meas tran vdout1_3ck210 FIND v(dout1_3) AT=110.025n

.meas tran vdout1_4ck210 FIND v(dout1_4) AT=110.025n

.meas tran vdout1_5ck210 FIND v(dout1_5) AT=110.025n

.meas tran vdout1_6ck210 FIND v(dout1_6) AT=110.025n

.meas tran vdout1_7ck210 FIND v(dout1_7) AT=110.025n

.meas tran vdout1_8ck210 FIND v(dout1_8) AT=110.025n

.meas tran vdout1_9ck210 FIND v(dout1_9) AT=110.025n

.meas tran vdout1_10ck210 FIND v(dout1_10) AT=110.025n

.meas tran vdout1_11ck210 FIND v(dout1_11) AT=110.025n

.meas tran vdout1_12ck210 FIND v(dout1_12) AT=110.025n

.meas tran vdout1_13ck210 FIND v(dout1_13) AT=110.025n

.meas tran vdout1_14ck210 FIND v(dout1_14) AT=110.025n

.meas tran vdout1_15ck210 FIND v(dout1_15) AT=110.025n

.meas tran vdout1_16ck210 FIND v(dout1_16) AT=110.025n

.meas tran vdout1_17ck210 FIND v(dout1_17) AT=110.025n

.meas tran vdout1_18ck210 FIND v(dout1_18) AT=110.025n

.meas tran vdout1_19ck210 FIND v(dout1_19) AT=110.025n

.meas tran vdout1_20ck210 FIND v(dout1_20) AT=110.025n

.meas tran vdout1_21ck210 FIND v(dout1_21) AT=110.025n

.meas tran vdout1_22ck210 FIND v(dout1_22) AT=110.025n

.meas tran vdout1_23ck210 FIND v(dout1_23) AT=110.025n

.meas tran vdout1_24ck210 FIND v(dout1_24) AT=110.025n

.meas tran vdout1_25ck210 FIND v(dout1_25) AT=110.025n

.meas tran vdout1_26ck210 FIND v(dout1_26) AT=110.025n

.meas tran vdout1_27ck210 FIND v(dout1_27) AT=110.025n

.meas tran vdout1_28ck210 FIND v(dout1_28) AT=110.025n

.meas tran vdout1_29ck210 FIND v(dout1_29) AT=110.025n

.meas tran vdout1_30ck210 FIND v(dout1_30) AT=110.025n

.meas tran vdout1_31ck210 FIND v(dout1_31) AT=110.025n

.meas tran vdout1_0ck220 FIND v(dout1_0) AT=115.025n

.meas tran vdout1_1ck220 FIND v(dout1_1) AT=115.025n

.meas tran vdout1_2ck220 FIND v(dout1_2) AT=115.025n

.meas tran vdout1_3ck220 FIND v(dout1_3) AT=115.025n

.meas tran vdout1_4ck220 FIND v(dout1_4) AT=115.025n

.meas tran vdout1_5ck220 FIND v(dout1_5) AT=115.025n

.meas tran vdout1_6ck220 FIND v(dout1_6) AT=115.025n

.meas tran vdout1_7ck220 FIND v(dout1_7) AT=115.025n

.meas tran vdout1_8ck220 FIND v(dout1_8) AT=115.025n

.meas tran vdout1_9ck220 FIND v(dout1_9) AT=115.025n

.meas tran vdout1_10ck220 FIND v(dout1_10) AT=115.025n

.meas tran vdout1_11ck220 FIND v(dout1_11) AT=115.025n

.meas tran vdout1_12ck220 FIND v(dout1_12) AT=115.025n

.meas tran vdout1_13ck220 FIND v(dout1_13) AT=115.025n

.meas tran vdout1_14ck220 FIND v(dout1_14) AT=115.025n

.meas tran vdout1_15ck220 FIND v(dout1_15) AT=115.025n

.meas tran vdout1_16ck220 FIND v(dout1_16) AT=115.025n

.meas tran vdout1_17ck220 FIND v(dout1_17) AT=115.025n

.meas tran vdout1_18ck220 FIND v(dout1_18) AT=115.025n

.meas tran vdout1_19ck220 FIND v(dout1_19) AT=115.025n

.meas tran vdout1_20ck220 FIND v(dout1_20) AT=115.025n

.meas tran vdout1_21ck220 FIND v(dout1_21) AT=115.025n

.meas tran vdout1_22ck220 FIND v(dout1_22) AT=115.025n

.meas tran vdout1_23ck220 FIND v(dout1_23) AT=115.025n

.meas tran vdout1_24ck220 FIND v(dout1_24) AT=115.025n

.meas tran vdout1_25ck220 FIND v(dout1_25) AT=115.025n

.meas tran vdout1_26ck220 FIND v(dout1_26) AT=115.025n

.meas tran vdout1_27ck220 FIND v(dout1_27) AT=115.025n

.meas tran vdout1_28ck220 FIND v(dout1_28) AT=115.025n

.meas tran vdout1_29ck220 FIND v(dout1_29) AT=115.025n

.meas tran vdout1_30ck220 FIND v(dout1_30) AT=115.025n

.meas tran vdout1_31ck220 FIND v(dout1_31) AT=115.025n

.meas tran vdout1_0ck240 FIND v(dout1_0) AT=125.025n

.meas tran vdout1_1ck240 FIND v(dout1_1) AT=125.025n

.meas tran vdout1_2ck240 FIND v(dout1_2) AT=125.025n

.meas tran vdout1_3ck240 FIND v(dout1_3) AT=125.025n

.meas tran vdout1_4ck240 FIND v(dout1_4) AT=125.025n

.meas tran vdout1_5ck240 FIND v(dout1_5) AT=125.025n

.meas tran vdout1_6ck240 FIND v(dout1_6) AT=125.025n

.meas tran vdout1_7ck240 FIND v(dout1_7) AT=125.025n

.meas tran vdout1_8ck240 FIND v(dout1_8) AT=125.025n

.meas tran vdout1_9ck240 FIND v(dout1_9) AT=125.025n

.meas tran vdout1_10ck240 FIND v(dout1_10) AT=125.025n

.meas tran vdout1_11ck240 FIND v(dout1_11) AT=125.025n

.meas tran vdout1_12ck240 FIND v(dout1_12) AT=125.025n

.meas tran vdout1_13ck240 FIND v(dout1_13) AT=125.025n

.meas tran vdout1_14ck240 FIND v(dout1_14) AT=125.025n

.meas tran vdout1_15ck240 FIND v(dout1_15) AT=125.025n

.meas tran vdout1_16ck240 FIND v(dout1_16) AT=125.025n

.meas tran vdout1_17ck240 FIND v(dout1_17) AT=125.025n

.meas tran vdout1_18ck240 FIND v(dout1_18) AT=125.025n

.meas tran vdout1_19ck240 FIND v(dout1_19) AT=125.025n

.meas tran vdout1_20ck240 FIND v(dout1_20) AT=125.025n

.meas tran vdout1_21ck240 FIND v(dout1_21) AT=125.025n

.meas tran vdout1_22ck240 FIND v(dout1_22) AT=125.025n

.meas tran vdout1_23ck240 FIND v(dout1_23) AT=125.025n

.meas tran vdout1_24ck240 FIND v(dout1_24) AT=125.025n

.meas tran vdout1_25ck240 FIND v(dout1_25) AT=125.025n

.meas tran vdout1_26ck240 FIND v(dout1_26) AT=125.025n

.meas tran vdout1_27ck240 FIND v(dout1_27) AT=125.025n

.meas tran vdout1_28ck240 FIND v(dout1_28) AT=125.025n

.meas tran vdout1_29ck240 FIND v(dout1_29) AT=125.025n

.meas tran vdout1_30ck240 FIND v(dout1_30) AT=125.025n

.meas tran vdout1_31ck240 FIND v(dout1_31) AT=125.025n

.meas tran vdout0_0ck260 FIND v(dout0_0) AT=135.025n

.meas tran vdout0_1ck260 FIND v(dout0_1) AT=135.025n

.meas tran vdout0_2ck260 FIND v(dout0_2) AT=135.025n

.meas tran vdout0_3ck260 FIND v(dout0_3) AT=135.025n

.meas tran vdout0_4ck260 FIND v(dout0_4) AT=135.025n

.meas tran vdout0_5ck260 FIND v(dout0_5) AT=135.025n

.meas tran vdout0_6ck260 FIND v(dout0_6) AT=135.025n

.meas tran vdout0_7ck260 FIND v(dout0_7) AT=135.025n

.meas tran vdout0_8ck260 FIND v(dout0_8) AT=135.025n

.meas tran vdout0_9ck260 FIND v(dout0_9) AT=135.025n

.meas tran vdout0_10ck260 FIND v(dout0_10) AT=135.025n

.meas tran vdout0_11ck260 FIND v(dout0_11) AT=135.025n

.meas tran vdout0_12ck260 FIND v(dout0_12) AT=135.025n

.meas tran vdout0_13ck260 FIND v(dout0_13) AT=135.025n

.meas tran vdout0_14ck260 FIND v(dout0_14) AT=135.025n

.meas tran vdout0_15ck260 FIND v(dout0_15) AT=135.025n

.meas tran vdout0_16ck260 FIND v(dout0_16) AT=135.025n

.meas tran vdout0_17ck260 FIND v(dout0_17) AT=135.025n

.meas tran vdout0_18ck260 FIND v(dout0_18) AT=135.025n

.meas tran vdout0_19ck260 FIND v(dout0_19) AT=135.025n

.meas tran vdout0_20ck260 FIND v(dout0_20) AT=135.025n

.meas tran vdout0_21ck260 FIND v(dout0_21) AT=135.025n

.meas tran vdout0_22ck260 FIND v(dout0_22) AT=135.025n

.meas tran vdout0_23ck260 FIND v(dout0_23) AT=135.025n

.meas tran vdout0_24ck260 FIND v(dout0_24) AT=135.025n

.meas tran vdout0_25ck260 FIND v(dout0_25) AT=135.025n

.meas tran vdout0_26ck260 FIND v(dout0_26) AT=135.025n

.meas tran vdout0_27ck260 FIND v(dout0_27) AT=135.025n

.meas tran vdout0_28ck260 FIND v(dout0_28) AT=135.025n

.meas tran vdout0_29ck260 FIND v(dout0_29) AT=135.025n

.meas tran vdout0_30ck260 FIND v(dout0_30) AT=135.025n

.meas tran vdout0_31ck260 FIND v(dout0_31) AT=135.025n

.meas tran vdout1_0ck260 FIND v(dout1_0) AT=135.025n

.meas tran vdout1_1ck260 FIND v(dout1_1) AT=135.025n

.meas tran vdout1_2ck260 FIND v(dout1_2) AT=135.025n

.meas tran vdout1_3ck260 FIND v(dout1_3) AT=135.025n

.meas tran vdout1_4ck260 FIND v(dout1_4) AT=135.025n

.meas tran vdout1_5ck260 FIND v(dout1_5) AT=135.025n

.meas tran vdout1_6ck260 FIND v(dout1_6) AT=135.025n

.meas tran vdout1_7ck260 FIND v(dout1_7) AT=135.025n

.meas tran vdout1_8ck260 FIND v(dout1_8) AT=135.025n

.meas tran vdout1_9ck260 FIND v(dout1_9) AT=135.025n

.meas tran vdout1_10ck260 FIND v(dout1_10) AT=135.025n

.meas tran vdout1_11ck260 FIND v(dout1_11) AT=135.025n

.meas tran vdout1_12ck260 FIND v(dout1_12) AT=135.025n

.meas tran vdout1_13ck260 FIND v(dout1_13) AT=135.025n

.meas tran vdout1_14ck260 FIND v(dout1_14) AT=135.025n

.meas tran vdout1_15ck260 FIND v(dout1_15) AT=135.025n

.meas tran vdout1_16ck260 FIND v(dout1_16) AT=135.025n

.meas tran vdout1_17ck260 FIND v(dout1_17) AT=135.025n

.meas tran vdout1_18ck260 FIND v(dout1_18) AT=135.025n

.meas tran vdout1_19ck260 FIND v(dout1_19) AT=135.025n

.meas tran vdout1_20ck260 FIND v(dout1_20) AT=135.025n

.meas tran vdout1_21ck260 FIND v(dout1_21) AT=135.025n

.meas tran vdout1_22ck260 FIND v(dout1_22) AT=135.025n

.meas tran vdout1_23ck260 FIND v(dout1_23) AT=135.025n

.meas tran vdout1_24ck260 FIND v(dout1_24) AT=135.025n

.meas tran vdout1_25ck260 FIND v(dout1_25) AT=135.025n

.meas tran vdout1_26ck260 FIND v(dout1_26) AT=135.025n

.meas tran vdout1_27ck260 FIND v(dout1_27) AT=135.025n

.meas tran vdout1_28ck260 FIND v(dout1_28) AT=135.025n

.meas tran vdout1_29ck260 FIND v(dout1_29) AT=135.025n

.meas tran vdout1_30ck260 FIND v(dout1_30) AT=135.025n

.meas tran vdout1_31ck260 FIND v(dout1_31) AT=135.025n

.meas tran vdout1_0ck270 FIND v(dout1_0) AT=140.025n

.meas tran vdout1_1ck270 FIND v(dout1_1) AT=140.025n

.meas tran vdout1_2ck270 FIND v(dout1_2) AT=140.025n

.meas tran vdout1_3ck270 FIND v(dout1_3) AT=140.025n

.meas tran vdout1_4ck270 FIND v(dout1_4) AT=140.025n

.meas tran vdout1_5ck270 FIND v(dout1_5) AT=140.025n

.meas tran vdout1_6ck270 FIND v(dout1_6) AT=140.025n

.meas tran vdout1_7ck270 FIND v(dout1_7) AT=140.025n

.meas tran vdout1_8ck270 FIND v(dout1_8) AT=140.025n

.meas tran vdout1_9ck270 FIND v(dout1_9) AT=140.025n

.meas tran vdout1_10ck270 FIND v(dout1_10) AT=140.025n

.meas tran vdout1_11ck270 FIND v(dout1_11) AT=140.025n

.meas tran vdout1_12ck270 FIND v(dout1_12) AT=140.025n

.meas tran vdout1_13ck270 FIND v(dout1_13) AT=140.025n

.meas tran vdout1_14ck270 FIND v(dout1_14) AT=140.025n

.meas tran vdout1_15ck270 FIND v(dout1_15) AT=140.025n

.meas tran vdout1_16ck270 FIND v(dout1_16) AT=140.025n

.meas tran vdout1_17ck270 FIND v(dout1_17) AT=140.025n

.meas tran vdout1_18ck270 FIND v(dout1_18) AT=140.025n

.meas tran vdout1_19ck270 FIND v(dout1_19) AT=140.025n

.meas tran vdout1_20ck270 FIND v(dout1_20) AT=140.025n

.meas tran vdout1_21ck270 FIND v(dout1_21) AT=140.025n

.meas tran vdout1_22ck270 FIND v(dout1_22) AT=140.025n

.meas tran vdout1_23ck270 FIND v(dout1_23) AT=140.025n

.meas tran vdout1_24ck270 FIND v(dout1_24) AT=140.025n

.meas tran vdout1_25ck270 FIND v(dout1_25) AT=140.025n

.meas tran vdout1_26ck270 FIND v(dout1_26) AT=140.025n

.meas tran vdout1_27ck270 FIND v(dout1_27) AT=140.025n

.meas tran vdout1_28ck270 FIND v(dout1_28) AT=140.025n

.meas tran vdout1_29ck270 FIND v(dout1_29) AT=140.025n

.meas tran vdout1_30ck270 FIND v(dout1_30) AT=140.025n

.meas tran vdout1_31ck270 FIND v(dout1_31) AT=140.025n

.meas tran vdout1_0ck290 FIND v(dout1_0) AT=150.025n

.meas tran vdout1_1ck290 FIND v(dout1_1) AT=150.025n

.meas tran vdout1_2ck290 FIND v(dout1_2) AT=150.025n

.meas tran vdout1_3ck290 FIND v(dout1_3) AT=150.025n

.meas tran vdout1_4ck290 FIND v(dout1_4) AT=150.025n

.meas tran vdout1_5ck290 FIND v(dout1_5) AT=150.025n

.meas tran vdout1_6ck290 FIND v(dout1_6) AT=150.025n

.meas tran vdout1_7ck290 FIND v(dout1_7) AT=150.025n

.meas tran vdout1_8ck290 FIND v(dout1_8) AT=150.025n

.meas tran vdout1_9ck290 FIND v(dout1_9) AT=150.025n

.meas tran vdout1_10ck290 FIND v(dout1_10) AT=150.025n

.meas tran vdout1_11ck290 FIND v(dout1_11) AT=150.025n

.meas tran vdout1_12ck290 FIND v(dout1_12) AT=150.025n

.meas tran vdout1_13ck290 FIND v(dout1_13) AT=150.025n

.meas tran vdout1_14ck290 FIND v(dout1_14) AT=150.025n

.meas tran vdout1_15ck290 FIND v(dout1_15) AT=150.025n

.meas tran vdout1_16ck290 FIND v(dout1_16) AT=150.025n

.meas tran vdout1_17ck290 FIND v(dout1_17) AT=150.025n

.meas tran vdout1_18ck290 FIND v(dout1_18) AT=150.025n

.meas tran vdout1_19ck290 FIND v(dout1_19) AT=150.025n

.meas tran vdout1_20ck290 FIND v(dout1_20) AT=150.025n

.meas tran vdout1_21ck290 FIND v(dout1_21) AT=150.025n

.meas tran vdout1_22ck290 FIND v(dout1_22) AT=150.025n

.meas tran vdout1_23ck290 FIND v(dout1_23) AT=150.025n

.meas tran vdout1_24ck290 FIND v(dout1_24) AT=150.025n

.meas tran vdout1_25ck290 FIND v(dout1_25) AT=150.025n

.meas tran vdout1_26ck290 FIND v(dout1_26) AT=150.025n

.meas tran vdout1_27ck290 FIND v(dout1_27) AT=150.025n

.meas tran vdout1_28ck290 FIND v(dout1_28) AT=150.025n

.meas tran vdout1_29ck290 FIND v(dout1_29) AT=150.025n

.meas tran vdout1_30ck290 FIND v(dout1_30) AT=150.025n

.meas tran vdout1_31ck290 FIND v(dout1_31) AT=150.025n

.meas tran vdout0_0ck300 FIND v(dout0_0) AT=155.025n

.meas tran vdout0_1ck300 FIND v(dout0_1) AT=155.025n

.meas tran vdout0_2ck300 FIND v(dout0_2) AT=155.025n

.meas tran vdout0_3ck300 FIND v(dout0_3) AT=155.025n

.meas tran vdout0_4ck300 FIND v(dout0_4) AT=155.025n

.meas tran vdout0_5ck300 FIND v(dout0_5) AT=155.025n

.meas tran vdout0_6ck300 FIND v(dout0_6) AT=155.025n

.meas tran vdout0_7ck300 FIND v(dout0_7) AT=155.025n

.meas tran vdout0_8ck300 FIND v(dout0_8) AT=155.025n

.meas tran vdout0_9ck300 FIND v(dout0_9) AT=155.025n

.meas tran vdout0_10ck300 FIND v(dout0_10) AT=155.025n

.meas tran vdout0_11ck300 FIND v(dout0_11) AT=155.025n

.meas tran vdout0_12ck300 FIND v(dout0_12) AT=155.025n

.meas tran vdout0_13ck300 FIND v(dout0_13) AT=155.025n

.meas tran vdout0_14ck300 FIND v(dout0_14) AT=155.025n

.meas tran vdout0_15ck300 FIND v(dout0_15) AT=155.025n

.meas tran vdout0_16ck300 FIND v(dout0_16) AT=155.025n

.meas tran vdout0_17ck300 FIND v(dout0_17) AT=155.025n

.meas tran vdout0_18ck300 FIND v(dout0_18) AT=155.025n

.meas tran vdout0_19ck300 FIND v(dout0_19) AT=155.025n

.meas tran vdout0_20ck300 FIND v(dout0_20) AT=155.025n

.meas tran vdout0_21ck300 FIND v(dout0_21) AT=155.025n

.meas tran vdout0_22ck300 FIND v(dout0_22) AT=155.025n

.meas tran vdout0_23ck300 FIND v(dout0_23) AT=155.025n

.meas tran vdout0_24ck300 FIND v(dout0_24) AT=155.025n

.meas tran vdout0_25ck300 FIND v(dout0_25) AT=155.025n

.meas tran vdout0_26ck300 FIND v(dout0_26) AT=155.025n

.meas tran vdout0_27ck300 FIND v(dout0_27) AT=155.025n

.meas tran vdout0_28ck300 FIND v(dout0_28) AT=155.025n

.meas tran vdout0_29ck300 FIND v(dout0_29) AT=155.025n

.meas tran vdout0_30ck300 FIND v(dout0_30) AT=155.025n

.meas tran vdout0_31ck300 FIND v(dout0_31) AT=155.025n

.meas tran vdout0_0ck310 FIND v(dout0_0) AT=160.025n

.meas tran vdout0_1ck310 FIND v(dout0_1) AT=160.025n

.meas tran vdout0_2ck310 FIND v(dout0_2) AT=160.025n

.meas tran vdout0_3ck310 FIND v(dout0_3) AT=160.025n

.meas tran vdout0_4ck310 FIND v(dout0_4) AT=160.025n

.meas tran vdout0_5ck310 FIND v(dout0_5) AT=160.025n

.meas tran vdout0_6ck310 FIND v(dout0_6) AT=160.025n

.meas tran vdout0_7ck310 FIND v(dout0_7) AT=160.025n

.meas tran vdout0_8ck310 FIND v(dout0_8) AT=160.025n

.meas tran vdout0_9ck310 FIND v(dout0_9) AT=160.025n

.meas tran vdout0_10ck310 FIND v(dout0_10) AT=160.025n

.meas tran vdout0_11ck310 FIND v(dout0_11) AT=160.025n

.meas tran vdout0_12ck310 FIND v(dout0_12) AT=160.025n

.meas tran vdout0_13ck310 FIND v(dout0_13) AT=160.025n

.meas tran vdout0_14ck310 FIND v(dout0_14) AT=160.025n

.meas tran vdout0_15ck310 FIND v(dout0_15) AT=160.025n

.meas tran vdout0_16ck310 FIND v(dout0_16) AT=160.025n

.meas tran vdout0_17ck310 FIND v(dout0_17) AT=160.025n

.meas tran vdout0_18ck310 FIND v(dout0_18) AT=160.025n

.meas tran vdout0_19ck310 FIND v(dout0_19) AT=160.025n

.meas tran vdout0_20ck310 FIND v(dout0_20) AT=160.025n

.meas tran vdout0_21ck310 FIND v(dout0_21) AT=160.025n

.meas tran vdout0_22ck310 FIND v(dout0_22) AT=160.025n

.meas tran vdout0_23ck310 FIND v(dout0_23) AT=160.025n

.meas tran vdout0_24ck310 FIND v(dout0_24) AT=160.025n

.meas tran vdout0_25ck310 FIND v(dout0_25) AT=160.025n

.meas tran vdout0_26ck310 FIND v(dout0_26) AT=160.025n

.meas tran vdout0_27ck310 FIND v(dout0_27) AT=160.025n

.meas tran vdout0_28ck310 FIND v(dout0_28) AT=160.025n

.meas tran vdout0_29ck310 FIND v(dout0_29) AT=160.025n

.meas tran vdout0_30ck310 FIND v(dout0_30) AT=160.025n

.meas tran vdout0_31ck310 FIND v(dout0_31) AT=160.025n

.meas tran vdout1_0ck310 FIND v(dout1_0) AT=160.025n

.meas tran vdout1_1ck310 FIND v(dout1_1) AT=160.025n

.meas tran vdout1_2ck310 FIND v(dout1_2) AT=160.025n

.meas tran vdout1_3ck310 FIND v(dout1_3) AT=160.025n

.meas tran vdout1_4ck310 FIND v(dout1_4) AT=160.025n

.meas tran vdout1_5ck310 FIND v(dout1_5) AT=160.025n

.meas tran vdout1_6ck310 FIND v(dout1_6) AT=160.025n

.meas tran vdout1_7ck310 FIND v(dout1_7) AT=160.025n

.meas tran vdout1_8ck310 FIND v(dout1_8) AT=160.025n

.meas tran vdout1_9ck310 FIND v(dout1_9) AT=160.025n

.meas tran vdout1_10ck310 FIND v(dout1_10) AT=160.025n

.meas tran vdout1_11ck310 FIND v(dout1_11) AT=160.025n

.meas tran vdout1_12ck310 FIND v(dout1_12) AT=160.025n

.meas tran vdout1_13ck310 FIND v(dout1_13) AT=160.025n

.meas tran vdout1_14ck310 FIND v(dout1_14) AT=160.025n

.meas tran vdout1_15ck310 FIND v(dout1_15) AT=160.025n

.meas tran vdout1_16ck310 FIND v(dout1_16) AT=160.025n

.meas tran vdout1_17ck310 FIND v(dout1_17) AT=160.025n

.meas tran vdout1_18ck310 FIND v(dout1_18) AT=160.025n

.meas tran vdout1_19ck310 FIND v(dout1_19) AT=160.025n

.meas tran vdout1_20ck310 FIND v(dout1_20) AT=160.025n

.meas tran vdout1_21ck310 FIND v(dout1_21) AT=160.025n

.meas tran vdout1_22ck310 FIND v(dout1_22) AT=160.025n

.meas tran vdout1_23ck310 FIND v(dout1_23) AT=160.025n

.meas tran vdout1_24ck310 FIND v(dout1_24) AT=160.025n

.meas tran vdout1_25ck310 FIND v(dout1_25) AT=160.025n

.meas tran vdout1_26ck310 FIND v(dout1_26) AT=160.025n

.meas tran vdout1_27ck310 FIND v(dout1_27) AT=160.025n

.meas tran vdout1_28ck310 FIND v(dout1_28) AT=160.025n

.meas tran vdout1_29ck310 FIND v(dout1_29) AT=160.025n

.meas tran vdout1_30ck310 FIND v(dout1_30) AT=160.025n

.meas tran vdout1_31ck310 FIND v(dout1_31) AT=160.025n

.meas tran vdout1_0ck320 FIND v(dout1_0) AT=165.025n

.meas tran vdout1_1ck320 FIND v(dout1_1) AT=165.025n

.meas tran vdout1_2ck320 FIND v(dout1_2) AT=165.025n

.meas tran vdout1_3ck320 FIND v(dout1_3) AT=165.025n

.meas tran vdout1_4ck320 FIND v(dout1_4) AT=165.025n

.meas tran vdout1_5ck320 FIND v(dout1_5) AT=165.025n

.meas tran vdout1_6ck320 FIND v(dout1_6) AT=165.025n

.meas tran vdout1_7ck320 FIND v(dout1_7) AT=165.025n

.meas tran vdout1_8ck320 FIND v(dout1_8) AT=165.025n

.meas tran vdout1_9ck320 FIND v(dout1_9) AT=165.025n

.meas tran vdout1_10ck320 FIND v(dout1_10) AT=165.025n

.meas tran vdout1_11ck320 FIND v(dout1_11) AT=165.025n

.meas tran vdout1_12ck320 FIND v(dout1_12) AT=165.025n

.meas tran vdout1_13ck320 FIND v(dout1_13) AT=165.025n

.meas tran vdout1_14ck320 FIND v(dout1_14) AT=165.025n

.meas tran vdout1_15ck320 FIND v(dout1_15) AT=165.025n

.meas tran vdout1_16ck320 FIND v(dout1_16) AT=165.025n

.meas tran vdout1_17ck320 FIND v(dout1_17) AT=165.025n

.meas tran vdout1_18ck320 FIND v(dout1_18) AT=165.025n

.meas tran vdout1_19ck320 FIND v(dout1_19) AT=165.025n

.meas tran vdout1_20ck320 FIND v(dout1_20) AT=165.025n

.meas tran vdout1_21ck320 FIND v(dout1_21) AT=165.025n

.meas tran vdout1_22ck320 FIND v(dout1_22) AT=165.025n

.meas tran vdout1_23ck320 FIND v(dout1_23) AT=165.025n

.meas tran vdout1_24ck320 FIND v(dout1_24) AT=165.025n

.meas tran vdout1_25ck320 FIND v(dout1_25) AT=165.025n

.meas tran vdout1_26ck320 FIND v(dout1_26) AT=165.025n

.meas tran vdout1_27ck320 FIND v(dout1_27) AT=165.025n

.meas tran vdout1_28ck320 FIND v(dout1_28) AT=165.025n

.meas tran vdout1_29ck320 FIND v(dout1_29) AT=165.025n

.meas tran vdout1_30ck320 FIND v(dout1_30) AT=165.025n

.meas tran vdout1_31ck320 FIND v(dout1_31) AT=165.025n

.meas tran vdout0_0ck330 FIND v(dout0_0) AT=170.025n

.meas tran vdout0_1ck330 FIND v(dout0_1) AT=170.025n

.meas tran vdout0_2ck330 FIND v(dout0_2) AT=170.025n

.meas tran vdout0_3ck330 FIND v(dout0_3) AT=170.025n

.meas tran vdout0_4ck330 FIND v(dout0_4) AT=170.025n

.meas tran vdout0_5ck330 FIND v(dout0_5) AT=170.025n

.meas tran vdout0_6ck330 FIND v(dout0_6) AT=170.025n

.meas tran vdout0_7ck330 FIND v(dout0_7) AT=170.025n

.meas tran vdout0_8ck330 FIND v(dout0_8) AT=170.025n

.meas tran vdout0_9ck330 FIND v(dout0_9) AT=170.025n

.meas tran vdout0_10ck330 FIND v(dout0_10) AT=170.025n

.meas tran vdout0_11ck330 FIND v(dout0_11) AT=170.025n

.meas tran vdout0_12ck330 FIND v(dout0_12) AT=170.025n

.meas tran vdout0_13ck330 FIND v(dout0_13) AT=170.025n

.meas tran vdout0_14ck330 FIND v(dout0_14) AT=170.025n

.meas tran vdout0_15ck330 FIND v(dout0_15) AT=170.025n

.meas tran vdout0_16ck330 FIND v(dout0_16) AT=170.025n

.meas tran vdout0_17ck330 FIND v(dout0_17) AT=170.025n

.meas tran vdout0_18ck330 FIND v(dout0_18) AT=170.025n

.meas tran vdout0_19ck330 FIND v(dout0_19) AT=170.025n

.meas tran vdout0_20ck330 FIND v(dout0_20) AT=170.025n

.meas tran vdout0_21ck330 FIND v(dout0_21) AT=170.025n

.meas tran vdout0_22ck330 FIND v(dout0_22) AT=170.025n

.meas tran vdout0_23ck330 FIND v(dout0_23) AT=170.025n

.meas tran vdout0_24ck330 FIND v(dout0_24) AT=170.025n

.meas tran vdout0_25ck330 FIND v(dout0_25) AT=170.025n

.meas tran vdout0_26ck330 FIND v(dout0_26) AT=170.025n

.meas tran vdout0_27ck330 FIND v(dout0_27) AT=170.025n

.meas tran vdout0_28ck330 FIND v(dout0_28) AT=170.025n

.meas tran vdout0_29ck330 FIND v(dout0_29) AT=170.025n

.meas tran vdout0_30ck330 FIND v(dout0_30) AT=170.025n

.meas tran vdout0_31ck330 FIND v(dout0_31) AT=170.025n

.meas tran vdout0_0ck340 FIND v(dout0_0) AT=175.025n

.meas tran vdout0_1ck340 FIND v(dout0_1) AT=175.025n

.meas tran vdout0_2ck340 FIND v(dout0_2) AT=175.025n

.meas tran vdout0_3ck340 FIND v(dout0_3) AT=175.025n

.meas tran vdout0_4ck340 FIND v(dout0_4) AT=175.025n

.meas tran vdout0_5ck340 FIND v(dout0_5) AT=175.025n

.meas tran vdout0_6ck340 FIND v(dout0_6) AT=175.025n

.meas tran vdout0_7ck340 FIND v(dout0_7) AT=175.025n

.meas tran vdout0_8ck340 FIND v(dout0_8) AT=175.025n

.meas tran vdout0_9ck340 FIND v(dout0_9) AT=175.025n

.meas tran vdout0_10ck340 FIND v(dout0_10) AT=175.025n

.meas tran vdout0_11ck340 FIND v(dout0_11) AT=175.025n

.meas tran vdout0_12ck340 FIND v(dout0_12) AT=175.025n

.meas tran vdout0_13ck340 FIND v(dout0_13) AT=175.025n

.meas tran vdout0_14ck340 FIND v(dout0_14) AT=175.025n

.meas tran vdout0_15ck340 FIND v(dout0_15) AT=175.025n

.meas tran vdout0_16ck340 FIND v(dout0_16) AT=175.025n

.meas tran vdout0_17ck340 FIND v(dout0_17) AT=175.025n

.meas tran vdout0_18ck340 FIND v(dout0_18) AT=175.025n

.meas tran vdout0_19ck340 FIND v(dout0_19) AT=175.025n

.meas tran vdout0_20ck340 FIND v(dout0_20) AT=175.025n

.meas tran vdout0_21ck340 FIND v(dout0_21) AT=175.025n

.meas tran vdout0_22ck340 FIND v(dout0_22) AT=175.025n

.meas tran vdout0_23ck340 FIND v(dout0_23) AT=175.025n

.meas tran vdout0_24ck340 FIND v(dout0_24) AT=175.025n

.meas tran vdout0_25ck340 FIND v(dout0_25) AT=175.025n

.meas tran vdout0_26ck340 FIND v(dout0_26) AT=175.025n

.meas tran vdout0_27ck340 FIND v(dout0_27) AT=175.025n

.meas tran vdout0_28ck340 FIND v(dout0_28) AT=175.025n

.meas tran vdout0_29ck340 FIND v(dout0_29) AT=175.025n

.meas tran vdout0_30ck340 FIND v(dout0_30) AT=175.025n

.meas tran vdout0_31ck340 FIND v(dout0_31) AT=175.025n

.meas tran vdout1_0ck340 FIND v(dout1_0) AT=175.025n

.meas tran vdout1_1ck340 FIND v(dout1_1) AT=175.025n

.meas tran vdout1_2ck340 FIND v(dout1_2) AT=175.025n

.meas tran vdout1_3ck340 FIND v(dout1_3) AT=175.025n

.meas tran vdout1_4ck340 FIND v(dout1_4) AT=175.025n

.meas tran vdout1_5ck340 FIND v(dout1_5) AT=175.025n

.meas tran vdout1_6ck340 FIND v(dout1_6) AT=175.025n

.meas tran vdout1_7ck340 FIND v(dout1_7) AT=175.025n

.meas tran vdout1_8ck340 FIND v(dout1_8) AT=175.025n

.meas tran vdout1_9ck340 FIND v(dout1_9) AT=175.025n

.meas tran vdout1_10ck340 FIND v(dout1_10) AT=175.025n

.meas tran vdout1_11ck340 FIND v(dout1_11) AT=175.025n

.meas tran vdout1_12ck340 FIND v(dout1_12) AT=175.025n

.meas tran vdout1_13ck340 FIND v(dout1_13) AT=175.025n

.meas tran vdout1_14ck340 FIND v(dout1_14) AT=175.025n

.meas tran vdout1_15ck340 FIND v(dout1_15) AT=175.025n

.meas tran vdout1_16ck340 FIND v(dout1_16) AT=175.025n

.meas tran vdout1_17ck340 FIND v(dout1_17) AT=175.025n

.meas tran vdout1_18ck340 FIND v(dout1_18) AT=175.025n

.meas tran vdout1_19ck340 FIND v(dout1_19) AT=175.025n

.meas tran vdout1_20ck340 FIND v(dout1_20) AT=175.025n

.meas tran vdout1_21ck340 FIND v(dout1_21) AT=175.025n

.meas tran vdout1_22ck340 FIND v(dout1_22) AT=175.025n

.meas tran vdout1_23ck340 FIND v(dout1_23) AT=175.025n

.meas tran vdout1_24ck340 FIND v(dout1_24) AT=175.025n

.meas tran vdout1_25ck340 FIND v(dout1_25) AT=175.025n

.meas tran vdout1_26ck340 FIND v(dout1_26) AT=175.025n

.meas tran vdout1_27ck340 FIND v(dout1_27) AT=175.025n

.meas tran vdout1_28ck340 FIND v(dout1_28) AT=175.025n

.meas tran vdout1_29ck340 FIND v(dout1_29) AT=175.025n

.meas tran vdout1_30ck340 FIND v(dout1_30) AT=175.025n

.meas tran vdout1_31ck340 FIND v(dout1_31) AT=175.025n

.meas tran vdout0_0ck360 FIND v(dout0_0) AT=185.025n

.meas tran vdout0_1ck360 FIND v(dout0_1) AT=185.025n

.meas tran vdout0_2ck360 FIND v(dout0_2) AT=185.025n

.meas tran vdout0_3ck360 FIND v(dout0_3) AT=185.025n

.meas tran vdout0_4ck360 FIND v(dout0_4) AT=185.025n

.meas tran vdout0_5ck360 FIND v(dout0_5) AT=185.025n

.meas tran vdout0_6ck360 FIND v(dout0_6) AT=185.025n

.meas tran vdout0_7ck360 FIND v(dout0_7) AT=185.025n

.meas tran vdout0_8ck360 FIND v(dout0_8) AT=185.025n

.meas tran vdout0_9ck360 FIND v(dout0_9) AT=185.025n

.meas tran vdout0_10ck360 FIND v(dout0_10) AT=185.025n

.meas tran vdout0_11ck360 FIND v(dout0_11) AT=185.025n

.meas tran vdout0_12ck360 FIND v(dout0_12) AT=185.025n

.meas tran vdout0_13ck360 FIND v(dout0_13) AT=185.025n

.meas tran vdout0_14ck360 FIND v(dout0_14) AT=185.025n

.meas tran vdout0_15ck360 FIND v(dout0_15) AT=185.025n

.meas tran vdout0_16ck360 FIND v(dout0_16) AT=185.025n

.meas tran vdout0_17ck360 FIND v(dout0_17) AT=185.025n

.meas tran vdout0_18ck360 FIND v(dout0_18) AT=185.025n

.meas tran vdout0_19ck360 FIND v(dout0_19) AT=185.025n

.meas tran vdout0_20ck360 FIND v(dout0_20) AT=185.025n

.meas tran vdout0_21ck360 FIND v(dout0_21) AT=185.025n

.meas tran vdout0_22ck360 FIND v(dout0_22) AT=185.025n

.meas tran vdout0_23ck360 FIND v(dout0_23) AT=185.025n

.meas tran vdout0_24ck360 FIND v(dout0_24) AT=185.025n

.meas tran vdout0_25ck360 FIND v(dout0_25) AT=185.025n

.meas tran vdout0_26ck360 FIND v(dout0_26) AT=185.025n

.meas tran vdout0_27ck360 FIND v(dout0_27) AT=185.025n

.meas tran vdout0_28ck360 FIND v(dout0_28) AT=185.025n

.meas tran vdout0_29ck360 FIND v(dout0_29) AT=185.025n

.meas tran vdout0_30ck360 FIND v(dout0_30) AT=185.025n

.meas tran vdout0_31ck360 FIND v(dout0_31) AT=185.025n

.meas tran vdout1_0ck360 FIND v(dout1_0) AT=185.025n

.meas tran vdout1_1ck360 FIND v(dout1_1) AT=185.025n

.meas tran vdout1_2ck360 FIND v(dout1_2) AT=185.025n

.meas tran vdout1_3ck360 FIND v(dout1_3) AT=185.025n

.meas tran vdout1_4ck360 FIND v(dout1_4) AT=185.025n

.meas tran vdout1_5ck360 FIND v(dout1_5) AT=185.025n

.meas tran vdout1_6ck360 FIND v(dout1_6) AT=185.025n

.meas tran vdout1_7ck360 FIND v(dout1_7) AT=185.025n

.meas tran vdout1_8ck360 FIND v(dout1_8) AT=185.025n

.meas tran vdout1_9ck360 FIND v(dout1_9) AT=185.025n

.meas tran vdout1_10ck360 FIND v(dout1_10) AT=185.025n

.meas tran vdout1_11ck360 FIND v(dout1_11) AT=185.025n

.meas tran vdout1_12ck360 FIND v(dout1_12) AT=185.025n

.meas tran vdout1_13ck360 FIND v(dout1_13) AT=185.025n

.meas tran vdout1_14ck360 FIND v(dout1_14) AT=185.025n

.meas tran vdout1_15ck360 FIND v(dout1_15) AT=185.025n

.meas tran vdout1_16ck360 FIND v(dout1_16) AT=185.025n

.meas tran vdout1_17ck360 FIND v(dout1_17) AT=185.025n

.meas tran vdout1_18ck360 FIND v(dout1_18) AT=185.025n

.meas tran vdout1_19ck360 FIND v(dout1_19) AT=185.025n

.meas tran vdout1_20ck360 FIND v(dout1_20) AT=185.025n

.meas tran vdout1_21ck360 FIND v(dout1_21) AT=185.025n

.meas tran vdout1_22ck360 FIND v(dout1_22) AT=185.025n

.meas tran vdout1_23ck360 FIND v(dout1_23) AT=185.025n

.meas tran vdout1_24ck360 FIND v(dout1_24) AT=185.025n

.meas tran vdout1_25ck360 FIND v(dout1_25) AT=185.025n

.meas tran vdout1_26ck360 FIND v(dout1_26) AT=185.025n

.meas tran vdout1_27ck360 FIND v(dout1_27) AT=185.025n

.meas tran vdout1_28ck360 FIND v(dout1_28) AT=185.025n

.meas tran vdout1_29ck360 FIND v(dout1_29) AT=185.025n

.meas tran vdout1_30ck360 FIND v(dout1_30) AT=185.025n

.meas tran vdout1_31ck360 FIND v(dout1_31) AT=185.025n

.meas tran vdout0_0ck370 FIND v(dout0_0) AT=190.025n

.meas tran vdout0_1ck370 FIND v(dout0_1) AT=190.025n

.meas tran vdout0_2ck370 FIND v(dout0_2) AT=190.025n

.meas tran vdout0_3ck370 FIND v(dout0_3) AT=190.025n

.meas tran vdout0_4ck370 FIND v(dout0_4) AT=190.025n

.meas tran vdout0_5ck370 FIND v(dout0_5) AT=190.025n

.meas tran vdout0_6ck370 FIND v(dout0_6) AT=190.025n

.meas tran vdout0_7ck370 FIND v(dout0_7) AT=190.025n

.meas tran vdout0_8ck370 FIND v(dout0_8) AT=190.025n

.meas tran vdout0_9ck370 FIND v(dout0_9) AT=190.025n

.meas tran vdout0_10ck370 FIND v(dout0_10) AT=190.025n

.meas tran vdout0_11ck370 FIND v(dout0_11) AT=190.025n

.meas tran vdout0_12ck370 FIND v(dout0_12) AT=190.025n

.meas tran vdout0_13ck370 FIND v(dout0_13) AT=190.025n

.meas tran vdout0_14ck370 FIND v(dout0_14) AT=190.025n

.meas tran vdout0_15ck370 FIND v(dout0_15) AT=190.025n

.meas tran vdout0_16ck370 FIND v(dout0_16) AT=190.025n

.meas tran vdout0_17ck370 FIND v(dout0_17) AT=190.025n

.meas tran vdout0_18ck370 FIND v(dout0_18) AT=190.025n

.meas tran vdout0_19ck370 FIND v(dout0_19) AT=190.025n

.meas tran vdout0_20ck370 FIND v(dout0_20) AT=190.025n

.meas tran vdout0_21ck370 FIND v(dout0_21) AT=190.025n

.meas tran vdout0_22ck370 FIND v(dout0_22) AT=190.025n

.meas tran vdout0_23ck370 FIND v(dout0_23) AT=190.025n

.meas tran vdout0_24ck370 FIND v(dout0_24) AT=190.025n

.meas tran vdout0_25ck370 FIND v(dout0_25) AT=190.025n

.meas tran vdout0_26ck370 FIND v(dout0_26) AT=190.025n

.meas tran vdout0_27ck370 FIND v(dout0_27) AT=190.025n

.meas tran vdout0_28ck370 FIND v(dout0_28) AT=190.025n

.meas tran vdout0_29ck370 FIND v(dout0_29) AT=190.025n

.meas tran vdout0_30ck370 FIND v(dout0_30) AT=190.025n

.meas tran vdout0_31ck370 FIND v(dout0_31) AT=190.025n

.meas tran vdout1_0ck370 FIND v(dout1_0) AT=190.025n

.meas tran vdout1_1ck370 FIND v(dout1_1) AT=190.025n

.meas tran vdout1_2ck370 FIND v(dout1_2) AT=190.025n

.meas tran vdout1_3ck370 FIND v(dout1_3) AT=190.025n

.meas tran vdout1_4ck370 FIND v(dout1_4) AT=190.025n

.meas tran vdout1_5ck370 FIND v(dout1_5) AT=190.025n

.meas tran vdout1_6ck370 FIND v(dout1_6) AT=190.025n

.meas tran vdout1_7ck370 FIND v(dout1_7) AT=190.025n

.meas tran vdout1_8ck370 FIND v(dout1_8) AT=190.025n

.meas tran vdout1_9ck370 FIND v(dout1_9) AT=190.025n

.meas tran vdout1_10ck370 FIND v(dout1_10) AT=190.025n

.meas tran vdout1_11ck370 FIND v(dout1_11) AT=190.025n

.meas tran vdout1_12ck370 FIND v(dout1_12) AT=190.025n

.meas tran vdout1_13ck370 FIND v(dout1_13) AT=190.025n

.meas tran vdout1_14ck370 FIND v(dout1_14) AT=190.025n

.meas tran vdout1_15ck370 FIND v(dout1_15) AT=190.025n

.meas tran vdout1_16ck370 FIND v(dout1_16) AT=190.025n

.meas tran vdout1_17ck370 FIND v(dout1_17) AT=190.025n

.meas tran vdout1_18ck370 FIND v(dout1_18) AT=190.025n

.meas tran vdout1_19ck370 FIND v(dout1_19) AT=190.025n

.meas tran vdout1_20ck370 FIND v(dout1_20) AT=190.025n

.meas tran vdout1_21ck370 FIND v(dout1_21) AT=190.025n

.meas tran vdout1_22ck370 FIND v(dout1_22) AT=190.025n

.meas tran vdout1_23ck370 FIND v(dout1_23) AT=190.025n

.meas tran vdout1_24ck370 FIND v(dout1_24) AT=190.025n

.meas tran vdout1_25ck370 FIND v(dout1_25) AT=190.025n

.meas tran vdout1_26ck370 FIND v(dout1_26) AT=190.025n

.meas tran vdout1_27ck370 FIND v(dout1_27) AT=190.025n

.meas tran vdout1_28ck370 FIND v(dout1_28) AT=190.025n

.meas tran vdout1_29ck370 FIND v(dout1_29) AT=190.025n

.meas tran vdout1_30ck370 FIND v(dout1_30) AT=190.025n

.meas tran vdout1_31ck370 FIND v(dout1_31) AT=190.025n

.meas tran vdout0_0ck380 FIND v(dout0_0) AT=195.025n

.meas tran vdout0_1ck380 FIND v(dout0_1) AT=195.025n

.meas tran vdout0_2ck380 FIND v(dout0_2) AT=195.025n

.meas tran vdout0_3ck380 FIND v(dout0_3) AT=195.025n

.meas tran vdout0_4ck380 FIND v(dout0_4) AT=195.025n

.meas tran vdout0_5ck380 FIND v(dout0_5) AT=195.025n

.meas tran vdout0_6ck380 FIND v(dout0_6) AT=195.025n

.meas tran vdout0_7ck380 FIND v(dout0_7) AT=195.025n

.meas tran vdout0_8ck380 FIND v(dout0_8) AT=195.025n

.meas tran vdout0_9ck380 FIND v(dout0_9) AT=195.025n

.meas tran vdout0_10ck380 FIND v(dout0_10) AT=195.025n

.meas tran vdout0_11ck380 FIND v(dout0_11) AT=195.025n

.meas tran vdout0_12ck380 FIND v(dout0_12) AT=195.025n

.meas tran vdout0_13ck380 FIND v(dout0_13) AT=195.025n

.meas tran vdout0_14ck380 FIND v(dout0_14) AT=195.025n

.meas tran vdout0_15ck380 FIND v(dout0_15) AT=195.025n

.meas tran vdout0_16ck380 FIND v(dout0_16) AT=195.025n

.meas tran vdout0_17ck380 FIND v(dout0_17) AT=195.025n

.meas tran vdout0_18ck380 FIND v(dout0_18) AT=195.025n

.meas tran vdout0_19ck380 FIND v(dout0_19) AT=195.025n

.meas tran vdout0_20ck380 FIND v(dout0_20) AT=195.025n

.meas tran vdout0_21ck380 FIND v(dout0_21) AT=195.025n

.meas tran vdout0_22ck380 FIND v(dout0_22) AT=195.025n

.meas tran vdout0_23ck380 FIND v(dout0_23) AT=195.025n

.meas tran vdout0_24ck380 FIND v(dout0_24) AT=195.025n

.meas tran vdout0_25ck380 FIND v(dout0_25) AT=195.025n

.meas tran vdout0_26ck380 FIND v(dout0_26) AT=195.025n

.meas tran vdout0_27ck380 FIND v(dout0_27) AT=195.025n

.meas tran vdout0_28ck380 FIND v(dout0_28) AT=195.025n

.meas tran vdout0_29ck380 FIND v(dout0_29) AT=195.025n

.meas tran vdout0_30ck380 FIND v(dout0_30) AT=195.025n

.meas tran vdout0_31ck380 FIND v(dout0_31) AT=195.025n

.meas tran vdout0_0ck390 FIND v(dout0_0) AT=200.025n

.meas tran vdout0_1ck390 FIND v(dout0_1) AT=200.025n

.meas tran vdout0_2ck390 FIND v(dout0_2) AT=200.025n

.meas tran vdout0_3ck390 FIND v(dout0_3) AT=200.025n

.meas tran vdout0_4ck390 FIND v(dout0_4) AT=200.025n

.meas tran vdout0_5ck390 FIND v(dout0_5) AT=200.025n

.meas tran vdout0_6ck390 FIND v(dout0_6) AT=200.025n

.meas tran vdout0_7ck390 FIND v(dout0_7) AT=200.025n

.meas tran vdout0_8ck390 FIND v(dout0_8) AT=200.025n

.meas tran vdout0_9ck390 FIND v(dout0_9) AT=200.025n

.meas tran vdout0_10ck390 FIND v(dout0_10) AT=200.025n

.meas tran vdout0_11ck390 FIND v(dout0_11) AT=200.025n

.meas tran vdout0_12ck390 FIND v(dout0_12) AT=200.025n

.meas tran vdout0_13ck390 FIND v(dout0_13) AT=200.025n

.meas tran vdout0_14ck390 FIND v(dout0_14) AT=200.025n

.meas tran vdout0_15ck390 FIND v(dout0_15) AT=200.025n

.meas tran vdout0_16ck390 FIND v(dout0_16) AT=200.025n

.meas tran vdout0_17ck390 FIND v(dout0_17) AT=200.025n

.meas tran vdout0_18ck390 FIND v(dout0_18) AT=200.025n

.meas tran vdout0_19ck390 FIND v(dout0_19) AT=200.025n

.meas tran vdout0_20ck390 FIND v(dout0_20) AT=200.025n

.meas tran vdout0_21ck390 FIND v(dout0_21) AT=200.025n

.meas tran vdout0_22ck390 FIND v(dout0_22) AT=200.025n

.meas tran vdout0_23ck390 FIND v(dout0_23) AT=200.025n

.meas tran vdout0_24ck390 FIND v(dout0_24) AT=200.025n

.meas tran vdout0_25ck390 FIND v(dout0_25) AT=200.025n

.meas tran vdout0_26ck390 FIND v(dout0_26) AT=200.025n

.meas tran vdout0_27ck390 FIND v(dout0_27) AT=200.025n

.meas tran vdout0_28ck390 FIND v(dout0_28) AT=200.025n

.meas tran vdout0_29ck390 FIND v(dout0_29) AT=200.025n

.meas tran vdout0_30ck390 FIND v(dout0_30) AT=200.025n

.meas tran vdout0_31ck390 FIND v(dout0_31) AT=200.025n

.meas tran vdout0_0ck400 FIND v(dout0_0) AT=205.025n

.meas tran vdout0_1ck400 FIND v(dout0_1) AT=205.025n

.meas tran vdout0_2ck400 FIND v(dout0_2) AT=205.025n

.meas tran vdout0_3ck400 FIND v(dout0_3) AT=205.025n

.meas tran vdout0_4ck400 FIND v(dout0_4) AT=205.025n

.meas tran vdout0_5ck400 FIND v(dout0_5) AT=205.025n

.meas tran vdout0_6ck400 FIND v(dout0_6) AT=205.025n

.meas tran vdout0_7ck400 FIND v(dout0_7) AT=205.025n

.meas tran vdout0_8ck400 FIND v(dout0_8) AT=205.025n

.meas tran vdout0_9ck400 FIND v(dout0_9) AT=205.025n

.meas tran vdout0_10ck400 FIND v(dout0_10) AT=205.025n

.meas tran vdout0_11ck400 FIND v(dout0_11) AT=205.025n

.meas tran vdout0_12ck400 FIND v(dout0_12) AT=205.025n

.meas tran vdout0_13ck400 FIND v(dout0_13) AT=205.025n

.meas tran vdout0_14ck400 FIND v(dout0_14) AT=205.025n

.meas tran vdout0_15ck400 FIND v(dout0_15) AT=205.025n

.meas tran vdout0_16ck400 FIND v(dout0_16) AT=205.025n

.meas tran vdout0_17ck400 FIND v(dout0_17) AT=205.025n

.meas tran vdout0_18ck400 FIND v(dout0_18) AT=205.025n

.meas tran vdout0_19ck400 FIND v(dout0_19) AT=205.025n

.meas tran vdout0_20ck400 FIND v(dout0_20) AT=205.025n

.meas tran vdout0_21ck400 FIND v(dout0_21) AT=205.025n

.meas tran vdout0_22ck400 FIND v(dout0_22) AT=205.025n

.meas tran vdout0_23ck400 FIND v(dout0_23) AT=205.025n

.meas tran vdout0_24ck400 FIND v(dout0_24) AT=205.025n

.meas tran vdout0_25ck400 FIND v(dout0_25) AT=205.025n

.meas tran vdout0_26ck400 FIND v(dout0_26) AT=205.025n

.meas tran vdout0_27ck400 FIND v(dout0_27) AT=205.025n

.meas tran vdout0_28ck400 FIND v(dout0_28) AT=205.025n

.meas tran vdout0_29ck400 FIND v(dout0_29) AT=205.025n

.meas tran vdout0_30ck400 FIND v(dout0_30) AT=205.025n

.meas tran vdout0_31ck400 FIND v(dout0_31) AT=205.025n

.meas tran vdout1_0ck400 FIND v(dout1_0) AT=205.025n

.meas tran vdout1_1ck400 FIND v(dout1_1) AT=205.025n

.meas tran vdout1_2ck400 FIND v(dout1_2) AT=205.025n

.meas tran vdout1_3ck400 FIND v(dout1_3) AT=205.025n

.meas tran vdout1_4ck400 FIND v(dout1_4) AT=205.025n

.meas tran vdout1_5ck400 FIND v(dout1_5) AT=205.025n

.meas tran vdout1_6ck400 FIND v(dout1_6) AT=205.025n

.meas tran vdout1_7ck400 FIND v(dout1_7) AT=205.025n

.meas tran vdout1_8ck400 FIND v(dout1_8) AT=205.025n

.meas tran vdout1_9ck400 FIND v(dout1_9) AT=205.025n

.meas tran vdout1_10ck400 FIND v(dout1_10) AT=205.025n

.meas tran vdout1_11ck400 FIND v(dout1_11) AT=205.025n

.meas tran vdout1_12ck400 FIND v(dout1_12) AT=205.025n

.meas tran vdout1_13ck400 FIND v(dout1_13) AT=205.025n

.meas tran vdout1_14ck400 FIND v(dout1_14) AT=205.025n

.meas tran vdout1_15ck400 FIND v(dout1_15) AT=205.025n

.meas tran vdout1_16ck400 FIND v(dout1_16) AT=205.025n

.meas tran vdout1_17ck400 FIND v(dout1_17) AT=205.025n

.meas tran vdout1_18ck400 FIND v(dout1_18) AT=205.025n

.meas tran vdout1_19ck400 FIND v(dout1_19) AT=205.025n

.meas tran vdout1_20ck400 FIND v(dout1_20) AT=205.025n

.meas tran vdout1_21ck400 FIND v(dout1_21) AT=205.025n

.meas tran vdout1_22ck400 FIND v(dout1_22) AT=205.025n

.meas tran vdout1_23ck400 FIND v(dout1_23) AT=205.025n

.meas tran vdout1_24ck400 FIND v(dout1_24) AT=205.025n

.meas tran vdout1_25ck400 FIND v(dout1_25) AT=205.025n

.meas tran vdout1_26ck400 FIND v(dout1_26) AT=205.025n

.meas tran vdout1_27ck400 FIND v(dout1_27) AT=205.025n

.meas tran vdout1_28ck400 FIND v(dout1_28) AT=205.025n

.meas tran vdout1_29ck400 FIND v(dout1_29) AT=205.025n

.meas tran vdout1_30ck400 FIND v(dout1_30) AT=205.025n

.meas tran vdout1_31ck400 FIND v(dout1_31) AT=205.025n

.meas tran vdout1_0ck420 FIND v(dout1_0) AT=215.025n

.meas tran vdout1_1ck420 FIND v(dout1_1) AT=215.025n

.meas tran vdout1_2ck420 FIND v(dout1_2) AT=215.025n

.meas tran vdout1_3ck420 FIND v(dout1_3) AT=215.025n

.meas tran vdout1_4ck420 FIND v(dout1_4) AT=215.025n

.meas tran vdout1_5ck420 FIND v(dout1_5) AT=215.025n

.meas tran vdout1_6ck420 FIND v(dout1_6) AT=215.025n

.meas tran vdout1_7ck420 FIND v(dout1_7) AT=215.025n

.meas tran vdout1_8ck420 FIND v(dout1_8) AT=215.025n

.meas tran vdout1_9ck420 FIND v(dout1_9) AT=215.025n

.meas tran vdout1_10ck420 FIND v(dout1_10) AT=215.025n

.meas tran vdout1_11ck420 FIND v(dout1_11) AT=215.025n

.meas tran vdout1_12ck420 FIND v(dout1_12) AT=215.025n

.meas tran vdout1_13ck420 FIND v(dout1_13) AT=215.025n

.meas tran vdout1_14ck420 FIND v(dout1_14) AT=215.025n

.meas tran vdout1_15ck420 FIND v(dout1_15) AT=215.025n

.meas tran vdout1_16ck420 FIND v(dout1_16) AT=215.025n

.meas tran vdout1_17ck420 FIND v(dout1_17) AT=215.025n

.meas tran vdout1_18ck420 FIND v(dout1_18) AT=215.025n

.meas tran vdout1_19ck420 FIND v(dout1_19) AT=215.025n

.meas tran vdout1_20ck420 FIND v(dout1_20) AT=215.025n

.meas tran vdout1_21ck420 FIND v(dout1_21) AT=215.025n

.meas tran vdout1_22ck420 FIND v(dout1_22) AT=215.025n

.meas tran vdout1_23ck420 FIND v(dout1_23) AT=215.025n

.meas tran vdout1_24ck420 FIND v(dout1_24) AT=215.025n

.meas tran vdout1_25ck420 FIND v(dout1_25) AT=215.025n

.meas tran vdout1_26ck420 FIND v(dout1_26) AT=215.025n

.meas tran vdout1_27ck420 FIND v(dout1_27) AT=215.025n

.meas tran vdout1_28ck420 FIND v(dout1_28) AT=215.025n

.meas tran vdout1_29ck420 FIND v(dout1_29) AT=215.025n

.meas tran vdout1_30ck420 FIND v(dout1_30) AT=215.025n

.meas tran vdout1_31ck420 FIND v(dout1_31) AT=215.025n

.meas tran vdout0_0ck430 FIND v(dout0_0) AT=220.025n

.meas tran vdout0_1ck430 FIND v(dout0_1) AT=220.025n

.meas tran vdout0_2ck430 FIND v(dout0_2) AT=220.025n

.meas tran vdout0_3ck430 FIND v(dout0_3) AT=220.025n

.meas tran vdout0_4ck430 FIND v(dout0_4) AT=220.025n

.meas tran vdout0_5ck430 FIND v(dout0_5) AT=220.025n

.meas tran vdout0_6ck430 FIND v(dout0_6) AT=220.025n

.meas tran vdout0_7ck430 FIND v(dout0_7) AT=220.025n

.meas tran vdout0_8ck430 FIND v(dout0_8) AT=220.025n

.meas tran vdout0_9ck430 FIND v(dout0_9) AT=220.025n

.meas tran vdout0_10ck430 FIND v(dout0_10) AT=220.025n

.meas tran vdout0_11ck430 FIND v(dout0_11) AT=220.025n

.meas tran vdout0_12ck430 FIND v(dout0_12) AT=220.025n

.meas tran vdout0_13ck430 FIND v(dout0_13) AT=220.025n

.meas tran vdout0_14ck430 FIND v(dout0_14) AT=220.025n

.meas tran vdout0_15ck430 FIND v(dout0_15) AT=220.025n

.meas tran vdout0_16ck430 FIND v(dout0_16) AT=220.025n

.meas tran vdout0_17ck430 FIND v(dout0_17) AT=220.025n

.meas tran vdout0_18ck430 FIND v(dout0_18) AT=220.025n

.meas tran vdout0_19ck430 FIND v(dout0_19) AT=220.025n

.meas tran vdout0_20ck430 FIND v(dout0_20) AT=220.025n

.meas tran vdout0_21ck430 FIND v(dout0_21) AT=220.025n

.meas tran vdout0_22ck430 FIND v(dout0_22) AT=220.025n

.meas tran vdout0_23ck430 FIND v(dout0_23) AT=220.025n

.meas tran vdout0_24ck430 FIND v(dout0_24) AT=220.025n

.meas tran vdout0_25ck430 FIND v(dout0_25) AT=220.025n

.meas tran vdout0_26ck430 FIND v(dout0_26) AT=220.025n

.meas tran vdout0_27ck430 FIND v(dout0_27) AT=220.025n

.meas tran vdout0_28ck430 FIND v(dout0_28) AT=220.025n

.meas tran vdout0_29ck430 FIND v(dout0_29) AT=220.025n

.meas tran vdout0_30ck430 FIND v(dout0_30) AT=220.025n

.meas tran vdout0_31ck430 FIND v(dout0_31) AT=220.025n

.meas tran vdout1_0ck430 FIND v(dout1_0) AT=220.025n

.meas tran vdout1_1ck430 FIND v(dout1_1) AT=220.025n

.meas tran vdout1_2ck430 FIND v(dout1_2) AT=220.025n

.meas tran vdout1_3ck430 FIND v(dout1_3) AT=220.025n

.meas tran vdout1_4ck430 FIND v(dout1_4) AT=220.025n

.meas tran vdout1_5ck430 FIND v(dout1_5) AT=220.025n

.meas tran vdout1_6ck430 FIND v(dout1_6) AT=220.025n

.meas tran vdout1_7ck430 FIND v(dout1_7) AT=220.025n

.meas tran vdout1_8ck430 FIND v(dout1_8) AT=220.025n

.meas tran vdout1_9ck430 FIND v(dout1_9) AT=220.025n

.meas tran vdout1_10ck430 FIND v(dout1_10) AT=220.025n

.meas tran vdout1_11ck430 FIND v(dout1_11) AT=220.025n

.meas tran vdout1_12ck430 FIND v(dout1_12) AT=220.025n

.meas tran vdout1_13ck430 FIND v(dout1_13) AT=220.025n

.meas tran vdout1_14ck430 FIND v(dout1_14) AT=220.025n

.meas tran vdout1_15ck430 FIND v(dout1_15) AT=220.025n

.meas tran vdout1_16ck430 FIND v(dout1_16) AT=220.025n

.meas tran vdout1_17ck430 FIND v(dout1_17) AT=220.025n

.meas tran vdout1_18ck430 FIND v(dout1_18) AT=220.025n

.meas tran vdout1_19ck430 FIND v(dout1_19) AT=220.025n

.meas tran vdout1_20ck430 FIND v(dout1_20) AT=220.025n

.meas tran vdout1_21ck430 FIND v(dout1_21) AT=220.025n

.meas tran vdout1_22ck430 FIND v(dout1_22) AT=220.025n

.meas tran vdout1_23ck430 FIND v(dout1_23) AT=220.025n

.meas tran vdout1_24ck430 FIND v(dout1_24) AT=220.025n

.meas tran vdout1_25ck430 FIND v(dout1_25) AT=220.025n

.meas tran vdout1_26ck430 FIND v(dout1_26) AT=220.025n

.meas tran vdout1_27ck430 FIND v(dout1_27) AT=220.025n

.meas tran vdout1_28ck430 FIND v(dout1_28) AT=220.025n

.meas tran vdout1_29ck430 FIND v(dout1_29) AT=220.025n

.meas tran vdout1_30ck430 FIND v(dout1_30) AT=220.025n

.meas tran vdout1_31ck430 FIND v(dout1_31) AT=220.025n

.meas tran vdout0_0ck440 FIND v(dout0_0) AT=225.025n

.meas tran vdout0_1ck440 FIND v(dout0_1) AT=225.025n

.meas tran vdout0_2ck440 FIND v(dout0_2) AT=225.025n

.meas tran vdout0_3ck440 FIND v(dout0_3) AT=225.025n

.meas tran vdout0_4ck440 FIND v(dout0_4) AT=225.025n

.meas tran vdout0_5ck440 FIND v(dout0_5) AT=225.025n

.meas tran vdout0_6ck440 FIND v(dout0_6) AT=225.025n

.meas tran vdout0_7ck440 FIND v(dout0_7) AT=225.025n

.meas tran vdout0_8ck440 FIND v(dout0_8) AT=225.025n

.meas tran vdout0_9ck440 FIND v(dout0_9) AT=225.025n

.meas tran vdout0_10ck440 FIND v(dout0_10) AT=225.025n

.meas tran vdout0_11ck440 FIND v(dout0_11) AT=225.025n

.meas tran vdout0_12ck440 FIND v(dout0_12) AT=225.025n

.meas tran vdout0_13ck440 FIND v(dout0_13) AT=225.025n

.meas tran vdout0_14ck440 FIND v(dout0_14) AT=225.025n

.meas tran vdout0_15ck440 FIND v(dout0_15) AT=225.025n

.meas tran vdout0_16ck440 FIND v(dout0_16) AT=225.025n

.meas tran vdout0_17ck440 FIND v(dout0_17) AT=225.025n

.meas tran vdout0_18ck440 FIND v(dout0_18) AT=225.025n

.meas tran vdout0_19ck440 FIND v(dout0_19) AT=225.025n

.meas tran vdout0_20ck440 FIND v(dout0_20) AT=225.025n

.meas tran vdout0_21ck440 FIND v(dout0_21) AT=225.025n

.meas tran vdout0_22ck440 FIND v(dout0_22) AT=225.025n

.meas tran vdout0_23ck440 FIND v(dout0_23) AT=225.025n

.meas tran vdout0_24ck440 FIND v(dout0_24) AT=225.025n

.meas tran vdout0_25ck440 FIND v(dout0_25) AT=225.025n

.meas tran vdout0_26ck440 FIND v(dout0_26) AT=225.025n

.meas tran vdout0_27ck440 FIND v(dout0_27) AT=225.025n

.meas tran vdout0_28ck440 FIND v(dout0_28) AT=225.025n

.meas tran vdout0_29ck440 FIND v(dout0_29) AT=225.025n

.meas tran vdout0_30ck440 FIND v(dout0_30) AT=225.025n

.meas tran vdout0_31ck440 FIND v(dout0_31) AT=225.025n

.meas tran vdout0_0ck450 FIND v(dout0_0) AT=230.025n

.meas tran vdout0_1ck450 FIND v(dout0_1) AT=230.025n

.meas tran vdout0_2ck450 FIND v(dout0_2) AT=230.025n

.meas tran vdout0_3ck450 FIND v(dout0_3) AT=230.025n

.meas tran vdout0_4ck450 FIND v(dout0_4) AT=230.025n

.meas tran vdout0_5ck450 FIND v(dout0_5) AT=230.025n

.meas tran vdout0_6ck450 FIND v(dout0_6) AT=230.025n

.meas tran vdout0_7ck450 FIND v(dout0_7) AT=230.025n

.meas tran vdout0_8ck450 FIND v(dout0_8) AT=230.025n

.meas tran vdout0_9ck450 FIND v(dout0_9) AT=230.025n

.meas tran vdout0_10ck450 FIND v(dout0_10) AT=230.025n

.meas tran vdout0_11ck450 FIND v(dout0_11) AT=230.025n

.meas tran vdout0_12ck450 FIND v(dout0_12) AT=230.025n

.meas tran vdout0_13ck450 FIND v(dout0_13) AT=230.025n

.meas tran vdout0_14ck450 FIND v(dout0_14) AT=230.025n

.meas tran vdout0_15ck450 FIND v(dout0_15) AT=230.025n

.meas tran vdout0_16ck450 FIND v(dout0_16) AT=230.025n

.meas tran vdout0_17ck450 FIND v(dout0_17) AT=230.025n

.meas tran vdout0_18ck450 FIND v(dout0_18) AT=230.025n

.meas tran vdout0_19ck450 FIND v(dout0_19) AT=230.025n

.meas tran vdout0_20ck450 FIND v(dout0_20) AT=230.025n

.meas tran vdout0_21ck450 FIND v(dout0_21) AT=230.025n

.meas tran vdout0_22ck450 FIND v(dout0_22) AT=230.025n

.meas tran vdout0_23ck450 FIND v(dout0_23) AT=230.025n

.meas tran vdout0_24ck450 FIND v(dout0_24) AT=230.025n

.meas tran vdout0_25ck450 FIND v(dout0_25) AT=230.025n

.meas tran vdout0_26ck450 FIND v(dout0_26) AT=230.025n

.meas tran vdout0_27ck450 FIND v(dout0_27) AT=230.025n

.meas tran vdout0_28ck450 FIND v(dout0_28) AT=230.025n

.meas tran vdout0_29ck450 FIND v(dout0_29) AT=230.025n

.meas tran vdout0_30ck450 FIND v(dout0_30) AT=230.025n

.meas tran vdout0_31ck450 FIND v(dout0_31) AT=230.025n

.meas tran vdout1_0ck450 FIND v(dout1_0) AT=230.025n

.meas tran vdout1_1ck450 FIND v(dout1_1) AT=230.025n

.meas tran vdout1_2ck450 FIND v(dout1_2) AT=230.025n

.meas tran vdout1_3ck450 FIND v(dout1_3) AT=230.025n

.meas tran vdout1_4ck450 FIND v(dout1_4) AT=230.025n

.meas tran vdout1_5ck450 FIND v(dout1_5) AT=230.025n

.meas tran vdout1_6ck450 FIND v(dout1_6) AT=230.025n

.meas tran vdout1_7ck450 FIND v(dout1_7) AT=230.025n

.meas tran vdout1_8ck450 FIND v(dout1_8) AT=230.025n

.meas tran vdout1_9ck450 FIND v(dout1_9) AT=230.025n

.meas tran vdout1_10ck450 FIND v(dout1_10) AT=230.025n

.meas tran vdout1_11ck450 FIND v(dout1_11) AT=230.025n

.meas tran vdout1_12ck450 FIND v(dout1_12) AT=230.025n

.meas tran vdout1_13ck450 FIND v(dout1_13) AT=230.025n

.meas tran vdout1_14ck450 FIND v(dout1_14) AT=230.025n

.meas tran vdout1_15ck450 FIND v(dout1_15) AT=230.025n

.meas tran vdout1_16ck450 FIND v(dout1_16) AT=230.025n

.meas tran vdout1_17ck450 FIND v(dout1_17) AT=230.025n

.meas tran vdout1_18ck450 FIND v(dout1_18) AT=230.025n

.meas tran vdout1_19ck450 FIND v(dout1_19) AT=230.025n

.meas tran vdout1_20ck450 FIND v(dout1_20) AT=230.025n

.meas tran vdout1_21ck450 FIND v(dout1_21) AT=230.025n

.meas tran vdout1_22ck450 FIND v(dout1_22) AT=230.025n

.meas tran vdout1_23ck450 FIND v(dout1_23) AT=230.025n

.meas tran vdout1_24ck450 FIND v(dout1_24) AT=230.025n

.meas tran vdout1_25ck450 FIND v(dout1_25) AT=230.025n

.meas tran vdout1_26ck450 FIND v(dout1_26) AT=230.025n

.meas tran vdout1_27ck450 FIND v(dout1_27) AT=230.025n

.meas tran vdout1_28ck450 FIND v(dout1_28) AT=230.025n

.meas tran vdout1_29ck450 FIND v(dout1_29) AT=230.025n

.meas tran vdout1_30ck450 FIND v(dout1_30) AT=230.025n

.meas tran vdout1_31ck450 FIND v(dout1_31) AT=230.025n

.meas tran vdout1_0ck460 FIND v(dout1_0) AT=235.025n

.meas tran vdout1_1ck460 FIND v(dout1_1) AT=235.025n

.meas tran vdout1_2ck460 FIND v(dout1_2) AT=235.025n

.meas tran vdout1_3ck460 FIND v(dout1_3) AT=235.025n

.meas tran vdout1_4ck460 FIND v(dout1_4) AT=235.025n

.meas tran vdout1_5ck460 FIND v(dout1_5) AT=235.025n

.meas tran vdout1_6ck460 FIND v(dout1_6) AT=235.025n

.meas tran vdout1_7ck460 FIND v(dout1_7) AT=235.025n

.meas tran vdout1_8ck460 FIND v(dout1_8) AT=235.025n

.meas tran vdout1_9ck460 FIND v(dout1_9) AT=235.025n

.meas tran vdout1_10ck460 FIND v(dout1_10) AT=235.025n

.meas tran vdout1_11ck460 FIND v(dout1_11) AT=235.025n

.meas tran vdout1_12ck460 FIND v(dout1_12) AT=235.025n

.meas tran vdout1_13ck460 FIND v(dout1_13) AT=235.025n

.meas tran vdout1_14ck460 FIND v(dout1_14) AT=235.025n

.meas tran vdout1_15ck460 FIND v(dout1_15) AT=235.025n

.meas tran vdout1_16ck460 FIND v(dout1_16) AT=235.025n

.meas tran vdout1_17ck460 FIND v(dout1_17) AT=235.025n

.meas tran vdout1_18ck460 FIND v(dout1_18) AT=235.025n

.meas tran vdout1_19ck460 FIND v(dout1_19) AT=235.025n

.meas tran vdout1_20ck460 FIND v(dout1_20) AT=235.025n

.meas tran vdout1_21ck460 FIND v(dout1_21) AT=235.025n

.meas tran vdout1_22ck460 FIND v(dout1_22) AT=235.025n

.meas tran vdout1_23ck460 FIND v(dout1_23) AT=235.025n

.meas tran vdout1_24ck460 FIND v(dout1_24) AT=235.025n

.meas tran vdout1_25ck460 FIND v(dout1_25) AT=235.025n

.meas tran vdout1_26ck460 FIND v(dout1_26) AT=235.025n

.meas tran vdout1_27ck460 FIND v(dout1_27) AT=235.025n

.meas tran vdout1_28ck460 FIND v(dout1_28) AT=235.025n

.meas tran vdout1_29ck460 FIND v(dout1_29) AT=235.025n

.meas tran vdout1_30ck460 FIND v(dout1_30) AT=235.025n

.meas tran vdout1_31ck460 FIND v(dout1_31) AT=235.025n

.meas tran vdout1_0ck490 FIND v(dout1_0) AT=250.025n

.meas tran vdout1_1ck490 FIND v(dout1_1) AT=250.025n

.meas tran vdout1_2ck490 FIND v(dout1_2) AT=250.025n

.meas tran vdout1_3ck490 FIND v(dout1_3) AT=250.025n

.meas tran vdout1_4ck490 FIND v(dout1_4) AT=250.025n

.meas tran vdout1_5ck490 FIND v(dout1_5) AT=250.025n

.meas tran vdout1_6ck490 FIND v(dout1_6) AT=250.025n

.meas tran vdout1_7ck490 FIND v(dout1_7) AT=250.025n

.meas tran vdout1_8ck490 FIND v(dout1_8) AT=250.025n

.meas tran vdout1_9ck490 FIND v(dout1_9) AT=250.025n

.meas tran vdout1_10ck490 FIND v(dout1_10) AT=250.025n

.meas tran vdout1_11ck490 FIND v(dout1_11) AT=250.025n

.meas tran vdout1_12ck490 FIND v(dout1_12) AT=250.025n

.meas tran vdout1_13ck490 FIND v(dout1_13) AT=250.025n

.meas tran vdout1_14ck490 FIND v(dout1_14) AT=250.025n

.meas tran vdout1_15ck490 FIND v(dout1_15) AT=250.025n

.meas tran vdout1_16ck490 FIND v(dout1_16) AT=250.025n

.meas tran vdout1_17ck490 FIND v(dout1_17) AT=250.025n

.meas tran vdout1_18ck490 FIND v(dout1_18) AT=250.025n

.meas tran vdout1_19ck490 FIND v(dout1_19) AT=250.025n

.meas tran vdout1_20ck490 FIND v(dout1_20) AT=250.025n

.meas tran vdout1_21ck490 FIND v(dout1_21) AT=250.025n

.meas tran vdout1_22ck490 FIND v(dout1_22) AT=250.025n

.meas tran vdout1_23ck490 FIND v(dout1_23) AT=250.025n

.meas tran vdout1_24ck490 FIND v(dout1_24) AT=250.025n

.meas tran vdout1_25ck490 FIND v(dout1_25) AT=250.025n

.meas tran vdout1_26ck490 FIND v(dout1_26) AT=250.025n

.meas tran vdout1_27ck490 FIND v(dout1_27) AT=250.025n

.meas tran vdout1_28ck490 FIND v(dout1_28) AT=250.025n

.meas tran vdout1_29ck490 FIND v(dout1_29) AT=250.025n

.meas tran vdout1_30ck490 FIND v(dout1_30) AT=250.025n

.meas tran vdout1_31ck490 FIND v(dout1_31) AT=250.025n

.meas tran vdout0_0ck510 FIND v(dout0_0) AT=260.025n

.meas tran vdout0_1ck510 FIND v(dout0_1) AT=260.025n

.meas tran vdout0_2ck510 FIND v(dout0_2) AT=260.025n

.meas tran vdout0_3ck510 FIND v(dout0_3) AT=260.025n

.meas tran vdout0_4ck510 FIND v(dout0_4) AT=260.025n

.meas tran vdout0_5ck510 FIND v(dout0_5) AT=260.025n

.meas tran vdout0_6ck510 FIND v(dout0_6) AT=260.025n

.meas tran vdout0_7ck510 FIND v(dout0_7) AT=260.025n

.meas tran vdout0_8ck510 FIND v(dout0_8) AT=260.025n

.meas tran vdout0_9ck510 FIND v(dout0_9) AT=260.025n

.meas tran vdout0_10ck510 FIND v(dout0_10) AT=260.025n

.meas tran vdout0_11ck510 FIND v(dout0_11) AT=260.025n

.meas tran vdout0_12ck510 FIND v(dout0_12) AT=260.025n

.meas tran vdout0_13ck510 FIND v(dout0_13) AT=260.025n

.meas tran vdout0_14ck510 FIND v(dout0_14) AT=260.025n

.meas tran vdout0_15ck510 FIND v(dout0_15) AT=260.025n

.meas tran vdout0_16ck510 FIND v(dout0_16) AT=260.025n

.meas tran vdout0_17ck510 FIND v(dout0_17) AT=260.025n

.meas tran vdout0_18ck510 FIND v(dout0_18) AT=260.025n

.meas tran vdout0_19ck510 FIND v(dout0_19) AT=260.025n

.meas tran vdout0_20ck510 FIND v(dout0_20) AT=260.025n

.meas tran vdout0_21ck510 FIND v(dout0_21) AT=260.025n

.meas tran vdout0_22ck510 FIND v(dout0_22) AT=260.025n

.meas tran vdout0_23ck510 FIND v(dout0_23) AT=260.025n

.meas tran vdout0_24ck510 FIND v(dout0_24) AT=260.025n

.meas tran vdout0_25ck510 FIND v(dout0_25) AT=260.025n

.meas tran vdout0_26ck510 FIND v(dout0_26) AT=260.025n

.meas tran vdout0_27ck510 FIND v(dout0_27) AT=260.025n

.meas tran vdout0_28ck510 FIND v(dout0_28) AT=260.025n

.meas tran vdout0_29ck510 FIND v(dout0_29) AT=260.025n

.meas tran vdout0_30ck510 FIND v(dout0_30) AT=260.025n

.meas tran vdout0_31ck510 FIND v(dout0_31) AT=260.025n

.meas tran vdout1_0ck510 FIND v(dout1_0) AT=260.025n

.meas tran vdout1_1ck510 FIND v(dout1_1) AT=260.025n

.meas tran vdout1_2ck510 FIND v(dout1_2) AT=260.025n

.meas tran vdout1_3ck510 FIND v(dout1_3) AT=260.025n

.meas tran vdout1_4ck510 FIND v(dout1_4) AT=260.025n

.meas tran vdout1_5ck510 FIND v(dout1_5) AT=260.025n

.meas tran vdout1_6ck510 FIND v(dout1_6) AT=260.025n

.meas tran vdout1_7ck510 FIND v(dout1_7) AT=260.025n

.meas tran vdout1_8ck510 FIND v(dout1_8) AT=260.025n

.meas tran vdout1_9ck510 FIND v(dout1_9) AT=260.025n

.meas tran vdout1_10ck510 FIND v(dout1_10) AT=260.025n

.meas tran vdout1_11ck510 FIND v(dout1_11) AT=260.025n

.meas tran vdout1_12ck510 FIND v(dout1_12) AT=260.025n

.meas tran vdout1_13ck510 FIND v(dout1_13) AT=260.025n

.meas tran vdout1_14ck510 FIND v(dout1_14) AT=260.025n

.meas tran vdout1_15ck510 FIND v(dout1_15) AT=260.025n

.meas tran vdout1_16ck510 FIND v(dout1_16) AT=260.025n

.meas tran vdout1_17ck510 FIND v(dout1_17) AT=260.025n

.meas tran vdout1_18ck510 FIND v(dout1_18) AT=260.025n

.meas tran vdout1_19ck510 FIND v(dout1_19) AT=260.025n

.meas tran vdout1_20ck510 FIND v(dout1_20) AT=260.025n

.meas tran vdout1_21ck510 FIND v(dout1_21) AT=260.025n

.meas tran vdout1_22ck510 FIND v(dout1_22) AT=260.025n

.meas tran vdout1_23ck510 FIND v(dout1_23) AT=260.025n

.meas tran vdout1_24ck510 FIND v(dout1_24) AT=260.025n

.meas tran vdout1_25ck510 FIND v(dout1_25) AT=260.025n

.meas tran vdout1_26ck510 FIND v(dout1_26) AT=260.025n

.meas tran vdout1_27ck510 FIND v(dout1_27) AT=260.025n

.meas tran vdout1_28ck510 FIND v(dout1_28) AT=260.025n

.meas tran vdout1_29ck510 FIND v(dout1_29) AT=260.025n

.meas tran vdout1_30ck510 FIND v(dout1_30) AT=260.025n

.meas tran vdout1_31ck510 FIND v(dout1_31) AT=260.025n

.meas tran vdout0_0ck520 FIND v(dout0_0) AT=265.025n

.meas tran vdout0_1ck520 FIND v(dout0_1) AT=265.025n

.meas tran vdout0_2ck520 FIND v(dout0_2) AT=265.025n

.meas tran vdout0_3ck520 FIND v(dout0_3) AT=265.025n

.meas tran vdout0_4ck520 FIND v(dout0_4) AT=265.025n

.meas tran vdout0_5ck520 FIND v(dout0_5) AT=265.025n

.meas tran vdout0_6ck520 FIND v(dout0_6) AT=265.025n

.meas tran vdout0_7ck520 FIND v(dout0_7) AT=265.025n

.meas tran vdout0_8ck520 FIND v(dout0_8) AT=265.025n

.meas tran vdout0_9ck520 FIND v(dout0_9) AT=265.025n

.meas tran vdout0_10ck520 FIND v(dout0_10) AT=265.025n

.meas tran vdout0_11ck520 FIND v(dout0_11) AT=265.025n

.meas tran vdout0_12ck520 FIND v(dout0_12) AT=265.025n

.meas tran vdout0_13ck520 FIND v(dout0_13) AT=265.025n

.meas tran vdout0_14ck520 FIND v(dout0_14) AT=265.025n

.meas tran vdout0_15ck520 FIND v(dout0_15) AT=265.025n

.meas tran vdout0_16ck520 FIND v(dout0_16) AT=265.025n

.meas tran vdout0_17ck520 FIND v(dout0_17) AT=265.025n

.meas tran vdout0_18ck520 FIND v(dout0_18) AT=265.025n

.meas tran vdout0_19ck520 FIND v(dout0_19) AT=265.025n

.meas tran vdout0_20ck520 FIND v(dout0_20) AT=265.025n

.meas tran vdout0_21ck520 FIND v(dout0_21) AT=265.025n

.meas tran vdout0_22ck520 FIND v(dout0_22) AT=265.025n

.meas tran vdout0_23ck520 FIND v(dout0_23) AT=265.025n

.meas tran vdout0_24ck520 FIND v(dout0_24) AT=265.025n

.meas tran vdout0_25ck520 FIND v(dout0_25) AT=265.025n

.meas tran vdout0_26ck520 FIND v(dout0_26) AT=265.025n

.meas tran vdout0_27ck520 FIND v(dout0_27) AT=265.025n

.meas tran vdout0_28ck520 FIND v(dout0_28) AT=265.025n

.meas tran vdout0_29ck520 FIND v(dout0_29) AT=265.025n

.meas tran vdout0_30ck520 FIND v(dout0_30) AT=265.025n

.meas tran vdout0_31ck520 FIND v(dout0_31) AT=265.025n

.meas tran vdout1_0ck530 FIND v(dout1_0) AT=270.025n

.meas tran vdout1_1ck530 FIND v(dout1_1) AT=270.025n

.meas tran vdout1_2ck530 FIND v(dout1_2) AT=270.025n

.meas tran vdout1_3ck530 FIND v(dout1_3) AT=270.025n

.meas tran vdout1_4ck530 FIND v(dout1_4) AT=270.025n

.meas tran vdout1_5ck530 FIND v(dout1_5) AT=270.025n

.meas tran vdout1_6ck530 FIND v(dout1_6) AT=270.025n

.meas tran vdout1_7ck530 FIND v(dout1_7) AT=270.025n

.meas tran vdout1_8ck530 FIND v(dout1_8) AT=270.025n

.meas tran vdout1_9ck530 FIND v(dout1_9) AT=270.025n

.meas tran vdout1_10ck530 FIND v(dout1_10) AT=270.025n

.meas tran vdout1_11ck530 FIND v(dout1_11) AT=270.025n

.meas tran vdout1_12ck530 FIND v(dout1_12) AT=270.025n

.meas tran vdout1_13ck530 FIND v(dout1_13) AT=270.025n

.meas tran vdout1_14ck530 FIND v(dout1_14) AT=270.025n

.meas tran vdout1_15ck530 FIND v(dout1_15) AT=270.025n

.meas tran vdout1_16ck530 FIND v(dout1_16) AT=270.025n

.meas tran vdout1_17ck530 FIND v(dout1_17) AT=270.025n

.meas tran vdout1_18ck530 FIND v(dout1_18) AT=270.025n

.meas tran vdout1_19ck530 FIND v(dout1_19) AT=270.025n

.meas tran vdout1_20ck530 FIND v(dout1_20) AT=270.025n

.meas tran vdout1_21ck530 FIND v(dout1_21) AT=270.025n

.meas tran vdout1_22ck530 FIND v(dout1_22) AT=270.025n

.meas tran vdout1_23ck530 FIND v(dout1_23) AT=270.025n

.meas tran vdout1_24ck530 FIND v(dout1_24) AT=270.025n

.meas tran vdout1_25ck530 FIND v(dout1_25) AT=270.025n

.meas tran vdout1_26ck530 FIND v(dout1_26) AT=270.025n

.meas tran vdout1_27ck530 FIND v(dout1_27) AT=270.025n

.meas tran vdout1_28ck530 FIND v(dout1_28) AT=270.025n

.meas tran vdout1_29ck530 FIND v(dout1_29) AT=270.025n

.meas tran vdout1_30ck530 FIND v(dout1_30) AT=270.025n

.meas tran vdout1_31ck530 FIND v(dout1_31) AT=270.025n

.meas tran vdout0_0ck540 FIND v(dout0_0) AT=275.025n

.meas tran vdout0_1ck540 FIND v(dout0_1) AT=275.025n

.meas tran vdout0_2ck540 FIND v(dout0_2) AT=275.025n

.meas tran vdout0_3ck540 FIND v(dout0_3) AT=275.025n

.meas tran vdout0_4ck540 FIND v(dout0_4) AT=275.025n

.meas tran vdout0_5ck540 FIND v(dout0_5) AT=275.025n

.meas tran vdout0_6ck540 FIND v(dout0_6) AT=275.025n

.meas tran vdout0_7ck540 FIND v(dout0_7) AT=275.025n

.meas tran vdout0_8ck540 FIND v(dout0_8) AT=275.025n

.meas tran vdout0_9ck540 FIND v(dout0_9) AT=275.025n

.meas tran vdout0_10ck540 FIND v(dout0_10) AT=275.025n

.meas tran vdout0_11ck540 FIND v(dout0_11) AT=275.025n

.meas tran vdout0_12ck540 FIND v(dout0_12) AT=275.025n

.meas tran vdout0_13ck540 FIND v(dout0_13) AT=275.025n

.meas tran vdout0_14ck540 FIND v(dout0_14) AT=275.025n

.meas tran vdout0_15ck540 FIND v(dout0_15) AT=275.025n

.meas tran vdout0_16ck540 FIND v(dout0_16) AT=275.025n

.meas tran vdout0_17ck540 FIND v(dout0_17) AT=275.025n

.meas tran vdout0_18ck540 FIND v(dout0_18) AT=275.025n

.meas tran vdout0_19ck540 FIND v(dout0_19) AT=275.025n

.meas tran vdout0_20ck540 FIND v(dout0_20) AT=275.025n

.meas tran vdout0_21ck540 FIND v(dout0_21) AT=275.025n

.meas tran vdout0_22ck540 FIND v(dout0_22) AT=275.025n

.meas tran vdout0_23ck540 FIND v(dout0_23) AT=275.025n

.meas tran vdout0_24ck540 FIND v(dout0_24) AT=275.025n

.meas tran vdout0_25ck540 FIND v(dout0_25) AT=275.025n

.meas tran vdout0_26ck540 FIND v(dout0_26) AT=275.025n

.meas tran vdout0_27ck540 FIND v(dout0_27) AT=275.025n

.meas tran vdout0_28ck540 FIND v(dout0_28) AT=275.025n

.meas tran vdout0_29ck540 FIND v(dout0_29) AT=275.025n

.meas tran vdout0_30ck540 FIND v(dout0_30) AT=275.025n

.meas tran vdout0_31ck540 FIND v(dout0_31) AT=275.025n

.meas tran vdout1_0ck540 FIND v(dout1_0) AT=275.025n

.meas tran vdout1_1ck540 FIND v(dout1_1) AT=275.025n

.meas tran vdout1_2ck540 FIND v(dout1_2) AT=275.025n

.meas tran vdout1_3ck540 FIND v(dout1_3) AT=275.025n

.meas tran vdout1_4ck540 FIND v(dout1_4) AT=275.025n

.meas tran vdout1_5ck540 FIND v(dout1_5) AT=275.025n

.meas tran vdout1_6ck540 FIND v(dout1_6) AT=275.025n

.meas tran vdout1_7ck540 FIND v(dout1_7) AT=275.025n

.meas tran vdout1_8ck540 FIND v(dout1_8) AT=275.025n

.meas tran vdout1_9ck540 FIND v(dout1_9) AT=275.025n

.meas tran vdout1_10ck540 FIND v(dout1_10) AT=275.025n

.meas tran vdout1_11ck540 FIND v(dout1_11) AT=275.025n

.meas tran vdout1_12ck540 FIND v(dout1_12) AT=275.025n

.meas tran vdout1_13ck540 FIND v(dout1_13) AT=275.025n

.meas tran vdout1_14ck540 FIND v(dout1_14) AT=275.025n

.meas tran vdout1_15ck540 FIND v(dout1_15) AT=275.025n

.meas tran vdout1_16ck540 FIND v(dout1_16) AT=275.025n

.meas tran vdout1_17ck540 FIND v(dout1_17) AT=275.025n

.meas tran vdout1_18ck540 FIND v(dout1_18) AT=275.025n

.meas tran vdout1_19ck540 FIND v(dout1_19) AT=275.025n

.meas tran vdout1_20ck540 FIND v(dout1_20) AT=275.025n

.meas tran vdout1_21ck540 FIND v(dout1_21) AT=275.025n

.meas tran vdout1_22ck540 FIND v(dout1_22) AT=275.025n

.meas tran vdout1_23ck540 FIND v(dout1_23) AT=275.025n

.meas tran vdout1_24ck540 FIND v(dout1_24) AT=275.025n

.meas tran vdout1_25ck540 FIND v(dout1_25) AT=275.025n

.meas tran vdout1_26ck540 FIND v(dout1_26) AT=275.025n

.meas tran vdout1_27ck540 FIND v(dout1_27) AT=275.025n

.meas tran vdout1_28ck540 FIND v(dout1_28) AT=275.025n

.meas tran vdout1_29ck540 FIND v(dout1_29) AT=275.025n

.meas tran vdout1_30ck540 FIND v(dout1_30) AT=275.025n

.meas tran vdout1_31ck540 FIND v(dout1_31) AT=275.025n

.meas tran vdout0_0ck560 FIND v(dout0_0) AT=285.025n

.meas tran vdout0_1ck560 FIND v(dout0_1) AT=285.025n

.meas tran vdout0_2ck560 FIND v(dout0_2) AT=285.025n

.meas tran vdout0_3ck560 FIND v(dout0_3) AT=285.025n

.meas tran vdout0_4ck560 FIND v(dout0_4) AT=285.025n

.meas tran vdout0_5ck560 FIND v(dout0_5) AT=285.025n

.meas tran vdout0_6ck560 FIND v(dout0_6) AT=285.025n

.meas tran vdout0_7ck560 FIND v(dout0_7) AT=285.025n

.meas tran vdout0_8ck560 FIND v(dout0_8) AT=285.025n

.meas tran vdout0_9ck560 FIND v(dout0_9) AT=285.025n

.meas tran vdout0_10ck560 FIND v(dout0_10) AT=285.025n

.meas tran vdout0_11ck560 FIND v(dout0_11) AT=285.025n

.meas tran vdout0_12ck560 FIND v(dout0_12) AT=285.025n

.meas tran vdout0_13ck560 FIND v(dout0_13) AT=285.025n

.meas tran vdout0_14ck560 FIND v(dout0_14) AT=285.025n

.meas tran vdout0_15ck560 FIND v(dout0_15) AT=285.025n

.meas tran vdout0_16ck560 FIND v(dout0_16) AT=285.025n

.meas tran vdout0_17ck560 FIND v(dout0_17) AT=285.025n

.meas tran vdout0_18ck560 FIND v(dout0_18) AT=285.025n

.meas tran vdout0_19ck560 FIND v(dout0_19) AT=285.025n

.meas tran vdout0_20ck560 FIND v(dout0_20) AT=285.025n

.meas tran vdout0_21ck560 FIND v(dout0_21) AT=285.025n

.meas tran vdout0_22ck560 FIND v(dout0_22) AT=285.025n

.meas tran vdout0_23ck560 FIND v(dout0_23) AT=285.025n

.meas tran vdout0_24ck560 FIND v(dout0_24) AT=285.025n

.meas tran vdout0_25ck560 FIND v(dout0_25) AT=285.025n

.meas tran vdout0_26ck560 FIND v(dout0_26) AT=285.025n

.meas tran vdout0_27ck560 FIND v(dout0_27) AT=285.025n

.meas tran vdout0_28ck560 FIND v(dout0_28) AT=285.025n

.meas tran vdout0_29ck560 FIND v(dout0_29) AT=285.025n

.meas tran vdout0_30ck560 FIND v(dout0_30) AT=285.025n

.meas tran vdout0_31ck560 FIND v(dout0_31) AT=285.025n

.meas tran vdout1_0ck560 FIND v(dout1_0) AT=285.025n

.meas tran vdout1_1ck560 FIND v(dout1_1) AT=285.025n

.meas tran vdout1_2ck560 FIND v(dout1_2) AT=285.025n

.meas tran vdout1_3ck560 FIND v(dout1_3) AT=285.025n

.meas tran vdout1_4ck560 FIND v(dout1_4) AT=285.025n

.meas tran vdout1_5ck560 FIND v(dout1_5) AT=285.025n

.meas tran vdout1_6ck560 FIND v(dout1_6) AT=285.025n

.meas tran vdout1_7ck560 FIND v(dout1_7) AT=285.025n

.meas tran vdout1_8ck560 FIND v(dout1_8) AT=285.025n

.meas tran vdout1_9ck560 FIND v(dout1_9) AT=285.025n

.meas tran vdout1_10ck560 FIND v(dout1_10) AT=285.025n

.meas tran vdout1_11ck560 FIND v(dout1_11) AT=285.025n

.meas tran vdout1_12ck560 FIND v(dout1_12) AT=285.025n

.meas tran vdout1_13ck560 FIND v(dout1_13) AT=285.025n

.meas tran vdout1_14ck560 FIND v(dout1_14) AT=285.025n

.meas tran vdout1_15ck560 FIND v(dout1_15) AT=285.025n

.meas tran vdout1_16ck560 FIND v(dout1_16) AT=285.025n

.meas tran vdout1_17ck560 FIND v(dout1_17) AT=285.025n

.meas tran vdout1_18ck560 FIND v(dout1_18) AT=285.025n

.meas tran vdout1_19ck560 FIND v(dout1_19) AT=285.025n

.meas tran vdout1_20ck560 FIND v(dout1_20) AT=285.025n

.meas tran vdout1_21ck560 FIND v(dout1_21) AT=285.025n

.meas tran vdout1_22ck560 FIND v(dout1_22) AT=285.025n

.meas tran vdout1_23ck560 FIND v(dout1_23) AT=285.025n

.meas tran vdout1_24ck560 FIND v(dout1_24) AT=285.025n

.meas tran vdout1_25ck560 FIND v(dout1_25) AT=285.025n

.meas tran vdout1_26ck560 FIND v(dout1_26) AT=285.025n

.meas tran vdout1_27ck560 FIND v(dout1_27) AT=285.025n

.meas tran vdout1_28ck560 FIND v(dout1_28) AT=285.025n

.meas tran vdout1_29ck560 FIND v(dout1_29) AT=285.025n

.meas tran vdout1_30ck560 FIND v(dout1_30) AT=285.025n

.meas tran vdout1_31ck560 FIND v(dout1_31) AT=285.025n

.meas tran vdout1_0ck570 FIND v(dout1_0) AT=290.025n

.meas tran vdout1_1ck570 FIND v(dout1_1) AT=290.025n

.meas tran vdout1_2ck570 FIND v(dout1_2) AT=290.025n

.meas tran vdout1_3ck570 FIND v(dout1_3) AT=290.025n

.meas tran vdout1_4ck570 FIND v(dout1_4) AT=290.025n

.meas tran vdout1_5ck570 FIND v(dout1_5) AT=290.025n

.meas tran vdout1_6ck570 FIND v(dout1_6) AT=290.025n

.meas tran vdout1_7ck570 FIND v(dout1_7) AT=290.025n

.meas tran vdout1_8ck570 FIND v(dout1_8) AT=290.025n

.meas tran vdout1_9ck570 FIND v(dout1_9) AT=290.025n

.meas tran vdout1_10ck570 FIND v(dout1_10) AT=290.025n

.meas tran vdout1_11ck570 FIND v(dout1_11) AT=290.025n

.meas tran vdout1_12ck570 FIND v(dout1_12) AT=290.025n

.meas tran vdout1_13ck570 FIND v(dout1_13) AT=290.025n

.meas tran vdout1_14ck570 FIND v(dout1_14) AT=290.025n

.meas tran vdout1_15ck570 FIND v(dout1_15) AT=290.025n

.meas tran vdout1_16ck570 FIND v(dout1_16) AT=290.025n

.meas tran vdout1_17ck570 FIND v(dout1_17) AT=290.025n

.meas tran vdout1_18ck570 FIND v(dout1_18) AT=290.025n

.meas tran vdout1_19ck570 FIND v(dout1_19) AT=290.025n

.meas tran vdout1_20ck570 FIND v(dout1_20) AT=290.025n

.meas tran vdout1_21ck570 FIND v(dout1_21) AT=290.025n

.meas tran vdout1_22ck570 FIND v(dout1_22) AT=290.025n

.meas tran vdout1_23ck570 FIND v(dout1_23) AT=290.025n

.meas tran vdout1_24ck570 FIND v(dout1_24) AT=290.025n

.meas tran vdout1_25ck570 FIND v(dout1_25) AT=290.025n

.meas tran vdout1_26ck570 FIND v(dout1_26) AT=290.025n

.meas tran vdout1_27ck570 FIND v(dout1_27) AT=290.025n

.meas tran vdout1_28ck570 FIND v(dout1_28) AT=290.025n

.meas tran vdout1_29ck570 FIND v(dout1_29) AT=290.025n

.meas tran vdout1_30ck570 FIND v(dout1_30) AT=290.025n

.meas tran vdout1_31ck570 FIND v(dout1_31) AT=290.025n

.meas tran vdout0_0ck580 FIND v(dout0_0) AT=295.025n

.meas tran vdout0_1ck580 FIND v(dout0_1) AT=295.025n

.meas tran vdout0_2ck580 FIND v(dout0_2) AT=295.025n

.meas tran vdout0_3ck580 FIND v(dout0_3) AT=295.025n

.meas tran vdout0_4ck580 FIND v(dout0_4) AT=295.025n

.meas tran vdout0_5ck580 FIND v(dout0_5) AT=295.025n

.meas tran vdout0_6ck580 FIND v(dout0_6) AT=295.025n

.meas tran vdout0_7ck580 FIND v(dout0_7) AT=295.025n

.meas tran vdout0_8ck580 FIND v(dout0_8) AT=295.025n

.meas tran vdout0_9ck580 FIND v(dout0_9) AT=295.025n

.meas tran vdout0_10ck580 FIND v(dout0_10) AT=295.025n

.meas tran vdout0_11ck580 FIND v(dout0_11) AT=295.025n

.meas tran vdout0_12ck580 FIND v(dout0_12) AT=295.025n

.meas tran vdout0_13ck580 FIND v(dout0_13) AT=295.025n

.meas tran vdout0_14ck580 FIND v(dout0_14) AT=295.025n

.meas tran vdout0_15ck580 FIND v(dout0_15) AT=295.025n

.meas tran vdout0_16ck580 FIND v(dout0_16) AT=295.025n

.meas tran vdout0_17ck580 FIND v(dout0_17) AT=295.025n

.meas tran vdout0_18ck580 FIND v(dout0_18) AT=295.025n

.meas tran vdout0_19ck580 FIND v(dout0_19) AT=295.025n

.meas tran vdout0_20ck580 FIND v(dout0_20) AT=295.025n

.meas tran vdout0_21ck580 FIND v(dout0_21) AT=295.025n

.meas tran vdout0_22ck580 FIND v(dout0_22) AT=295.025n

.meas tran vdout0_23ck580 FIND v(dout0_23) AT=295.025n

.meas tran vdout0_24ck580 FIND v(dout0_24) AT=295.025n

.meas tran vdout0_25ck580 FIND v(dout0_25) AT=295.025n

.meas tran vdout0_26ck580 FIND v(dout0_26) AT=295.025n

.meas tran vdout0_27ck580 FIND v(dout0_27) AT=295.025n

.meas tran vdout0_28ck580 FIND v(dout0_28) AT=295.025n

.meas tran vdout0_29ck580 FIND v(dout0_29) AT=295.025n

.meas tran vdout0_30ck580 FIND v(dout0_30) AT=295.025n

.meas tran vdout0_31ck580 FIND v(dout0_31) AT=295.025n

.meas tran vdout0_0ck590 FIND v(dout0_0) AT=300.025n

.meas tran vdout0_1ck590 FIND v(dout0_1) AT=300.025n

.meas tran vdout0_2ck590 FIND v(dout0_2) AT=300.025n

.meas tran vdout0_3ck590 FIND v(dout0_3) AT=300.025n

.meas tran vdout0_4ck590 FIND v(dout0_4) AT=300.025n

.meas tran vdout0_5ck590 FIND v(dout0_5) AT=300.025n

.meas tran vdout0_6ck590 FIND v(dout0_6) AT=300.025n

.meas tran vdout0_7ck590 FIND v(dout0_7) AT=300.025n

.meas tran vdout0_8ck590 FIND v(dout0_8) AT=300.025n

.meas tran vdout0_9ck590 FIND v(dout0_9) AT=300.025n

.meas tran vdout0_10ck590 FIND v(dout0_10) AT=300.025n

.meas tran vdout0_11ck590 FIND v(dout0_11) AT=300.025n

.meas tran vdout0_12ck590 FIND v(dout0_12) AT=300.025n

.meas tran vdout0_13ck590 FIND v(dout0_13) AT=300.025n

.meas tran vdout0_14ck590 FIND v(dout0_14) AT=300.025n

.meas tran vdout0_15ck590 FIND v(dout0_15) AT=300.025n

.meas tran vdout0_16ck590 FIND v(dout0_16) AT=300.025n

.meas tran vdout0_17ck590 FIND v(dout0_17) AT=300.025n

.meas tran vdout0_18ck590 FIND v(dout0_18) AT=300.025n

.meas tran vdout0_19ck590 FIND v(dout0_19) AT=300.025n

.meas tran vdout0_20ck590 FIND v(dout0_20) AT=300.025n

.meas tran vdout0_21ck590 FIND v(dout0_21) AT=300.025n

.meas tran vdout0_22ck590 FIND v(dout0_22) AT=300.025n

.meas tran vdout0_23ck590 FIND v(dout0_23) AT=300.025n

.meas tran vdout0_24ck590 FIND v(dout0_24) AT=300.025n

.meas tran vdout0_25ck590 FIND v(dout0_25) AT=300.025n

.meas tran vdout0_26ck590 FIND v(dout0_26) AT=300.025n

.meas tran vdout0_27ck590 FIND v(dout0_27) AT=300.025n

.meas tran vdout0_28ck590 FIND v(dout0_28) AT=300.025n

.meas tran vdout0_29ck590 FIND v(dout0_29) AT=300.025n

.meas tran vdout0_30ck590 FIND v(dout0_30) AT=300.025n

.meas tran vdout0_31ck590 FIND v(dout0_31) AT=300.025n

.meas tran vdout1_0ck590 FIND v(dout1_0) AT=300.025n

.meas tran vdout1_1ck590 FIND v(dout1_1) AT=300.025n

.meas tran vdout1_2ck590 FIND v(dout1_2) AT=300.025n

.meas tran vdout1_3ck590 FIND v(dout1_3) AT=300.025n

.meas tran vdout1_4ck590 FIND v(dout1_4) AT=300.025n

.meas tran vdout1_5ck590 FIND v(dout1_5) AT=300.025n

.meas tran vdout1_6ck590 FIND v(dout1_6) AT=300.025n

.meas tran vdout1_7ck590 FIND v(dout1_7) AT=300.025n

.meas tran vdout1_8ck590 FIND v(dout1_8) AT=300.025n

.meas tran vdout1_9ck590 FIND v(dout1_9) AT=300.025n

.meas tran vdout1_10ck590 FIND v(dout1_10) AT=300.025n

.meas tran vdout1_11ck590 FIND v(dout1_11) AT=300.025n

.meas tran vdout1_12ck590 FIND v(dout1_12) AT=300.025n

.meas tran vdout1_13ck590 FIND v(dout1_13) AT=300.025n

.meas tran vdout1_14ck590 FIND v(dout1_14) AT=300.025n

.meas tran vdout1_15ck590 FIND v(dout1_15) AT=300.025n

.meas tran vdout1_16ck590 FIND v(dout1_16) AT=300.025n

.meas tran vdout1_17ck590 FIND v(dout1_17) AT=300.025n

.meas tran vdout1_18ck590 FIND v(dout1_18) AT=300.025n

.meas tran vdout1_19ck590 FIND v(dout1_19) AT=300.025n

.meas tran vdout1_20ck590 FIND v(dout1_20) AT=300.025n

.meas tran vdout1_21ck590 FIND v(dout1_21) AT=300.025n

.meas tran vdout1_22ck590 FIND v(dout1_22) AT=300.025n

.meas tran vdout1_23ck590 FIND v(dout1_23) AT=300.025n

.meas tran vdout1_24ck590 FIND v(dout1_24) AT=300.025n

.meas tran vdout1_25ck590 FIND v(dout1_25) AT=300.025n

.meas tran vdout1_26ck590 FIND v(dout1_26) AT=300.025n

.meas tran vdout1_27ck590 FIND v(dout1_27) AT=300.025n

.meas tran vdout1_28ck590 FIND v(dout1_28) AT=300.025n

.meas tran vdout1_29ck590 FIND v(dout1_29) AT=300.025n

.meas tran vdout1_30ck590 FIND v(dout1_30) AT=300.025n

.meas tran vdout1_31ck590 FIND v(dout1_31) AT=300.025n

.meas tran vdout1_0ck600 FIND v(dout1_0) AT=305.025n

.meas tran vdout1_1ck600 FIND v(dout1_1) AT=305.025n

.meas tran vdout1_2ck600 FIND v(dout1_2) AT=305.025n

.meas tran vdout1_3ck600 FIND v(dout1_3) AT=305.025n

.meas tran vdout1_4ck600 FIND v(dout1_4) AT=305.025n

.meas tran vdout1_5ck600 FIND v(dout1_5) AT=305.025n

.meas tran vdout1_6ck600 FIND v(dout1_6) AT=305.025n

.meas tran vdout1_7ck600 FIND v(dout1_7) AT=305.025n

.meas tran vdout1_8ck600 FIND v(dout1_8) AT=305.025n

.meas tran vdout1_9ck600 FIND v(dout1_9) AT=305.025n

.meas tran vdout1_10ck600 FIND v(dout1_10) AT=305.025n

.meas tran vdout1_11ck600 FIND v(dout1_11) AT=305.025n

.meas tran vdout1_12ck600 FIND v(dout1_12) AT=305.025n

.meas tran vdout1_13ck600 FIND v(dout1_13) AT=305.025n

.meas tran vdout1_14ck600 FIND v(dout1_14) AT=305.025n

.meas tran vdout1_15ck600 FIND v(dout1_15) AT=305.025n

.meas tran vdout1_16ck600 FIND v(dout1_16) AT=305.025n

.meas tran vdout1_17ck600 FIND v(dout1_17) AT=305.025n

.meas tran vdout1_18ck600 FIND v(dout1_18) AT=305.025n

.meas tran vdout1_19ck600 FIND v(dout1_19) AT=305.025n

.meas tran vdout1_20ck600 FIND v(dout1_20) AT=305.025n

.meas tran vdout1_21ck600 FIND v(dout1_21) AT=305.025n

.meas tran vdout1_22ck600 FIND v(dout1_22) AT=305.025n

.meas tran vdout1_23ck600 FIND v(dout1_23) AT=305.025n

.meas tran vdout1_24ck600 FIND v(dout1_24) AT=305.025n

.meas tran vdout1_25ck600 FIND v(dout1_25) AT=305.025n

.meas tran vdout1_26ck600 FIND v(dout1_26) AT=305.025n

.meas tran vdout1_27ck600 FIND v(dout1_27) AT=305.025n

.meas tran vdout1_28ck600 FIND v(dout1_28) AT=305.025n

.meas tran vdout1_29ck600 FIND v(dout1_29) AT=305.025n

.meas tran vdout1_30ck600 FIND v(dout1_30) AT=305.025n

.meas tran vdout1_31ck600 FIND v(dout1_31) AT=305.025n

.meas tran vdout0_0ck610 FIND v(dout0_0) AT=310.025n

.meas tran vdout0_1ck610 FIND v(dout0_1) AT=310.025n

.meas tran vdout0_2ck610 FIND v(dout0_2) AT=310.025n

.meas tran vdout0_3ck610 FIND v(dout0_3) AT=310.025n

.meas tran vdout0_4ck610 FIND v(dout0_4) AT=310.025n

.meas tran vdout0_5ck610 FIND v(dout0_5) AT=310.025n

.meas tran vdout0_6ck610 FIND v(dout0_6) AT=310.025n

.meas tran vdout0_7ck610 FIND v(dout0_7) AT=310.025n

.meas tran vdout0_8ck610 FIND v(dout0_8) AT=310.025n

.meas tran vdout0_9ck610 FIND v(dout0_9) AT=310.025n

.meas tran vdout0_10ck610 FIND v(dout0_10) AT=310.025n

.meas tran vdout0_11ck610 FIND v(dout0_11) AT=310.025n

.meas tran vdout0_12ck610 FIND v(dout0_12) AT=310.025n

.meas tran vdout0_13ck610 FIND v(dout0_13) AT=310.025n

.meas tran vdout0_14ck610 FIND v(dout0_14) AT=310.025n

.meas tran vdout0_15ck610 FIND v(dout0_15) AT=310.025n

.meas tran vdout0_16ck610 FIND v(dout0_16) AT=310.025n

.meas tran vdout0_17ck610 FIND v(dout0_17) AT=310.025n

.meas tran vdout0_18ck610 FIND v(dout0_18) AT=310.025n

.meas tran vdout0_19ck610 FIND v(dout0_19) AT=310.025n

.meas tran vdout0_20ck610 FIND v(dout0_20) AT=310.025n

.meas tran vdout0_21ck610 FIND v(dout0_21) AT=310.025n

.meas tran vdout0_22ck610 FIND v(dout0_22) AT=310.025n

.meas tran vdout0_23ck610 FIND v(dout0_23) AT=310.025n

.meas tran vdout0_24ck610 FIND v(dout0_24) AT=310.025n

.meas tran vdout0_25ck610 FIND v(dout0_25) AT=310.025n

.meas tran vdout0_26ck610 FIND v(dout0_26) AT=310.025n

.meas tran vdout0_27ck610 FIND v(dout0_27) AT=310.025n

.meas tran vdout0_28ck610 FIND v(dout0_28) AT=310.025n

.meas tran vdout0_29ck610 FIND v(dout0_29) AT=310.025n

.meas tran vdout0_30ck610 FIND v(dout0_30) AT=310.025n

.meas tran vdout0_31ck610 FIND v(dout0_31) AT=310.025n

.meas tran vdout1_0ck610 FIND v(dout1_0) AT=310.025n

.meas tran vdout1_1ck610 FIND v(dout1_1) AT=310.025n

.meas tran vdout1_2ck610 FIND v(dout1_2) AT=310.025n

.meas tran vdout1_3ck610 FIND v(dout1_3) AT=310.025n

.meas tran vdout1_4ck610 FIND v(dout1_4) AT=310.025n

.meas tran vdout1_5ck610 FIND v(dout1_5) AT=310.025n

.meas tran vdout1_6ck610 FIND v(dout1_6) AT=310.025n

.meas tran vdout1_7ck610 FIND v(dout1_7) AT=310.025n

.meas tran vdout1_8ck610 FIND v(dout1_8) AT=310.025n

.meas tran vdout1_9ck610 FIND v(dout1_9) AT=310.025n

.meas tran vdout1_10ck610 FIND v(dout1_10) AT=310.025n

.meas tran vdout1_11ck610 FIND v(dout1_11) AT=310.025n

.meas tran vdout1_12ck610 FIND v(dout1_12) AT=310.025n

.meas tran vdout1_13ck610 FIND v(dout1_13) AT=310.025n

.meas tran vdout1_14ck610 FIND v(dout1_14) AT=310.025n

.meas tran vdout1_15ck610 FIND v(dout1_15) AT=310.025n

.meas tran vdout1_16ck610 FIND v(dout1_16) AT=310.025n

.meas tran vdout1_17ck610 FIND v(dout1_17) AT=310.025n

.meas tran vdout1_18ck610 FIND v(dout1_18) AT=310.025n

.meas tran vdout1_19ck610 FIND v(dout1_19) AT=310.025n

.meas tran vdout1_20ck610 FIND v(dout1_20) AT=310.025n

.meas tran vdout1_21ck610 FIND v(dout1_21) AT=310.025n

.meas tran vdout1_22ck610 FIND v(dout1_22) AT=310.025n

.meas tran vdout1_23ck610 FIND v(dout1_23) AT=310.025n

.meas tran vdout1_24ck610 FIND v(dout1_24) AT=310.025n

.meas tran vdout1_25ck610 FIND v(dout1_25) AT=310.025n

.meas tran vdout1_26ck610 FIND v(dout1_26) AT=310.025n

.meas tran vdout1_27ck610 FIND v(dout1_27) AT=310.025n

.meas tran vdout1_28ck610 FIND v(dout1_28) AT=310.025n

.meas tran vdout1_29ck610 FIND v(dout1_29) AT=310.025n

.meas tran vdout1_30ck610 FIND v(dout1_30) AT=310.025n

.meas tran vdout1_31ck610 FIND v(dout1_31) AT=310.025n

.meas tran vdout0_0ck630 FIND v(dout0_0) AT=320.025n

.meas tran vdout0_1ck630 FIND v(dout0_1) AT=320.025n

.meas tran vdout0_2ck630 FIND v(dout0_2) AT=320.025n

.meas tran vdout0_3ck630 FIND v(dout0_3) AT=320.025n

.meas tran vdout0_4ck630 FIND v(dout0_4) AT=320.025n

.meas tran vdout0_5ck630 FIND v(dout0_5) AT=320.025n

.meas tran vdout0_6ck630 FIND v(dout0_6) AT=320.025n

.meas tran vdout0_7ck630 FIND v(dout0_7) AT=320.025n

.meas tran vdout0_8ck630 FIND v(dout0_8) AT=320.025n

.meas tran vdout0_9ck630 FIND v(dout0_9) AT=320.025n

.meas tran vdout0_10ck630 FIND v(dout0_10) AT=320.025n

.meas tran vdout0_11ck630 FIND v(dout0_11) AT=320.025n

.meas tran vdout0_12ck630 FIND v(dout0_12) AT=320.025n

.meas tran vdout0_13ck630 FIND v(dout0_13) AT=320.025n

.meas tran vdout0_14ck630 FIND v(dout0_14) AT=320.025n

.meas tran vdout0_15ck630 FIND v(dout0_15) AT=320.025n

.meas tran vdout0_16ck630 FIND v(dout0_16) AT=320.025n

.meas tran vdout0_17ck630 FIND v(dout0_17) AT=320.025n

.meas tran vdout0_18ck630 FIND v(dout0_18) AT=320.025n

.meas tran vdout0_19ck630 FIND v(dout0_19) AT=320.025n

.meas tran vdout0_20ck630 FIND v(dout0_20) AT=320.025n

.meas tran vdout0_21ck630 FIND v(dout0_21) AT=320.025n

.meas tran vdout0_22ck630 FIND v(dout0_22) AT=320.025n

.meas tran vdout0_23ck630 FIND v(dout0_23) AT=320.025n

.meas tran vdout0_24ck630 FIND v(dout0_24) AT=320.025n

.meas tran vdout0_25ck630 FIND v(dout0_25) AT=320.025n

.meas tran vdout0_26ck630 FIND v(dout0_26) AT=320.025n

.meas tran vdout0_27ck630 FIND v(dout0_27) AT=320.025n

.meas tran vdout0_28ck630 FIND v(dout0_28) AT=320.025n

.meas tran vdout0_29ck630 FIND v(dout0_29) AT=320.025n

.meas tran vdout0_30ck630 FIND v(dout0_30) AT=320.025n

.meas tran vdout0_31ck630 FIND v(dout0_31) AT=320.025n

.meas tran vdout1_0ck630 FIND v(dout1_0) AT=320.025n

.meas tran vdout1_1ck630 FIND v(dout1_1) AT=320.025n

.meas tran vdout1_2ck630 FIND v(dout1_2) AT=320.025n

.meas tran vdout1_3ck630 FIND v(dout1_3) AT=320.025n

.meas tran vdout1_4ck630 FIND v(dout1_4) AT=320.025n

.meas tran vdout1_5ck630 FIND v(dout1_5) AT=320.025n

.meas tran vdout1_6ck630 FIND v(dout1_6) AT=320.025n

.meas tran vdout1_7ck630 FIND v(dout1_7) AT=320.025n

.meas tran vdout1_8ck630 FIND v(dout1_8) AT=320.025n

.meas tran vdout1_9ck630 FIND v(dout1_9) AT=320.025n

.meas tran vdout1_10ck630 FIND v(dout1_10) AT=320.025n

.meas tran vdout1_11ck630 FIND v(dout1_11) AT=320.025n

.meas tran vdout1_12ck630 FIND v(dout1_12) AT=320.025n

.meas tran vdout1_13ck630 FIND v(dout1_13) AT=320.025n

.meas tran vdout1_14ck630 FIND v(dout1_14) AT=320.025n

.meas tran vdout1_15ck630 FIND v(dout1_15) AT=320.025n

.meas tran vdout1_16ck630 FIND v(dout1_16) AT=320.025n

.meas tran vdout1_17ck630 FIND v(dout1_17) AT=320.025n

.meas tran vdout1_18ck630 FIND v(dout1_18) AT=320.025n

.meas tran vdout1_19ck630 FIND v(dout1_19) AT=320.025n

.meas tran vdout1_20ck630 FIND v(dout1_20) AT=320.025n

.meas tran vdout1_21ck630 FIND v(dout1_21) AT=320.025n

.meas tran vdout1_22ck630 FIND v(dout1_22) AT=320.025n

.meas tran vdout1_23ck630 FIND v(dout1_23) AT=320.025n

.meas tran vdout1_24ck630 FIND v(dout1_24) AT=320.025n

.meas tran vdout1_25ck630 FIND v(dout1_25) AT=320.025n

.meas tran vdout1_26ck630 FIND v(dout1_26) AT=320.025n

.meas tran vdout1_27ck630 FIND v(dout1_27) AT=320.025n

.meas tran vdout1_28ck630 FIND v(dout1_28) AT=320.025n

.meas tran vdout1_29ck630 FIND v(dout1_29) AT=320.025n

.meas tran vdout1_30ck630 FIND v(dout1_30) AT=320.025n

.meas tran vdout1_31ck630 FIND v(dout1_31) AT=320.025n

.meas tran vdout0_0ck640 FIND v(dout0_0) AT=325.025n

.meas tran vdout0_1ck640 FIND v(dout0_1) AT=325.025n

.meas tran vdout0_2ck640 FIND v(dout0_2) AT=325.025n

.meas tran vdout0_3ck640 FIND v(dout0_3) AT=325.025n

.meas tran vdout0_4ck640 FIND v(dout0_4) AT=325.025n

.meas tran vdout0_5ck640 FIND v(dout0_5) AT=325.025n

.meas tran vdout0_6ck640 FIND v(dout0_6) AT=325.025n

.meas tran vdout0_7ck640 FIND v(dout0_7) AT=325.025n

.meas tran vdout0_8ck640 FIND v(dout0_8) AT=325.025n

.meas tran vdout0_9ck640 FIND v(dout0_9) AT=325.025n

.meas tran vdout0_10ck640 FIND v(dout0_10) AT=325.025n

.meas tran vdout0_11ck640 FIND v(dout0_11) AT=325.025n

.meas tran vdout0_12ck640 FIND v(dout0_12) AT=325.025n

.meas tran vdout0_13ck640 FIND v(dout0_13) AT=325.025n

.meas tran vdout0_14ck640 FIND v(dout0_14) AT=325.025n

.meas tran vdout0_15ck640 FIND v(dout0_15) AT=325.025n

.meas tran vdout0_16ck640 FIND v(dout0_16) AT=325.025n

.meas tran vdout0_17ck640 FIND v(dout0_17) AT=325.025n

.meas tran vdout0_18ck640 FIND v(dout0_18) AT=325.025n

.meas tran vdout0_19ck640 FIND v(dout0_19) AT=325.025n

.meas tran vdout0_20ck640 FIND v(dout0_20) AT=325.025n

.meas tran vdout0_21ck640 FIND v(dout0_21) AT=325.025n

.meas tran vdout0_22ck640 FIND v(dout0_22) AT=325.025n

.meas tran vdout0_23ck640 FIND v(dout0_23) AT=325.025n

.meas tran vdout0_24ck640 FIND v(dout0_24) AT=325.025n

.meas tran vdout0_25ck640 FIND v(dout0_25) AT=325.025n

.meas tran vdout0_26ck640 FIND v(dout0_26) AT=325.025n

.meas tran vdout0_27ck640 FIND v(dout0_27) AT=325.025n

.meas tran vdout0_28ck640 FIND v(dout0_28) AT=325.025n

.meas tran vdout0_29ck640 FIND v(dout0_29) AT=325.025n

.meas tran vdout0_30ck640 FIND v(dout0_30) AT=325.025n

.meas tran vdout0_31ck640 FIND v(dout0_31) AT=325.025n

.meas tran vdout1_0ck640 FIND v(dout1_0) AT=325.025n

.meas tran vdout1_1ck640 FIND v(dout1_1) AT=325.025n

.meas tran vdout1_2ck640 FIND v(dout1_2) AT=325.025n

.meas tran vdout1_3ck640 FIND v(dout1_3) AT=325.025n

.meas tran vdout1_4ck640 FIND v(dout1_4) AT=325.025n

.meas tran vdout1_5ck640 FIND v(dout1_5) AT=325.025n

.meas tran vdout1_6ck640 FIND v(dout1_6) AT=325.025n

.meas tran vdout1_7ck640 FIND v(dout1_7) AT=325.025n

.meas tran vdout1_8ck640 FIND v(dout1_8) AT=325.025n

.meas tran vdout1_9ck640 FIND v(dout1_9) AT=325.025n

.meas tran vdout1_10ck640 FIND v(dout1_10) AT=325.025n

.meas tran vdout1_11ck640 FIND v(dout1_11) AT=325.025n

.meas tran vdout1_12ck640 FIND v(dout1_12) AT=325.025n

.meas tran vdout1_13ck640 FIND v(dout1_13) AT=325.025n

.meas tran vdout1_14ck640 FIND v(dout1_14) AT=325.025n

.meas tran vdout1_15ck640 FIND v(dout1_15) AT=325.025n

.meas tran vdout1_16ck640 FIND v(dout1_16) AT=325.025n

.meas tran vdout1_17ck640 FIND v(dout1_17) AT=325.025n

.meas tran vdout1_18ck640 FIND v(dout1_18) AT=325.025n

.meas tran vdout1_19ck640 FIND v(dout1_19) AT=325.025n

.meas tran vdout1_20ck640 FIND v(dout1_20) AT=325.025n

.meas tran vdout1_21ck640 FIND v(dout1_21) AT=325.025n

.meas tran vdout1_22ck640 FIND v(dout1_22) AT=325.025n

.meas tran vdout1_23ck640 FIND v(dout1_23) AT=325.025n

.meas tran vdout1_24ck640 FIND v(dout1_24) AT=325.025n

.meas tran vdout1_25ck640 FIND v(dout1_25) AT=325.025n

.meas tran vdout1_26ck640 FIND v(dout1_26) AT=325.025n

.meas tran vdout1_27ck640 FIND v(dout1_27) AT=325.025n

.meas tran vdout1_28ck640 FIND v(dout1_28) AT=325.025n

.meas tran vdout1_29ck640 FIND v(dout1_29) AT=325.025n

.meas tran vdout1_30ck640 FIND v(dout1_30) AT=325.025n

.meas tran vdout1_31ck640 FIND v(dout1_31) AT=325.025n

.meas tran vdout1_0ck660 FIND v(dout1_0) AT=335.025n

.meas tran vdout1_1ck660 FIND v(dout1_1) AT=335.025n

.meas tran vdout1_2ck660 FIND v(dout1_2) AT=335.025n

.meas tran vdout1_3ck660 FIND v(dout1_3) AT=335.025n

.meas tran vdout1_4ck660 FIND v(dout1_4) AT=335.025n

.meas tran vdout1_5ck660 FIND v(dout1_5) AT=335.025n

.meas tran vdout1_6ck660 FIND v(dout1_6) AT=335.025n

.meas tran vdout1_7ck660 FIND v(dout1_7) AT=335.025n

.meas tran vdout1_8ck660 FIND v(dout1_8) AT=335.025n

.meas tran vdout1_9ck660 FIND v(dout1_9) AT=335.025n

.meas tran vdout1_10ck660 FIND v(dout1_10) AT=335.025n

.meas tran vdout1_11ck660 FIND v(dout1_11) AT=335.025n

.meas tran vdout1_12ck660 FIND v(dout1_12) AT=335.025n

.meas tran vdout1_13ck660 FIND v(dout1_13) AT=335.025n

.meas tran vdout1_14ck660 FIND v(dout1_14) AT=335.025n

.meas tran vdout1_15ck660 FIND v(dout1_15) AT=335.025n

.meas tran vdout1_16ck660 FIND v(dout1_16) AT=335.025n

.meas tran vdout1_17ck660 FIND v(dout1_17) AT=335.025n

.meas tran vdout1_18ck660 FIND v(dout1_18) AT=335.025n

.meas tran vdout1_19ck660 FIND v(dout1_19) AT=335.025n

.meas tran vdout1_20ck660 FIND v(dout1_20) AT=335.025n

.meas tran vdout1_21ck660 FIND v(dout1_21) AT=335.025n

.meas tran vdout1_22ck660 FIND v(dout1_22) AT=335.025n

.meas tran vdout1_23ck660 FIND v(dout1_23) AT=335.025n

.meas tran vdout1_24ck660 FIND v(dout1_24) AT=335.025n

.meas tran vdout1_25ck660 FIND v(dout1_25) AT=335.025n

.meas tran vdout1_26ck660 FIND v(dout1_26) AT=335.025n

.meas tran vdout1_27ck660 FIND v(dout1_27) AT=335.025n

.meas tran vdout1_28ck660 FIND v(dout1_28) AT=335.025n

.meas tran vdout1_29ck660 FIND v(dout1_29) AT=335.025n

.meas tran vdout1_30ck660 FIND v(dout1_30) AT=335.025n

.meas tran vdout1_31ck660 FIND v(dout1_31) AT=335.025n

.meas tran vdout0_0ck670 FIND v(dout0_0) AT=340.025n

.meas tran vdout0_1ck670 FIND v(dout0_1) AT=340.025n

.meas tran vdout0_2ck670 FIND v(dout0_2) AT=340.025n

.meas tran vdout0_3ck670 FIND v(dout0_3) AT=340.025n

.meas tran vdout0_4ck670 FIND v(dout0_4) AT=340.025n

.meas tran vdout0_5ck670 FIND v(dout0_5) AT=340.025n

.meas tran vdout0_6ck670 FIND v(dout0_6) AT=340.025n

.meas tran vdout0_7ck670 FIND v(dout0_7) AT=340.025n

.meas tran vdout0_8ck670 FIND v(dout0_8) AT=340.025n

.meas tran vdout0_9ck670 FIND v(dout0_9) AT=340.025n

.meas tran vdout0_10ck670 FIND v(dout0_10) AT=340.025n

.meas tran vdout0_11ck670 FIND v(dout0_11) AT=340.025n

.meas tran vdout0_12ck670 FIND v(dout0_12) AT=340.025n

.meas tran vdout0_13ck670 FIND v(dout0_13) AT=340.025n

.meas tran vdout0_14ck670 FIND v(dout0_14) AT=340.025n

.meas tran vdout0_15ck670 FIND v(dout0_15) AT=340.025n

.meas tran vdout0_16ck670 FIND v(dout0_16) AT=340.025n

.meas tran vdout0_17ck670 FIND v(dout0_17) AT=340.025n

.meas tran vdout0_18ck670 FIND v(dout0_18) AT=340.025n

.meas tran vdout0_19ck670 FIND v(dout0_19) AT=340.025n

.meas tran vdout0_20ck670 FIND v(dout0_20) AT=340.025n

.meas tran vdout0_21ck670 FIND v(dout0_21) AT=340.025n

.meas tran vdout0_22ck670 FIND v(dout0_22) AT=340.025n

.meas tran vdout0_23ck670 FIND v(dout0_23) AT=340.025n

.meas tran vdout0_24ck670 FIND v(dout0_24) AT=340.025n

.meas tran vdout0_25ck670 FIND v(dout0_25) AT=340.025n

.meas tran vdout0_26ck670 FIND v(dout0_26) AT=340.025n

.meas tran vdout0_27ck670 FIND v(dout0_27) AT=340.025n

.meas tran vdout0_28ck670 FIND v(dout0_28) AT=340.025n

.meas tran vdout0_29ck670 FIND v(dout0_29) AT=340.025n

.meas tran vdout0_30ck670 FIND v(dout0_30) AT=340.025n

.meas tran vdout0_31ck670 FIND v(dout0_31) AT=340.025n

.meas tran vdout1_0ck670 FIND v(dout1_0) AT=340.025n

.meas tran vdout1_1ck670 FIND v(dout1_1) AT=340.025n

.meas tran vdout1_2ck670 FIND v(dout1_2) AT=340.025n

.meas tran vdout1_3ck670 FIND v(dout1_3) AT=340.025n

.meas tran vdout1_4ck670 FIND v(dout1_4) AT=340.025n

.meas tran vdout1_5ck670 FIND v(dout1_5) AT=340.025n

.meas tran vdout1_6ck670 FIND v(dout1_6) AT=340.025n

.meas tran vdout1_7ck670 FIND v(dout1_7) AT=340.025n

.meas tran vdout1_8ck670 FIND v(dout1_8) AT=340.025n

.meas tran vdout1_9ck670 FIND v(dout1_9) AT=340.025n

.meas tran vdout1_10ck670 FIND v(dout1_10) AT=340.025n

.meas tran vdout1_11ck670 FIND v(dout1_11) AT=340.025n

.meas tran vdout1_12ck670 FIND v(dout1_12) AT=340.025n

.meas tran vdout1_13ck670 FIND v(dout1_13) AT=340.025n

.meas tran vdout1_14ck670 FIND v(dout1_14) AT=340.025n

.meas tran vdout1_15ck670 FIND v(dout1_15) AT=340.025n

.meas tran vdout1_16ck670 FIND v(dout1_16) AT=340.025n

.meas tran vdout1_17ck670 FIND v(dout1_17) AT=340.025n

.meas tran vdout1_18ck670 FIND v(dout1_18) AT=340.025n

.meas tran vdout1_19ck670 FIND v(dout1_19) AT=340.025n

.meas tran vdout1_20ck670 FIND v(dout1_20) AT=340.025n

.meas tran vdout1_21ck670 FIND v(dout1_21) AT=340.025n

.meas tran vdout1_22ck670 FIND v(dout1_22) AT=340.025n

.meas tran vdout1_23ck670 FIND v(dout1_23) AT=340.025n

.meas tran vdout1_24ck670 FIND v(dout1_24) AT=340.025n

.meas tran vdout1_25ck670 FIND v(dout1_25) AT=340.025n

.meas tran vdout1_26ck670 FIND v(dout1_26) AT=340.025n

.meas tran vdout1_27ck670 FIND v(dout1_27) AT=340.025n

.meas tran vdout1_28ck670 FIND v(dout1_28) AT=340.025n

.meas tran vdout1_29ck670 FIND v(dout1_29) AT=340.025n

.meas tran vdout1_30ck670 FIND v(dout1_30) AT=340.025n

.meas tran vdout1_31ck670 FIND v(dout1_31) AT=340.025n

.meas tran vdout1_0ck710 FIND v(dout1_0) AT=360.025n

.meas tran vdout1_1ck710 FIND v(dout1_1) AT=360.025n

.meas tran vdout1_2ck710 FIND v(dout1_2) AT=360.025n

.meas tran vdout1_3ck710 FIND v(dout1_3) AT=360.025n

.meas tran vdout1_4ck710 FIND v(dout1_4) AT=360.025n

.meas tran vdout1_5ck710 FIND v(dout1_5) AT=360.025n

.meas tran vdout1_6ck710 FIND v(dout1_6) AT=360.025n

.meas tran vdout1_7ck710 FIND v(dout1_7) AT=360.025n

.meas tran vdout1_8ck710 FIND v(dout1_8) AT=360.025n

.meas tran vdout1_9ck710 FIND v(dout1_9) AT=360.025n

.meas tran vdout1_10ck710 FIND v(dout1_10) AT=360.025n

.meas tran vdout1_11ck710 FIND v(dout1_11) AT=360.025n

.meas tran vdout1_12ck710 FIND v(dout1_12) AT=360.025n

.meas tran vdout1_13ck710 FIND v(dout1_13) AT=360.025n

.meas tran vdout1_14ck710 FIND v(dout1_14) AT=360.025n

.meas tran vdout1_15ck710 FIND v(dout1_15) AT=360.025n

.meas tran vdout1_16ck710 FIND v(dout1_16) AT=360.025n

.meas tran vdout1_17ck710 FIND v(dout1_17) AT=360.025n

.meas tran vdout1_18ck710 FIND v(dout1_18) AT=360.025n

.meas tran vdout1_19ck710 FIND v(dout1_19) AT=360.025n

.meas tran vdout1_20ck710 FIND v(dout1_20) AT=360.025n

.meas tran vdout1_21ck710 FIND v(dout1_21) AT=360.025n

.meas tran vdout1_22ck710 FIND v(dout1_22) AT=360.025n

.meas tran vdout1_23ck710 FIND v(dout1_23) AT=360.025n

.meas tran vdout1_24ck710 FIND v(dout1_24) AT=360.025n

.meas tran vdout1_25ck710 FIND v(dout1_25) AT=360.025n

.meas tran vdout1_26ck710 FIND v(dout1_26) AT=360.025n

.meas tran vdout1_27ck710 FIND v(dout1_27) AT=360.025n

.meas tran vdout1_28ck710 FIND v(dout1_28) AT=360.025n

.meas tran vdout1_29ck710 FIND v(dout1_29) AT=360.025n

.meas tran vdout1_30ck710 FIND v(dout1_30) AT=360.025n

.meas tran vdout1_31ck710 FIND v(dout1_31) AT=360.025n

.meas tran vdout0_0ck720 FIND v(dout0_0) AT=365.025n

.meas tran vdout0_1ck720 FIND v(dout0_1) AT=365.025n

.meas tran vdout0_2ck720 FIND v(dout0_2) AT=365.025n

.meas tran vdout0_3ck720 FIND v(dout0_3) AT=365.025n

.meas tran vdout0_4ck720 FIND v(dout0_4) AT=365.025n

.meas tran vdout0_5ck720 FIND v(dout0_5) AT=365.025n

.meas tran vdout0_6ck720 FIND v(dout0_6) AT=365.025n

.meas tran vdout0_7ck720 FIND v(dout0_7) AT=365.025n

.meas tran vdout0_8ck720 FIND v(dout0_8) AT=365.025n

.meas tran vdout0_9ck720 FIND v(dout0_9) AT=365.025n

.meas tran vdout0_10ck720 FIND v(dout0_10) AT=365.025n

.meas tran vdout0_11ck720 FIND v(dout0_11) AT=365.025n

.meas tran vdout0_12ck720 FIND v(dout0_12) AT=365.025n

.meas tran vdout0_13ck720 FIND v(dout0_13) AT=365.025n

.meas tran vdout0_14ck720 FIND v(dout0_14) AT=365.025n

.meas tran vdout0_15ck720 FIND v(dout0_15) AT=365.025n

.meas tran vdout0_16ck720 FIND v(dout0_16) AT=365.025n

.meas tran vdout0_17ck720 FIND v(dout0_17) AT=365.025n

.meas tran vdout0_18ck720 FIND v(dout0_18) AT=365.025n

.meas tran vdout0_19ck720 FIND v(dout0_19) AT=365.025n

.meas tran vdout0_20ck720 FIND v(dout0_20) AT=365.025n

.meas tran vdout0_21ck720 FIND v(dout0_21) AT=365.025n

.meas tran vdout0_22ck720 FIND v(dout0_22) AT=365.025n

.meas tran vdout0_23ck720 FIND v(dout0_23) AT=365.025n

.meas tran vdout0_24ck720 FIND v(dout0_24) AT=365.025n

.meas tran vdout0_25ck720 FIND v(dout0_25) AT=365.025n

.meas tran vdout0_26ck720 FIND v(dout0_26) AT=365.025n

.meas tran vdout0_27ck720 FIND v(dout0_27) AT=365.025n

.meas tran vdout0_28ck720 FIND v(dout0_28) AT=365.025n

.meas tran vdout0_29ck720 FIND v(dout0_29) AT=365.025n

.meas tran vdout0_30ck720 FIND v(dout0_30) AT=365.025n

.meas tran vdout0_31ck720 FIND v(dout0_31) AT=365.025n

.meas tran vdout0_0ck730 FIND v(dout0_0) AT=370.025n

.meas tran vdout0_1ck730 FIND v(dout0_1) AT=370.025n

.meas tran vdout0_2ck730 FIND v(dout0_2) AT=370.025n

.meas tran vdout0_3ck730 FIND v(dout0_3) AT=370.025n

.meas tran vdout0_4ck730 FIND v(dout0_4) AT=370.025n

.meas tran vdout0_5ck730 FIND v(dout0_5) AT=370.025n

.meas tran vdout0_6ck730 FIND v(dout0_6) AT=370.025n

.meas tran vdout0_7ck730 FIND v(dout0_7) AT=370.025n

.meas tran vdout0_8ck730 FIND v(dout0_8) AT=370.025n

.meas tran vdout0_9ck730 FIND v(dout0_9) AT=370.025n

.meas tran vdout0_10ck730 FIND v(dout0_10) AT=370.025n

.meas tran vdout0_11ck730 FIND v(dout0_11) AT=370.025n

.meas tran vdout0_12ck730 FIND v(dout0_12) AT=370.025n

.meas tran vdout0_13ck730 FIND v(dout0_13) AT=370.025n

.meas tran vdout0_14ck730 FIND v(dout0_14) AT=370.025n

.meas tran vdout0_15ck730 FIND v(dout0_15) AT=370.025n

.meas tran vdout0_16ck730 FIND v(dout0_16) AT=370.025n

.meas tran vdout0_17ck730 FIND v(dout0_17) AT=370.025n

.meas tran vdout0_18ck730 FIND v(dout0_18) AT=370.025n

.meas tran vdout0_19ck730 FIND v(dout0_19) AT=370.025n

.meas tran vdout0_20ck730 FIND v(dout0_20) AT=370.025n

.meas tran vdout0_21ck730 FIND v(dout0_21) AT=370.025n

.meas tran vdout0_22ck730 FIND v(dout0_22) AT=370.025n

.meas tran vdout0_23ck730 FIND v(dout0_23) AT=370.025n

.meas tran vdout0_24ck730 FIND v(dout0_24) AT=370.025n

.meas tran vdout0_25ck730 FIND v(dout0_25) AT=370.025n

.meas tran vdout0_26ck730 FIND v(dout0_26) AT=370.025n

.meas tran vdout0_27ck730 FIND v(dout0_27) AT=370.025n

.meas tran vdout0_28ck730 FIND v(dout0_28) AT=370.025n

.meas tran vdout0_29ck730 FIND v(dout0_29) AT=370.025n

.meas tran vdout0_30ck730 FIND v(dout0_30) AT=370.025n

.meas tran vdout0_31ck730 FIND v(dout0_31) AT=370.025n

.meas tran vdout1_0ck730 FIND v(dout1_0) AT=370.025n

.meas tran vdout1_1ck730 FIND v(dout1_1) AT=370.025n

.meas tran vdout1_2ck730 FIND v(dout1_2) AT=370.025n

.meas tran vdout1_3ck730 FIND v(dout1_3) AT=370.025n

.meas tran vdout1_4ck730 FIND v(dout1_4) AT=370.025n

.meas tran vdout1_5ck730 FIND v(dout1_5) AT=370.025n

.meas tran vdout1_6ck730 FIND v(dout1_6) AT=370.025n

.meas tran vdout1_7ck730 FIND v(dout1_7) AT=370.025n

.meas tran vdout1_8ck730 FIND v(dout1_8) AT=370.025n

.meas tran vdout1_9ck730 FIND v(dout1_9) AT=370.025n

.meas tran vdout1_10ck730 FIND v(dout1_10) AT=370.025n

.meas tran vdout1_11ck730 FIND v(dout1_11) AT=370.025n

.meas tran vdout1_12ck730 FIND v(dout1_12) AT=370.025n

.meas tran vdout1_13ck730 FIND v(dout1_13) AT=370.025n

.meas tran vdout1_14ck730 FIND v(dout1_14) AT=370.025n

.meas tran vdout1_15ck730 FIND v(dout1_15) AT=370.025n

.meas tran vdout1_16ck730 FIND v(dout1_16) AT=370.025n

.meas tran vdout1_17ck730 FIND v(dout1_17) AT=370.025n

.meas tran vdout1_18ck730 FIND v(dout1_18) AT=370.025n

.meas tran vdout1_19ck730 FIND v(dout1_19) AT=370.025n

.meas tran vdout1_20ck730 FIND v(dout1_20) AT=370.025n

.meas tran vdout1_21ck730 FIND v(dout1_21) AT=370.025n

.meas tran vdout1_22ck730 FIND v(dout1_22) AT=370.025n

.meas tran vdout1_23ck730 FIND v(dout1_23) AT=370.025n

.meas tran vdout1_24ck730 FIND v(dout1_24) AT=370.025n

.meas tran vdout1_25ck730 FIND v(dout1_25) AT=370.025n

.meas tran vdout1_26ck730 FIND v(dout1_26) AT=370.025n

.meas tran vdout1_27ck730 FIND v(dout1_27) AT=370.025n

.meas tran vdout1_28ck730 FIND v(dout1_28) AT=370.025n

.meas tran vdout1_29ck730 FIND v(dout1_29) AT=370.025n

.meas tran vdout1_30ck730 FIND v(dout1_30) AT=370.025n

.meas tran vdout1_31ck730 FIND v(dout1_31) AT=370.025n

.meas tran vdout1_0ck740 FIND v(dout1_0) AT=375.025n

.meas tran vdout1_1ck740 FIND v(dout1_1) AT=375.025n

.meas tran vdout1_2ck740 FIND v(dout1_2) AT=375.025n

.meas tran vdout1_3ck740 FIND v(dout1_3) AT=375.025n

.meas tran vdout1_4ck740 FIND v(dout1_4) AT=375.025n

.meas tran vdout1_5ck740 FIND v(dout1_5) AT=375.025n

.meas tran vdout1_6ck740 FIND v(dout1_6) AT=375.025n

.meas tran vdout1_7ck740 FIND v(dout1_7) AT=375.025n

.meas tran vdout1_8ck740 FIND v(dout1_8) AT=375.025n

.meas tran vdout1_9ck740 FIND v(dout1_9) AT=375.025n

.meas tran vdout1_10ck740 FIND v(dout1_10) AT=375.025n

.meas tran vdout1_11ck740 FIND v(dout1_11) AT=375.025n

.meas tran vdout1_12ck740 FIND v(dout1_12) AT=375.025n

.meas tran vdout1_13ck740 FIND v(dout1_13) AT=375.025n

.meas tran vdout1_14ck740 FIND v(dout1_14) AT=375.025n

.meas tran vdout1_15ck740 FIND v(dout1_15) AT=375.025n

.meas tran vdout1_16ck740 FIND v(dout1_16) AT=375.025n

.meas tran vdout1_17ck740 FIND v(dout1_17) AT=375.025n

.meas tran vdout1_18ck740 FIND v(dout1_18) AT=375.025n

.meas tran vdout1_19ck740 FIND v(dout1_19) AT=375.025n

.meas tran vdout1_20ck740 FIND v(dout1_20) AT=375.025n

.meas tran vdout1_21ck740 FIND v(dout1_21) AT=375.025n

.meas tran vdout1_22ck740 FIND v(dout1_22) AT=375.025n

.meas tran vdout1_23ck740 FIND v(dout1_23) AT=375.025n

.meas tran vdout1_24ck740 FIND v(dout1_24) AT=375.025n

.meas tran vdout1_25ck740 FIND v(dout1_25) AT=375.025n

.meas tran vdout1_26ck740 FIND v(dout1_26) AT=375.025n

.meas tran vdout1_27ck740 FIND v(dout1_27) AT=375.025n

.meas tran vdout1_28ck740 FIND v(dout1_28) AT=375.025n

.meas tran vdout1_29ck740 FIND v(dout1_29) AT=375.025n

.meas tran vdout1_30ck740 FIND v(dout1_30) AT=375.025n

.meas tran vdout1_31ck740 FIND v(dout1_31) AT=375.025n

.meas tran vdout0_0ck750 FIND v(dout0_0) AT=380.025n

.meas tran vdout0_1ck750 FIND v(dout0_1) AT=380.025n

.meas tran vdout0_2ck750 FIND v(dout0_2) AT=380.025n

.meas tran vdout0_3ck750 FIND v(dout0_3) AT=380.025n

.meas tran vdout0_4ck750 FIND v(dout0_4) AT=380.025n

.meas tran vdout0_5ck750 FIND v(dout0_5) AT=380.025n

.meas tran vdout0_6ck750 FIND v(dout0_6) AT=380.025n

.meas tran vdout0_7ck750 FIND v(dout0_7) AT=380.025n

.meas tran vdout0_8ck750 FIND v(dout0_8) AT=380.025n

.meas tran vdout0_9ck750 FIND v(dout0_9) AT=380.025n

.meas tran vdout0_10ck750 FIND v(dout0_10) AT=380.025n

.meas tran vdout0_11ck750 FIND v(dout0_11) AT=380.025n

.meas tran vdout0_12ck750 FIND v(dout0_12) AT=380.025n

.meas tran vdout0_13ck750 FIND v(dout0_13) AT=380.025n

.meas tran vdout0_14ck750 FIND v(dout0_14) AT=380.025n

.meas tran vdout0_15ck750 FIND v(dout0_15) AT=380.025n

.meas tran vdout0_16ck750 FIND v(dout0_16) AT=380.025n

.meas tran vdout0_17ck750 FIND v(dout0_17) AT=380.025n

.meas tran vdout0_18ck750 FIND v(dout0_18) AT=380.025n

.meas tran vdout0_19ck750 FIND v(dout0_19) AT=380.025n

.meas tran vdout0_20ck750 FIND v(dout0_20) AT=380.025n

.meas tran vdout0_21ck750 FIND v(dout0_21) AT=380.025n

.meas tran vdout0_22ck750 FIND v(dout0_22) AT=380.025n

.meas tran vdout0_23ck750 FIND v(dout0_23) AT=380.025n

.meas tran vdout0_24ck750 FIND v(dout0_24) AT=380.025n

.meas tran vdout0_25ck750 FIND v(dout0_25) AT=380.025n

.meas tran vdout0_26ck750 FIND v(dout0_26) AT=380.025n

.meas tran vdout0_27ck750 FIND v(dout0_27) AT=380.025n

.meas tran vdout0_28ck750 FIND v(dout0_28) AT=380.025n

.meas tran vdout0_29ck750 FIND v(dout0_29) AT=380.025n

.meas tran vdout0_30ck750 FIND v(dout0_30) AT=380.025n

.meas tran vdout0_31ck750 FIND v(dout0_31) AT=380.025n

.meas tran vdout1_0ck750 FIND v(dout1_0) AT=380.025n

.meas tran vdout1_1ck750 FIND v(dout1_1) AT=380.025n

.meas tran vdout1_2ck750 FIND v(dout1_2) AT=380.025n

.meas tran vdout1_3ck750 FIND v(dout1_3) AT=380.025n

.meas tran vdout1_4ck750 FIND v(dout1_4) AT=380.025n

.meas tran vdout1_5ck750 FIND v(dout1_5) AT=380.025n

.meas tran vdout1_6ck750 FIND v(dout1_6) AT=380.025n

.meas tran vdout1_7ck750 FIND v(dout1_7) AT=380.025n

.meas tran vdout1_8ck750 FIND v(dout1_8) AT=380.025n

.meas tran vdout1_9ck750 FIND v(dout1_9) AT=380.025n

.meas tran vdout1_10ck750 FIND v(dout1_10) AT=380.025n

.meas tran vdout1_11ck750 FIND v(dout1_11) AT=380.025n

.meas tran vdout1_12ck750 FIND v(dout1_12) AT=380.025n

.meas tran vdout1_13ck750 FIND v(dout1_13) AT=380.025n

.meas tran vdout1_14ck750 FIND v(dout1_14) AT=380.025n

.meas tran vdout1_15ck750 FIND v(dout1_15) AT=380.025n

.meas tran vdout1_16ck750 FIND v(dout1_16) AT=380.025n

.meas tran vdout1_17ck750 FIND v(dout1_17) AT=380.025n

.meas tran vdout1_18ck750 FIND v(dout1_18) AT=380.025n

.meas tran vdout1_19ck750 FIND v(dout1_19) AT=380.025n

.meas tran vdout1_20ck750 FIND v(dout1_20) AT=380.025n

.meas tran vdout1_21ck750 FIND v(dout1_21) AT=380.025n

.meas tran vdout1_22ck750 FIND v(dout1_22) AT=380.025n

.meas tran vdout1_23ck750 FIND v(dout1_23) AT=380.025n

.meas tran vdout1_24ck750 FIND v(dout1_24) AT=380.025n

.meas tran vdout1_25ck750 FIND v(dout1_25) AT=380.025n

.meas tran vdout1_26ck750 FIND v(dout1_26) AT=380.025n

.meas tran vdout1_27ck750 FIND v(dout1_27) AT=380.025n

.meas tran vdout1_28ck750 FIND v(dout1_28) AT=380.025n

.meas tran vdout1_29ck750 FIND v(dout1_29) AT=380.025n

.meas tran vdout1_30ck750 FIND v(dout1_30) AT=380.025n

.meas tran vdout1_31ck750 FIND v(dout1_31) AT=380.025n

.meas tran vdout0_0ck760 FIND v(dout0_0) AT=385.025n

.meas tran vdout0_1ck760 FIND v(dout0_1) AT=385.025n

.meas tran vdout0_2ck760 FIND v(dout0_2) AT=385.025n

.meas tran vdout0_3ck760 FIND v(dout0_3) AT=385.025n

.meas tran vdout0_4ck760 FIND v(dout0_4) AT=385.025n

.meas tran vdout0_5ck760 FIND v(dout0_5) AT=385.025n

.meas tran vdout0_6ck760 FIND v(dout0_6) AT=385.025n

.meas tran vdout0_7ck760 FIND v(dout0_7) AT=385.025n

.meas tran vdout0_8ck760 FIND v(dout0_8) AT=385.025n

.meas tran vdout0_9ck760 FIND v(dout0_9) AT=385.025n

.meas tran vdout0_10ck760 FIND v(dout0_10) AT=385.025n

.meas tran vdout0_11ck760 FIND v(dout0_11) AT=385.025n

.meas tran vdout0_12ck760 FIND v(dout0_12) AT=385.025n

.meas tran vdout0_13ck760 FIND v(dout0_13) AT=385.025n

.meas tran vdout0_14ck760 FIND v(dout0_14) AT=385.025n

.meas tran vdout0_15ck760 FIND v(dout0_15) AT=385.025n

.meas tran vdout0_16ck760 FIND v(dout0_16) AT=385.025n

.meas tran vdout0_17ck760 FIND v(dout0_17) AT=385.025n

.meas tran vdout0_18ck760 FIND v(dout0_18) AT=385.025n

.meas tran vdout0_19ck760 FIND v(dout0_19) AT=385.025n

.meas tran vdout0_20ck760 FIND v(dout0_20) AT=385.025n

.meas tran vdout0_21ck760 FIND v(dout0_21) AT=385.025n

.meas tran vdout0_22ck760 FIND v(dout0_22) AT=385.025n

.meas tran vdout0_23ck760 FIND v(dout0_23) AT=385.025n

.meas tran vdout0_24ck760 FIND v(dout0_24) AT=385.025n

.meas tran vdout0_25ck760 FIND v(dout0_25) AT=385.025n

.meas tran vdout0_26ck760 FIND v(dout0_26) AT=385.025n

.meas tran vdout0_27ck760 FIND v(dout0_27) AT=385.025n

.meas tran vdout0_28ck760 FIND v(dout0_28) AT=385.025n

.meas tran vdout0_29ck760 FIND v(dout0_29) AT=385.025n

.meas tran vdout0_30ck760 FIND v(dout0_30) AT=385.025n

.meas tran vdout0_31ck760 FIND v(dout0_31) AT=385.025n

.meas tran vdout1_0ck780 FIND v(dout1_0) AT=395.025n

.meas tran vdout1_1ck780 FIND v(dout1_1) AT=395.025n

.meas tran vdout1_2ck780 FIND v(dout1_2) AT=395.025n

.meas tran vdout1_3ck780 FIND v(dout1_3) AT=395.025n

.meas tran vdout1_4ck780 FIND v(dout1_4) AT=395.025n

.meas tran vdout1_5ck780 FIND v(dout1_5) AT=395.025n

.meas tran vdout1_6ck780 FIND v(dout1_6) AT=395.025n

.meas tran vdout1_7ck780 FIND v(dout1_7) AT=395.025n

.meas tran vdout1_8ck780 FIND v(dout1_8) AT=395.025n

.meas tran vdout1_9ck780 FIND v(dout1_9) AT=395.025n

.meas tran vdout1_10ck780 FIND v(dout1_10) AT=395.025n

.meas tran vdout1_11ck780 FIND v(dout1_11) AT=395.025n

.meas tran vdout1_12ck780 FIND v(dout1_12) AT=395.025n

.meas tran vdout1_13ck780 FIND v(dout1_13) AT=395.025n

.meas tran vdout1_14ck780 FIND v(dout1_14) AT=395.025n

.meas tran vdout1_15ck780 FIND v(dout1_15) AT=395.025n

.meas tran vdout1_16ck780 FIND v(dout1_16) AT=395.025n

.meas tran vdout1_17ck780 FIND v(dout1_17) AT=395.025n

.meas tran vdout1_18ck780 FIND v(dout1_18) AT=395.025n

.meas tran vdout1_19ck780 FIND v(dout1_19) AT=395.025n

.meas tran vdout1_20ck780 FIND v(dout1_20) AT=395.025n

.meas tran vdout1_21ck780 FIND v(dout1_21) AT=395.025n

.meas tran vdout1_22ck780 FIND v(dout1_22) AT=395.025n

.meas tran vdout1_23ck780 FIND v(dout1_23) AT=395.025n

.meas tran vdout1_24ck780 FIND v(dout1_24) AT=395.025n

.meas tran vdout1_25ck780 FIND v(dout1_25) AT=395.025n

.meas tran vdout1_26ck780 FIND v(dout1_26) AT=395.025n

.meas tran vdout1_27ck780 FIND v(dout1_27) AT=395.025n

.meas tran vdout1_28ck780 FIND v(dout1_28) AT=395.025n

.meas tran vdout1_29ck780 FIND v(dout1_29) AT=395.025n

.meas tran vdout1_30ck780 FIND v(dout1_30) AT=395.025n

.meas tran vdout1_31ck780 FIND v(dout1_31) AT=395.025n

.meas tran vdout0_0ck790 FIND v(dout0_0) AT=400.025n

.meas tran vdout0_1ck790 FIND v(dout0_1) AT=400.025n

.meas tran vdout0_2ck790 FIND v(dout0_2) AT=400.025n

.meas tran vdout0_3ck790 FIND v(dout0_3) AT=400.025n

.meas tran vdout0_4ck790 FIND v(dout0_4) AT=400.025n

.meas tran vdout0_5ck790 FIND v(dout0_5) AT=400.025n

.meas tran vdout0_6ck790 FIND v(dout0_6) AT=400.025n

.meas tran vdout0_7ck790 FIND v(dout0_7) AT=400.025n

.meas tran vdout0_8ck790 FIND v(dout0_8) AT=400.025n

.meas tran vdout0_9ck790 FIND v(dout0_9) AT=400.025n

.meas tran vdout0_10ck790 FIND v(dout0_10) AT=400.025n

.meas tran vdout0_11ck790 FIND v(dout0_11) AT=400.025n

.meas tran vdout0_12ck790 FIND v(dout0_12) AT=400.025n

.meas tran vdout0_13ck790 FIND v(dout0_13) AT=400.025n

.meas tran vdout0_14ck790 FIND v(dout0_14) AT=400.025n

.meas tran vdout0_15ck790 FIND v(dout0_15) AT=400.025n

.meas tran vdout0_16ck790 FIND v(dout0_16) AT=400.025n

.meas tran vdout0_17ck790 FIND v(dout0_17) AT=400.025n

.meas tran vdout0_18ck790 FIND v(dout0_18) AT=400.025n

.meas tran vdout0_19ck790 FIND v(dout0_19) AT=400.025n

.meas tran vdout0_20ck790 FIND v(dout0_20) AT=400.025n

.meas tran vdout0_21ck790 FIND v(dout0_21) AT=400.025n

.meas tran vdout0_22ck790 FIND v(dout0_22) AT=400.025n

.meas tran vdout0_23ck790 FIND v(dout0_23) AT=400.025n

.meas tran vdout0_24ck790 FIND v(dout0_24) AT=400.025n

.meas tran vdout0_25ck790 FIND v(dout0_25) AT=400.025n

.meas tran vdout0_26ck790 FIND v(dout0_26) AT=400.025n

.meas tran vdout0_27ck790 FIND v(dout0_27) AT=400.025n

.meas tran vdout0_28ck790 FIND v(dout0_28) AT=400.025n

.meas tran vdout0_29ck790 FIND v(dout0_29) AT=400.025n

.meas tran vdout0_30ck790 FIND v(dout0_30) AT=400.025n

.meas tran vdout0_31ck790 FIND v(dout0_31) AT=400.025n

.meas tran vdout1_0ck790 FIND v(dout1_0) AT=400.025n

.meas tran vdout1_1ck790 FIND v(dout1_1) AT=400.025n

.meas tran vdout1_2ck790 FIND v(dout1_2) AT=400.025n

.meas tran vdout1_3ck790 FIND v(dout1_3) AT=400.025n

.meas tran vdout1_4ck790 FIND v(dout1_4) AT=400.025n

.meas tran vdout1_5ck790 FIND v(dout1_5) AT=400.025n

.meas tran vdout1_6ck790 FIND v(dout1_6) AT=400.025n

.meas tran vdout1_7ck790 FIND v(dout1_7) AT=400.025n

.meas tran vdout1_8ck790 FIND v(dout1_8) AT=400.025n

.meas tran vdout1_9ck790 FIND v(dout1_9) AT=400.025n

.meas tran vdout1_10ck790 FIND v(dout1_10) AT=400.025n

.meas tran vdout1_11ck790 FIND v(dout1_11) AT=400.025n

.meas tran vdout1_12ck790 FIND v(dout1_12) AT=400.025n

.meas tran vdout1_13ck790 FIND v(dout1_13) AT=400.025n

.meas tran vdout1_14ck790 FIND v(dout1_14) AT=400.025n

.meas tran vdout1_15ck790 FIND v(dout1_15) AT=400.025n

.meas tran vdout1_16ck790 FIND v(dout1_16) AT=400.025n

.meas tran vdout1_17ck790 FIND v(dout1_17) AT=400.025n

.meas tran vdout1_18ck790 FIND v(dout1_18) AT=400.025n

.meas tran vdout1_19ck790 FIND v(dout1_19) AT=400.025n

.meas tran vdout1_20ck790 FIND v(dout1_20) AT=400.025n

.meas tran vdout1_21ck790 FIND v(dout1_21) AT=400.025n

.meas tran vdout1_22ck790 FIND v(dout1_22) AT=400.025n

.meas tran vdout1_23ck790 FIND v(dout1_23) AT=400.025n

.meas tran vdout1_24ck790 FIND v(dout1_24) AT=400.025n

.meas tran vdout1_25ck790 FIND v(dout1_25) AT=400.025n

.meas tran vdout1_26ck790 FIND v(dout1_26) AT=400.025n

.meas tran vdout1_27ck790 FIND v(dout1_27) AT=400.025n

.meas tran vdout1_28ck790 FIND v(dout1_28) AT=400.025n

.meas tran vdout1_29ck790 FIND v(dout1_29) AT=400.025n

.meas tran vdout1_30ck790 FIND v(dout1_30) AT=400.025n

.meas tran vdout1_31ck790 FIND v(dout1_31) AT=400.025n

.meas tran vdout0_0ck800 FIND v(dout0_0) AT=405.025n

.meas tran vdout0_1ck800 FIND v(dout0_1) AT=405.025n

.meas tran vdout0_2ck800 FIND v(dout0_2) AT=405.025n

.meas tran vdout0_3ck800 FIND v(dout0_3) AT=405.025n

.meas tran vdout0_4ck800 FIND v(dout0_4) AT=405.025n

.meas tran vdout0_5ck800 FIND v(dout0_5) AT=405.025n

.meas tran vdout0_6ck800 FIND v(dout0_6) AT=405.025n

.meas tran vdout0_7ck800 FIND v(dout0_7) AT=405.025n

.meas tran vdout0_8ck800 FIND v(dout0_8) AT=405.025n

.meas tran vdout0_9ck800 FIND v(dout0_9) AT=405.025n

.meas tran vdout0_10ck800 FIND v(dout0_10) AT=405.025n

.meas tran vdout0_11ck800 FIND v(dout0_11) AT=405.025n

.meas tran vdout0_12ck800 FIND v(dout0_12) AT=405.025n

.meas tran vdout0_13ck800 FIND v(dout0_13) AT=405.025n

.meas tran vdout0_14ck800 FIND v(dout0_14) AT=405.025n

.meas tran vdout0_15ck800 FIND v(dout0_15) AT=405.025n

.meas tran vdout0_16ck800 FIND v(dout0_16) AT=405.025n

.meas tran vdout0_17ck800 FIND v(dout0_17) AT=405.025n

.meas tran vdout0_18ck800 FIND v(dout0_18) AT=405.025n

.meas tran vdout0_19ck800 FIND v(dout0_19) AT=405.025n

.meas tran vdout0_20ck800 FIND v(dout0_20) AT=405.025n

.meas tran vdout0_21ck800 FIND v(dout0_21) AT=405.025n

.meas tran vdout0_22ck800 FIND v(dout0_22) AT=405.025n

.meas tran vdout0_23ck800 FIND v(dout0_23) AT=405.025n

.meas tran vdout0_24ck800 FIND v(dout0_24) AT=405.025n

.meas tran vdout0_25ck800 FIND v(dout0_25) AT=405.025n

.meas tran vdout0_26ck800 FIND v(dout0_26) AT=405.025n

.meas tran vdout0_27ck800 FIND v(dout0_27) AT=405.025n

.meas tran vdout0_28ck800 FIND v(dout0_28) AT=405.025n

.meas tran vdout0_29ck800 FIND v(dout0_29) AT=405.025n

.meas tran vdout0_30ck800 FIND v(dout0_30) AT=405.025n

.meas tran vdout0_31ck800 FIND v(dout0_31) AT=405.025n

.meas tran vdout0_0ck810 FIND v(dout0_0) AT=410.025n

.meas tran vdout0_1ck810 FIND v(dout0_1) AT=410.025n

.meas tran vdout0_2ck810 FIND v(dout0_2) AT=410.025n

.meas tran vdout0_3ck810 FIND v(dout0_3) AT=410.025n

.meas tran vdout0_4ck810 FIND v(dout0_4) AT=410.025n

.meas tran vdout0_5ck810 FIND v(dout0_5) AT=410.025n

.meas tran vdout0_6ck810 FIND v(dout0_6) AT=410.025n

.meas tran vdout0_7ck810 FIND v(dout0_7) AT=410.025n

.meas tran vdout0_8ck810 FIND v(dout0_8) AT=410.025n

.meas tran vdout0_9ck810 FIND v(dout0_9) AT=410.025n

.meas tran vdout0_10ck810 FIND v(dout0_10) AT=410.025n

.meas tran vdout0_11ck810 FIND v(dout0_11) AT=410.025n

.meas tran vdout0_12ck810 FIND v(dout0_12) AT=410.025n

.meas tran vdout0_13ck810 FIND v(dout0_13) AT=410.025n

.meas tran vdout0_14ck810 FIND v(dout0_14) AT=410.025n

.meas tran vdout0_15ck810 FIND v(dout0_15) AT=410.025n

.meas tran vdout0_16ck810 FIND v(dout0_16) AT=410.025n

.meas tran vdout0_17ck810 FIND v(dout0_17) AT=410.025n

.meas tran vdout0_18ck810 FIND v(dout0_18) AT=410.025n

.meas tran vdout0_19ck810 FIND v(dout0_19) AT=410.025n

.meas tran vdout0_20ck810 FIND v(dout0_20) AT=410.025n

.meas tran vdout0_21ck810 FIND v(dout0_21) AT=410.025n

.meas tran vdout0_22ck810 FIND v(dout0_22) AT=410.025n

.meas tran vdout0_23ck810 FIND v(dout0_23) AT=410.025n

.meas tran vdout0_24ck810 FIND v(dout0_24) AT=410.025n

.meas tran vdout0_25ck810 FIND v(dout0_25) AT=410.025n

.meas tran vdout0_26ck810 FIND v(dout0_26) AT=410.025n

.meas tran vdout0_27ck810 FIND v(dout0_27) AT=410.025n

.meas tran vdout0_28ck810 FIND v(dout0_28) AT=410.025n

.meas tran vdout0_29ck810 FIND v(dout0_29) AT=410.025n

.meas tran vdout0_30ck810 FIND v(dout0_30) AT=410.025n

.meas tran vdout0_31ck810 FIND v(dout0_31) AT=410.025n

.meas tran vdout1_0ck820 FIND v(dout1_0) AT=415.025n

.meas tran vdout1_1ck820 FIND v(dout1_1) AT=415.025n

.meas tran vdout1_2ck820 FIND v(dout1_2) AT=415.025n

.meas tran vdout1_3ck820 FIND v(dout1_3) AT=415.025n

.meas tran vdout1_4ck820 FIND v(dout1_4) AT=415.025n

.meas tran vdout1_5ck820 FIND v(dout1_5) AT=415.025n

.meas tran vdout1_6ck820 FIND v(dout1_6) AT=415.025n

.meas tran vdout1_7ck820 FIND v(dout1_7) AT=415.025n

.meas tran vdout1_8ck820 FIND v(dout1_8) AT=415.025n

.meas tran vdout1_9ck820 FIND v(dout1_9) AT=415.025n

.meas tran vdout1_10ck820 FIND v(dout1_10) AT=415.025n

.meas tran vdout1_11ck820 FIND v(dout1_11) AT=415.025n

.meas tran vdout1_12ck820 FIND v(dout1_12) AT=415.025n

.meas tran vdout1_13ck820 FIND v(dout1_13) AT=415.025n

.meas tran vdout1_14ck820 FIND v(dout1_14) AT=415.025n

.meas tran vdout1_15ck820 FIND v(dout1_15) AT=415.025n

.meas tran vdout1_16ck820 FIND v(dout1_16) AT=415.025n

.meas tran vdout1_17ck820 FIND v(dout1_17) AT=415.025n

.meas tran vdout1_18ck820 FIND v(dout1_18) AT=415.025n

.meas tran vdout1_19ck820 FIND v(dout1_19) AT=415.025n

.meas tran vdout1_20ck820 FIND v(dout1_20) AT=415.025n

.meas tran vdout1_21ck820 FIND v(dout1_21) AT=415.025n

.meas tran vdout1_22ck820 FIND v(dout1_22) AT=415.025n

.meas tran vdout1_23ck820 FIND v(dout1_23) AT=415.025n

.meas tran vdout1_24ck820 FIND v(dout1_24) AT=415.025n

.meas tran vdout1_25ck820 FIND v(dout1_25) AT=415.025n

.meas tran vdout1_26ck820 FIND v(dout1_26) AT=415.025n

.meas tran vdout1_27ck820 FIND v(dout1_27) AT=415.025n

.meas tran vdout1_28ck820 FIND v(dout1_28) AT=415.025n

.meas tran vdout1_29ck820 FIND v(dout1_29) AT=415.025n

.meas tran vdout1_30ck820 FIND v(dout1_30) AT=415.025n

.meas tran vdout1_31ck820 FIND v(dout1_31) AT=415.025n

.meas tran vdout0_0ck830 FIND v(dout0_0) AT=420.025n

.meas tran vdout0_1ck830 FIND v(dout0_1) AT=420.025n

.meas tran vdout0_2ck830 FIND v(dout0_2) AT=420.025n

.meas tran vdout0_3ck830 FIND v(dout0_3) AT=420.025n

.meas tran vdout0_4ck830 FIND v(dout0_4) AT=420.025n

.meas tran vdout0_5ck830 FIND v(dout0_5) AT=420.025n

.meas tran vdout0_6ck830 FIND v(dout0_6) AT=420.025n

.meas tran vdout0_7ck830 FIND v(dout0_7) AT=420.025n

.meas tran vdout0_8ck830 FIND v(dout0_8) AT=420.025n

.meas tran vdout0_9ck830 FIND v(dout0_9) AT=420.025n

.meas tran vdout0_10ck830 FIND v(dout0_10) AT=420.025n

.meas tran vdout0_11ck830 FIND v(dout0_11) AT=420.025n

.meas tran vdout0_12ck830 FIND v(dout0_12) AT=420.025n

.meas tran vdout0_13ck830 FIND v(dout0_13) AT=420.025n

.meas tran vdout0_14ck830 FIND v(dout0_14) AT=420.025n

.meas tran vdout0_15ck830 FIND v(dout0_15) AT=420.025n

.meas tran vdout0_16ck830 FIND v(dout0_16) AT=420.025n

.meas tran vdout0_17ck830 FIND v(dout0_17) AT=420.025n

.meas tran vdout0_18ck830 FIND v(dout0_18) AT=420.025n

.meas tran vdout0_19ck830 FIND v(dout0_19) AT=420.025n

.meas tran vdout0_20ck830 FIND v(dout0_20) AT=420.025n

.meas tran vdout0_21ck830 FIND v(dout0_21) AT=420.025n

.meas tran vdout0_22ck830 FIND v(dout0_22) AT=420.025n

.meas tran vdout0_23ck830 FIND v(dout0_23) AT=420.025n

.meas tran vdout0_24ck830 FIND v(dout0_24) AT=420.025n

.meas tran vdout0_25ck830 FIND v(dout0_25) AT=420.025n

.meas tran vdout0_26ck830 FIND v(dout0_26) AT=420.025n

.meas tran vdout0_27ck830 FIND v(dout0_27) AT=420.025n

.meas tran vdout0_28ck830 FIND v(dout0_28) AT=420.025n

.meas tran vdout0_29ck830 FIND v(dout0_29) AT=420.025n

.meas tran vdout0_30ck830 FIND v(dout0_30) AT=420.025n

.meas tran vdout0_31ck830 FIND v(dout0_31) AT=420.025n

.meas tran vdout0_0ck840 FIND v(dout0_0) AT=425.025n

.meas tran vdout0_1ck840 FIND v(dout0_1) AT=425.025n

.meas tran vdout0_2ck840 FIND v(dout0_2) AT=425.025n

.meas tran vdout0_3ck840 FIND v(dout0_3) AT=425.025n

.meas tran vdout0_4ck840 FIND v(dout0_4) AT=425.025n

.meas tran vdout0_5ck840 FIND v(dout0_5) AT=425.025n

.meas tran vdout0_6ck840 FIND v(dout0_6) AT=425.025n

.meas tran vdout0_7ck840 FIND v(dout0_7) AT=425.025n

.meas tran vdout0_8ck840 FIND v(dout0_8) AT=425.025n

.meas tran vdout0_9ck840 FIND v(dout0_9) AT=425.025n

.meas tran vdout0_10ck840 FIND v(dout0_10) AT=425.025n

.meas tran vdout0_11ck840 FIND v(dout0_11) AT=425.025n

.meas tran vdout0_12ck840 FIND v(dout0_12) AT=425.025n

.meas tran vdout0_13ck840 FIND v(dout0_13) AT=425.025n

.meas tran vdout0_14ck840 FIND v(dout0_14) AT=425.025n

.meas tran vdout0_15ck840 FIND v(dout0_15) AT=425.025n

.meas tran vdout0_16ck840 FIND v(dout0_16) AT=425.025n

.meas tran vdout0_17ck840 FIND v(dout0_17) AT=425.025n

.meas tran vdout0_18ck840 FIND v(dout0_18) AT=425.025n

.meas tran vdout0_19ck840 FIND v(dout0_19) AT=425.025n

.meas tran vdout0_20ck840 FIND v(dout0_20) AT=425.025n

.meas tran vdout0_21ck840 FIND v(dout0_21) AT=425.025n

.meas tran vdout0_22ck840 FIND v(dout0_22) AT=425.025n

.meas tran vdout0_23ck840 FIND v(dout0_23) AT=425.025n

.meas tran vdout0_24ck840 FIND v(dout0_24) AT=425.025n

.meas tran vdout0_25ck840 FIND v(dout0_25) AT=425.025n

.meas tran vdout0_26ck840 FIND v(dout0_26) AT=425.025n

.meas tran vdout0_27ck840 FIND v(dout0_27) AT=425.025n

.meas tran vdout0_28ck840 FIND v(dout0_28) AT=425.025n

.meas tran vdout0_29ck840 FIND v(dout0_29) AT=425.025n

.meas tran vdout0_30ck840 FIND v(dout0_30) AT=425.025n

.meas tran vdout0_31ck840 FIND v(dout0_31) AT=425.025n

.meas tran vdout0_0ck850 FIND v(dout0_0) AT=430.025n

.meas tran vdout0_1ck850 FIND v(dout0_1) AT=430.025n

.meas tran vdout0_2ck850 FIND v(dout0_2) AT=430.025n

.meas tran vdout0_3ck850 FIND v(dout0_3) AT=430.025n

.meas tran vdout0_4ck850 FIND v(dout0_4) AT=430.025n

.meas tran vdout0_5ck850 FIND v(dout0_5) AT=430.025n

.meas tran vdout0_6ck850 FIND v(dout0_6) AT=430.025n

.meas tran vdout0_7ck850 FIND v(dout0_7) AT=430.025n

.meas tran vdout0_8ck850 FIND v(dout0_8) AT=430.025n

.meas tran vdout0_9ck850 FIND v(dout0_9) AT=430.025n

.meas tran vdout0_10ck850 FIND v(dout0_10) AT=430.025n

.meas tran vdout0_11ck850 FIND v(dout0_11) AT=430.025n

.meas tran vdout0_12ck850 FIND v(dout0_12) AT=430.025n

.meas tran vdout0_13ck850 FIND v(dout0_13) AT=430.025n

.meas tran vdout0_14ck850 FIND v(dout0_14) AT=430.025n

.meas tran vdout0_15ck850 FIND v(dout0_15) AT=430.025n

.meas tran vdout0_16ck850 FIND v(dout0_16) AT=430.025n

.meas tran vdout0_17ck850 FIND v(dout0_17) AT=430.025n

.meas tran vdout0_18ck850 FIND v(dout0_18) AT=430.025n

.meas tran vdout0_19ck850 FIND v(dout0_19) AT=430.025n

.meas tran vdout0_20ck850 FIND v(dout0_20) AT=430.025n

.meas tran vdout0_21ck850 FIND v(dout0_21) AT=430.025n

.meas tran vdout0_22ck850 FIND v(dout0_22) AT=430.025n

.meas tran vdout0_23ck850 FIND v(dout0_23) AT=430.025n

.meas tran vdout0_24ck850 FIND v(dout0_24) AT=430.025n

.meas tran vdout0_25ck850 FIND v(dout0_25) AT=430.025n

.meas tran vdout0_26ck850 FIND v(dout0_26) AT=430.025n

.meas tran vdout0_27ck850 FIND v(dout0_27) AT=430.025n

.meas tran vdout0_28ck850 FIND v(dout0_28) AT=430.025n

.meas tran vdout0_29ck850 FIND v(dout0_29) AT=430.025n

.meas tran vdout0_30ck850 FIND v(dout0_30) AT=430.025n

.meas tran vdout0_31ck850 FIND v(dout0_31) AT=430.025n

.meas tran vdout1_0ck850 FIND v(dout1_0) AT=430.025n

.meas tran vdout1_1ck850 FIND v(dout1_1) AT=430.025n

.meas tran vdout1_2ck850 FIND v(dout1_2) AT=430.025n

.meas tran vdout1_3ck850 FIND v(dout1_3) AT=430.025n

.meas tran vdout1_4ck850 FIND v(dout1_4) AT=430.025n

.meas tran vdout1_5ck850 FIND v(dout1_5) AT=430.025n

.meas tran vdout1_6ck850 FIND v(dout1_6) AT=430.025n

.meas tran vdout1_7ck850 FIND v(dout1_7) AT=430.025n

.meas tran vdout1_8ck850 FIND v(dout1_8) AT=430.025n

.meas tran vdout1_9ck850 FIND v(dout1_9) AT=430.025n

.meas tran vdout1_10ck850 FIND v(dout1_10) AT=430.025n

.meas tran vdout1_11ck850 FIND v(dout1_11) AT=430.025n

.meas tran vdout1_12ck850 FIND v(dout1_12) AT=430.025n

.meas tran vdout1_13ck850 FIND v(dout1_13) AT=430.025n

.meas tran vdout1_14ck850 FIND v(dout1_14) AT=430.025n

.meas tran vdout1_15ck850 FIND v(dout1_15) AT=430.025n

.meas tran vdout1_16ck850 FIND v(dout1_16) AT=430.025n

.meas tran vdout1_17ck850 FIND v(dout1_17) AT=430.025n

.meas tran vdout1_18ck850 FIND v(dout1_18) AT=430.025n

.meas tran vdout1_19ck850 FIND v(dout1_19) AT=430.025n

.meas tran vdout1_20ck850 FIND v(dout1_20) AT=430.025n

.meas tran vdout1_21ck850 FIND v(dout1_21) AT=430.025n

.meas tran vdout1_22ck850 FIND v(dout1_22) AT=430.025n

.meas tran vdout1_23ck850 FIND v(dout1_23) AT=430.025n

.meas tran vdout1_24ck850 FIND v(dout1_24) AT=430.025n

.meas tran vdout1_25ck850 FIND v(dout1_25) AT=430.025n

.meas tran vdout1_26ck850 FIND v(dout1_26) AT=430.025n

.meas tran vdout1_27ck850 FIND v(dout1_27) AT=430.025n

.meas tran vdout1_28ck850 FIND v(dout1_28) AT=430.025n

.meas tran vdout1_29ck850 FIND v(dout1_29) AT=430.025n

.meas tran vdout1_30ck850 FIND v(dout1_30) AT=430.025n

.meas tran vdout1_31ck850 FIND v(dout1_31) AT=430.025n

.meas tran vdout1_0ck860 FIND v(dout1_0) AT=435.025n

.meas tran vdout1_1ck860 FIND v(dout1_1) AT=435.025n

.meas tran vdout1_2ck860 FIND v(dout1_2) AT=435.025n

.meas tran vdout1_3ck860 FIND v(dout1_3) AT=435.025n

.meas tran vdout1_4ck860 FIND v(dout1_4) AT=435.025n

.meas tran vdout1_5ck860 FIND v(dout1_5) AT=435.025n

.meas tran vdout1_6ck860 FIND v(dout1_6) AT=435.025n

.meas tran vdout1_7ck860 FIND v(dout1_7) AT=435.025n

.meas tran vdout1_8ck860 FIND v(dout1_8) AT=435.025n

.meas tran vdout1_9ck860 FIND v(dout1_9) AT=435.025n

.meas tran vdout1_10ck860 FIND v(dout1_10) AT=435.025n

.meas tran vdout1_11ck860 FIND v(dout1_11) AT=435.025n

.meas tran vdout1_12ck860 FIND v(dout1_12) AT=435.025n

.meas tran vdout1_13ck860 FIND v(dout1_13) AT=435.025n

.meas tran vdout1_14ck860 FIND v(dout1_14) AT=435.025n

.meas tran vdout1_15ck860 FIND v(dout1_15) AT=435.025n

.meas tran vdout1_16ck860 FIND v(dout1_16) AT=435.025n

.meas tran vdout1_17ck860 FIND v(dout1_17) AT=435.025n

.meas tran vdout1_18ck860 FIND v(dout1_18) AT=435.025n

.meas tran vdout1_19ck860 FIND v(dout1_19) AT=435.025n

.meas tran vdout1_20ck860 FIND v(dout1_20) AT=435.025n

.meas tran vdout1_21ck860 FIND v(dout1_21) AT=435.025n

.meas tran vdout1_22ck860 FIND v(dout1_22) AT=435.025n

.meas tran vdout1_23ck860 FIND v(dout1_23) AT=435.025n

.meas tran vdout1_24ck860 FIND v(dout1_24) AT=435.025n

.meas tran vdout1_25ck860 FIND v(dout1_25) AT=435.025n

.meas tran vdout1_26ck860 FIND v(dout1_26) AT=435.025n

.meas tran vdout1_27ck860 FIND v(dout1_27) AT=435.025n

.meas tran vdout1_28ck860 FIND v(dout1_28) AT=435.025n

.meas tran vdout1_29ck860 FIND v(dout1_29) AT=435.025n

.meas tran vdout1_30ck860 FIND v(dout1_30) AT=435.025n

.meas tran vdout1_31ck860 FIND v(dout1_31) AT=435.025n

.meas tran vdout1_0ck890 FIND v(dout1_0) AT=450.025n

.meas tran vdout1_1ck890 FIND v(dout1_1) AT=450.025n

.meas tran vdout1_2ck890 FIND v(dout1_2) AT=450.025n

.meas tran vdout1_3ck890 FIND v(dout1_3) AT=450.025n

.meas tran vdout1_4ck890 FIND v(dout1_4) AT=450.025n

.meas tran vdout1_5ck890 FIND v(dout1_5) AT=450.025n

.meas tran vdout1_6ck890 FIND v(dout1_6) AT=450.025n

.meas tran vdout1_7ck890 FIND v(dout1_7) AT=450.025n

.meas tran vdout1_8ck890 FIND v(dout1_8) AT=450.025n

.meas tran vdout1_9ck890 FIND v(dout1_9) AT=450.025n

.meas tran vdout1_10ck890 FIND v(dout1_10) AT=450.025n

.meas tran vdout1_11ck890 FIND v(dout1_11) AT=450.025n

.meas tran vdout1_12ck890 FIND v(dout1_12) AT=450.025n

.meas tran vdout1_13ck890 FIND v(dout1_13) AT=450.025n

.meas tran vdout1_14ck890 FIND v(dout1_14) AT=450.025n

.meas tran vdout1_15ck890 FIND v(dout1_15) AT=450.025n

.meas tran vdout1_16ck890 FIND v(dout1_16) AT=450.025n

.meas tran vdout1_17ck890 FIND v(dout1_17) AT=450.025n

.meas tran vdout1_18ck890 FIND v(dout1_18) AT=450.025n

.meas tran vdout1_19ck890 FIND v(dout1_19) AT=450.025n

.meas tran vdout1_20ck890 FIND v(dout1_20) AT=450.025n

.meas tran vdout1_21ck890 FIND v(dout1_21) AT=450.025n

.meas tran vdout1_22ck890 FIND v(dout1_22) AT=450.025n

.meas tran vdout1_23ck890 FIND v(dout1_23) AT=450.025n

.meas tran vdout1_24ck890 FIND v(dout1_24) AT=450.025n

.meas tran vdout1_25ck890 FIND v(dout1_25) AT=450.025n

.meas tran vdout1_26ck890 FIND v(dout1_26) AT=450.025n

.meas tran vdout1_27ck890 FIND v(dout1_27) AT=450.025n

.meas tran vdout1_28ck890 FIND v(dout1_28) AT=450.025n

.meas tran vdout1_29ck890 FIND v(dout1_29) AT=450.025n

.meas tran vdout1_30ck890 FIND v(dout1_30) AT=450.025n

.meas tran vdout1_31ck890 FIND v(dout1_31) AT=450.025n

.meas tran vdout0_0ck900 FIND v(dout0_0) AT=455.025n

.meas tran vdout0_1ck900 FIND v(dout0_1) AT=455.025n

.meas tran vdout0_2ck900 FIND v(dout0_2) AT=455.025n

.meas tran vdout0_3ck900 FIND v(dout0_3) AT=455.025n

.meas tran vdout0_4ck900 FIND v(dout0_4) AT=455.025n

.meas tran vdout0_5ck900 FIND v(dout0_5) AT=455.025n

.meas tran vdout0_6ck900 FIND v(dout0_6) AT=455.025n

.meas tran vdout0_7ck900 FIND v(dout0_7) AT=455.025n

.meas tran vdout0_8ck900 FIND v(dout0_8) AT=455.025n

.meas tran vdout0_9ck900 FIND v(dout0_9) AT=455.025n

.meas tran vdout0_10ck900 FIND v(dout0_10) AT=455.025n

.meas tran vdout0_11ck900 FIND v(dout0_11) AT=455.025n

.meas tran vdout0_12ck900 FIND v(dout0_12) AT=455.025n

.meas tran vdout0_13ck900 FIND v(dout0_13) AT=455.025n

.meas tran vdout0_14ck900 FIND v(dout0_14) AT=455.025n

.meas tran vdout0_15ck900 FIND v(dout0_15) AT=455.025n

.meas tran vdout0_16ck900 FIND v(dout0_16) AT=455.025n

.meas tran vdout0_17ck900 FIND v(dout0_17) AT=455.025n

.meas tran vdout0_18ck900 FIND v(dout0_18) AT=455.025n

.meas tran vdout0_19ck900 FIND v(dout0_19) AT=455.025n

.meas tran vdout0_20ck900 FIND v(dout0_20) AT=455.025n

.meas tran vdout0_21ck900 FIND v(dout0_21) AT=455.025n

.meas tran vdout0_22ck900 FIND v(dout0_22) AT=455.025n

.meas tran vdout0_23ck900 FIND v(dout0_23) AT=455.025n

.meas tran vdout0_24ck900 FIND v(dout0_24) AT=455.025n

.meas tran vdout0_25ck900 FIND v(dout0_25) AT=455.025n

.meas tran vdout0_26ck900 FIND v(dout0_26) AT=455.025n

.meas tran vdout0_27ck900 FIND v(dout0_27) AT=455.025n

.meas tran vdout0_28ck900 FIND v(dout0_28) AT=455.025n

.meas tran vdout0_29ck900 FIND v(dout0_29) AT=455.025n

.meas tran vdout0_30ck900 FIND v(dout0_30) AT=455.025n

.meas tran vdout0_31ck900 FIND v(dout0_31) AT=455.025n

.meas tran vdout1_0ck900 FIND v(dout1_0) AT=455.025n

.meas tran vdout1_1ck900 FIND v(dout1_1) AT=455.025n

.meas tran vdout1_2ck900 FIND v(dout1_2) AT=455.025n

.meas tran vdout1_3ck900 FIND v(dout1_3) AT=455.025n

.meas tran vdout1_4ck900 FIND v(dout1_4) AT=455.025n

.meas tran vdout1_5ck900 FIND v(dout1_5) AT=455.025n

.meas tran vdout1_6ck900 FIND v(dout1_6) AT=455.025n

.meas tran vdout1_7ck900 FIND v(dout1_7) AT=455.025n

.meas tran vdout1_8ck900 FIND v(dout1_8) AT=455.025n

.meas tran vdout1_9ck900 FIND v(dout1_9) AT=455.025n

.meas tran vdout1_10ck900 FIND v(dout1_10) AT=455.025n

.meas tran vdout1_11ck900 FIND v(dout1_11) AT=455.025n

.meas tran vdout1_12ck900 FIND v(dout1_12) AT=455.025n

.meas tran vdout1_13ck900 FIND v(dout1_13) AT=455.025n

.meas tran vdout1_14ck900 FIND v(dout1_14) AT=455.025n

.meas tran vdout1_15ck900 FIND v(dout1_15) AT=455.025n

.meas tran vdout1_16ck900 FIND v(dout1_16) AT=455.025n

.meas tran vdout1_17ck900 FIND v(dout1_17) AT=455.025n

.meas tran vdout1_18ck900 FIND v(dout1_18) AT=455.025n

.meas tran vdout1_19ck900 FIND v(dout1_19) AT=455.025n

.meas tran vdout1_20ck900 FIND v(dout1_20) AT=455.025n

.meas tran vdout1_21ck900 FIND v(dout1_21) AT=455.025n

.meas tran vdout1_22ck900 FIND v(dout1_22) AT=455.025n

.meas tran vdout1_23ck900 FIND v(dout1_23) AT=455.025n

.meas tran vdout1_24ck900 FIND v(dout1_24) AT=455.025n

.meas tran vdout1_25ck900 FIND v(dout1_25) AT=455.025n

.meas tran vdout1_26ck900 FIND v(dout1_26) AT=455.025n

.meas tran vdout1_27ck900 FIND v(dout1_27) AT=455.025n

.meas tran vdout1_28ck900 FIND v(dout1_28) AT=455.025n

.meas tran vdout1_29ck900 FIND v(dout1_29) AT=455.025n

.meas tran vdout1_30ck900 FIND v(dout1_30) AT=455.025n

.meas tran vdout1_31ck900 FIND v(dout1_31) AT=455.025n

.meas tran vdout1_0ck940 FIND v(dout1_0) AT=475.025n

.meas tran vdout1_1ck940 FIND v(dout1_1) AT=475.025n

.meas tran vdout1_2ck940 FIND v(dout1_2) AT=475.025n

.meas tran vdout1_3ck940 FIND v(dout1_3) AT=475.025n

.meas tran vdout1_4ck940 FIND v(dout1_4) AT=475.025n

.meas tran vdout1_5ck940 FIND v(dout1_5) AT=475.025n

.meas tran vdout1_6ck940 FIND v(dout1_6) AT=475.025n

.meas tran vdout1_7ck940 FIND v(dout1_7) AT=475.025n

.meas tran vdout1_8ck940 FIND v(dout1_8) AT=475.025n

.meas tran vdout1_9ck940 FIND v(dout1_9) AT=475.025n

.meas tran vdout1_10ck940 FIND v(dout1_10) AT=475.025n

.meas tran vdout1_11ck940 FIND v(dout1_11) AT=475.025n

.meas tran vdout1_12ck940 FIND v(dout1_12) AT=475.025n

.meas tran vdout1_13ck940 FIND v(dout1_13) AT=475.025n

.meas tran vdout1_14ck940 FIND v(dout1_14) AT=475.025n

.meas tran vdout1_15ck940 FIND v(dout1_15) AT=475.025n

.meas tran vdout1_16ck940 FIND v(dout1_16) AT=475.025n

.meas tran vdout1_17ck940 FIND v(dout1_17) AT=475.025n

.meas tran vdout1_18ck940 FIND v(dout1_18) AT=475.025n

.meas tran vdout1_19ck940 FIND v(dout1_19) AT=475.025n

.meas tran vdout1_20ck940 FIND v(dout1_20) AT=475.025n

.meas tran vdout1_21ck940 FIND v(dout1_21) AT=475.025n

.meas tran vdout1_22ck940 FIND v(dout1_22) AT=475.025n

.meas tran vdout1_23ck940 FIND v(dout1_23) AT=475.025n

.meas tran vdout1_24ck940 FIND v(dout1_24) AT=475.025n

.meas tran vdout1_25ck940 FIND v(dout1_25) AT=475.025n

.meas tran vdout1_26ck940 FIND v(dout1_26) AT=475.025n

.meas tran vdout1_27ck940 FIND v(dout1_27) AT=475.025n

.meas tran vdout1_28ck940 FIND v(dout1_28) AT=475.025n

.meas tran vdout1_29ck940 FIND v(dout1_29) AT=475.025n

.meas tran vdout1_30ck940 FIND v(dout1_30) AT=475.025n

.meas tran vdout1_31ck940 FIND v(dout1_31) AT=475.025n

.meas tran vdout0_0ck950 FIND v(dout0_0) AT=480.025n

.meas tran vdout0_1ck950 FIND v(dout0_1) AT=480.025n

.meas tran vdout0_2ck950 FIND v(dout0_2) AT=480.025n

.meas tran vdout0_3ck950 FIND v(dout0_3) AT=480.025n

.meas tran vdout0_4ck950 FIND v(dout0_4) AT=480.025n

.meas tran vdout0_5ck950 FIND v(dout0_5) AT=480.025n

.meas tran vdout0_6ck950 FIND v(dout0_6) AT=480.025n

.meas tran vdout0_7ck950 FIND v(dout0_7) AT=480.025n

.meas tran vdout0_8ck950 FIND v(dout0_8) AT=480.025n

.meas tran vdout0_9ck950 FIND v(dout0_9) AT=480.025n

.meas tran vdout0_10ck950 FIND v(dout0_10) AT=480.025n

.meas tran vdout0_11ck950 FIND v(dout0_11) AT=480.025n

.meas tran vdout0_12ck950 FIND v(dout0_12) AT=480.025n

.meas tran vdout0_13ck950 FIND v(dout0_13) AT=480.025n

.meas tran vdout0_14ck950 FIND v(dout0_14) AT=480.025n

.meas tran vdout0_15ck950 FIND v(dout0_15) AT=480.025n

.meas tran vdout0_16ck950 FIND v(dout0_16) AT=480.025n

.meas tran vdout0_17ck950 FIND v(dout0_17) AT=480.025n

.meas tran vdout0_18ck950 FIND v(dout0_18) AT=480.025n

.meas tran vdout0_19ck950 FIND v(dout0_19) AT=480.025n

.meas tran vdout0_20ck950 FIND v(dout0_20) AT=480.025n

.meas tran vdout0_21ck950 FIND v(dout0_21) AT=480.025n

.meas tran vdout0_22ck950 FIND v(dout0_22) AT=480.025n

.meas tran vdout0_23ck950 FIND v(dout0_23) AT=480.025n

.meas tran vdout0_24ck950 FIND v(dout0_24) AT=480.025n

.meas tran vdout0_25ck950 FIND v(dout0_25) AT=480.025n

.meas tran vdout0_26ck950 FIND v(dout0_26) AT=480.025n

.meas tran vdout0_27ck950 FIND v(dout0_27) AT=480.025n

.meas tran vdout0_28ck950 FIND v(dout0_28) AT=480.025n

.meas tran vdout0_29ck950 FIND v(dout0_29) AT=480.025n

.meas tran vdout0_30ck950 FIND v(dout0_30) AT=480.025n

.meas tran vdout0_31ck950 FIND v(dout0_31) AT=480.025n

.meas tran vdout1_0ck950 FIND v(dout1_0) AT=480.025n

.meas tran vdout1_1ck950 FIND v(dout1_1) AT=480.025n

.meas tran vdout1_2ck950 FIND v(dout1_2) AT=480.025n

.meas tran vdout1_3ck950 FIND v(dout1_3) AT=480.025n

.meas tran vdout1_4ck950 FIND v(dout1_4) AT=480.025n

.meas tran vdout1_5ck950 FIND v(dout1_5) AT=480.025n

.meas tran vdout1_6ck950 FIND v(dout1_6) AT=480.025n

.meas tran vdout1_7ck950 FIND v(dout1_7) AT=480.025n

.meas tran vdout1_8ck950 FIND v(dout1_8) AT=480.025n

.meas tran vdout1_9ck950 FIND v(dout1_9) AT=480.025n

.meas tran vdout1_10ck950 FIND v(dout1_10) AT=480.025n

.meas tran vdout1_11ck950 FIND v(dout1_11) AT=480.025n

.meas tran vdout1_12ck950 FIND v(dout1_12) AT=480.025n

.meas tran vdout1_13ck950 FIND v(dout1_13) AT=480.025n

.meas tran vdout1_14ck950 FIND v(dout1_14) AT=480.025n

.meas tran vdout1_15ck950 FIND v(dout1_15) AT=480.025n

.meas tran vdout1_16ck950 FIND v(dout1_16) AT=480.025n

.meas tran vdout1_17ck950 FIND v(dout1_17) AT=480.025n

.meas tran vdout1_18ck950 FIND v(dout1_18) AT=480.025n

.meas tran vdout1_19ck950 FIND v(dout1_19) AT=480.025n

.meas tran vdout1_20ck950 FIND v(dout1_20) AT=480.025n

.meas tran vdout1_21ck950 FIND v(dout1_21) AT=480.025n

.meas tran vdout1_22ck950 FIND v(dout1_22) AT=480.025n

.meas tran vdout1_23ck950 FIND v(dout1_23) AT=480.025n

.meas tran vdout1_24ck950 FIND v(dout1_24) AT=480.025n

.meas tran vdout1_25ck950 FIND v(dout1_25) AT=480.025n

.meas tran vdout1_26ck950 FIND v(dout1_26) AT=480.025n

.meas tran vdout1_27ck950 FIND v(dout1_27) AT=480.025n

.meas tran vdout1_28ck950 FIND v(dout1_28) AT=480.025n

.meas tran vdout1_29ck950 FIND v(dout1_29) AT=480.025n

.meas tran vdout1_30ck950 FIND v(dout1_30) AT=480.025n

.meas tran vdout1_31ck950 FIND v(dout1_31) AT=480.025n

.meas tran vdout0_0ck960 FIND v(dout0_0) AT=485.025n

.meas tran vdout0_1ck960 FIND v(dout0_1) AT=485.025n

.meas tran vdout0_2ck960 FIND v(dout0_2) AT=485.025n

.meas tran vdout0_3ck960 FIND v(dout0_3) AT=485.025n

.meas tran vdout0_4ck960 FIND v(dout0_4) AT=485.025n

.meas tran vdout0_5ck960 FIND v(dout0_5) AT=485.025n

.meas tran vdout0_6ck960 FIND v(dout0_6) AT=485.025n

.meas tran vdout0_7ck960 FIND v(dout0_7) AT=485.025n

.meas tran vdout0_8ck960 FIND v(dout0_8) AT=485.025n

.meas tran vdout0_9ck960 FIND v(dout0_9) AT=485.025n

.meas tran vdout0_10ck960 FIND v(dout0_10) AT=485.025n

.meas tran vdout0_11ck960 FIND v(dout0_11) AT=485.025n

.meas tran vdout0_12ck960 FIND v(dout0_12) AT=485.025n

.meas tran vdout0_13ck960 FIND v(dout0_13) AT=485.025n

.meas tran vdout0_14ck960 FIND v(dout0_14) AT=485.025n

.meas tran vdout0_15ck960 FIND v(dout0_15) AT=485.025n

.meas tran vdout0_16ck960 FIND v(dout0_16) AT=485.025n

.meas tran vdout0_17ck960 FIND v(dout0_17) AT=485.025n

.meas tran vdout0_18ck960 FIND v(dout0_18) AT=485.025n

.meas tran vdout0_19ck960 FIND v(dout0_19) AT=485.025n

.meas tran vdout0_20ck960 FIND v(dout0_20) AT=485.025n

.meas tran vdout0_21ck960 FIND v(dout0_21) AT=485.025n

.meas tran vdout0_22ck960 FIND v(dout0_22) AT=485.025n

.meas tran vdout0_23ck960 FIND v(dout0_23) AT=485.025n

.meas tran vdout0_24ck960 FIND v(dout0_24) AT=485.025n

.meas tran vdout0_25ck960 FIND v(dout0_25) AT=485.025n

.meas tran vdout0_26ck960 FIND v(dout0_26) AT=485.025n

.meas tran vdout0_27ck960 FIND v(dout0_27) AT=485.025n

.meas tran vdout0_28ck960 FIND v(dout0_28) AT=485.025n

.meas tran vdout0_29ck960 FIND v(dout0_29) AT=485.025n

.meas tran vdout0_30ck960 FIND v(dout0_30) AT=485.025n

.meas tran vdout0_31ck960 FIND v(dout0_31) AT=485.025n

.meas tran vdout0_0ck970 FIND v(dout0_0) AT=490.025n

.meas tran vdout0_1ck970 FIND v(dout0_1) AT=490.025n

.meas tran vdout0_2ck970 FIND v(dout0_2) AT=490.025n

.meas tran vdout0_3ck970 FIND v(dout0_3) AT=490.025n

.meas tran vdout0_4ck970 FIND v(dout0_4) AT=490.025n

.meas tran vdout0_5ck970 FIND v(dout0_5) AT=490.025n

.meas tran vdout0_6ck970 FIND v(dout0_6) AT=490.025n

.meas tran vdout0_7ck970 FIND v(dout0_7) AT=490.025n

.meas tran vdout0_8ck970 FIND v(dout0_8) AT=490.025n

.meas tran vdout0_9ck970 FIND v(dout0_9) AT=490.025n

.meas tran vdout0_10ck970 FIND v(dout0_10) AT=490.025n

.meas tran vdout0_11ck970 FIND v(dout0_11) AT=490.025n

.meas tran vdout0_12ck970 FIND v(dout0_12) AT=490.025n

.meas tran vdout0_13ck970 FIND v(dout0_13) AT=490.025n

.meas tran vdout0_14ck970 FIND v(dout0_14) AT=490.025n

.meas tran vdout0_15ck970 FIND v(dout0_15) AT=490.025n

.meas tran vdout0_16ck970 FIND v(dout0_16) AT=490.025n

.meas tran vdout0_17ck970 FIND v(dout0_17) AT=490.025n

.meas tran vdout0_18ck970 FIND v(dout0_18) AT=490.025n

.meas tran vdout0_19ck970 FIND v(dout0_19) AT=490.025n

.meas tran vdout0_20ck970 FIND v(dout0_20) AT=490.025n

.meas tran vdout0_21ck970 FIND v(dout0_21) AT=490.025n

.meas tran vdout0_22ck970 FIND v(dout0_22) AT=490.025n

.meas tran vdout0_23ck970 FIND v(dout0_23) AT=490.025n

.meas tran vdout0_24ck970 FIND v(dout0_24) AT=490.025n

.meas tran vdout0_25ck970 FIND v(dout0_25) AT=490.025n

.meas tran vdout0_26ck970 FIND v(dout0_26) AT=490.025n

.meas tran vdout0_27ck970 FIND v(dout0_27) AT=490.025n

.meas tran vdout0_28ck970 FIND v(dout0_28) AT=490.025n

.meas tran vdout0_29ck970 FIND v(dout0_29) AT=490.025n

.meas tran vdout0_30ck970 FIND v(dout0_30) AT=490.025n

.meas tran vdout0_31ck970 FIND v(dout0_31) AT=490.025n

.meas tran vdout1_0ck970 FIND v(dout1_0) AT=490.025n

.meas tran vdout1_1ck970 FIND v(dout1_1) AT=490.025n

.meas tran vdout1_2ck970 FIND v(dout1_2) AT=490.025n

.meas tran vdout1_3ck970 FIND v(dout1_3) AT=490.025n

.meas tran vdout1_4ck970 FIND v(dout1_4) AT=490.025n

.meas tran vdout1_5ck970 FIND v(dout1_5) AT=490.025n

.meas tran vdout1_6ck970 FIND v(dout1_6) AT=490.025n

.meas tran vdout1_7ck970 FIND v(dout1_7) AT=490.025n

.meas tran vdout1_8ck970 FIND v(dout1_8) AT=490.025n

.meas tran vdout1_9ck970 FIND v(dout1_9) AT=490.025n

.meas tran vdout1_10ck970 FIND v(dout1_10) AT=490.025n

.meas tran vdout1_11ck970 FIND v(dout1_11) AT=490.025n

.meas tran vdout1_12ck970 FIND v(dout1_12) AT=490.025n

.meas tran vdout1_13ck970 FIND v(dout1_13) AT=490.025n

.meas tran vdout1_14ck970 FIND v(dout1_14) AT=490.025n

.meas tran vdout1_15ck970 FIND v(dout1_15) AT=490.025n

.meas tran vdout1_16ck970 FIND v(dout1_16) AT=490.025n

.meas tran vdout1_17ck970 FIND v(dout1_17) AT=490.025n

.meas tran vdout1_18ck970 FIND v(dout1_18) AT=490.025n

.meas tran vdout1_19ck970 FIND v(dout1_19) AT=490.025n

.meas tran vdout1_20ck970 FIND v(dout1_20) AT=490.025n

.meas tran vdout1_21ck970 FIND v(dout1_21) AT=490.025n

.meas tran vdout1_22ck970 FIND v(dout1_22) AT=490.025n

.meas tran vdout1_23ck970 FIND v(dout1_23) AT=490.025n

.meas tran vdout1_24ck970 FIND v(dout1_24) AT=490.025n

.meas tran vdout1_25ck970 FIND v(dout1_25) AT=490.025n

.meas tran vdout1_26ck970 FIND v(dout1_26) AT=490.025n

.meas tran vdout1_27ck970 FIND v(dout1_27) AT=490.025n

.meas tran vdout1_28ck970 FIND v(dout1_28) AT=490.025n

.meas tran vdout1_29ck970 FIND v(dout1_29) AT=490.025n

.meas tran vdout1_30ck970 FIND v(dout1_30) AT=490.025n

.meas tran vdout1_31ck970 FIND v(dout1_31) AT=490.025n

.meas tran vdout0_0ck980 FIND v(dout0_0) AT=495.025n

.meas tran vdout0_1ck980 FIND v(dout0_1) AT=495.025n

.meas tran vdout0_2ck980 FIND v(dout0_2) AT=495.025n

.meas tran vdout0_3ck980 FIND v(dout0_3) AT=495.025n

.meas tran vdout0_4ck980 FIND v(dout0_4) AT=495.025n

.meas tran vdout0_5ck980 FIND v(dout0_5) AT=495.025n

.meas tran vdout0_6ck980 FIND v(dout0_6) AT=495.025n

.meas tran vdout0_7ck980 FIND v(dout0_7) AT=495.025n

.meas tran vdout0_8ck980 FIND v(dout0_8) AT=495.025n

.meas tran vdout0_9ck980 FIND v(dout0_9) AT=495.025n

.meas tran vdout0_10ck980 FIND v(dout0_10) AT=495.025n

.meas tran vdout0_11ck980 FIND v(dout0_11) AT=495.025n

.meas tran vdout0_12ck980 FIND v(dout0_12) AT=495.025n

.meas tran vdout0_13ck980 FIND v(dout0_13) AT=495.025n

.meas tran vdout0_14ck980 FIND v(dout0_14) AT=495.025n

.meas tran vdout0_15ck980 FIND v(dout0_15) AT=495.025n

.meas tran vdout0_16ck980 FIND v(dout0_16) AT=495.025n

.meas tran vdout0_17ck980 FIND v(dout0_17) AT=495.025n

.meas tran vdout0_18ck980 FIND v(dout0_18) AT=495.025n

.meas tran vdout0_19ck980 FIND v(dout0_19) AT=495.025n

.meas tran vdout0_20ck980 FIND v(dout0_20) AT=495.025n

.meas tran vdout0_21ck980 FIND v(dout0_21) AT=495.025n

.meas tran vdout0_22ck980 FIND v(dout0_22) AT=495.025n

.meas tran vdout0_23ck980 FIND v(dout0_23) AT=495.025n

.meas tran vdout0_24ck980 FIND v(dout0_24) AT=495.025n

.meas tran vdout0_25ck980 FIND v(dout0_25) AT=495.025n

.meas tran vdout0_26ck980 FIND v(dout0_26) AT=495.025n

.meas tran vdout0_27ck980 FIND v(dout0_27) AT=495.025n

.meas tran vdout0_28ck980 FIND v(dout0_28) AT=495.025n

.meas tran vdout0_29ck980 FIND v(dout0_29) AT=495.025n

.meas tran vdout0_30ck980 FIND v(dout0_30) AT=495.025n

.meas tran vdout0_31ck980 FIND v(dout0_31) AT=495.025n

.meas tran vdout1_0ck980 FIND v(dout1_0) AT=495.025n

.meas tran vdout1_1ck980 FIND v(dout1_1) AT=495.025n

.meas tran vdout1_2ck980 FIND v(dout1_2) AT=495.025n

.meas tran vdout1_3ck980 FIND v(dout1_3) AT=495.025n

.meas tran vdout1_4ck980 FIND v(dout1_4) AT=495.025n

.meas tran vdout1_5ck980 FIND v(dout1_5) AT=495.025n

.meas tran vdout1_6ck980 FIND v(dout1_6) AT=495.025n

.meas tran vdout1_7ck980 FIND v(dout1_7) AT=495.025n

.meas tran vdout1_8ck980 FIND v(dout1_8) AT=495.025n

.meas tran vdout1_9ck980 FIND v(dout1_9) AT=495.025n

.meas tran vdout1_10ck980 FIND v(dout1_10) AT=495.025n

.meas tran vdout1_11ck980 FIND v(dout1_11) AT=495.025n

.meas tran vdout1_12ck980 FIND v(dout1_12) AT=495.025n

.meas tran vdout1_13ck980 FIND v(dout1_13) AT=495.025n

.meas tran vdout1_14ck980 FIND v(dout1_14) AT=495.025n

.meas tran vdout1_15ck980 FIND v(dout1_15) AT=495.025n

.meas tran vdout1_16ck980 FIND v(dout1_16) AT=495.025n

.meas tran vdout1_17ck980 FIND v(dout1_17) AT=495.025n

.meas tran vdout1_18ck980 FIND v(dout1_18) AT=495.025n

.meas tran vdout1_19ck980 FIND v(dout1_19) AT=495.025n

.meas tran vdout1_20ck980 FIND v(dout1_20) AT=495.025n

.meas tran vdout1_21ck980 FIND v(dout1_21) AT=495.025n

.meas tran vdout1_22ck980 FIND v(dout1_22) AT=495.025n

.meas tran vdout1_23ck980 FIND v(dout1_23) AT=495.025n

.meas tran vdout1_24ck980 FIND v(dout1_24) AT=495.025n

.meas tran vdout1_25ck980 FIND v(dout1_25) AT=495.025n

.meas tran vdout1_26ck980 FIND v(dout1_26) AT=495.025n

.meas tran vdout1_27ck980 FIND v(dout1_27) AT=495.025n

.meas tran vdout1_28ck980 FIND v(dout1_28) AT=495.025n

.meas tran vdout1_29ck980 FIND v(dout1_29) AT=495.025n

.meas tran vdout1_30ck980 FIND v(dout1_30) AT=495.025n

.meas tran vdout1_31ck980 FIND v(dout1_31) AT=495.025n

.meas tran vdout1_0ck990 FIND v(dout1_0) AT=500.025n

.meas tran vdout1_1ck990 FIND v(dout1_1) AT=500.025n

.meas tran vdout1_2ck990 FIND v(dout1_2) AT=500.025n

.meas tran vdout1_3ck990 FIND v(dout1_3) AT=500.025n

.meas tran vdout1_4ck990 FIND v(dout1_4) AT=500.025n

.meas tran vdout1_5ck990 FIND v(dout1_5) AT=500.025n

.meas tran vdout1_6ck990 FIND v(dout1_6) AT=500.025n

.meas tran vdout1_7ck990 FIND v(dout1_7) AT=500.025n

.meas tran vdout1_8ck990 FIND v(dout1_8) AT=500.025n

.meas tran vdout1_9ck990 FIND v(dout1_9) AT=500.025n

.meas tran vdout1_10ck990 FIND v(dout1_10) AT=500.025n

.meas tran vdout1_11ck990 FIND v(dout1_11) AT=500.025n

.meas tran vdout1_12ck990 FIND v(dout1_12) AT=500.025n

.meas tran vdout1_13ck990 FIND v(dout1_13) AT=500.025n

.meas tran vdout1_14ck990 FIND v(dout1_14) AT=500.025n

.meas tran vdout1_15ck990 FIND v(dout1_15) AT=500.025n

.meas tran vdout1_16ck990 FIND v(dout1_16) AT=500.025n

.meas tran vdout1_17ck990 FIND v(dout1_17) AT=500.025n

.meas tran vdout1_18ck990 FIND v(dout1_18) AT=500.025n

.meas tran vdout1_19ck990 FIND v(dout1_19) AT=500.025n

.meas tran vdout1_20ck990 FIND v(dout1_20) AT=500.025n

.meas tran vdout1_21ck990 FIND v(dout1_21) AT=500.025n

.meas tran vdout1_22ck990 FIND v(dout1_22) AT=500.025n

.meas tran vdout1_23ck990 FIND v(dout1_23) AT=500.025n

.meas tran vdout1_24ck990 FIND v(dout1_24) AT=500.025n

.meas tran vdout1_25ck990 FIND v(dout1_25) AT=500.025n

.meas tran vdout1_26ck990 FIND v(dout1_26) AT=500.025n

.meas tran vdout1_27ck990 FIND v(dout1_27) AT=500.025n

.meas tran vdout1_28ck990 FIND v(dout1_28) AT=500.025n

.meas tran vdout1_29ck990 FIND v(dout1_29) AT=500.025n

.meas tran vdout1_30ck990 FIND v(dout1_30) AT=500.025n

.meas tran vdout1_31ck990 FIND v(dout1_31) AT=500.025n

.meas tran vdout0_0ck1000 FIND v(dout0_0) AT=505.025n

.meas tran vdout0_1ck1000 FIND v(dout0_1) AT=505.025n

.meas tran vdout0_2ck1000 FIND v(dout0_2) AT=505.025n

.meas tran vdout0_3ck1000 FIND v(dout0_3) AT=505.025n

.meas tran vdout0_4ck1000 FIND v(dout0_4) AT=505.025n

.meas tran vdout0_5ck1000 FIND v(dout0_5) AT=505.025n

.meas tran vdout0_6ck1000 FIND v(dout0_6) AT=505.025n

.meas tran vdout0_7ck1000 FIND v(dout0_7) AT=505.025n

.meas tran vdout0_8ck1000 FIND v(dout0_8) AT=505.025n

.meas tran vdout0_9ck1000 FIND v(dout0_9) AT=505.025n

.meas tran vdout0_10ck1000 FIND v(dout0_10) AT=505.025n

.meas tran vdout0_11ck1000 FIND v(dout0_11) AT=505.025n

.meas tran vdout0_12ck1000 FIND v(dout0_12) AT=505.025n

.meas tran vdout0_13ck1000 FIND v(dout0_13) AT=505.025n

.meas tran vdout0_14ck1000 FIND v(dout0_14) AT=505.025n

.meas tran vdout0_15ck1000 FIND v(dout0_15) AT=505.025n

.meas tran vdout0_16ck1000 FIND v(dout0_16) AT=505.025n

.meas tran vdout0_17ck1000 FIND v(dout0_17) AT=505.025n

.meas tran vdout0_18ck1000 FIND v(dout0_18) AT=505.025n

.meas tran vdout0_19ck1000 FIND v(dout0_19) AT=505.025n

.meas tran vdout0_20ck1000 FIND v(dout0_20) AT=505.025n

.meas tran vdout0_21ck1000 FIND v(dout0_21) AT=505.025n

.meas tran vdout0_22ck1000 FIND v(dout0_22) AT=505.025n

.meas tran vdout0_23ck1000 FIND v(dout0_23) AT=505.025n

.meas tran vdout0_24ck1000 FIND v(dout0_24) AT=505.025n

.meas tran vdout0_25ck1000 FIND v(dout0_25) AT=505.025n

.meas tran vdout0_26ck1000 FIND v(dout0_26) AT=505.025n

.meas tran vdout0_27ck1000 FIND v(dout0_27) AT=505.025n

.meas tran vdout0_28ck1000 FIND v(dout0_28) AT=505.025n

.meas tran vdout0_29ck1000 FIND v(dout0_29) AT=505.025n

.meas tran vdout0_30ck1000 FIND v(dout0_30) AT=505.025n

.meas tran vdout0_31ck1000 FIND v(dout0_31) AT=505.025n

.meas tran vdout0_0ck1010 FIND v(dout0_0) AT=510.025n

.meas tran vdout0_1ck1010 FIND v(dout0_1) AT=510.025n

.meas tran vdout0_2ck1010 FIND v(dout0_2) AT=510.025n

.meas tran vdout0_3ck1010 FIND v(dout0_3) AT=510.025n

.meas tran vdout0_4ck1010 FIND v(dout0_4) AT=510.025n

.meas tran vdout0_5ck1010 FIND v(dout0_5) AT=510.025n

.meas tran vdout0_6ck1010 FIND v(dout0_6) AT=510.025n

.meas tran vdout0_7ck1010 FIND v(dout0_7) AT=510.025n

.meas tran vdout0_8ck1010 FIND v(dout0_8) AT=510.025n

.meas tran vdout0_9ck1010 FIND v(dout0_9) AT=510.025n

.meas tran vdout0_10ck1010 FIND v(dout0_10) AT=510.025n

.meas tran vdout0_11ck1010 FIND v(dout0_11) AT=510.025n

.meas tran vdout0_12ck1010 FIND v(dout0_12) AT=510.025n

.meas tran vdout0_13ck1010 FIND v(dout0_13) AT=510.025n

.meas tran vdout0_14ck1010 FIND v(dout0_14) AT=510.025n

.meas tran vdout0_15ck1010 FIND v(dout0_15) AT=510.025n

.meas tran vdout0_16ck1010 FIND v(dout0_16) AT=510.025n

.meas tran vdout0_17ck1010 FIND v(dout0_17) AT=510.025n

.meas tran vdout0_18ck1010 FIND v(dout0_18) AT=510.025n

.meas tran vdout0_19ck1010 FIND v(dout0_19) AT=510.025n

.meas tran vdout0_20ck1010 FIND v(dout0_20) AT=510.025n

.meas tran vdout0_21ck1010 FIND v(dout0_21) AT=510.025n

.meas tran vdout0_22ck1010 FIND v(dout0_22) AT=510.025n

.meas tran vdout0_23ck1010 FIND v(dout0_23) AT=510.025n

.meas tran vdout0_24ck1010 FIND v(dout0_24) AT=510.025n

.meas tran vdout0_25ck1010 FIND v(dout0_25) AT=510.025n

.meas tran vdout0_26ck1010 FIND v(dout0_26) AT=510.025n

.meas tran vdout0_27ck1010 FIND v(dout0_27) AT=510.025n

.meas tran vdout0_28ck1010 FIND v(dout0_28) AT=510.025n

.meas tran vdout0_29ck1010 FIND v(dout0_29) AT=510.025n

.meas tran vdout0_30ck1010 FIND v(dout0_30) AT=510.025n

.meas tran vdout0_31ck1010 FIND v(dout0_31) AT=510.025n

.meas tran vdout0_0ck1030 FIND v(dout0_0) AT=520.025n

.meas tran vdout0_1ck1030 FIND v(dout0_1) AT=520.025n

.meas tran vdout0_2ck1030 FIND v(dout0_2) AT=520.025n

.meas tran vdout0_3ck1030 FIND v(dout0_3) AT=520.025n

.meas tran vdout0_4ck1030 FIND v(dout0_4) AT=520.025n

.meas tran vdout0_5ck1030 FIND v(dout0_5) AT=520.025n

.meas tran vdout0_6ck1030 FIND v(dout0_6) AT=520.025n

.meas tran vdout0_7ck1030 FIND v(dout0_7) AT=520.025n

.meas tran vdout0_8ck1030 FIND v(dout0_8) AT=520.025n

.meas tran vdout0_9ck1030 FIND v(dout0_9) AT=520.025n

.meas tran vdout0_10ck1030 FIND v(dout0_10) AT=520.025n

.meas tran vdout0_11ck1030 FIND v(dout0_11) AT=520.025n

.meas tran vdout0_12ck1030 FIND v(dout0_12) AT=520.025n

.meas tran vdout0_13ck1030 FIND v(dout0_13) AT=520.025n

.meas tran vdout0_14ck1030 FIND v(dout0_14) AT=520.025n

.meas tran vdout0_15ck1030 FIND v(dout0_15) AT=520.025n

.meas tran vdout0_16ck1030 FIND v(dout0_16) AT=520.025n

.meas tran vdout0_17ck1030 FIND v(dout0_17) AT=520.025n

.meas tran vdout0_18ck1030 FIND v(dout0_18) AT=520.025n

.meas tran vdout0_19ck1030 FIND v(dout0_19) AT=520.025n

.meas tran vdout0_20ck1030 FIND v(dout0_20) AT=520.025n

.meas tran vdout0_21ck1030 FIND v(dout0_21) AT=520.025n

.meas tran vdout0_22ck1030 FIND v(dout0_22) AT=520.025n

.meas tran vdout0_23ck1030 FIND v(dout0_23) AT=520.025n

.meas tran vdout0_24ck1030 FIND v(dout0_24) AT=520.025n

.meas tran vdout0_25ck1030 FIND v(dout0_25) AT=520.025n

.meas tran vdout0_26ck1030 FIND v(dout0_26) AT=520.025n

.meas tran vdout0_27ck1030 FIND v(dout0_27) AT=520.025n

.meas tran vdout0_28ck1030 FIND v(dout0_28) AT=520.025n

.meas tran vdout0_29ck1030 FIND v(dout0_29) AT=520.025n

.meas tran vdout0_30ck1030 FIND v(dout0_30) AT=520.025n

.meas tran vdout0_31ck1030 FIND v(dout0_31) AT=520.025n

.meas tran vdout1_0ck1030 FIND v(dout1_0) AT=520.025n

.meas tran vdout1_1ck1030 FIND v(dout1_1) AT=520.025n

.meas tran vdout1_2ck1030 FIND v(dout1_2) AT=520.025n

.meas tran vdout1_3ck1030 FIND v(dout1_3) AT=520.025n

.meas tran vdout1_4ck1030 FIND v(dout1_4) AT=520.025n

.meas tran vdout1_5ck1030 FIND v(dout1_5) AT=520.025n

.meas tran vdout1_6ck1030 FIND v(dout1_6) AT=520.025n

.meas tran vdout1_7ck1030 FIND v(dout1_7) AT=520.025n

.meas tran vdout1_8ck1030 FIND v(dout1_8) AT=520.025n

.meas tran vdout1_9ck1030 FIND v(dout1_9) AT=520.025n

.meas tran vdout1_10ck1030 FIND v(dout1_10) AT=520.025n

.meas tran vdout1_11ck1030 FIND v(dout1_11) AT=520.025n

.meas tran vdout1_12ck1030 FIND v(dout1_12) AT=520.025n

.meas tran vdout1_13ck1030 FIND v(dout1_13) AT=520.025n

.meas tran vdout1_14ck1030 FIND v(dout1_14) AT=520.025n

.meas tran vdout1_15ck1030 FIND v(dout1_15) AT=520.025n

.meas tran vdout1_16ck1030 FIND v(dout1_16) AT=520.025n

.meas tran vdout1_17ck1030 FIND v(dout1_17) AT=520.025n

.meas tran vdout1_18ck1030 FIND v(dout1_18) AT=520.025n

.meas tran vdout1_19ck1030 FIND v(dout1_19) AT=520.025n

.meas tran vdout1_20ck1030 FIND v(dout1_20) AT=520.025n

.meas tran vdout1_21ck1030 FIND v(dout1_21) AT=520.025n

.meas tran vdout1_22ck1030 FIND v(dout1_22) AT=520.025n

.meas tran vdout1_23ck1030 FIND v(dout1_23) AT=520.025n

.meas tran vdout1_24ck1030 FIND v(dout1_24) AT=520.025n

.meas tran vdout1_25ck1030 FIND v(dout1_25) AT=520.025n

.meas tran vdout1_26ck1030 FIND v(dout1_26) AT=520.025n

.meas tran vdout1_27ck1030 FIND v(dout1_27) AT=520.025n

.meas tran vdout1_28ck1030 FIND v(dout1_28) AT=520.025n

.meas tran vdout1_29ck1030 FIND v(dout1_29) AT=520.025n

.meas tran vdout1_30ck1030 FIND v(dout1_30) AT=520.025n

.meas tran vdout1_31ck1030 FIND v(dout1_31) AT=520.025n

.meas tran vdout1_0ck1040 FIND v(dout1_0) AT=525.025n

.meas tran vdout1_1ck1040 FIND v(dout1_1) AT=525.025n

.meas tran vdout1_2ck1040 FIND v(dout1_2) AT=525.025n

.meas tran vdout1_3ck1040 FIND v(dout1_3) AT=525.025n

.meas tran vdout1_4ck1040 FIND v(dout1_4) AT=525.025n

.meas tran vdout1_5ck1040 FIND v(dout1_5) AT=525.025n

.meas tran vdout1_6ck1040 FIND v(dout1_6) AT=525.025n

.meas tran vdout1_7ck1040 FIND v(dout1_7) AT=525.025n

.meas tran vdout1_8ck1040 FIND v(dout1_8) AT=525.025n

.meas tran vdout1_9ck1040 FIND v(dout1_9) AT=525.025n

.meas tran vdout1_10ck1040 FIND v(dout1_10) AT=525.025n

.meas tran vdout1_11ck1040 FIND v(dout1_11) AT=525.025n

.meas tran vdout1_12ck1040 FIND v(dout1_12) AT=525.025n

.meas tran vdout1_13ck1040 FIND v(dout1_13) AT=525.025n

.meas tran vdout1_14ck1040 FIND v(dout1_14) AT=525.025n

.meas tran vdout1_15ck1040 FIND v(dout1_15) AT=525.025n

.meas tran vdout1_16ck1040 FIND v(dout1_16) AT=525.025n

.meas tran vdout1_17ck1040 FIND v(dout1_17) AT=525.025n

.meas tran vdout1_18ck1040 FIND v(dout1_18) AT=525.025n

.meas tran vdout1_19ck1040 FIND v(dout1_19) AT=525.025n

.meas tran vdout1_20ck1040 FIND v(dout1_20) AT=525.025n

.meas tran vdout1_21ck1040 FIND v(dout1_21) AT=525.025n

.meas tran vdout1_22ck1040 FIND v(dout1_22) AT=525.025n

.meas tran vdout1_23ck1040 FIND v(dout1_23) AT=525.025n

.meas tran vdout1_24ck1040 FIND v(dout1_24) AT=525.025n

.meas tran vdout1_25ck1040 FIND v(dout1_25) AT=525.025n

.meas tran vdout1_26ck1040 FIND v(dout1_26) AT=525.025n

.meas tran vdout1_27ck1040 FIND v(dout1_27) AT=525.025n

.meas tran vdout1_28ck1040 FIND v(dout1_28) AT=525.025n

.meas tran vdout1_29ck1040 FIND v(dout1_29) AT=525.025n

.meas tran vdout1_30ck1040 FIND v(dout1_30) AT=525.025n

.meas tran vdout1_31ck1040 FIND v(dout1_31) AT=525.025n

.meas tran vdout0_0ck1050 FIND v(dout0_0) AT=530.025n

.meas tran vdout0_1ck1050 FIND v(dout0_1) AT=530.025n

.meas tran vdout0_2ck1050 FIND v(dout0_2) AT=530.025n

.meas tran vdout0_3ck1050 FIND v(dout0_3) AT=530.025n

.meas tran vdout0_4ck1050 FIND v(dout0_4) AT=530.025n

.meas tran vdout0_5ck1050 FIND v(dout0_5) AT=530.025n

.meas tran vdout0_6ck1050 FIND v(dout0_6) AT=530.025n

.meas tran vdout0_7ck1050 FIND v(dout0_7) AT=530.025n

.meas tran vdout0_8ck1050 FIND v(dout0_8) AT=530.025n

.meas tran vdout0_9ck1050 FIND v(dout0_9) AT=530.025n

.meas tran vdout0_10ck1050 FIND v(dout0_10) AT=530.025n

.meas tran vdout0_11ck1050 FIND v(dout0_11) AT=530.025n

.meas tran vdout0_12ck1050 FIND v(dout0_12) AT=530.025n

.meas tran vdout0_13ck1050 FIND v(dout0_13) AT=530.025n

.meas tran vdout0_14ck1050 FIND v(dout0_14) AT=530.025n

.meas tran vdout0_15ck1050 FIND v(dout0_15) AT=530.025n

.meas tran vdout0_16ck1050 FIND v(dout0_16) AT=530.025n

.meas tran vdout0_17ck1050 FIND v(dout0_17) AT=530.025n

.meas tran vdout0_18ck1050 FIND v(dout0_18) AT=530.025n

.meas tran vdout0_19ck1050 FIND v(dout0_19) AT=530.025n

.meas tran vdout0_20ck1050 FIND v(dout0_20) AT=530.025n

.meas tran vdout0_21ck1050 FIND v(dout0_21) AT=530.025n

.meas tran vdout0_22ck1050 FIND v(dout0_22) AT=530.025n

.meas tran vdout0_23ck1050 FIND v(dout0_23) AT=530.025n

.meas tran vdout0_24ck1050 FIND v(dout0_24) AT=530.025n

.meas tran vdout0_25ck1050 FIND v(dout0_25) AT=530.025n

.meas tran vdout0_26ck1050 FIND v(dout0_26) AT=530.025n

.meas tran vdout0_27ck1050 FIND v(dout0_27) AT=530.025n

.meas tran vdout0_28ck1050 FIND v(dout0_28) AT=530.025n

.meas tran vdout0_29ck1050 FIND v(dout0_29) AT=530.025n

.meas tran vdout0_30ck1050 FIND v(dout0_30) AT=530.025n

.meas tran vdout0_31ck1050 FIND v(dout0_31) AT=530.025n

.meas tran vdout0_0ck1060 FIND v(dout0_0) AT=535.025n

.meas tran vdout0_1ck1060 FIND v(dout0_1) AT=535.025n

.meas tran vdout0_2ck1060 FIND v(dout0_2) AT=535.025n

.meas tran vdout0_3ck1060 FIND v(dout0_3) AT=535.025n

.meas tran vdout0_4ck1060 FIND v(dout0_4) AT=535.025n

.meas tran vdout0_5ck1060 FIND v(dout0_5) AT=535.025n

.meas tran vdout0_6ck1060 FIND v(dout0_6) AT=535.025n

.meas tran vdout0_7ck1060 FIND v(dout0_7) AT=535.025n

.meas tran vdout0_8ck1060 FIND v(dout0_8) AT=535.025n

.meas tran vdout0_9ck1060 FIND v(dout0_9) AT=535.025n

.meas tran vdout0_10ck1060 FIND v(dout0_10) AT=535.025n

.meas tran vdout0_11ck1060 FIND v(dout0_11) AT=535.025n

.meas tran vdout0_12ck1060 FIND v(dout0_12) AT=535.025n

.meas tran vdout0_13ck1060 FIND v(dout0_13) AT=535.025n

.meas tran vdout0_14ck1060 FIND v(dout0_14) AT=535.025n

.meas tran vdout0_15ck1060 FIND v(dout0_15) AT=535.025n

.meas tran vdout0_16ck1060 FIND v(dout0_16) AT=535.025n

.meas tran vdout0_17ck1060 FIND v(dout0_17) AT=535.025n

.meas tran vdout0_18ck1060 FIND v(dout0_18) AT=535.025n

.meas tran vdout0_19ck1060 FIND v(dout0_19) AT=535.025n

.meas tran vdout0_20ck1060 FIND v(dout0_20) AT=535.025n

.meas tran vdout0_21ck1060 FIND v(dout0_21) AT=535.025n

.meas tran vdout0_22ck1060 FIND v(dout0_22) AT=535.025n

.meas tran vdout0_23ck1060 FIND v(dout0_23) AT=535.025n

.meas tran vdout0_24ck1060 FIND v(dout0_24) AT=535.025n

.meas tran vdout0_25ck1060 FIND v(dout0_25) AT=535.025n

.meas tran vdout0_26ck1060 FIND v(dout0_26) AT=535.025n

.meas tran vdout0_27ck1060 FIND v(dout0_27) AT=535.025n

.meas tran vdout0_28ck1060 FIND v(dout0_28) AT=535.025n

.meas tran vdout0_29ck1060 FIND v(dout0_29) AT=535.025n

.meas tran vdout0_30ck1060 FIND v(dout0_30) AT=535.025n

.meas tran vdout0_31ck1060 FIND v(dout0_31) AT=535.025n

.meas tran vdout1_0ck1060 FIND v(dout1_0) AT=535.025n

.meas tran vdout1_1ck1060 FIND v(dout1_1) AT=535.025n

.meas tran vdout1_2ck1060 FIND v(dout1_2) AT=535.025n

.meas tran vdout1_3ck1060 FIND v(dout1_3) AT=535.025n

.meas tran vdout1_4ck1060 FIND v(dout1_4) AT=535.025n

.meas tran vdout1_5ck1060 FIND v(dout1_5) AT=535.025n

.meas tran vdout1_6ck1060 FIND v(dout1_6) AT=535.025n

.meas tran vdout1_7ck1060 FIND v(dout1_7) AT=535.025n

.meas tran vdout1_8ck1060 FIND v(dout1_8) AT=535.025n

.meas tran vdout1_9ck1060 FIND v(dout1_9) AT=535.025n

.meas tran vdout1_10ck1060 FIND v(dout1_10) AT=535.025n

.meas tran vdout1_11ck1060 FIND v(dout1_11) AT=535.025n

.meas tran vdout1_12ck1060 FIND v(dout1_12) AT=535.025n

.meas tran vdout1_13ck1060 FIND v(dout1_13) AT=535.025n

.meas tran vdout1_14ck1060 FIND v(dout1_14) AT=535.025n

.meas tran vdout1_15ck1060 FIND v(dout1_15) AT=535.025n

.meas tran vdout1_16ck1060 FIND v(dout1_16) AT=535.025n

.meas tran vdout1_17ck1060 FIND v(dout1_17) AT=535.025n

.meas tran vdout1_18ck1060 FIND v(dout1_18) AT=535.025n

.meas tran vdout1_19ck1060 FIND v(dout1_19) AT=535.025n

.meas tran vdout1_20ck1060 FIND v(dout1_20) AT=535.025n

.meas tran vdout1_21ck1060 FIND v(dout1_21) AT=535.025n

.meas tran vdout1_22ck1060 FIND v(dout1_22) AT=535.025n

.meas tran vdout1_23ck1060 FIND v(dout1_23) AT=535.025n

.meas tran vdout1_24ck1060 FIND v(dout1_24) AT=535.025n

.meas tran vdout1_25ck1060 FIND v(dout1_25) AT=535.025n

.meas tran vdout1_26ck1060 FIND v(dout1_26) AT=535.025n

.meas tran vdout1_27ck1060 FIND v(dout1_27) AT=535.025n

.meas tran vdout1_28ck1060 FIND v(dout1_28) AT=535.025n

.meas tran vdout1_29ck1060 FIND v(dout1_29) AT=535.025n

.meas tran vdout1_30ck1060 FIND v(dout1_30) AT=535.025n

.meas tran vdout1_31ck1060 FIND v(dout1_31) AT=535.025n

.meas tran vdout0_0ck1070 FIND v(dout0_0) AT=540.025n

.meas tran vdout0_1ck1070 FIND v(dout0_1) AT=540.025n

.meas tran vdout0_2ck1070 FIND v(dout0_2) AT=540.025n

.meas tran vdout0_3ck1070 FIND v(dout0_3) AT=540.025n

.meas tran vdout0_4ck1070 FIND v(dout0_4) AT=540.025n

.meas tran vdout0_5ck1070 FIND v(dout0_5) AT=540.025n

.meas tran vdout0_6ck1070 FIND v(dout0_6) AT=540.025n

.meas tran vdout0_7ck1070 FIND v(dout0_7) AT=540.025n

.meas tran vdout0_8ck1070 FIND v(dout0_8) AT=540.025n

.meas tran vdout0_9ck1070 FIND v(dout0_9) AT=540.025n

.meas tran vdout0_10ck1070 FIND v(dout0_10) AT=540.025n

.meas tran vdout0_11ck1070 FIND v(dout0_11) AT=540.025n

.meas tran vdout0_12ck1070 FIND v(dout0_12) AT=540.025n

.meas tran vdout0_13ck1070 FIND v(dout0_13) AT=540.025n

.meas tran vdout0_14ck1070 FIND v(dout0_14) AT=540.025n

.meas tran vdout0_15ck1070 FIND v(dout0_15) AT=540.025n

.meas tran vdout0_16ck1070 FIND v(dout0_16) AT=540.025n

.meas tran vdout0_17ck1070 FIND v(dout0_17) AT=540.025n

.meas tran vdout0_18ck1070 FIND v(dout0_18) AT=540.025n

.meas tran vdout0_19ck1070 FIND v(dout0_19) AT=540.025n

.meas tran vdout0_20ck1070 FIND v(dout0_20) AT=540.025n

.meas tran vdout0_21ck1070 FIND v(dout0_21) AT=540.025n

.meas tran vdout0_22ck1070 FIND v(dout0_22) AT=540.025n

.meas tran vdout0_23ck1070 FIND v(dout0_23) AT=540.025n

.meas tran vdout0_24ck1070 FIND v(dout0_24) AT=540.025n

.meas tran vdout0_25ck1070 FIND v(dout0_25) AT=540.025n

.meas tran vdout0_26ck1070 FIND v(dout0_26) AT=540.025n

.meas tran vdout0_27ck1070 FIND v(dout0_27) AT=540.025n

.meas tran vdout0_28ck1070 FIND v(dout0_28) AT=540.025n

.meas tran vdout0_29ck1070 FIND v(dout0_29) AT=540.025n

.meas tran vdout0_30ck1070 FIND v(dout0_30) AT=540.025n

.meas tran vdout0_31ck1070 FIND v(dout0_31) AT=540.025n

.meas tran vdout0_0ck1080 FIND v(dout0_0) AT=545.025n

.meas tran vdout0_1ck1080 FIND v(dout0_1) AT=545.025n

.meas tran vdout0_2ck1080 FIND v(dout0_2) AT=545.025n

.meas tran vdout0_3ck1080 FIND v(dout0_3) AT=545.025n

.meas tran vdout0_4ck1080 FIND v(dout0_4) AT=545.025n

.meas tran vdout0_5ck1080 FIND v(dout0_5) AT=545.025n

.meas tran vdout0_6ck1080 FIND v(dout0_6) AT=545.025n

.meas tran vdout0_7ck1080 FIND v(dout0_7) AT=545.025n

.meas tran vdout0_8ck1080 FIND v(dout0_8) AT=545.025n

.meas tran vdout0_9ck1080 FIND v(dout0_9) AT=545.025n

.meas tran vdout0_10ck1080 FIND v(dout0_10) AT=545.025n

.meas tran vdout0_11ck1080 FIND v(dout0_11) AT=545.025n

.meas tran vdout0_12ck1080 FIND v(dout0_12) AT=545.025n

.meas tran vdout0_13ck1080 FIND v(dout0_13) AT=545.025n

.meas tran vdout0_14ck1080 FIND v(dout0_14) AT=545.025n

.meas tran vdout0_15ck1080 FIND v(dout0_15) AT=545.025n

.meas tran vdout0_16ck1080 FIND v(dout0_16) AT=545.025n

.meas tran vdout0_17ck1080 FIND v(dout0_17) AT=545.025n

.meas tran vdout0_18ck1080 FIND v(dout0_18) AT=545.025n

.meas tran vdout0_19ck1080 FIND v(dout0_19) AT=545.025n

.meas tran vdout0_20ck1080 FIND v(dout0_20) AT=545.025n

.meas tran vdout0_21ck1080 FIND v(dout0_21) AT=545.025n

.meas tran vdout0_22ck1080 FIND v(dout0_22) AT=545.025n

.meas tran vdout0_23ck1080 FIND v(dout0_23) AT=545.025n

.meas tran vdout0_24ck1080 FIND v(dout0_24) AT=545.025n

.meas tran vdout0_25ck1080 FIND v(dout0_25) AT=545.025n

.meas tran vdout0_26ck1080 FIND v(dout0_26) AT=545.025n

.meas tran vdout0_27ck1080 FIND v(dout0_27) AT=545.025n

.meas tran vdout0_28ck1080 FIND v(dout0_28) AT=545.025n

.meas tran vdout0_29ck1080 FIND v(dout0_29) AT=545.025n

.meas tran vdout0_30ck1080 FIND v(dout0_30) AT=545.025n

.meas tran vdout0_31ck1080 FIND v(dout0_31) AT=545.025n

.meas tran vdout0_0ck1100 FIND v(dout0_0) AT=555.025n

.meas tran vdout0_1ck1100 FIND v(dout0_1) AT=555.025n

.meas tran vdout0_2ck1100 FIND v(dout0_2) AT=555.025n

.meas tran vdout0_3ck1100 FIND v(dout0_3) AT=555.025n

.meas tran vdout0_4ck1100 FIND v(dout0_4) AT=555.025n

.meas tran vdout0_5ck1100 FIND v(dout0_5) AT=555.025n

.meas tran vdout0_6ck1100 FIND v(dout0_6) AT=555.025n

.meas tran vdout0_7ck1100 FIND v(dout0_7) AT=555.025n

.meas tran vdout0_8ck1100 FIND v(dout0_8) AT=555.025n

.meas tran vdout0_9ck1100 FIND v(dout0_9) AT=555.025n

.meas tran vdout0_10ck1100 FIND v(dout0_10) AT=555.025n

.meas tran vdout0_11ck1100 FIND v(dout0_11) AT=555.025n

.meas tran vdout0_12ck1100 FIND v(dout0_12) AT=555.025n

.meas tran vdout0_13ck1100 FIND v(dout0_13) AT=555.025n

.meas tran vdout0_14ck1100 FIND v(dout0_14) AT=555.025n

.meas tran vdout0_15ck1100 FIND v(dout0_15) AT=555.025n

.meas tran vdout0_16ck1100 FIND v(dout0_16) AT=555.025n

.meas tran vdout0_17ck1100 FIND v(dout0_17) AT=555.025n

.meas tran vdout0_18ck1100 FIND v(dout0_18) AT=555.025n

.meas tran vdout0_19ck1100 FIND v(dout0_19) AT=555.025n

.meas tran vdout0_20ck1100 FIND v(dout0_20) AT=555.025n

.meas tran vdout0_21ck1100 FIND v(dout0_21) AT=555.025n

.meas tran vdout0_22ck1100 FIND v(dout0_22) AT=555.025n

.meas tran vdout0_23ck1100 FIND v(dout0_23) AT=555.025n

.meas tran vdout0_24ck1100 FIND v(dout0_24) AT=555.025n

.meas tran vdout0_25ck1100 FIND v(dout0_25) AT=555.025n

.meas tran vdout0_26ck1100 FIND v(dout0_26) AT=555.025n

.meas tran vdout0_27ck1100 FIND v(dout0_27) AT=555.025n

.meas tran vdout0_28ck1100 FIND v(dout0_28) AT=555.025n

.meas tran vdout0_29ck1100 FIND v(dout0_29) AT=555.025n

.meas tran vdout0_30ck1100 FIND v(dout0_30) AT=555.025n

.meas tran vdout0_31ck1100 FIND v(dout0_31) AT=555.025n

.meas tran vdout1_0ck1100 FIND v(dout1_0) AT=555.025n

.meas tran vdout1_1ck1100 FIND v(dout1_1) AT=555.025n

.meas tran vdout1_2ck1100 FIND v(dout1_2) AT=555.025n

.meas tran vdout1_3ck1100 FIND v(dout1_3) AT=555.025n

.meas tran vdout1_4ck1100 FIND v(dout1_4) AT=555.025n

.meas tran vdout1_5ck1100 FIND v(dout1_5) AT=555.025n

.meas tran vdout1_6ck1100 FIND v(dout1_6) AT=555.025n

.meas tran vdout1_7ck1100 FIND v(dout1_7) AT=555.025n

.meas tran vdout1_8ck1100 FIND v(dout1_8) AT=555.025n

.meas tran vdout1_9ck1100 FIND v(dout1_9) AT=555.025n

.meas tran vdout1_10ck1100 FIND v(dout1_10) AT=555.025n

.meas tran vdout1_11ck1100 FIND v(dout1_11) AT=555.025n

.meas tran vdout1_12ck1100 FIND v(dout1_12) AT=555.025n

.meas tran vdout1_13ck1100 FIND v(dout1_13) AT=555.025n

.meas tran vdout1_14ck1100 FIND v(dout1_14) AT=555.025n

.meas tran vdout1_15ck1100 FIND v(dout1_15) AT=555.025n

.meas tran vdout1_16ck1100 FIND v(dout1_16) AT=555.025n

.meas tran vdout1_17ck1100 FIND v(dout1_17) AT=555.025n

.meas tran vdout1_18ck1100 FIND v(dout1_18) AT=555.025n

.meas tran vdout1_19ck1100 FIND v(dout1_19) AT=555.025n

.meas tran vdout1_20ck1100 FIND v(dout1_20) AT=555.025n

.meas tran vdout1_21ck1100 FIND v(dout1_21) AT=555.025n

.meas tran vdout1_22ck1100 FIND v(dout1_22) AT=555.025n

.meas tran vdout1_23ck1100 FIND v(dout1_23) AT=555.025n

.meas tran vdout1_24ck1100 FIND v(dout1_24) AT=555.025n

.meas tran vdout1_25ck1100 FIND v(dout1_25) AT=555.025n

.meas tran vdout1_26ck1100 FIND v(dout1_26) AT=555.025n

.meas tran vdout1_27ck1100 FIND v(dout1_27) AT=555.025n

.meas tran vdout1_28ck1100 FIND v(dout1_28) AT=555.025n

.meas tran vdout1_29ck1100 FIND v(dout1_29) AT=555.025n

.meas tran vdout1_30ck1100 FIND v(dout1_30) AT=555.025n

.meas tran vdout1_31ck1100 FIND v(dout1_31) AT=555.025n

.meas tran vdout1_0ck1110 FIND v(dout1_0) AT=560.025n

.meas tran vdout1_1ck1110 FIND v(dout1_1) AT=560.025n

.meas tran vdout1_2ck1110 FIND v(dout1_2) AT=560.025n

.meas tran vdout1_3ck1110 FIND v(dout1_3) AT=560.025n

.meas tran vdout1_4ck1110 FIND v(dout1_4) AT=560.025n

.meas tran vdout1_5ck1110 FIND v(dout1_5) AT=560.025n

.meas tran vdout1_6ck1110 FIND v(dout1_6) AT=560.025n

.meas tran vdout1_7ck1110 FIND v(dout1_7) AT=560.025n

.meas tran vdout1_8ck1110 FIND v(dout1_8) AT=560.025n

.meas tran vdout1_9ck1110 FIND v(dout1_9) AT=560.025n

.meas tran vdout1_10ck1110 FIND v(dout1_10) AT=560.025n

.meas tran vdout1_11ck1110 FIND v(dout1_11) AT=560.025n

.meas tran vdout1_12ck1110 FIND v(dout1_12) AT=560.025n

.meas tran vdout1_13ck1110 FIND v(dout1_13) AT=560.025n

.meas tran vdout1_14ck1110 FIND v(dout1_14) AT=560.025n

.meas tran vdout1_15ck1110 FIND v(dout1_15) AT=560.025n

.meas tran vdout1_16ck1110 FIND v(dout1_16) AT=560.025n

.meas tran vdout1_17ck1110 FIND v(dout1_17) AT=560.025n

.meas tran vdout1_18ck1110 FIND v(dout1_18) AT=560.025n

.meas tran vdout1_19ck1110 FIND v(dout1_19) AT=560.025n

.meas tran vdout1_20ck1110 FIND v(dout1_20) AT=560.025n

.meas tran vdout1_21ck1110 FIND v(dout1_21) AT=560.025n

.meas tran vdout1_22ck1110 FIND v(dout1_22) AT=560.025n

.meas tran vdout1_23ck1110 FIND v(dout1_23) AT=560.025n

.meas tran vdout1_24ck1110 FIND v(dout1_24) AT=560.025n

.meas tran vdout1_25ck1110 FIND v(dout1_25) AT=560.025n

.meas tran vdout1_26ck1110 FIND v(dout1_26) AT=560.025n

.meas tran vdout1_27ck1110 FIND v(dout1_27) AT=560.025n

.meas tran vdout1_28ck1110 FIND v(dout1_28) AT=560.025n

.meas tran vdout1_29ck1110 FIND v(dout1_29) AT=560.025n

.meas tran vdout1_30ck1110 FIND v(dout1_30) AT=560.025n

.meas tran vdout1_31ck1110 FIND v(dout1_31) AT=560.025n

.meas tran vdout1_0ck1120 FIND v(dout1_0) AT=565.025n

.meas tran vdout1_1ck1120 FIND v(dout1_1) AT=565.025n

.meas tran vdout1_2ck1120 FIND v(dout1_2) AT=565.025n

.meas tran vdout1_3ck1120 FIND v(dout1_3) AT=565.025n

.meas tran vdout1_4ck1120 FIND v(dout1_4) AT=565.025n

.meas tran vdout1_5ck1120 FIND v(dout1_5) AT=565.025n

.meas tran vdout1_6ck1120 FIND v(dout1_6) AT=565.025n

.meas tran vdout1_7ck1120 FIND v(dout1_7) AT=565.025n

.meas tran vdout1_8ck1120 FIND v(dout1_8) AT=565.025n

.meas tran vdout1_9ck1120 FIND v(dout1_9) AT=565.025n

.meas tran vdout1_10ck1120 FIND v(dout1_10) AT=565.025n

.meas tran vdout1_11ck1120 FIND v(dout1_11) AT=565.025n

.meas tran vdout1_12ck1120 FIND v(dout1_12) AT=565.025n

.meas tran vdout1_13ck1120 FIND v(dout1_13) AT=565.025n

.meas tran vdout1_14ck1120 FIND v(dout1_14) AT=565.025n

.meas tran vdout1_15ck1120 FIND v(dout1_15) AT=565.025n

.meas tran vdout1_16ck1120 FIND v(dout1_16) AT=565.025n

.meas tran vdout1_17ck1120 FIND v(dout1_17) AT=565.025n

.meas tran vdout1_18ck1120 FIND v(dout1_18) AT=565.025n

.meas tran vdout1_19ck1120 FIND v(dout1_19) AT=565.025n

.meas tran vdout1_20ck1120 FIND v(dout1_20) AT=565.025n

.meas tran vdout1_21ck1120 FIND v(dout1_21) AT=565.025n

.meas tran vdout1_22ck1120 FIND v(dout1_22) AT=565.025n

.meas tran vdout1_23ck1120 FIND v(dout1_23) AT=565.025n

.meas tran vdout1_24ck1120 FIND v(dout1_24) AT=565.025n

.meas tran vdout1_25ck1120 FIND v(dout1_25) AT=565.025n

.meas tran vdout1_26ck1120 FIND v(dout1_26) AT=565.025n

.meas tran vdout1_27ck1120 FIND v(dout1_27) AT=565.025n

.meas tran vdout1_28ck1120 FIND v(dout1_28) AT=565.025n

.meas tran vdout1_29ck1120 FIND v(dout1_29) AT=565.025n

.meas tran vdout1_30ck1120 FIND v(dout1_30) AT=565.025n

.meas tran vdout1_31ck1120 FIND v(dout1_31) AT=565.025n

.meas tran vdout1_0ck1130 FIND v(dout1_0) AT=570.025n

.meas tran vdout1_1ck1130 FIND v(dout1_1) AT=570.025n

.meas tran vdout1_2ck1130 FIND v(dout1_2) AT=570.025n

.meas tran vdout1_3ck1130 FIND v(dout1_3) AT=570.025n

.meas tran vdout1_4ck1130 FIND v(dout1_4) AT=570.025n

.meas tran vdout1_5ck1130 FIND v(dout1_5) AT=570.025n

.meas tran vdout1_6ck1130 FIND v(dout1_6) AT=570.025n

.meas tran vdout1_7ck1130 FIND v(dout1_7) AT=570.025n

.meas tran vdout1_8ck1130 FIND v(dout1_8) AT=570.025n

.meas tran vdout1_9ck1130 FIND v(dout1_9) AT=570.025n

.meas tran vdout1_10ck1130 FIND v(dout1_10) AT=570.025n

.meas tran vdout1_11ck1130 FIND v(dout1_11) AT=570.025n

.meas tran vdout1_12ck1130 FIND v(dout1_12) AT=570.025n

.meas tran vdout1_13ck1130 FIND v(dout1_13) AT=570.025n

.meas tran vdout1_14ck1130 FIND v(dout1_14) AT=570.025n

.meas tran vdout1_15ck1130 FIND v(dout1_15) AT=570.025n

.meas tran vdout1_16ck1130 FIND v(dout1_16) AT=570.025n

.meas tran vdout1_17ck1130 FIND v(dout1_17) AT=570.025n

.meas tran vdout1_18ck1130 FIND v(dout1_18) AT=570.025n

.meas tran vdout1_19ck1130 FIND v(dout1_19) AT=570.025n

.meas tran vdout1_20ck1130 FIND v(dout1_20) AT=570.025n

.meas tran vdout1_21ck1130 FIND v(dout1_21) AT=570.025n

.meas tran vdout1_22ck1130 FIND v(dout1_22) AT=570.025n

.meas tran vdout1_23ck1130 FIND v(dout1_23) AT=570.025n

.meas tran vdout1_24ck1130 FIND v(dout1_24) AT=570.025n

.meas tran vdout1_25ck1130 FIND v(dout1_25) AT=570.025n

.meas tran vdout1_26ck1130 FIND v(dout1_26) AT=570.025n

.meas tran vdout1_27ck1130 FIND v(dout1_27) AT=570.025n

.meas tran vdout1_28ck1130 FIND v(dout1_28) AT=570.025n

.meas tran vdout1_29ck1130 FIND v(dout1_29) AT=570.025n

.meas tran vdout1_30ck1130 FIND v(dout1_30) AT=570.025n

.meas tran vdout1_31ck1130 FIND v(dout1_31) AT=570.025n

.meas tran vdout0_0ck1140 FIND v(dout0_0) AT=575.025n

.meas tran vdout0_1ck1140 FIND v(dout0_1) AT=575.025n

.meas tran vdout0_2ck1140 FIND v(dout0_2) AT=575.025n

.meas tran vdout0_3ck1140 FIND v(dout0_3) AT=575.025n

.meas tran vdout0_4ck1140 FIND v(dout0_4) AT=575.025n

.meas tran vdout0_5ck1140 FIND v(dout0_5) AT=575.025n

.meas tran vdout0_6ck1140 FIND v(dout0_6) AT=575.025n

.meas tran vdout0_7ck1140 FIND v(dout0_7) AT=575.025n

.meas tran vdout0_8ck1140 FIND v(dout0_8) AT=575.025n

.meas tran vdout0_9ck1140 FIND v(dout0_9) AT=575.025n

.meas tran vdout0_10ck1140 FIND v(dout0_10) AT=575.025n

.meas tran vdout0_11ck1140 FIND v(dout0_11) AT=575.025n

.meas tran vdout0_12ck1140 FIND v(dout0_12) AT=575.025n

.meas tran vdout0_13ck1140 FIND v(dout0_13) AT=575.025n

.meas tran vdout0_14ck1140 FIND v(dout0_14) AT=575.025n

.meas tran vdout0_15ck1140 FIND v(dout0_15) AT=575.025n

.meas tran vdout0_16ck1140 FIND v(dout0_16) AT=575.025n

.meas tran vdout0_17ck1140 FIND v(dout0_17) AT=575.025n

.meas tran vdout0_18ck1140 FIND v(dout0_18) AT=575.025n

.meas tran vdout0_19ck1140 FIND v(dout0_19) AT=575.025n

.meas tran vdout0_20ck1140 FIND v(dout0_20) AT=575.025n

.meas tran vdout0_21ck1140 FIND v(dout0_21) AT=575.025n

.meas tran vdout0_22ck1140 FIND v(dout0_22) AT=575.025n

.meas tran vdout0_23ck1140 FIND v(dout0_23) AT=575.025n

.meas tran vdout0_24ck1140 FIND v(dout0_24) AT=575.025n

.meas tran vdout0_25ck1140 FIND v(dout0_25) AT=575.025n

.meas tran vdout0_26ck1140 FIND v(dout0_26) AT=575.025n

.meas tran vdout0_27ck1140 FIND v(dout0_27) AT=575.025n

.meas tran vdout0_28ck1140 FIND v(dout0_28) AT=575.025n

.meas tran vdout0_29ck1140 FIND v(dout0_29) AT=575.025n

.meas tran vdout0_30ck1140 FIND v(dout0_30) AT=575.025n

.meas tran vdout0_31ck1140 FIND v(dout0_31) AT=575.025n

.meas tran vdout0_0ck1150 FIND v(dout0_0) AT=580.025n

.meas tran vdout0_1ck1150 FIND v(dout0_1) AT=580.025n

.meas tran vdout0_2ck1150 FIND v(dout0_2) AT=580.025n

.meas tran vdout0_3ck1150 FIND v(dout0_3) AT=580.025n

.meas tran vdout0_4ck1150 FIND v(dout0_4) AT=580.025n

.meas tran vdout0_5ck1150 FIND v(dout0_5) AT=580.025n

.meas tran vdout0_6ck1150 FIND v(dout0_6) AT=580.025n

.meas tran vdout0_7ck1150 FIND v(dout0_7) AT=580.025n

.meas tran vdout0_8ck1150 FIND v(dout0_8) AT=580.025n

.meas tran vdout0_9ck1150 FIND v(dout0_9) AT=580.025n

.meas tran vdout0_10ck1150 FIND v(dout0_10) AT=580.025n

.meas tran vdout0_11ck1150 FIND v(dout0_11) AT=580.025n

.meas tran vdout0_12ck1150 FIND v(dout0_12) AT=580.025n

.meas tran vdout0_13ck1150 FIND v(dout0_13) AT=580.025n

.meas tran vdout0_14ck1150 FIND v(dout0_14) AT=580.025n

.meas tran vdout0_15ck1150 FIND v(dout0_15) AT=580.025n

.meas tran vdout0_16ck1150 FIND v(dout0_16) AT=580.025n

.meas tran vdout0_17ck1150 FIND v(dout0_17) AT=580.025n

.meas tran vdout0_18ck1150 FIND v(dout0_18) AT=580.025n

.meas tran vdout0_19ck1150 FIND v(dout0_19) AT=580.025n

.meas tran vdout0_20ck1150 FIND v(dout0_20) AT=580.025n

.meas tran vdout0_21ck1150 FIND v(dout0_21) AT=580.025n

.meas tran vdout0_22ck1150 FIND v(dout0_22) AT=580.025n

.meas tran vdout0_23ck1150 FIND v(dout0_23) AT=580.025n

.meas tran vdout0_24ck1150 FIND v(dout0_24) AT=580.025n

.meas tran vdout0_25ck1150 FIND v(dout0_25) AT=580.025n

.meas tran vdout0_26ck1150 FIND v(dout0_26) AT=580.025n

.meas tran vdout0_27ck1150 FIND v(dout0_27) AT=580.025n

.meas tran vdout0_28ck1150 FIND v(dout0_28) AT=580.025n

.meas tran vdout0_29ck1150 FIND v(dout0_29) AT=580.025n

.meas tran vdout0_30ck1150 FIND v(dout0_30) AT=580.025n

.meas tran vdout0_31ck1150 FIND v(dout0_31) AT=580.025n

.meas tran vdout1_0ck1150 FIND v(dout1_0) AT=580.025n

.meas tran vdout1_1ck1150 FIND v(dout1_1) AT=580.025n

.meas tran vdout1_2ck1150 FIND v(dout1_2) AT=580.025n

.meas tran vdout1_3ck1150 FIND v(dout1_3) AT=580.025n

.meas tran vdout1_4ck1150 FIND v(dout1_4) AT=580.025n

.meas tran vdout1_5ck1150 FIND v(dout1_5) AT=580.025n

.meas tran vdout1_6ck1150 FIND v(dout1_6) AT=580.025n

.meas tran vdout1_7ck1150 FIND v(dout1_7) AT=580.025n

.meas tran vdout1_8ck1150 FIND v(dout1_8) AT=580.025n

.meas tran vdout1_9ck1150 FIND v(dout1_9) AT=580.025n

.meas tran vdout1_10ck1150 FIND v(dout1_10) AT=580.025n

.meas tran vdout1_11ck1150 FIND v(dout1_11) AT=580.025n

.meas tran vdout1_12ck1150 FIND v(dout1_12) AT=580.025n

.meas tran vdout1_13ck1150 FIND v(dout1_13) AT=580.025n

.meas tran vdout1_14ck1150 FIND v(dout1_14) AT=580.025n

.meas tran vdout1_15ck1150 FIND v(dout1_15) AT=580.025n

.meas tran vdout1_16ck1150 FIND v(dout1_16) AT=580.025n

.meas tran vdout1_17ck1150 FIND v(dout1_17) AT=580.025n

.meas tran vdout1_18ck1150 FIND v(dout1_18) AT=580.025n

.meas tran vdout1_19ck1150 FIND v(dout1_19) AT=580.025n

.meas tran vdout1_20ck1150 FIND v(dout1_20) AT=580.025n

.meas tran vdout1_21ck1150 FIND v(dout1_21) AT=580.025n

.meas tran vdout1_22ck1150 FIND v(dout1_22) AT=580.025n

.meas tran vdout1_23ck1150 FIND v(dout1_23) AT=580.025n

.meas tran vdout1_24ck1150 FIND v(dout1_24) AT=580.025n

.meas tran vdout1_25ck1150 FIND v(dout1_25) AT=580.025n

.meas tran vdout1_26ck1150 FIND v(dout1_26) AT=580.025n

.meas tran vdout1_27ck1150 FIND v(dout1_27) AT=580.025n

.meas tran vdout1_28ck1150 FIND v(dout1_28) AT=580.025n

.meas tran vdout1_29ck1150 FIND v(dout1_29) AT=580.025n

.meas tran vdout1_30ck1150 FIND v(dout1_30) AT=580.025n

.meas tran vdout1_31ck1150 FIND v(dout1_31) AT=580.025n

.meas tran vdout1_0ck1160 FIND v(dout1_0) AT=585.025n

.meas tran vdout1_1ck1160 FIND v(dout1_1) AT=585.025n

.meas tran vdout1_2ck1160 FIND v(dout1_2) AT=585.025n

.meas tran vdout1_3ck1160 FIND v(dout1_3) AT=585.025n

.meas tran vdout1_4ck1160 FIND v(dout1_4) AT=585.025n

.meas tran vdout1_5ck1160 FIND v(dout1_5) AT=585.025n

.meas tran vdout1_6ck1160 FIND v(dout1_6) AT=585.025n

.meas tran vdout1_7ck1160 FIND v(dout1_7) AT=585.025n

.meas tran vdout1_8ck1160 FIND v(dout1_8) AT=585.025n

.meas tran vdout1_9ck1160 FIND v(dout1_9) AT=585.025n

.meas tran vdout1_10ck1160 FIND v(dout1_10) AT=585.025n

.meas tran vdout1_11ck1160 FIND v(dout1_11) AT=585.025n

.meas tran vdout1_12ck1160 FIND v(dout1_12) AT=585.025n

.meas tran vdout1_13ck1160 FIND v(dout1_13) AT=585.025n

.meas tran vdout1_14ck1160 FIND v(dout1_14) AT=585.025n

.meas tran vdout1_15ck1160 FIND v(dout1_15) AT=585.025n

.meas tran vdout1_16ck1160 FIND v(dout1_16) AT=585.025n

.meas tran vdout1_17ck1160 FIND v(dout1_17) AT=585.025n

.meas tran vdout1_18ck1160 FIND v(dout1_18) AT=585.025n

.meas tran vdout1_19ck1160 FIND v(dout1_19) AT=585.025n

.meas tran vdout1_20ck1160 FIND v(dout1_20) AT=585.025n

.meas tran vdout1_21ck1160 FIND v(dout1_21) AT=585.025n

.meas tran vdout1_22ck1160 FIND v(dout1_22) AT=585.025n

.meas tran vdout1_23ck1160 FIND v(dout1_23) AT=585.025n

.meas tran vdout1_24ck1160 FIND v(dout1_24) AT=585.025n

.meas tran vdout1_25ck1160 FIND v(dout1_25) AT=585.025n

.meas tran vdout1_26ck1160 FIND v(dout1_26) AT=585.025n

.meas tran vdout1_27ck1160 FIND v(dout1_27) AT=585.025n

.meas tran vdout1_28ck1160 FIND v(dout1_28) AT=585.025n

.meas tran vdout1_29ck1160 FIND v(dout1_29) AT=585.025n

.meas tran vdout1_30ck1160 FIND v(dout1_30) AT=585.025n

.meas tran vdout1_31ck1160 FIND v(dout1_31) AT=585.025n

.meas tran vdout0_0ck1170 FIND v(dout0_0) AT=590.025n

.meas tran vdout0_1ck1170 FIND v(dout0_1) AT=590.025n

.meas tran vdout0_2ck1170 FIND v(dout0_2) AT=590.025n

.meas tran vdout0_3ck1170 FIND v(dout0_3) AT=590.025n

.meas tran vdout0_4ck1170 FIND v(dout0_4) AT=590.025n

.meas tran vdout0_5ck1170 FIND v(dout0_5) AT=590.025n

.meas tran vdout0_6ck1170 FIND v(dout0_6) AT=590.025n

.meas tran vdout0_7ck1170 FIND v(dout0_7) AT=590.025n

.meas tran vdout0_8ck1170 FIND v(dout0_8) AT=590.025n

.meas tran vdout0_9ck1170 FIND v(dout0_9) AT=590.025n

.meas tran vdout0_10ck1170 FIND v(dout0_10) AT=590.025n

.meas tran vdout0_11ck1170 FIND v(dout0_11) AT=590.025n

.meas tran vdout0_12ck1170 FIND v(dout0_12) AT=590.025n

.meas tran vdout0_13ck1170 FIND v(dout0_13) AT=590.025n

.meas tran vdout0_14ck1170 FIND v(dout0_14) AT=590.025n

.meas tran vdout0_15ck1170 FIND v(dout0_15) AT=590.025n

.meas tran vdout0_16ck1170 FIND v(dout0_16) AT=590.025n

.meas tran vdout0_17ck1170 FIND v(dout0_17) AT=590.025n

.meas tran vdout0_18ck1170 FIND v(dout0_18) AT=590.025n

.meas tran vdout0_19ck1170 FIND v(dout0_19) AT=590.025n

.meas tran vdout0_20ck1170 FIND v(dout0_20) AT=590.025n

.meas tran vdout0_21ck1170 FIND v(dout0_21) AT=590.025n

.meas tran vdout0_22ck1170 FIND v(dout0_22) AT=590.025n

.meas tran vdout0_23ck1170 FIND v(dout0_23) AT=590.025n

.meas tran vdout0_24ck1170 FIND v(dout0_24) AT=590.025n

.meas tran vdout0_25ck1170 FIND v(dout0_25) AT=590.025n

.meas tran vdout0_26ck1170 FIND v(dout0_26) AT=590.025n

.meas tran vdout0_27ck1170 FIND v(dout0_27) AT=590.025n

.meas tran vdout0_28ck1170 FIND v(dout0_28) AT=590.025n

.meas tran vdout0_29ck1170 FIND v(dout0_29) AT=590.025n

.meas tran vdout0_30ck1170 FIND v(dout0_30) AT=590.025n

.meas tran vdout0_31ck1170 FIND v(dout0_31) AT=590.025n

.meas tran vdout0_0ck1180 FIND v(dout0_0) AT=595.025n

.meas tran vdout0_1ck1180 FIND v(dout0_1) AT=595.025n

.meas tran vdout0_2ck1180 FIND v(dout0_2) AT=595.025n

.meas tran vdout0_3ck1180 FIND v(dout0_3) AT=595.025n

.meas tran vdout0_4ck1180 FIND v(dout0_4) AT=595.025n

.meas tran vdout0_5ck1180 FIND v(dout0_5) AT=595.025n

.meas tran vdout0_6ck1180 FIND v(dout0_6) AT=595.025n

.meas tran vdout0_7ck1180 FIND v(dout0_7) AT=595.025n

.meas tran vdout0_8ck1180 FIND v(dout0_8) AT=595.025n

.meas tran vdout0_9ck1180 FIND v(dout0_9) AT=595.025n

.meas tran vdout0_10ck1180 FIND v(dout0_10) AT=595.025n

.meas tran vdout0_11ck1180 FIND v(dout0_11) AT=595.025n

.meas tran vdout0_12ck1180 FIND v(dout0_12) AT=595.025n

.meas tran vdout0_13ck1180 FIND v(dout0_13) AT=595.025n

.meas tran vdout0_14ck1180 FIND v(dout0_14) AT=595.025n

.meas tran vdout0_15ck1180 FIND v(dout0_15) AT=595.025n

.meas tran vdout0_16ck1180 FIND v(dout0_16) AT=595.025n

.meas tran vdout0_17ck1180 FIND v(dout0_17) AT=595.025n

.meas tran vdout0_18ck1180 FIND v(dout0_18) AT=595.025n

.meas tran vdout0_19ck1180 FIND v(dout0_19) AT=595.025n

.meas tran vdout0_20ck1180 FIND v(dout0_20) AT=595.025n

.meas tran vdout0_21ck1180 FIND v(dout0_21) AT=595.025n

.meas tran vdout0_22ck1180 FIND v(dout0_22) AT=595.025n

.meas tran vdout0_23ck1180 FIND v(dout0_23) AT=595.025n

.meas tran vdout0_24ck1180 FIND v(dout0_24) AT=595.025n

.meas tran vdout0_25ck1180 FIND v(dout0_25) AT=595.025n

.meas tran vdout0_26ck1180 FIND v(dout0_26) AT=595.025n

.meas tran vdout0_27ck1180 FIND v(dout0_27) AT=595.025n

.meas tran vdout0_28ck1180 FIND v(dout0_28) AT=595.025n

.meas tran vdout0_29ck1180 FIND v(dout0_29) AT=595.025n

.meas tran vdout0_30ck1180 FIND v(dout0_30) AT=595.025n

.meas tran vdout0_31ck1180 FIND v(dout0_31) AT=595.025n

.meas tran vdout0_0ck1190 FIND v(dout0_0) AT=600.025n

.meas tran vdout0_1ck1190 FIND v(dout0_1) AT=600.025n

.meas tran vdout0_2ck1190 FIND v(dout0_2) AT=600.025n

.meas tran vdout0_3ck1190 FIND v(dout0_3) AT=600.025n

.meas tran vdout0_4ck1190 FIND v(dout0_4) AT=600.025n

.meas tran vdout0_5ck1190 FIND v(dout0_5) AT=600.025n

.meas tran vdout0_6ck1190 FIND v(dout0_6) AT=600.025n

.meas tran vdout0_7ck1190 FIND v(dout0_7) AT=600.025n

.meas tran vdout0_8ck1190 FIND v(dout0_8) AT=600.025n

.meas tran vdout0_9ck1190 FIND v(dout0_9) AT=600.025n

.meas tran vdout0_10ck1190 FIND v(dout0_10) AT=600.025n

.meas tran vdout0_11ck1190 FIND v(dout0_11) AT=600.025n

.meas tran vdout0_12ck1190 FIND v(dout0_12) AT=600.025n

.meas tran vdout0_13ck1190 FIND v(dout0_13) AT=600.025n

.meas tran vdout0_14ck1190 FIND v(dout0_14) AT=600.025n

.meas tran vdout0_15ck1190 FIND v(dout0_15) AT=600.025n

.meas tran vdout0_16ck1190 FIND v(dout0_16) AT=600.025n

.meas tran vdout0_17ck1190 FIND v(dout0_17) AT=600.025n

.meas tran vdout0_18ck1190 FIND v(dout0_18) AT=600.025n

.meas tran vdout0_19ck1190 FIND v(dout0_19) AT=600.025n

.meas tran vdout0_20ck1190 FIND v(dout0_20) AT=600.025n

.meas tran vdout0_21ck1190 FIND v(dout0_21) AT=600.025n

.meas tran vdout0_22ck1190 FIND v(dout0_22) AT=600.025n

.meas tran vdout0_23ck1190 FIND v(dout0_23) AT=600.025n

.meas tran vdout0_24ck1190 FIND v(dout0_24) AT=600.025n

.meas tran vdout0_25ck1190 FIND v(dout0_25) AT=600.025n

.meas tran vdout0_26ck1190 FIND v(dout0_26) AT=600.025n

.meas tran vdout0_27ck1190 FIND v(dout0_27) AT=600.025n

.meas tran vdout0_28ck1190 FIND v(dout0_28) AT=600.025n

.meas tran vdout0_29ck1190 FIND v(dout0_29) AT=600.025n

.meas tran vdout0_30ck1190 FIND v(dout0_30) AT=600.025n

.meas tran vdout0_31ck1190 FIND v(dout0_31) AT=600.025n

.meas tran vdout1_0ck1190 FIND v(dout1_0) AT=600.025n

.meas tran vdout1_1ck1190 FIND v(dout1_1) AT=600.025n

.meas tran vdout1_2ck1190 FIND v(dout1_2) AT=600.025n

.meas tran vdout1_3ck1190 FIND v(dout1_3) AT=600.025n

.meas tran vdout1_4ck1190 FIND v(dout1_4) AT=600.025n

.meas tran vdout1_5ck1190 FIND v(dout1_5) AT=600.025n

.meas tran vdout1_6ck1190 FIND v(dout1_6) AT=600.025n

.meas tran vdout1_7ck1190 FIND v(dout1_7) AT=600.025n

.meas tran vdout1_8ck1190 FIND v(dout1_8) AT=600.025n

.meas tran vdout1_9ck1190 FIND v(dout1_9) AT=600.025n

.meas tran vdout1_10ck1190 FIND v(dout1_10) AT=600.025n

.meas tran vdout1_11ck1190 FIND v(dout1_11) AT=600.025n

.meas tran vdout1_12ck1190 FIND v(dout1_12) AT=600.025n

.meas tran vdout1_13ck1190 FIND v(dout1_13) AT=600.025n

.meas tran vdout1_14ck1190 FIND v(dout1_14) AT=600.025n

.meas tran vdout1_15ck1190 FIND v(dout1_15) AT=600.025n

.meas tran vdout1_16ck1190 FIND v(dout1_16) AT=600.025n

.meas tran vdout1_17ck1190 FIND v(dout1_17) AT=600.025n

.meas tran vdout1_18ck1190 FIND v(dout1_18) AT=600.025n

.meas tran vdout1_19ck1190 FIND v(dout1_19) AT=600.025n

.meas tran vdout1_20ck1190 FIND v(dout1_20) AT=600.025n

.meas tran vdout1_21ck1190 FIND v(dout1_21) AT=600.025n

.meas tran vdout1_22ck1190 FIND v(dout1_22) AT=600.025n

.meas tran vdout1_23ck1190 FIND v(dout1_23) AT=600.025n

.meas tran vdout1_24ck1190 FIND v(dout1_24) AT=600.025n

.meas tran vdout1_25ck1190 FIND v(dout1_25) AT=600.025n

.meas tran vdout1_26ck1190 FIND v(dout1_26) AT=600.025n

.meas tran vdout1_27ck1190 FIND v(dout1_27) AT=600.025n

.meas tran vdout1_28ck1190 FIND v(dout1_28) AT=600.025n

.meas tran vdout1_29ck1190 FIND v(dout1_29) AT=600.025n

.meas tran vdout1_30ck1190 FIND v(dout1_30) AT=600.025n

.meas tran vdout1_31ck1190 FIND v(dout1_31) AT=600.025n

.meas tran vdout1_0ck1200 FIND v(dout1_0) AT=605.025n

.meas tran vdout1_1ck1200 FIND v(dout1_1) AT=605.025n

.meas tran vdout1_2ck1200 FIND v(dout1_2) AT=605.025n

.meas tran vdout1_3ck1200 FIND v(dout1_3) AT=605.025n

.meas tran vdout1_4ck1200 FIND v(dout1_4) AT=605.025n

.meas tran vdout1_5ck1200 FIND v(dout1_5) AT=605.025n

.meas tran vdout1_6ck1200 FIND v(dout1_6) AT=605.025n

.meas tran vdout1_7ck1200 FIND v(dout1_7) AT=605.025n

.meas tran vdout1_8ck1200 FIND v(dout1_8) AT=605.025n

.meas tran vdout1_9ck1200 FIND v(dout1_9) AT=605.025n

.meas tran vdout1_10ck1200 FIND v(dout1_10) AT=605.025n

.meas tran vdout1_11ck1200 FIND v(dout1_11) AT=605.025n

.meas tran vdout1_12ck1200 FIND v(dout1_12) AT=605.025n

.meas tran vdout1_13ck1200 FIND v(dout1_13) AT=605.025n

.meas tran vdout1_14ck1200 FIND v(dout1_14) AT=605.025n

.meas tran vdout1_15ck1200 FIND v(dout1_15) AT=605.025n

.meas tran vdout1_16ck1200 FIND v(dout1_16) AT=605.025n

.meas tran vdout1_17ck1200 FIND v(dout1_17) AT=605.025n

.meas tran vdout1_18ck1200 FIND v(dout1_18) AT=605.025n

.meas tran vdout1_19ck1200 FIND v(dout1_19) AT=605.025n

.meas tran vdout1_20ck1200 FIND v(dout1_20) AT=605.025n

.meas tran vdout1_21ck1200 FIND v(dout1_21) AT=605.025n

.meas tran vdout1_22ck1200 FIND v(dout1_22) AT=605.025n

.meas tran vdout1_23ck1200 FIND v(dout1_23) AT=605.025n

.meas tran vdout1_24ck1200 FIND v(dout1_24) AT=605.025n

.meas tran vdout1_25ck1200 FIND v(dout1_25) AT=605.025n

.meas tran vdout1_26ck1200 FIND v(dout1_26) AT=605.025n

.meas tran vdout1_27ck1200 FIND v(dout1_27) AT=605.025n

.meas tran vdout1_28ck1200 FIND v(dout1_28) AT=605.025n

.meas tran vdout1_29ck1200 FIND v(dout1_29) AT=605.025n

.meas tran vdout1_30ck1200 FIND v(dout1_30) AT=605.025n

.meas tran vdout1_31ck1200 FIND v(dout1_31) AT=605.025n

.meas tran vdout0_0ck1210 FIND v(dout0_0) AT=610.025n

.meas tran vdout0_1ck1210 FIND v(dout0_1) AT=610.025n

.meas tran vdout0_2ck1210 FIND v(dout0_2) AT=610.025n

.meas tran vdout0_3ck1210 FIND v(dout0_3) AT=610.025n

.meas tran vdout0_4ck1210 FIND v(dout0_4) AT=610.025n

.meas tran vdout0_5ck1210 FIND v(dout0_5) AT=610.025n

.meas tran vdout0_6ck1210 FIND v(dout0_6) AT=610.025n

.meas tran vdout0_7ck1210 FIND v(dout0_7) AT=610.025n

.meas tran vdout0_8ck1210 FIND v(dout0_8) AT=610.025n

.meas tran vdout0_9ck1210 FIND v(dout0_9) AT=610.025n

.meas tran vdout0_10ck1210 FIND v(dout0_10) AT=610.025n

.meas tran vdout0_11ck1210 FIND v(dout0_11) AT=610.025n

.meas tran vdout0_12ck1210 FIND v(dout0_12) AT=610.025n

.meas tran vdout0_13ck1210 FIND v(dout0_13) AT=610.025n

.meas tran vdout0_14ck1210 FIND v(dout0_14) AT=610.025n

.meas tran vdout0_15ck1210 FIND v(dout0_15) AT=610.025n

.meas tran vdout0_16ck1210 FIND v(dout0_16) AT=610.025n

.meas tran vdout0_17ck1210 FIND v(dout0_17) AT=610.025n

.meas tran vdout0_18ck1210 FIND v(dout0_18) AT=610.025n

.meas tran vdout0_19ck1210 FIND v(dout0_19) AT=610.025n

.meas tran vdout0_20ck1210 FIND v(dout0_20) AT=610.025n

.meas tran vdout0_21ck1210 FIND v(dout0_21) AT=610.025n

.meas tran vdout0_22ck1210 FIND v(dout0_22) AT=610.025n

.meas tran vdout0_23ck1210 FIND v(dout0_23) AT=610.025n

.meas tran vdout0_24ck1210 FIND v(dout0_24) AT=610.025n

.meas tran vdout0_25ck1210 FIND v(dout0_25) AT=610.025n

.meas tran vdout0_26ck1210 FIND v(dout0_26) AT=610.025n

.meas tran vdout0_27ck1210 FIND v(dout0_27) AT=610.025n

.meas tran vdout0_28ck1210 FIND v(dout0_28) AT=610.025n

.meas tran vdout0_29ck1210 FIND v(dout0_29) AT=610.025n

.meas tran vdout0_30ck1210 FIND v(dout0_30) AT=610.025n

.meas tran vdout0_31ck1210 FIND v(dout0_31) AT=610.025n

.meas tran vdout0_0ck1220 FIND v(dout0_0) AT=615.025n

.meas tran vdout0_1ck1220 FIND v(dout0_1) AT=615.025n

.meas tran vdout0_2ck1220 FIND v(dout0_2) AT=615.025n

.meas tran vdout0_3ck1220 FIND v(dout0_3) AT=615.025n

.meas tran vdout0_4ck1220 FIND v(dout0_4) AT=615.025n

.meas tran vdout0_5ck1220 FIND v(dout0_5) AT=615.025n

.meas tran vdout0_6ck1220 FIND v(dout0_6) AT=615.025n

.meas tran vdout0_7ck1220 FIND v(dout0_7) AT=615.025n

.meas tran vdout0_8ck1220 FIND v(dout0_8) AT=615.025n

.meas tran vdout0_9ck1220 FIND v(dout0_9) AT=615.025n

.meas tran vdout0_10ck1220 FIND v(dout0_10) AT=615.025n

.meas tran vdout0_11ck1220 FIND v(dout0_11) AT=615.025n

.meas tran vdout0_12ck1220 FIND v(dout0_12) AT=615.025n

.meas tran vdout0_13ck1220 FIND v(dout0_13) AT=615.025n

.meas tran vdout0_14ck1220 FIND v(dout0_14) AT=615.025n

.meas tran vdout0_15ck1220 FIND v(dout0_15) AT=615.025n

.meas tran vdout0_16ck1220 FIND v(dout0_16) AT=615.025n

.meas tran vdout0_17ck1220 FIND v(dout0_17) AT=615.025n

.meas tran vdout0_18ck1220 FIND v(dout0_18) AT=615.025n

.meas tran vdout0_19ck1220 FIND v(dout0_19) AT=615.025n

.meas tran vdout0_20ck1220 FIND v(dout0_20) AT=615.025n

.meas tran vdout0_21ck1220 FIND v(dout0_21) AT=615.025n

.meas tran vdout0_22ck1220 FIND v(dout0_22) AT=615.025n

.meas tran vdout0_23ck1220 FIND v(dout0_23) AT=615.025n

.meas tran vdout0_24ck1220 FIND v(dout0_24) AT=615.025n

.meas tran vdout0_25ck1220 FIND v(dout0_25) AT=615.025n

.meas tran vdout0_26ck1220 FIND v(dout0_26) AT=615.025n

.meas tran vdout0_27ck1220 FIND v(dout0_27) AT=615.025n

.meas tran vdout0_28ck1220 FIND v(dout0_28) AT=615.025n

.meas tran vdout0_29ck1220 FIND v(dout0_29) AT=615.025n

.meas tran vdout0_30ck1220 FIND v(dout0_30) AT=615.025n

.meas tran vdout0_31ck1220 FIND v(dout0_31) AT=615.025n

.meas tran vdout1_0ck1220 FIND v(dout1_0) AT=615.025n

.meas tran vdout1_1ck1220 FIND v(dout1_1) AT=615.025n

.meas tran vdout1_2ck1220 FIND v(dout1_2) AT=615.025n

.meas tran vdout1_3ck1220 FIND v(dout1_3) AT=615.025n

.meas tran vdout1_4ck1220 FIND v(dout1_4) AT=615.025n

.meas tran vdout1_5ck1220 FIND v(dout1_5) AT=615.025n

.meas tran vdout1_6ck1220 FIND v(dout1_6) AT=615.025n

.meas tran vdout1_7ck1220 FIND v(dout1_7) AT=615.025n

.meas tran vdout1_8ck1220 FIND v(dout1_8) AT=615.025n

.meas tran vdout1_9ck1220 FIND v(dout1_9) AT=615.025n

.meas tran vdout1_10ck1220 FIND v(dout1_10) AT=615.025n

.meas tran vdout1_11ck1220 FIND v(dout1_11) AT=615.025n

.meas tran vdout1_12ck1220 FIND v(dout1_12) AT=615.025n

.meas tran vdout1_13ck1220 FIND v(dout1_13) AT=615.025n

.meas tran vdout1_14ck1220 FIND v(dout1_14) AT=615.025n

.meas tran vdout1_15ck1220 FIND v(dout1_15) AT=615.025n

.meas tran vdout1_16ck1220 FIND v(dout1_16) AT=615.025n

.meas tran vdout1_17ck1220 FIND v(dout1_17) AT=615.025n

.meas tran vdout1_18ck1220 FIND v(dout1_18) AT=615.025n

.meas tran vdout1_19ck1220 FIND v(dout1_19) AT=615.025n

.meas tran vdout1_20ck1220 FIND v(dout1_20) AT=615.025n

.meas tran vdout1_21ck1220 FIND v(dout1_21) AT=615.025n

.meas tran vdout1_22ck1220 FIND v(dout1_22) AT=615.025n

.meas tran vdout1_23ck1220 FIND v(dout1_23) AT=615.025n

.meas tran vdout1_24ck1220 FIND v(dout1_24) AT=615.025n

.meas tran vdout1_25ck1220 FIND v(dout1_25) AT=615.025n

.meas tran vdout1_26ck1220 FIND v(dout1_26) AT=615.025n

.meas tran vdout1_27ck1220 FIND v(dout1_27) AT=615.025n

.meas tran vdout1_28ck1220 FIND v(dout1_28) AT=615.025n

.meas tran vdout1_29ck1220 FIND v(dout1_29) AT=615.025n

.meas tran vdout1_30ck1220 FIND v(dout1_30) AT=615.025n

.meas tran vdout1_31ck1220 FIND v(dout1_31) AT=615.025n

.meas tran vdout1_0ck1250 FIND v(dout1_0) AT=630.025n

.meas tran vdout1_1ck1250 FIND v(dout1_1) AT=630.025n

.meas tran vdout1_2ck1250 FIND v(dout1_2) AT=630.025n

.meas tran vdout1_3ck1250 FIND v(dout1_3) AT=630.025n

.meas tran vdout1_4ck1250 FIND v(dout1_4) AT=630.025n

.meas tran vdout1_5ck1250 FIND v(dout1_5) AT=630.025n

.meas tran vdout1_6ck1250 FIND v(dout1_6) AT=630.025n

.meas tran vdout1_7ck1250 FIND v(dout1_7) AT=630.025n

.meas tran vdout1_8ck1250 FIND v(dout1_8) AT=630.025n

.meas tran vdout1_9ck1250 FIND v(dout1_9) AT=630.025n

.meas tran vdout1_10ck1250 FIND v(dout1_10) AT=630.025n

.meas tran vdout1_11ck1250 FIND v(dout1_11) AT=630.025n

.meas tran vdout1_12ck1250 FIND v(dout1_12) AT=630.025n

.meas tran vdout1_13ck1250 FIND v(dout1_13) AT=630.025n

.meas tran vdout1_14ck1250 FIND v(dout1_14) AT=630.025n

.meas tran vdout1_15ck1250 FIND v(dout1_15) AT=630.025n

.meas tran vdout1_16ck1250 FIND v(dout1_16) AT=630.025n

.meas tran vdout1_17ck1250 FIND v(dout1_17) AT=630.025n

.meas tran vdout1_18ck1250 FIND v(dout1_18) AT=630.025n

.meas tran vdout1_19ck1250 FIND v(dout1_19) AT=630.025n

.meas tran vdout1_20ck1250 FIND v(dout1_20) AT=630.025n

.meas tran vdout1_21ck1250 FIND v(dout1_21) AT=630.025n

.meas tran vdout1_22ck1250 FIND v(dout1_22) AT=630.025n

.meas tran vdout1_23ck1250 FIND v(dout1_23) AT=630.025n

.meas tran vdout1_24ck1250 FIND v(dout1_24) AT=630.025n

.meas tran vdout1_25ck1250 FIND v(dout1_25) AT=630.025n

.meas tran vdout1_26ck1250 FIND v(dout1_26) AT=630.025n

.meas tran vdout1_27ck1250 FIND v(dout1_27) AT=630.025n

.meas tran vdout1_28ck1250 FIND v(dout1_28) AT=630.025n

.meas tran vdout1_29ck1250 FIND v(dout1_29) AT=630.025n

.meas tran vdout1_30ck1250 FIND v(dout1_30) AT=630.025n

.meas tran vdout1_31ck1250 FIND v(dout1_31) AT=630.025n

.meas tran vdout1_0ck1260 FIND v(dout1_0) AT=635.025n

.meas tran vdout1_1ck1260 FIND v(dout1_1) AT=635.025n

.meas tran vdout1_2ck1260 FIND v(dout1_2) AT=635.025n

.meas tran vdout1_3ck1260 FIND v(dout1_3) AT=635.025n

.meas tran vdout1_4ck1260 FIND v(dout1_4) AT=635.025n

.meas tran vdout1_5ck1260 FIND v(dout1_5) AT=635.025n

.meas tran vdout1_6ck1260 FIND v(dout1_6) AT=635.025n

.meas tran vdout1_7ck1260 FIND v(dout1_7) AT=635.025n

.meas tran vdout1_8ck1260 FIND v(dout1_8) AT=635.025n

.meas tran vdout1_9ck1260 FIND v(dout1_9) AT=635.025n

.meas tran vdout1_10ck1260 FIND v(dout1_10) AT=635.025n

.meas tran vdout1_11ck1260 FIND v(dout1_11) AT=635.025n

.meas tran vdout1_12ck1260 FIND v(dout1_12) AT=635.025n

.meas tran vdout1_13ck1260 FIND v(dout1_13) AT=635.025n

.meas tran vdout1_14ck1260 FIND v(dout1_14) AT=635.025n

.meas tran vdout1_15ck1260 FIND v(dout1_15) AT=635.025n

.meas tran vdout1_16ck1260 FIND v(dout1_16) AT=635.025n

.meas tran vdout1_17ck1260 FIND v(dout1_17) AT=635.025n

.meas tran vdout1_18ck1260 FIND v(dout1_18) AT=635.025n

.meas tran vdout1_19ck1260 FIND v(dout1_19) AT=635.025n

.meas tran vdout1_20ck1260 FIND v(dout1_20) AT=635.025n

.meas tran vdout1_21ck1260 FIND v(dout1_21) AT=635.025n

.meas tran vdout1_22ck1260 FIND v(dout1_22) AT=635.025n

.meas tran vdout1_23ck1260 FIND v(dout1_23) AT=635.025n

.meas tran vdout1_24ck1260 FIND v(dout1_24) AT=635.025n

.meas tran vdout1_25ck1260 FIND v(dout1_25) AT=635.025n

.meas tran vdout1_26ck1260 FIND v(dout1_26) AT=635.025n

.meas tran vdout1_27ck1260 FIND v(dout1_27) AT=635.025n

.meas tran vdout1_28ck1260 FIND v(dout1_28) AT=635.025n

.meas tran vdout1_29ck1260 FIND v(dout1_29) AT=635.025n

.meas tran vdout1_30ck1260 FIND v(dout1_30) AT=635.025n

.meas tran vdout1_31ck1260 FIND v(dout1_31) AT=635.025n

.meas tran vdout0_0ck1270 FIND v(dout0_0) AT=640.025n

.meas tran vdout0_1ck1270 FIND v(dout0_1) AT=640.025n

.meas tran vdout0_2ck1270 FIND v(dout0_2) AT=640.025n

.meas tran vdout0_3ck1270 FIND v(dout0_3) AT=640.025n

.meas tran vdout0_4ck1270 FIND v(dout0_4) AT=640.025n

.meas tran vdout0_5ck1270 FIND v(dout0_5) AT=640.025n

.meas tran vdout0_6ck1270 FIND v(dout0_6) AT=640.025n

.meas tran vdout0_7ck1270 FIND v(dout0_7) AT=640.025n

.meas tran vdout0_8ck1270 FIND v(dout0_8) AT=640.025n

.meas tran vdout0_9ck1270 FIND v(dout0_9) AT=640.025n

.meas tran vdout0_10ck1270 FIND v(dout0_10) AT=640.025n

.meas tran vdout0_11ck1270 FIND v(dout0_11) AT=640.025n

.meas tran vdout0_12ck1270 FIND v(dout0_12) AT=640.025n

.meas tran vdout0_13ck1270 FIND v(dout0_13) AT=640.025n

.meas tran vdout0_14ck1270 FIND v(dout0_14) AT=640.025n

.meas tran vdout0_15ck1270 FIND v(dout0_15) AT=640.025n

.meas tran vdout0_16ck1270 FIND v(dout0_16) AT=640.025n

.meas tran vdout0_17ck1270 FIND v(dout0_17) AT=640.025n

.meas tran vdout0_18ck1270 FIND v(dout0_18) AT=640.025n

.meas tran vdout0_19ck1270 FIND v(dout0_19) AT=640.025n

.meas tran vdout0_20ck1270 FIND v(dout0_20) AT=640.025n

.meas tran vdout0_21ck1270 FIND v(dout0_21) AT=640.025n

.meas tran vdout0_22ck1270 FIND v(dout0_22) AT=640.025n

.meas tran vdout0_23ck1270 FIND v(dout0_23) AT=640.025n

.meas tran vdout0_24ck1270 FIND v(dout0_24) AT=640.025n

.meas tran vdout0_25ck1270 FIND v(dout0_25) AT=640.025n

.meas tran vdout0_26ck1270 FIND v(dout0_26) AT=640.025n

.meas tran vdout0_27ck1270 FIND v(dout0_27) AT=640.025n

.meas tran vdout0_28ck1270 FIND v(dout0_28) AT=640.025n

.meas tran vdout0_29ck1270 FIND v(dout0_29) AT=640.025n

.meas tran vdout0_30ck1270 FIND v(dout0_30) AT=640.025n

.meas tran vdout0_31ck1270 FIND v(dout0_31) AT=640.025n

.meas tran vdout0_0ck1280 FIND v(dout0_0) AT=645.025n

.meas tran vdout0_1ck1280 FIND v(dout0_1) AT=645.025n

.meas tran vdout0_2ck1280 FIND v(dout0_2) AT=645.025n

.meas tran vdout0_3ck1280 FIND v(dout0_3) AT=645.025n

.meas tran vdout0_4ck1280 FIND v(dout0_4) AT=645.025n

.meas tran vdout0_5ck1280 FIND v(dout0_5) AT=645.025n

.meas tran vdout0_6ck1280 FIND v(dout0_6) AT=645.025n

.meas tran vdout0_7ck1280 FIND v(dout0_7) AT=645.025n

.meas tran vdout0_8ck1280 FIND v(dout0_8) AT=645.025n

.meas tran vdout0_9ck1280 FIND v(dout0_9) AT=645.025n

.meas tran vdout0_10ck1280 FIND v(dout0_10) AT=645.025n

.meas tran vdout0_11ck1280 FIND v(dout0_11) AT=645.025n

.meas tran vdout0_12ck1280 FIND v(dout0_12) AT=645.025n

.meas tran vdout0_13ck1280 FIND v(dout0_13) AT=645.025n

.meas tran vdout0_14ck1280 FIND v(dout0_14) AT=645.025n

.meas tran vdout0_15ck1280 FIND v(dout0_15) AT=645.025n

.meas tran vdout0_16ck1280 FIND v(dout0_16) AT=645.025n

.meas tran vdout0_17ck1280 FIND v(dout0_17) AT=645.025n

.meas tran vdout0_18ck1280 FIND v(dout0_18) AT=645.025n

.meas tran vdout0_19ck1280 FIND v(dout0_19) AT=645.025n

.meas tran vdout0_20ck1280 FIND v(dout0_20) AT=645.025n

.meas tran vdout0_21ck1280 FIND v(dout0_21) AT=645.025n

.meas tran vdout0_22ck1280 FIND v(dout0_22) AT=645.025n

.meas tran vdout0_23ck1280 FIND v(dout0_23) AT=645.025n

.meas tran vdout0_24ck1280 FIND v(dout0_24) AT=645.025n

.meas tran vdout0_25ck1280 FIND v(dout0_25) AT=645.025n

.meas tran vdout0_26ck1280 FIND v(dout0_26) AT=645.025n

.meas tran vdout0_27ck1280 FIND v(dout0_27) AT=645.025n

.meas tran vdout0_28ck1280 FIND v(dout0_28) AT=645.025n

.meas tran vdout0_29ck1280 FIND v(dout0_29) AT=645.025n

.meas tran vdout0_30ck1280 FIND v(dout0_30) AT=645.025n

.meas tran vdout0_31ck1280 FIND v(dout0_31) AT=645.025n

.meas tran vdout1_0ck1290 FIND v(dout1_0) AT=650.025n

.meas tran vdout1_1ck1290 FIND v(dout1_1) AT=650.025n

.meas tran vdout1_2ck1290 FIND v(dout1_2) AT=650.025n

.meas tran vdout1_3ck1290 FIND v(dout1_3) AT=650.025n

.meas tran vdout1_4ck1290 FIND v(dout1_4) AT=650.025n

.meas tran vdout1_5ck1290 FIND v(dout1_5) AT=650.025n

.meas tran vdout1_6ck1290 FIND v(dout1_6) AT=650.025n

.meas tran vdout1_7ck1290 FIND v(dout1_7) AT=650.025n

.meas tran vdout1_8ck1290 FIND v(dout1_8) AT=650.025n

.meas tran vdout1_9ck1290 FIND v(dout1_9) AT=650.025n

.meas tran vdout1_10ck1290 FIND v(dout1_10) AT=650.025n

.meas tran vdout1_11ck1290 FIND v(dout1_11) AT=650.025n

.meas tran vdout1_12ck1290 FIND v(dout1_12) AT=650.025n

.meas tran vdout1_13ck1290 FIND v(dout1_13) AT=650.025n

.meas tran vdout1_14ck1290 FIND v(dout1_14) AT=650.025n

.meas tran vdout1_15ck1290 FIND v(dout1_15) AT=650.025n

.meas tran vdout1_16ck1290 FIND v(dout1_16) AT=650.025n

.meas tran vdout1_17ck1290 FIND v(dout1_17) AT=650.025n

.meas tran vdout1_18ck1290 FIND v(dout1_18) AT=650.025n

.meas tran vdout1_19ck1290 FIND v(dout1_19) AT=650.025n

.meas tran vdout1_20ck1290 FIND v(dout1_20) AT=650.025n

.meas tran vdout1_21ck1290 FIND v(dout1_21) AT=650.025n

.meas tran vdout1_22ck1290 FIND v(dout1_22) AT=650.025n

.meas tran vdout1_23ck1290 FIND v(dout1_23) AT=650.025n

.meas tran vdout1_24ck1290 FIND v(dout1_24) AT=650.025n

.meas tran vdout1_25ck1290 FIND v(dout1_25) AT=650.025n

.meas tran vdout1_26ck1290 FIND v(dout1_26) AT=650.025n

.meas tran vdout1_27ck1290 FIND v(dout1_27) AT=650.025n

.meas tran vdout1_28ck1290 FIND v(dout1_28) AT=650.025n

.meas tran vdout1_29ck1290 FIND v(dout1_29) AT=650.025n

.meas tran vdout1_30ck1290 FIND v(dout1_30) AT=650.025n

.meas tran vdout1_31ck1290 FIND v(dout1_31) AT=650.025n

.meas tran vdout1_0ck1300 FIND v(dout1_0) AT=655.025n

.meas tran vdout1_1ck1300 FIND v(dout1_1) AT=655.025n

.meas tran vdout1_2ck1300 FIND v(dout1_2) AT=655.025n

.meas tran vdout1_3ck1300 FIND v(dout1_3) AT=655.025n

.meas tran vdout1_4ck1300 FIND v(dout1_4) AT=655.025n

.meas tran vdout1_5ck1300 FIND v(dout1_5) AT=655.025n

.meas tran vdout1_6ck1300 FIND v(dout1_6) AT=655.025n

.meas tran vdout1_7ck1300 FIND v(dout1_7) AT=655.025n

.meas tran vdout1_8ck1300 FIND v(dout1_8) AT=655.025n

.meas tran vdout1_9ck1300 FIND v(dout1_9) AT=655.025n

.meas tran vdout1_10ck1300 FIND v(dout1_10) AT=655.025n

.meas tran vdout1_11ck1300 FIND v(dout1_11) AT=655.025n

.meas tran vdout1_12ck1300 FIND v(dout1_12) AT=655.025n

.meas tran vdout1_13ck1300 FIND v(dout1_13) AT=655.025n

.meas tran vdout1_14ck1300 FIND v(dout1_14) AT=655.025n

.meas tran vdout1_15ck1300 FIND v(dout1_15) AT=655.025n

.meas tran vdout1_16ck1300 FIND v(dout1_16) AT=655.025n

.meas tran vdout1_17ck1300 FIND v(dout1_17) AT=655.025n

.meas tran vdout1_18ck1300 FIND v(dout1_18) AT=655.025n

.meas tran vdout1_19ck1300 FIND v(dout1_19) AT=655.025n

.meas tran vdout1_20ck1300 FIND v(dout1_20) AT=655.025n

.meas tran vdout1_21ck1300 FIND v(dout1_21) AT=655.025n

.meas tran vdout1_22ck1300 FIND v(dout1_22) AT=655.025n

.meas tran vdout1_23ck1300 FIND v(dout1_23) AT=655.025n

.meas tran vdout1_24ck1300 FIND v(dout1_24) AT=655.025n

.meas tran vdout1_25ck1300 FIND v(dout1_25) AT=655.025n

.meas tran vdout1_26ck1300 FIND v(dout1_26) AT=655.025n

.meas tran vdout1_27ck1300 FIND v(dout1_27) AT=655.025n

.meas tran vdout1_28ck1300 FIND v(dout1_28) AT=655.025n

.meas tran vdout1_29ck1300 FIND v(dout1_29) AT=655.025n

.meas tran vdout1_30ck1300 FIND v(dout1_30) AT=655.025n

.meas tran vdout1_31ck1300 FIND v(dout1_31) AT=655.025n

.meas tran vdout0_0ck1310 FIND v(dout0_0) AT=660.025n

.meas tran vdout0_1ck1310 FIND v(dout0_1) AT=660.025n

.meas tran vdout0_2ck1310 FIND v(dout0_2) AT=660.025n

.meas tran vdout0_3ck1310 FIND v(dout0_3) AT=660.025n

.meas tran vdout0_4ck1310 FIND v(dout0_4) AT=660.025n

.meas tran vdout0_5ck1310 FIND v(dout0_5) AT=660.025n

.meas tran vdout0_6ck1310 FIND v(dout0_6) AT=660.025n

.meas tran vdout0_7ck1310 FIND v(dout0_7) AT=660.025n

.meas tran vdout0_8ck1310 FIND v(dout0_8) AT=660.025n

.meas tran vdout0_9ck1310 FIND v(dout0_9) AT=660.025n

.meas tran vdout0_10ck1310 FIND v(dout0_10) AT=660.025n

.meas tran vdout0_11ck1310 FIND v(dout0_11) AT=660.025n

.meas tran vdout0_12ck1310 FIND v(dout0_12) AT=660.025n

.meas tran vdout0_13ck1310 FIND v(dout0_13) AT=660.025n

.meas tran vdout0_14ck1310 FIND v(dout0_14) AT=660.025n

.meas tran vdout0_15ck1310 FIND v(dout0_15) AT=660.025n

.meas tran vdout0_16ck1310 FIND v(dout0_16) AT=660.025n

.meas tran vdout0_17ck1310 FIND v(dout0_17) AT=660.025n

.meas tran vdout0_18ck1310 FIND v(dout0_18) AT=660.025n

.meas tran vdout0_19ck1310 FIND v(dout0_19) AT=660.025n

.meas tran vdout0_20ck1310 FIND v(dout0_20) AT=660.025n

.meas tran vdout0_21ck1310 FIND v(dout0_21) AT=660.025n

.meas tran vdout0_22ck1310 FIND v(dout0_22) AT=660.025n

.meas tran vdout0_23ck1310 FIND v(dout0_23) AT=660.025n

.meas tran vdout0_24ck1310 FIND v(dout0_24) AT=660.025n

.meas tran vdout0_25ck1310 FIND v(dout0_25) AT=660.025n

.meas tran vdout0_26ck1310 FIND v(dout0_26) AT=660.025n

.meas tran vdout0_27ck1310 FIND v(dout0_27) AT=660.025n

.meas tran vdout0_28ck1310 FIND v(dout0_28) AT=660.025n

.meas tran vdout0_29ck1310 FIND v(dout0_29) AT=660.025n

.meas tran vdout0_30ck1310 FIND v(dout0_30) AT=660.025n

.meas tran vdout0_31ck1310 FIND v(dout0_31) AT=660.025n

.meas tran vdout0_0ck1320 FIND v(dout0_0) AT=665.025n

.meas tran vdout0_1ck1320 FIND v(dout0_1) AT=665.025n

.meas tran vdout0_2ck1320 FIND v(dout0_2) AT=665.025n

.meas tran vdout0_3ck1320 FIND v(dout0_3) AT=665.025n

.meas tran vdout0_4ck1320 FIND v(dout0_4) AT=665.025n

.meas tran vdout0_5ck1320 FIND v(dout0_5) AT=665.025n

.meas tran vdout0_6ck1320 FIND v(dout0_6) AT=665.025n

.meas tran vdout0_7ck1320 FIND v(dout0_7) AT=665.025n

.meas tran vdout0_8ck1320 FIND v(dout0_8) AT=665.025n

.meas tran vdout0_9ck1320 FIND v(dout0_9) AT=665.025n

.meas tran vdout0_10ck1320 FIND v(dout0_10) AT=665.025n

.meas tran vdout0_11ck1320 FIND v(dout0_11) AT=665.025n

.meas tran vdout0_12ck1320 FIND v(dout0_12) AT=665.025n

.meas tran vdout0_13ck1320 FIND v(dout0_13) AT=665.025n

.meas tran vdout0_14ck1320 FIND v(dout0_14) AT=665.025n

.meas tran vdout0_15ck1320 FIND v(dout0_15) AT=665.025n

.meas tran vdout0_16ck1320 FIND v(dout0_16) AT=665.025n

.meas tran vdout0_17ck1320 FIND v(dout0_17) AT=665.025n

.meas tran vdout0_18ck1320 FIND v(dout0_18) AT=665.025n

.meas tran vdout0_19ck1320 FIND v(dout0_19) AT=665.025n

.meas tran vdout0_20ck1320 FIND v(dout0_20) AT=665.025n

.meas tran vdout0_21ck1320 FIND v(dout0_21) AT=665.025n

.meas tran vdout0_22ck1320 FIND v(dout0_22) AT=665.025n

.meas tran vdout0_23ck1320 FIND v(dout0_23) AT=665.025n

.meas tran vdout0_24ck1320 FIND v(dout0_24) AT=665.025n

.meas tran vdout0_25ck1320 FIND v(dout0_25) AT=665.025n

.meas tran vdout0_26ck1320 FIND v(dout0_26) AT=665.025n

.meas tran vdout0_27ck1320 FIND v(dout0_27) AT=665.025n

.meas tran vdout0_28ck1320 FIND v(dout0_28) AT=665.025n

.meas tran vdout0_29ck1320 FIND v(dout0_29) AT=665.025n

.meas tran vdout0_30ck1320 FIND v(dout0_30) AT=665.025n

.meas tran vdout0_31ck1320 FIND v(dout0_31) AT=665.025n

.meas tran vdout1_0ck1320 FIND v(dout1_0) AT=665.025n

.meas tran vdout1_1ck1320 FIND v(dout1_1) AT=665.025n

.meas tran vdout1_2ck1320 FIND v(dout1_2) AT=665.025n

.meas tran vdout1_3ck1320 FIND v(dout1_3) AT=665.025n

.meas tran vdout1_4ck1320 FIND v(dout1_4) AT=665.025n

.meas tran vdout1_5ck1320 FIND v(dout1_5) AT=665.025n

.meas tran vdout1_6ck1320 FIND v(dout1_6) AT=665.025n

.meas tran vdout1_7ck1320 FIND v(dout1_7) AT=665.025n

.meas tran vdout1_8ck1320 FIND v(dout1_8) AT=665.025n

.meas tran vdout1_9ck1320 FIND v(dout1_9) AT=665.025n

.meas tran vdout1_10ck1320 FIND v(dout1_10) AT=665.025n

.meas tran vdout1_11ck1320 FIND v(dout1_11) AT=665.025n

.meas tran vdout1_12ck1320 FIND v(dout1_12) AT=665.025n

.meas tran vdout1_13ck1320 FIND v(dout1_13) AT=665.025n

.meas tran vdout1_14ck1320 FIND v(dout1_14) AT=665.025n

.meas tran vdout1_15ck1320 FIND v(dout1_15) AT=665.025n

.meas tran vdout1_16ck1320 FIND v(dout1_16) AT=665.025n

.meas tran vdout1_17ck1320 FIND v(dout1_17) AT=665.025n

.meas tran vdout1_18ck1320 FIND v(dout1_18) AT=665.025n

.meas tran vdout1_19ck1320 FIND v(dout1_19) AT=665.025n

.meas tran vdout1_20ck1320 FIND v(dout1_20) AT=665.025n

.meas tran vdout1_21ck1320 FIND v(dout1_21) AT=665.025n

.meas tran vdout1_22ck1320 FIND v(dout1_22) AT=665.025n

.meas tran vdout1_23ck1320 FIND v(dout1_23) AT=665.025n

.meas tran vdout1_24ck1320 FIND v(dout1_24) AT=665.025n

.meas tran vdout1_25ck1320 FIND v(dout1_25) AT=665.025n

.meas tran vdout1_26ck1320 FIND v(dout1_26) AT=665.025n

.meas tran vdout1_27ck1320 FIND v(dout1_27) AT=665.025n

.meas tran vdout1_28ck1320 FIND v(dout1_28) AT=665.025n

.meas tran vdout1_29ck1320 FIND v(dout1_29) AT=665.025n

.meas tran vdout1_30ck1320 FIND v(dout1_30) AT=665.025n

.meas tran vdout1_31ck1320 FIND v(dout1_31) AT=665.025n

.meas tran vdout0_0ck1330 FIND v(dout0_0) AT=670.025n

.meas tran vdout0_1ck1330 FIND v(dout0_1) AT=670.025n

.meas tran vdout0_2ck1330 FIND v(dout0_2) AT=670.025n

.meas tran vdout0_3ck1330 FIND v(dout0_3) AT=670.025n

.meas tran vdout0_4ck1330 FIND v(dout0_4) AT=670.025n

.meas tran vdout0_5ck1330 FIND v(dout0_5) AT=670.025n

.meas tran vdout0_6ck1330 FIND v(dout0_6) AT=670.025n

.meas tran vdout0_7ck1330 FIND v(dout0_7) AT=670.025n

.meas tran vdout0_8ck1330 FIND v(dout0_8) AT=670.025n

.meas tran vdout0_9ck1330 FIND v(dout0_9) AT=670.025n

.meas tran vdout0_10ck1330 FIND v(dout0_10) AT=670.025n

.meas tran vdout0_11ck1330 FIND v(dout0_11) AT=670.025n

.meas tran vdout0_12ck1330 FIND v(dout0_12) AT=670.025n

.meas tran vdout0_13ck1330 FIND v(dout0_13) AT=670.025n

.meas tran vdout0_14ck1330 FIND v(dout0_14) AT=670.025n

.meas tran vdout0_15ck1330 FIND v(dout0_15) AT=670.025n

.meas tran vdout0_16ck1330 FIND v(dout0_16) AT=670.025n

.meas tran vdout0_17ck1330 FIND v(dout0_17) AT=670.025n

.meas tran vdout0_18ck1330 FIND v(dout0_18) AT=670.025n

.meas tran vdout0_19ck1330 FIND v(dout0_19) AT=670.025n

.meas tran vdout0_20ck1330 FIND v(dout0_20) AT=670.025n

.meas tran vdout0_21ck1330 FIND v(dout0_21) AT=670.025n

.meas tran vdout0_22ck1330 FIND v(dout0_22) AT=670.025n

.meas tran vdout0_23ck1330 FIND v(dout0_23) AT=670.025n

.meas tran vdout0_24ck1330 FIND v(dout0_24) AT=670.025n

.meas tran vdout0_25ck1330 FIND v(dout0_25) AT=670.025n

.meas tran vdout0_26ck1330 FIND v(dout0_26) AT=670.025n

.meas tran vdout0_27ck1330 FIND v(dout0_27) AT=670.025n

.meas tran vdout0_28ck1330 FIND v(dout0_28) AT=670.025n

.meas tran vdout0_29ck1330 FIND v(dout0_29) AT=670.025n

.meas tran vdout0_30ck1330 FIND v(dout0_30) AT=670.025n

.meas tran vdout0_31ck1330 FIND v(dout0_31) AT=670.025n

.meas tran vdout1_0ck1330 FIND v(dout1_0) AT=670.025n

.meas tran vdout1_1ck1330 FIND v(dout1_1) AT=670.025n

.meas tran vdout1_2ck1330 FIND v(dout1_2) AT=670.025n

.meas tran vdout1_3ck1330 FIND v(dout1_3) AT=670.025n

.meas tran vdout1_4ck1330 FIND v(dout1_4) AT=670.025n

.meas tran vdout1_5ck1330 FIND v(dout1_5) AT=670.025n

.meas tran vdout1_6ck1330 FIND v(dout1_6) AT=670.025n

.meas tran vdout1_7ck1330 FIND v(dout1_7) AT=670.025n

.meas tran vdout1_8ck1330 FIND v(dout1_8) AT=670.025n

.meas tran vdout1_9ck1330 FIND v(dout1_9) AT=670.025n

.meas tran vdout1_10ck1330 FIND v(dout1_10) AT=670.025n

.meas tran vdout1_11ck1330 FIND v(dout1_11) AT=670.025n

.meas tran vdout1_12ck1330 FIND v(dout1_12) AT=670.025n

.meas tran vdout1_13ck1330 FIND v(dout1_13) AT=670.025n

.meas tran vdout1_14ck1330 FIND v(dout1_14) AT=670.025n

.meas tran vdout1_15ck1330 FIND v(dout1_15) AT=670.025n

.meas tran vdout1_16ck1330 FIND v(dout1_16) AT=670.025n

.meas tran vdout1_17ck1330 FIND v(dout1_17) AT=670.025n

.meas tran vdout1_18ck1330 FIND v(dout1_18) AT=670.025n

.meas tran vdout1_19ck1330 FIND v(dout1_19) AT=670.025n

.meas tran vdout1_20ck1330 FIND v(dout1_20) AT=670.025n

.meas tran vdout1_21ck1330 FIND v(dout1_21) AT=670.025n

.meas tran vdout1_22ck1330 FIND v(dout1_22) AT=670.025n

.meas tran vdout1_23ck1330 FIND v(dout1_23) AT=670.025n

.meas tran vdout1_24ck1330 FIND v(dout1_24) AT=670.025n

.meas tran vdout1_25ck1330 FIND v(dout1_25) AT=670.025n

.meas tran vdout1_26ck1330 FIND v(dout1_26) AT=670.025n

.meas tran vdout1_27ck1330 FIND v(dout1_27) AT=670.025n

.meas tran vdout1_28ck1330 FIND v(dout1_28) AT=670.025n

.meas tran vdout1_29ck1330 FIND v(dout1_29) AT=670.025n

.meas tran vdout1_30ck1330 FIND v(dout1_30) AT=670.025n

.meas tran vdout1_31ck1330 FIND v(dout1_31) AT=670.025n

.meas tran vdout0_0ck1340 FIND v(dout0_0) AT=675.025n

.meas tran vdout0_1ck1340 FIND v(dout0_1) AT=675.025n

.meas tran vdout0_2ck1340 FIND v(dout0_2) AT=675.025n

.meas tran vdout0_3ck1340 FIND v(dout0_3) AT=675.025n

.meas tran vdout0_4ck1340 FIND v(dout0_4) AT=675.025n

.meas tran vdout0_5ck1340 FIND v(dout0_5) AT=675.025n

.meas tran vdout0_6ck1340 FIND v(dout0_6) AT=675.025n

.meas tran vdout0_7ck1340 FIND v(dout0_7) AT=675.025n

.meas tran vdout0_8ck1340 FIND v(dout0_8) AT=675.025n

.meas tran vdout0_9ck1340 FIND v(dout0_9) AT=675.025n

.meas tran vdout0_10ck1340 FIND v(dout0_10) AT=675.025n

.meas tran vdout0_11ck1340 FIND v(dout0_11) AT=675.025n

.meas tran vdout0_12ck1340 FIND v(dout0_12) AT=675.025n

.meas tran vdout0_13ck1340 FIND v(dout0_13) AT=675.025n

.meas tran vdout0_14ck1340 FIND v(dout0_14) AT=675.025n

.meas tran vdout0_15ck1340 FIND v(dout0_15) AT=675.025n

.meas tran vdout0_16ck1340 FIND v(dout0_16) AT=675.025n

.meas tran vdout0_17ck1340 FIND v(dout0_17) AT=675.025n

.meas tran vdout0_18ck1340 FIND v(dout0_18) AT=675.025n

.meas tran vdout0_19ck1340 FIND v(dout0_19) AT=675.025n

.meas tran vdout0_20ck1340 FIND v(dout0_20) AT=675.025n

.meas tran vdout0_21ck1340 FIND v(dout0_21) AT=675.025n

.meas tran vdout0_22ck1340 FIND v(dout0_22) AT=675.025n

.meas tran vdout0_23ck1340 FIND v(dout0_23) AT=675.025n

.meas tran vdout0_24ck1340 FIND v(dout0_24) AT=675.025n

.meas tran vdout0_25ck1340 FIND v(dout0_25) AT=675.025n

.meas tran vdout0_26ck1340 FIND v(dout0_26) AT=675.025n

.meas tran vdout0_27ck1340 FIND v(dout0_27) AT=675.025n

.meas tran vdout0_28ck1340 FIND v(dout0_28) AT=675.025n

.meas tran vdout0_29ck1340 FIND v(dout0_29) AT=675.025n

.meas tran vdout0_30ck1340 FIND v(dout0_30) AT=675.025n

.meas tran vdout0_31ck1340 FIND v(dout0_31) AT=675.025n

.meas tran vdout1_0ck1340 FIND v(dout1_0) AT=675.025n

.meas tran vdout1_1ck1340 FIND v(dout1_1) AT=675.025n

.meas tran vdout1_2ck1340 FIND v(dout1_2) AT=675.025n

.meas tran vdout1_3ck1340 FIND v(dout1_3) AT=675.025n

.meas tran vdout1_4ck1340 FIND v(dout1_4) AT=675.025n

.meas tran vdout1_5ck1340 FIND v(dout1_5) AT=675.025n

.meas tran vdout1_6ck1340 FIND v(dout1_6) AT=675.025n

.meas tran vdout1_7ck1340 FIND v(dout1_7) AT=675.025n

.meas tran vdout1_8ck1340 FIND v(dout1_8) AT=675.025n

.meas tran vdout1_9ck1340 FIND v(dout1_9) AT=675.025n

.meas tran vdout1_10ck1340 FIND v(dout1_10) AT=675.025n

.meas tran vdout1_11ck1340 FIND v(dout1_11) AT=675.025n

.meas tran vdout1_12ck1340 FIND v(dout1_12) AT=675.025n

.meas tran vdout1_13ck1340 FIND v(dout1_13) AT=675.025n

.meas tran vdout1_14ck1340 FIND v(dout1_14) AT=675.025n

.meas tran vdout1_15ck1340 FIND v(dout1_15) AT=675.025n

.meas tran vdout1_16ck1340 FIND v(dout1_16) AT=675.025n

.meas tran vdout1_17ck1340 FIND v(dout1_17) AT=675.025n

.meas tran vdout1_18ck1340 FIND v(dout1_18) AT=675.025n

.meas tran vdout1_19ck1340 FIND v(dout1_19) AT=675.025n

.meas tran vdout1_20ck1340 FIND v(dout1_20) AT=675.025n

.meas tran vdout1_21ck1340 FIND v(dout1_21) AT=675.025n

.meas tran vdout1_22ck1340 FIND v(dout1_22) AT=675.025n

.meas tran vdout1_23ck1340 FIND v(dout1_23) AT=675.025n

.meas tran vdout1_24ck1340 FIND v(dout1_24) AT=675.025n

.meas tran vdout1_25ck1340 FIND v(dout1_25) AT=675.025n

.meas tran vdout1_26ck1340 FIND v(dout1_26) AT=675.025n

.meas tran vdout1_27ck1340 FIND v(dout1_27) AT=675.025n

.meas tran vdout1_28ck1340 FIND v(dout1_28) AT=675.025n

.meas tran vdout1_29ck1340 FIND v(dout1_29) AT=675.025n

.meas tran vdout1_30ck1340 FIND v(dout1_30) AT=675.025n

.meas tran vdout1_31ck1340 FIND v(dout1_31) AT=675.025n

.meas tran vdout0_0ck1350 FIND v(dout0_0) AT=680.025n

.meas tran vdout0_1ck1350 FIND v(dout0_1) AT=680.025n

.meas tran vdout0_2ck1350 FIND v(dout0_2) AT=680.025n

.meas tran vdout0_3ck1350 FIND v(dout0_3) AT=680.025n

.meas tran vdout0_4ck1350 FIND v(dout0_4) AT=680.025n

.meas tran vdout0_5ck1350 FIND v(dout0_5) AT=680.025n

.meas tran vdout0_6ck1350 FIND v(dout0_6) AT=680.025n

.meas tran vdout0_7ck1350 FIND v(dout0_7) AT=680.025n

.meas tran vdout0_8ck1350 FIND v(dout0_8) AT=680.025n

.meas tran vdout0_9ck1350 FIND v(dout0_9) AT=680.025n

.meas tran vdout0_10ck1350 FIND v(dout0_10) AT=680.025n

.meas tran vdout0_11ck1350 FIND v(dout0_11) AT=680.025n

.meas tran vdout0_12ck1350 FIND v(dout0_12) AT=680.025n

.meas tran vdout0_13ck1350 FIND v(dout0_13) AT=680.025n

.meas tran vdout0_14ck1350 FIND v(dout0_14) AT=680.025n

.meas tran vdout0_15ck1350 FIND v(dout0_15) AT=680.025n

.meas tran vdout0_16ck1350 FIND v(dout0_16) AT=680.025n

.meas tran vdout0_17ck1350 FIND v(dout0_17) AT=680.025n

.meas tran vdout0_18ck1350 FIND v(dout0_18) AT=680.025n

.meas tran vdout0_19ck1350 FIND v(dout0_19) AT=680.025n

.meas tran vdout0_20ck1350 FIND v(dout0_20) AT=680.025n

.meas tran vdout0_21ck1350 FIND v(dout0_21) AT=680.025n

.meas tran vdout0_22ck1350 FIND v(dout0_22) AT=680.025n

.meas tran vdout0_23ck1350 FIND v(dout0_23) AT=680.025n

.meas tran vdout0_24ck1350 FIND v(dout0_24) AT=680.025n

.meas tran vdout0_25ck1350 FIND v(dout0_25) AT=680.025n

.meas tran vdout0_26ck1350 FIND v(dout0_26) AT=680.025n

.meas tran vdout0_27ck1350 FIND v(dout0_27) AT=680.025n

.meas tran vdout0_28ck1350 FIND v(dout0_28) AT=680.025n

.meas tran vdout0_29ck1350 FIND v(dout0_29) AT=680.025n

.meas tran vdout0_30ck1350 FIND v(dout0_30) AT=680.025n

.meas tran vdout0_31ck1350 FIND v(dout0_31) AT=680.025n

.meas tran vdout0_0ck1370 FIND v(dout0_0) AT=690.025n

.meas tran vdout0_1ck1370 FIND v(dout0_1) AT=690.025n

.meas tran vdout0_2ck1370 FIND v(dout0_2) AT=690.025n

.meas tran vdout0_3ck1370 FIND v(dout0_3) AT=690.025n

.meas tran vdout0_4ck1370 FIND v(dout0_4) AT=690.025n

.meas tran vdout0_5ck1370 FIND v(dout0_5) AT=690.025n

.meas tran vdout0_6ck1370 FIND v(dout0_6) AT=690.025n

.meas tran vdout0_7ck1370 FIND v(dout0_7) AT=690.025n

.meas tran vdout0_8ck1370 FIND v(dout0_8) AT=690.025n

.meas tran vdout0_9ck1370 FIND v(dout0_9) AT=690.025n

.meas tran vdout0_10ck1370 FIND v(dout0_10) AT=690.025n

.meas tran vdout0_11ck1370 FIND v(dout0_11) AT=690.025n

.meas tran vdout0_12ck1370 FIND v(dout0_12) AT=690.025n

.meas tran vdout0_13ck1370 FIND v(dout0_13) AT=690.025n

.meas tran vdout0_14ck1370 FIND v(dout0_14) AT=690.025n

.meas tran vdout0_15ck1370 FIND v(dout0_15) AT=690.025n

.meas tran vdout0_16ck1370 FIND v(dout0_16) AT=690.025n

.meas tran vdout0_17ck1370 FIND v(dout0_17) AT=690.025n

.meas tran vdout0_18ck1370 FIND v(dout0_18) AT=690.025n

.meas tran vdout0_19ck1370 FIND v(dout0_19) AT=690.025n

.meas tran vdout0_20ck1370 FIND v(dout0_20) AT=690.025n

.meas tran vdout0_21ck1370 FIND v(dout0_21) AT=690.025n

.meas tran vdout0_22ck1370 FIND v(dout0_22) AT=690.025n

.meas tran vdout0_23ck1370 FIND v(dout0_23) AT=690.025n

.meas tran vdout0_24ck1370 FIND v(dout0_24) AT=690.025n

.meas tran vdout0_25ck1370 FIND v(dout0_25) AT=690.025n

.meas tran vdout0_26ck1370 FIND v(dout0_26) AT=690.025n

.meas tran vdout0_27ck1370 FIND v(dout0_27) AT=690.025n

.meas tran vdout0_28ck1370 FIND v(dout0_28) AT=690.025n

.meas tran vdout0_29ck1370 FIND v(dout0_29) AT=690.025n

.meas tran vdout0_30ck1370 FIND v(dout0_30) AT=690.025n

.meas tran vdout0_31ck1370 FIND v(dout0_31) AT=690.025n

.meas tran vdout1_0ck1370 FIND v(dout1_0) AT=690.025n

.meas tran vdout1_1ck1370 FIND v(dout1_1) AT=690.025n

.meas tran vdout1_2ck1370 FIND v(dout1_2) AT=690.025n

.meas tran vdout1_3ck1370 FIND v(dout1_3) AT=690.025n

.meas tran vdout1_4ck1370 FIND v(dout1_4) AT=690.025n

.meas tran vdout1_5ck1370 FIND v(dout1_5) AT=690.025n

.meas tran vdout1_6ck1370 FIND v(dout1_6) AT=690.025n

.meas tran vdout1_7ck1370 FIND v(dout1_7) AT=690.025n

.meas tran vdout1_8ck1370 FIND v(dout1_8) AT=690.025n

.meas tran vdout1_9ck1370 FIND v(dout1_9) AT=690.025n

.meas tran vdout1_10ck1370 FIND v(dout1_10) AT=690.025n

.meas tran vdout1_11ck1370 FIND v(dout1_11) AT=690.025n

.meas tran vdout1_12ck1370 FIND v(dout1_12) AT=690.025n

.meas tran vdout1_13ck1370 FIND v(dout1_13) AT=690.025n

.meas tran vdout1_14ck1370 FIND v(dout1_14) AT=690.025n

.meas tran vdout1_15ck1370 FIND v(dout1_15) AT=690.025n

.meas tran vdout1_16ck1370 FIND v(dout1_16) AT=690.025n

.meas tran vdout1_17ck1370 FIND v(dout1_17) AT=690.025n

.meas tran vdout1_18ck1370 FIND v(dout1_18) AT=690.025n

.meas tran vdout1_19ck1370 FIND v(dout1_19) AT=690.025n

.meas tran vdout1_20ck1370 FIND v(dout1_20) AT=690.025n

.meas tran vdout1_21ck1370 FIND v(dout1_21) AT=690.025n

.meas tran vdout1_22ck1370 FIND v(dout1_22) AT=690.025n

.meas tran vdout1_23ck1370 FIND v(dout1_23) AT=690.025n

.meas tran vdout1_24ck1370 FIND v(dout1_24) AT=690.025n

.meas tran vdout1_25ck1370 FIND v(dout1_25) AT=690.025n

.meas tran vdout1_26ck1370 FIND v(dout1_26) AT=690.025n

.meas tran vdout1_27ck1370 FIND v(dout1_27) AT=690.025n

.meas tran vdout1_28ck1370 FIND v(dout1_28) AT=690.025n

.meas tran vdout1_29ck1370 FIND v(dout1_29) AT=690.025n

.meas tran vdout1_30ck1370 FIND v(dout1_30) AT=690.025n

.meas tran vdout1_31ck1370 FIND v(dout1_31) AT=690.025n

.meas tran vdout1_0ck1380 FIND v(dout1_0) AT=695.025n

.meas tran vdout1_1ck1380 FIND v(dout1_1) AT=695.025n

.meas tran vdout1_2ck1380 FIND v(dout1_2) AT=695.025n

.meas tran vdout1_3ck1380 FIND v(dout1_3) AT=695.025n

.meas tran vdout1_4ck1380 FIND v(dout1_4) AT=695.025n

.meas tran vdout1_5ck1380 FIND v(dout1_5) AT=695.025n

.meas tran vdout1_6ck1380 FIND v(dout1_6) AT=695.025n

.meas tran vdout1_7ck1380 FIND v(dout1_7) AT=695.025n

.meas tran vdout1_8ck1380 FIND v(dout1_8) AT=695.025n

.meas tran vdout1_9ck1380 FIND v(dout1_9) AT=695.025n

.meas tran vdout1_10ck1380 FIND v(dout1_10) AT=695.025n

.meas tran vdout1_11ck1380 FIND v(dout1_11) AT=695.025n

.meas tran vdout1_12ck1380 FIND v(dout1_12) AT=695.025n

.meas tran vdout1_13ck1380 FIND v(dout1_13) AT=695.025n

.meas tran vdout1_14ck1380 FIND v(dout1_14) AT=695.025n

.meas tran vdout1_15ck1380 FIND v(dout1_15) AT=695.025n

.meas tran vdout1_16ck1380 FIND v(dout1_16) AT=695.025n

.meas tran vdout1_17ck1380 FIND v(dout1_17) AT=695.025n

.meas tran vdout1_18ck1380 FIND v(dout1_18) AT=695.025n

.meas tran vdout1_19ck1380 FIND v(dout1_19) AT=695.025n

.meas tran vdout1_20ck1380 FIND v(dout1_20) AT=695.025n

.meas tran vdout1_21ck1380 FIND v(dout1_21) AT=695.025n

.meas tran vdout1_22ck1380 FIND v(dout1_22) AT=695.025n

.meas tran vdout1_23ck1380 FIND v(dout1_23) AT=695.025n

.meas tran vdout1_24ck1380 FIND v(dout1_24) AT=695.025n

.meas tran vdout1_25ck1380 FIND v(dout1_25) AT=695.025n

.meas tran vdout1_26ck1380 FIND v(dout1_26) AT=695.025n

.meas tran vdout1_27ck1380 FIND v(dout1_27) AT=695.025n

.meas tran vdout1_28ck1380 FIND v(dout1_28) AT=695.025n

.meas tran vdout1_29ck1380 FIND v(dout1_29) AT=695.025n

.meas tran vdout1_30ck1380 FIND v(dout1_30) AT=695.025n

.meas tran vdout1_31ck1380 FIND v(dout1_31) AT=695.025n

.meas tran vdout0_0ck1390 FIND v(dout0_0) AT=700.025n

.meas tran vdout0_1ck1390 FIND v(dout0_1) AT=700.025n

.meas tran vdout0_2ck1390 FIND v(dout0_2) AT=700.025n

.meas tran vdout0_3ck1390 FIND v(dout0_3) AT=700.025n

.meas tran vdout0_4ck1390 FIND v(dout0_4) AT=700.025n

.meas tran vdout0_5ck1390 FIND v(dout0_5) AT=700.025n

.meas tran vdout0_6ck1390 FIND v(dout0_6) AT=700.025n

.meas tran vdout0_7ck1390 FIND v(dout0_7) AT=700.025n

.meas tran vdout0_8ck1390 FIND v(dout0_8) AT=700.025n

.meas tran vdout0_9ck1390 FIND v(dout0_9) AT=700.025n

.meas tran vdout0_10ck1390 FIND v(dout0_10) AT=700.025n

.meas tran vdout0_11ck1390 FIND v(dout0_11) AT=700.025n

.meas tran vdout0_12ck1390 FIND v(dout0_12) AT=700.025n

.meas tran vdout0_13ck1390 FIND v(dout0_13) AT=700.025n

.meas tran vdout0_14ck1390 FIND v(dout0_14) AT=700.025n

.meas tran vdout0_15ck1390 FIND v(dout0_15) AT=700.025n

.meas tran vdout0_16ck1390 FIND v(dout0_16) AT=700.025n

.meas tran vdout0_17ck1390 FIND v(dout0_17) AT=700.025n

.meas tran vdout0_18ck1390 FIND v(dout0_18) AT=700.025n

.meas tran vdout0_19ck1390 FIND v(dout0_19) AT=700.025n

.meas tran vdout0_20ck1390 FIND v(dout0_20) AT=700.025n

.meas tran vdout0_21ck1390 FIND v(dout0_21) AT=700.025n

.meas tran vdout0_22ck1390 FIND v(dout0_22) AT=700.025n

.meas tran vdout0_23ck1390 FIND v(dout0_23) AT=700.025n

.meas tran vdout0_24ck1390 FIND v(dout0_24) AT=700.025n

.meas tran vdout0_25ck1390 FIND v(dout0_25) AT=700.025n

.meas tran vdout0_26ck1390 FIND v(dout0_26) AT=700.025n

.meas tran vdout0_27ck1390 FIND v(dout0_27) AT=700.025n

.meas tran vdout0_28ck1390 FIND v(dout0_28) AT=700.025n

.meas tran vdout0_29ck1390 FIND v(dout0_29) AT=700.025n

.meas tran vdout0_30ck1390 FIND v(dout0_30) AT=700.025n

.meas tran vdout0_31ck1390 FIND v(dout0_31) AT=700.025n

.meas tran vdout1_0ck1400 FIND v(dout1_0) AT=705.025n

.meas tran vdout1_1ck1400 FIND v(dout1_1) AT=705.025n

.meas tran vdout1_2ck1400 FIND v(dout1_2) AT=705.025n

.meas tran vdout1_3ck1400 FIND v(dout1_3) AT=705.025n

.meas tran vdout1_4ck1400 FIND v(dout1_4) AT=705.025n

.meas tran vdout1_5ck1400 FIND v(dout1_5) AT=705.025n

.meas tran vdout1_6ck1400 FIND v(dout1_6) AT=705.025n

.meas tran vdout1_7ck1400 FIND v(dout1_7) AT=705.025n

.meas tran vdout1_8ck1400 FIND v(dout1_8) AT=705.025n

.meas tran vdout1_9ck1400 FIND v(dout1_9) AT=705.025n

.meas tran vdout1_10ck1400 FIND v(dout1_10) AT=705.025n

.meas tran vdout1_11ck1400 FIND v(dout1_11) AT=705.025n

.meas tran vdout1_12ck1400 FIND v(dout1_12) AT=705.025n

.meas tran vdout1_13ck1400 FIND v(dout1_13) AT=705.025n

.meas tran vdout1_14ck1400 FIND v(dout1_14) AT=705.025n

.meas tran vdout1_15ck1400 FIND v(dout1_15) AT=705.025n

.meas tran vdout1_16ck1400 FIND v(dout1_16) AT=705.025n

.meas tran vdout1_17ck1400 FIND v(dout1_17) AT=705.025n

.meas tran vdout1_18ck1400 FIND v(dout1_18) AT=705.025n

.meas tran vdout1_19ck1400 FIND v(dout1_19) AT=705.025n

.meas tran vdout1_20ck1400 FIND v(dout1_20) AT=705.025n

.meas tran vdout1_21ck1400 FIND v(dout1_21) AT=705.025n

.meas tran vdout1_22ck1400 FIND v(dout1_22) AT=705.025n

.meas tran vdout1_23ck1400 FIND v(dout1_23) AT=705.025n

.meas tran vdout1_24ck1400 FIND v(dout1_24) AT=705.025n

.meas tran vdout1_25ck1400 FIND v(dout1_25) AT=705.025n

.meas tran vdout1_26ck1400 FIND v(dout1_26) AT=705.025n

.meas tran vdout1_27ck1400 FIND v(dout1_27) AT=705.025n

.meas tran vdout1_28ck1400 FIND v(dout1_28) AT=705.025n

.meas tran vdout1_29ck1400 FIND v(dout1_29) AT=705.025n

.meas tran vdout1_30ck1400 FIND v(dout1_30) AT=705.025n

.meas tran vdout1_31ck1400 FIND v(dout1_31) AT=705.025n

.meas tran vdout0_0ck1410 FIND v(dout0_0) AT=710.025n

.meas tran vdout0_1ck1410 FIND v(dout0_1) AT=710.025n

.meas tran vdout0_2ck1410 FIND v(dout0_2) AT=710.025n

.meas tran vdout0_3ck1410 FIND v(dout0_3) AT=710.025n

.meas tran vdout0_4ck1410 FIND v(dout0_4) AT=710.025n

.meas tran vdout0_5ck1410 FIND v(dout0_5) AT=710.025n

.meas tran vdout0_6ck1410 FIND v(dout0_6) AT=710.025n

.meas tran vdout0_7ck1410 FIND v(dout0_7) AT=710.025n

.meas tran vdout0_8ck1410 FIND v(dout0_8) AT=710.025n

.meas tran vdout0_9ck1410 FIND v(dout0_9) AT=710.025n

.meas tran vdout0_10ck1410 FIND v(dout0_10) AT=710.025n

.meas tran vdout0_11ck1410 FIND v(dout0_11) AT=710.025n

.meas tran vdout0_12ck1410 FIND v(dout0_12) AT=710.025n

.meas tran vdout0_13ck1410 FIND v(dout0_13) AT=710.025n

.meas tran vdout0_14ck1410 FIND v(dout0_14) AT=710.025n

.meas tran vdout0_15ck1410 FIND v(dout0_15) AT=710.025n

.meas tran vdout0_16ck1410 FIND v(dout0_16) AT=710.025n

.meas tran vdout0_17ck1410 FIND v(dout0_17) AT=710.025n

.meas tran vdout0_18ck1410 FIND v(dout0_18) AT=710.025n

.meas tran vdout0_19ck1410 FIND v(dout0_19) AT=710.025n

.meas tran vdout0_20ck1410 FIND v(dout0_20) AT=710.025n

.meas tran vdout0_21ck1410 FIND v(dout0_21) AT=710.025n

.meas tran vdout0_22ck1410 FIND v(dout0_22) AT=710.025n

.meas tran vdout0_23ck1410 FIND v(dout0_23) AT=710.025n

.meas tran vdout0_24ck1410 FIND v(dout0_24) AT=710.025n

.meas tran vdout0_25ck1410 FIND v(dout0_25) AT=710.025n

.meas tran vdout0_26ck1410 FIND v(dout0_26) AT=710.025n

.meas tran vdout0_27ck1410 FIND v(dout0_27) AT=710.025n

.meas tran vdout0_28ck1410 FIND v(dout0_28) AT=710.025n

.meas tran vdout0_29ck1410 FIND v(dout0_29) AT=710.025n

.meas tran vdout0_30ck1410 FIND v(dout0_30) AT=710.025n

.meas tran vdout0_31ck1410 FIND v(dout0_31) AT=710.025n

.meas tran vdout1_0ck1430 FIND v(dout1_0) AT=720.025n

.meas tran vdout1_1ck1430 FIND v(dout1_1) AT=720.025n

.meas tran vdout1_2ck1430 FIND v(dout1_2) AT=720.025n

.meas tran vdout1_3ck1430 FIND v(dout1_3) AT=720.025n

.meas tran vdout1_4ck1430 FIND v(dout1_4) AT=720.025n

.meas tran vdout1_5ck1430 FIND v(dout1_5) AT=720.025n

.meas tran vdout1_6ck1430 FIND v(dout1_6) AT=720.025n

.meas tran vdout1_7ck1430 FIND v(dout1_7) AT=720.025n

.meas tran vdout1_8ck1430 FIND v(dout1_8) AT=720.025n

.meas tran vdout1_9ck1430 FIND v(dout1_9) AT=720.025n

.meas tran vdout1_10ck1430 FIND v(dout1_10) AT=720.025n

.meas tran vdout1_11ck1430 FIND v(dout1_11) AT=720.025n

.meas tran vdout1_12ck1430 FIND v(dout1_12) AT=720.025n

.meas tran vdout1_13ck1430 FIND v(dout1_13) AT=720.025n

.meas tran vdout1_14ck1430 FIND v(dout1_14) AT=720.025n

.meas tran vdout1_15ck1430 FIND v(dout1_15) AT=720.025n

.meas tran vdout1_16ck1430 FIND v(dout1_16) AT=720.025n

.meas tran vdout1_17ck1430 FIND v(dout1_17) AT=720.025n

.meas tran vdout1_18ck1430 FIND v(dout1_18) AT=720.025n

.meas tran vdout1_19ck1430 FIND v(dout1_19) AT=720.025n

.meas tran vdout1_20ck1430 FIND v(dout1_20) AT=720.025n

.meas tran vdout1_21ck1430 FIND v(dout1_21) AT=720.025n

.meas tran vdout1_22ck1430 FIND v(dout1_22) AT=720.025n

.meas tran vdout1_23ck1430 FIND v(dout1_23) AT=720.025n

.meas tran vdout1_24ck1430 FIND v(dout1_24) AT=720.025n

.meas tran vdout1_25ck1430 FIND v(dout1_25) AT=720.025n

.meas tran vdout1_26ck1430 FIND v(dout1_26) AT=720.025n

.meas tran vdout1_27ck1430 FIND v(dout1_27) AT=720.025n

.meas tran vdout1_28ck1430 FIND v(dout1_28) AT=720.025n

.meas tran vdout1_29ck1430 FIND v(dout1_29) AT=720.025n

.meas tran vdout1_30ck1430 FIND v(dout1_30) AT=720.025n

.meas tran vdout1_31ck1430 FIND v(dout1_31) AT=720.025n

.meas tran vdout0_0ck1450 FIND v(dout0_0) AT=730.025n

.meas tran vdout0_1ck1450 FIND v(dout0_1) AT=730.025n

.meas tran vdout0_2ck1450 FIND v(dout0_2) AT=730.025n

.meas tran vdout0_3ck1450 FIND v(dout0_3) AT=730.025n

.meas tran vdout0_4ck1450 FIND v(dout0_4) AT=730.025n

.meas tran vdout0_5ck1450 FIND v(dout0_5) AT=730.025n

.meas tran vdout0_6ck1450 FIND v(dout0_6) AT=730.025n

.meas tran vdout0_7ck1450 FIND v(dout0_7) AT=730.025n

.meas tran vdout0_8ck1450 FIND v(dout0_8) AT=730.025n

.meas tran vdout0_9ck1450 FIND v(dout0_9) AT=730.025n

.meas tran vdout0_10ck1450 FIND v(dout0_10) AT=730.025n

.meas tran vdout0_11ck1450 FIND v(dout0_11) AT=730.025n

.meas tran vdout0_12ck1450 FIND v(dout0_12) AT=730.025n

.meas tran vdout0_13ck1450 FIND v(dout0_13) AT=730.025n

.meas tran vdout0_14ck1450 FIND v(dout0_14) AT=730.025n

.meas tran vdout0_15ck1450 FIND v(dout0_15) AT=730.025n

.meas tran vdout0_16ck1450 FIND v(dout0_16) AT=730.025n

.meas tran vdout0_17ck1450 FIND v(dout0_17) AT=730.025n

.meas tran vdout0_18ck1450 FIND v(dout0_18) AT=730.025n

.meas tran vdout0_19ck1450 FIND v(dout0_19) AT=730.025n

.meas tran vdout0_20ck1450 FIND v(dout0_20) AT=730.025n

.meas tran vdout0_21ck1450 FIND v(dout0_21) AT=730.025n

.meas tran vdout0_22ck1450 FIND v(dout0_22) AT=730.025n

.meas tran vdout0_23ck1450 FIND v(dout0_23) AT=730.025n

.meas tran vdout0_24ck1450 FIND v(dout0_24) AT=730.025n

.meas tran vdout0_25ck1450 FIND v(dout0_25) AT=730.025n

.meas tran vdout0_26ck1450 FIND v(dout0_26) AT=730.025n

.meas tran vdout0_27ck1450 FIND v(dout0_27) AT=730.025n

.meas tran vdout0_28ck1450 FIND v(dout0_28) AT=730.025n

.meas tran vdout0_29ck1450 FIND v(dout0_29) AT=730.025n

.meas tran vdout0_30ck1450 FIND v(dout0_30) AT=730.025n

.meas tran vdout0_31ck1450 FIND v(dout0_31) AT=730.025n

.meas tran vdout1_0ck1450 FIND v(dout1_0) AT=730.025n

.meas tran vdout1_1ck1450 FIND v(dout1_1) AT=730.025n

.meas tran vdout1_2ck1450 FIND v(dout1_2) AT=730.025n

.meas tran vdout1_3ck1450 FIND v(dout1_3) AT=730.025n

.meas tran vdout1_4ck1450 FIND v(dout1_4) AT=730.025n

.meas tran vdout1_5ck1450 FIND v(dout1_5) AT=730.025n

.meas tran vdout1_6ck1450 FIND v(dout1_6) AT=730.025n

.meas tran vdout1_7ck1450 FIND v(dout1_7) AT=730.025n

.meas tran vdout1_8ck1450 FIND v(dout1_8) AT=730.025n

.meas tran vdout1_9ck1450 FIND v(dout1_9) AT=730.025n

.meas tran vdout1_10ck1450 FIND v(dout1_10) AT=730.025n

.meas tran vdout1_11ck1450 FIND v(dout1_11) AT=730.025n

.meas tran vdout1_12ck1450 FIND v(dout1_12) AT=730.025n

.meas tran vdout1_13ck1450 FIND v(dout1_13) AT=730.025n

.meas tran vdout1_14ck1450 FIND v(dout1_14) AT=730.025n

.meas tran vdout1_15ck1450 FIND v(dout1_15) AT=730.025n

.meas tran vdout1_16ck1450 FIND v(dout1_16) AT=730.025n

.meas tran vdout1_17ck1450 FIND v(dout1_17) AT=730.025n

.meas tran vdout1_18ck1450 FIND v(dout1_18) AT=730.025n

.meas tran vdout1_19ck1450 FIND v(dout1_19) AT=730.025n

.meas tran vdout1_20ck1450 FIND v(dout1_20) AT=730.025n

.meas tran vdout1_21ck1450 FIND v(dout1_21) AT=730.025n

.meas tran vdout1_22ck1450 FIND v(dout1_22) AT=730.025n

.meas tran vdout1_23ck1450 FIND v(dout1_23) AT=730.025n

.meas tran vdout1_24ck1450 FIND v(dout1_24) AT=730.025n

.meas tran vdout1_25ck1450 FIND v(dout1_25) AT=730.025n

.meas tran vdout1_26ck1450 FIND v(dout1_26) AT=730.025n

.meas tran vdout1_27ck1450 FIND v(dout1_27) AT=730.025n

.meas tran vdout1_28ck1450 FIND v(dout1_28) AT=730.025n

.meas tran vdout1_29ck1450 FIND v(dout1_29) AT=730.025n

.meas tran vdout1_30ck1450 FIND v(dout1_30) AT=730.025n

.meas tran vdout1_31ck1450 FIND v(dout1_31) AT=730.025n

.meas tran vdout0_0ck1460 FIND v(dout0_0) AT=735.025n

.meas tran vdout0_1ck1460 FIND v(dout0_1) AT=735.025n

.meas tran vdout0_2ck1460 FIND v(dout0_2) AT=735.025n

.meas tran vdout0_3ck1460 FIND v(dout0_3) AT=735.025n

.meas tran vdout0_4ck1460 FIND v(dout0_4) AT=735.025n

.meas tran vdout0_5ck1460 FIND v(dout0_5) AT=735.025n

.meas tran vdout0_6ck1460 FIND v(dout0_6) AT=735.025n

.meas tran vdout0_7ck1460 FIND v(dout0_7) AT=735.025n

.meas tran vdout0_8ck1460 FIND v(dout0_8) AT=735.025n

.meas tran vdout0_9ck1460 FIND v(dout0_9) AT=735.025n

.meas tran vdout0_10ck1460 FIND v(dout0_10) AT=735.025n

.meas tran vdout0_11ck1460 FIND v(dout0_11) AT=735.025n

.meas tran vdout0_12ck1460 FIND v(dout0_12) AT=735.025n

.meas tran vdout0_13ck1460 FIND v(dout0_13) AT=735.025n

.meas tran vdout0_14ck1460 FIND v(dout0_14) AT=735.025n

.meas tran vdout0_15ck1460 FIND v(dout0_15) AT=735.025n

.meas tran vdout0_16ck1460 FIND v(dout0_16) AT=735.025n

.meas tran vdout0_17ck1460 FIND v(dout0_17) AT=735.025n

.meas tran vdout0_18ck1460 FIND v(dout0_18) AT=735.025n

.meas tran vdout0_19ck1460 FIND v(dout0_19) AT=735.025n

.meas tran vdout0_20ck1460 FIND v(dout0_20) AT=735.025n

.meas tran vdout0_21ck1460 FIND v(dout0_21) AT=735.025n

.meas tran vdout0_22ck1460 FIND v(dout0_22) AT=735.025n

.meas tran vdout0_23ck1460 FIND v(dout0_23) AT=735.025n

.meas tran vdout0_24ck1460 FIND v(dout0_24) AT=735.025n

.meas tran vdout0_25ck1460 FIND v(dout0_25) AT=735.025n

.meas tran vdout0_26ck1460 FIND v(dout0_26) AT=735.025n

.meas tran vdout0_27ck1460 FIND v(dout0_27) AT=735.025n

.meas tran vdout0_28ck1460 FIND v(dout0_28) AT=735.025n

.meas tran vdout0_29ck1460 FIND v(dout0_29) AT=735.025n

.meas tran vdout0_30ck1460 FIND v(dout0_30) AT=735.025n

.meas tran vdout0_31ck1460 FIND v(dout0_31) AT=735.025n

.meas tran vdout1_0ck1460 FIND v(dout1_0) AT=735.025n

.meas tran vdout1_1ck1460 FIND v(dout1_1) AT=735.025n

.meas tran vdout1_2ck1460 FIND v(dout1_2) AT=735.025n

.meas tran vdout1_3ck1460 FIND v(dout1_3) AT=735.025n

.meas tran vdout1_4ck1460 FIND v(dout1_4) AT=735.025n

.meas tran vdout1_5ck1460 FIND v(dout1_5) AT=735.025n

.meas tran vdout1_6ck1460 FIND v(dout1_6) AT=735.025n

.meas tran vdout1_7ck1460 FIND v(dout1_7) AT=735.025n

.meas tran vdout1_8ck1460 FIND v(dout1_8) AT=735.025n

.meas tran vdout1_9ck1460 FIND v(dout1_9) AT=735.025n

.meas tran vdout1_10ck1460 FIND v(dout1_10) AT=735.025n

.meas tran vdout1_11ck1460 FIND v(dout1_11) AT=735.025n

.meas tran vdout1_12ck1460 FIND v(dout1_12) AT=735.025n

.meas tran vdout1_13ck1460 FIND v(dout1_13) AT=735.025n

.meas tran vdout1_14ck1460 FIND v(dout1_14) AT=735.025n

.meas tran vdout1_15ck1460 FIND v(dout1_15) AT=735.025n

.meas tran vdout1_16ck1460 FIND v(dout1_16) AT=735.025n

.meas tran vdout1_17ck1460 FIND v(dout1_17) AT=735.025n

.meas tran vdout1_18ck1460 FIND v(dout1_18) AT=735.025n

.meas tran vdout1_19ck1460 FIND v(dout1_19) AT=735.025n

.meas tran vdout1_20ck1460 FIND v(dout1_20) AT=735.025n

.meas tran vdout1_21ck1460 FIND v(dout1_21) AT=735.025n

.meas tran vdout1_22ck1460 FIND v(dout1_22) AT=735.025n

.meas tran vdout1_23ck1460 FIND v(dout1_23) AT=735.025n

.meas tran vdout1_24ck1460 FIND v(dout1_24) AT=735.025n

.meas tran vdout1_25ck1460 FIND v(dout1_25) AT=735.025n

.meas tran vdout1_26ck1460 FIND v(dout1_26) AT=735.025n

.meas tran vdout1_27ck1460 FIND v(dout1_27) AT=735.025n

.meas tran vdout1_28ck1460 FIND v(dout1_28) AT=735.025n

.meas tran vdout1_29ck1460 FIND v(dout1_29) AT=735.025n

.meas tran vdout1_30ck1460 FIND v(dout1_30) AT=735.025n

.meas tran vdout1_31ck1460 FIND v(dout1_31) AT=735.025n

.meas tran vdout1_0ck1490 FIND v(dout1_0) AT=750.025n

.meas tran vdout1_1ck1490 FIND v(dout1_1) AT=750.025n

.meas tran vdout1_2ck1490 FIND v(dout1_2) AT=750.025n

.meas tran vdout1_3ck1490 FIND v(dout1_3) AT=750.025n

.meas tran vdout1_4ck1490 FIND v(dout1_4) AT=750.025n

.meas tran vdout1_5ck1490 FIND v(dout1_5) AT=750.025n

.meas tran vdout1_6ck1490 FIND v(dout1_6) AT=750.025n

.meas tran vdout1_7ck1490 FIND v(dout1_7) AT=750.025n

.meas tran vdout1_8ck1490 FIND v(dout1_8) AT=750.025n

.meas tran vdout1_9ck1490 FIND v(dout1_9) AT=750.025n

.meas tran vdout1_10ck1490 FIND v(dout1_10) AT=750.025n

.meas tran vdout1_11ck1490 FIND v(dout1_11) AT=750.025n

.meas tran vdout1_12ck1490 FIND v(dout1_12) AT=750.025n

.meas tran vdout1_13ck1490 FIND v(dout1_13) AT=750.025n

.meas tran vdout1_14ck1490 FIND v(dout1_14) AT=750.025n

.meas tran vdout1_15ck1490 FIND v(dout1_15) AT=750.025n

.meas tran vdout1_16ck1490 FIND v(dout1_16) AT=750.025n

.meas tran vdout1_17ck1490 FIND v(dout1_17) AT=750.025n

.meas tran vdout1_18ck1490 FIND v(dout1_18) AT=750.025n

.meas tran vdout1_19ck1490 FIND v(dout1_19) AT=750.025n

.meas tran vdout1_20ck1490 FIND v(dout1_20) AT=750.025n

.meas tran vdout1_21ck1490 FIND v(dout1_21) AT=750.025n

.meas tran vdout1_22ck1490 FIND v(dout1_22) AT=750.025n

.meas tran vdout1_23ck1490 FIND v(dout1_23) AT=750.025n

.meas tran vdout1_24ck1490 FIND v(dout1_24) AT=750.025n

.meas tran vdout1_25ck1490 FIND v(dout1_25) AT=750.025n

.meas tran vdout1_26ck1490 FIND v(dout1_26) AT=750.025n

.meas tran vdout1_27ck1490 FIND v(dout1_27) AT=750.025n

.meas tran vdout1_28ck1490 FIND v(dout1_28) AT=750.025n

.meas tran vdout1_29ck1490 FIND v(dout1_29) AT=750.025n

.meas tran vdout1_30ck1490 FIND v(dout1_30) AT=750.025n

.meas tran vdout1_31ck1490 FIND v(dout1_31) AT=750.025n

.meas tran vdout0_0ck1510 FIND v(dout0_0) AT=760.025n

.meas tran vdout0_1ck1510 FIND v(dout0_1) AT=760.025n

.meas tran vdout0_2ck1510 FIND v(dout0_2) AT=760.025n

.meas tran vdout0_3ck1510 FIND v(dout0_3) AT=760.025n

.meas tran vdout0_4ck1510 FIND v(dout0_4) AT=760.025n

.meas tran vdout0_5ck1510 FIND v(dout0_5) AT=760.025n

.meas tran vdout0_6ck1510 FIND v(dout0_6) AT=760.025n

.meas tran vdout0_7ck1510 FIND v(dout0_7) AT=760.025n

.meas tran vdout0_8ck1510 FIND v(dout0_8) AT=760.025n

.meas tran vdout0_9ck1510 FIND v(dout0_9) AT=760.025n

.meas tran vdout0_10ck1510 FIND v(dout0_10) AT=760.025n

.meas tran vdout0_11ck1510 FIND v(dout0_11) AT=760.025n

.meas tran vdout0_12ck1510 FIND v(dout0_12) AT=760.025n

.meas tran vdout0_13ck1510 FIND v(dout0_13) AT=760.025n

.meas tran vdout0_14ck1510 FIND v(dout0_14) AT=760.025n

.meas tran vdout0_15ck1510 FIND v(dout0_15) AT=760.025n

.meas tran vdout0_16ck1510 FIND v(dout0_16) AT=760.025n

.meas tran vdout0_17ck1510 FIND v(dout0_17) AT=760.025n

.meas tran vdout0_18ck1510 FIND v(dout0_18) AT=760.025n

.meas tran vdout0_19ck1510 FIND v(dout0_19) AT=760.025n

.meas tran vdout0_20ck1510 FIND v(dout0_20) AT=760.025n

.meas tran vdout0_21ck1510 FIND v(dout0_21) AT=760.025n

.meas tran vdout0_22ck1510 FIND v(dout0_22) AT=760.025n

.meas tran vdout0_23ck1510 FIND v(dout0_23) AT=760.025n

.meas tran vdout0_24ck1510 FIND v(dout0_24) AT=760.025n

.meas tran vdout0_25ck1510 FIND v(dout0_25) AT=760.025n

.meas tran vdout0_26ck1510 FIND v(dout0_26) AT=760.025n

.meas tran vdout0_27ck1510 FIND v(dout0_27) AT=760.025n

.meas tran vdout0_28ck1510 FIND v(dout0_28) AT=760.025n

.meas tran vdout0_29ck1510 FIND v(dout0_29) AT=760.025n

.meas tran vdout0_30ck1510 FIND v(dout0_30) AT=760.025n

.meas tran vdout0_31ck1510 FIND v(dout0_31) AT=760.025n

.meas tran vdout1_0ck1510 FIND v(dout1_0) AT=760.025n

.meas tran vdout1_1ck1510 FIND v(dout1_1) AT=760.025n

.meas tran vdout1_2ck1510 FIND v(dout1_2) AT=760.025n

.meas tran vdout1_3ck1510 FIND v(dout1_3) AT=760.025n

.meas tran vdout1_4ck1510 FIND v(dout1_4) AT=760.025n

.meas tran vdout1_5ck1510 FIND v(dout1_5) AT=760.025n

.meas tran vdout1_6ck1510 FIND v(dout1_6) AT=760.025n

.meas tran vdout1_7ck1510 FIND v(dout1_7) AT=760.025n

.meas tran vdout1_8ck1510 FIND v(dout1_8) AT=760.025n

.meas tran vdout1_9ck1510 FIND v(dout1_9) AT=760.025n

.meas tran vdout1_10ck1510 FIND v(dout1_10) AT=760.025n

.meas tran vdout1_11ck1510 FIND v(dout1_11) AT=760.025n

.meas tran vdout1_12ck1510 FIND v(dout1_12) AT=760.025n

.meas tran vdout1_13ck1510 FIND v(dout1_13) AT=760.025n

.meas tran vdout1_14ck1510 FIND v(dout1_14) AT=760.025n

.meas tran vdout1_15ck1510 FIND v(dout1_15) AT=760.025n

.meas tran vdout1_16ck1510 FIND v(dout1_16) AT=760.025n

.meas tran vdout1_17ck1510 FIND v(dout1_17) AT=760.025n

.meas tran vdout1_18ck1510 FIND v(dout1_18) AT=760.025n

.meas tran vdout1_19ck1510 FIND v(dout1_19) AT=760.025n

.meas tran vdout1_20ck1510 FIND v(dout1_20) AT=760.025n

.meas tran vdout1_21ck1510 FIND v(dout1_21) AT=760.025n

.meas tran vdout1_22ck1510 FIND v(dout1_22) AT=760.025n

.meas tran vdout1_23ck1510 FIND v(dout1_23) AT=760.025n

.meas tran vdout1_24ck1510 FIND v(dout1_24) AT=760.025n

.meas tran vdout1_25ck1510 FIND v(dout1_25) AT=760.025n

.meas tran vdout1_26ck1510 FIND v(dout1_26) AT=760.025n

.meas tran vdout1_27ck1510 FIND v(dout1_27) AT=760.025n

.meas tran vdout1_28ck1510 FIND v(dout1_28) AT=760.025n

.meas tran vdout1_29ck1510 FIND v(dout1_29) AT=760.025n

.meas tran vdout1_30ck1510 FIND v(dout1_30) AT=760.025n

.meas tran vdout1_31ck1510 FIND v(dout1_31) AT=760.025n

.meas tran vdout0_0ck1520 FIND v(dout0_0) AT=765.025n

.meas tran vdout0_1ck1520 FIND v(dout0_1) AT=765.025n

.meas tran vdout0_2ck1520 FIND v(dout0_2) AT=765.025n

.meas tran vdout0_3ck1520 FIND v(dout0_3) AT=765.025n

.meas tran vdout0_4ck1520 FIND v(dout0_4) AT=765.025n

.meas tran vdout0_5ck1520 FIND v(dout0_5) AT=765.025n

.meas tran vdout0_6ck1520 FIND v(dout0_6) AT=765.025n

.meas tran vdout0_7ck1520 FIND v(dout0_7) AT=765.025n

.meas tran vdout0_8ck1520 FIND v(dout0_8) AT=765.025n

.meas tran vdout0_9ck1520 FIND v(dout0_9) AT=765.025n

.meas tran vdout0_10ck1520 FIND v(dout0_10) AT=765.025n

.meas tran vdout0_11ck1520 FIND v(dout0_11) AT=765.025n

.meas tran vdout0_12ck1520 FIND v(dout0_12) AT=765.025n

.meas tran vdout0_13ck1520 FIND v(dout0_13) AT=765.025n

.meas tran vdout0_14ck1520 FIND v(dout0_14) AT=765.025n

.meas tran vdout0_15ck1520 FIND v(dout0_15) AT=765.025n

.meas tran vdout0_16ck1520 FIND v(dout0_16) AT=765.025n

.meas tran vdout0_17ck1520 FIND v(dout0_17) AT=765.025n

.meas tran vdout0_18ck1520 FIND v(dout0_18) AT=765.025n

.meas tran vdout0_19ck1520 FIND v(dout0_19) AT=765.025n

.meas tran vdout0_20ck1520 FIND v(dout0_20) AT=765.025n

.meas tran vdout0_21ck1520 FIND v(dout0_21) AT=765.025n

.meas tran vdout0_22ck1520 FIND v(dout0_22) AT=765.025n

.meas tran vdout0_23ck1520 FIND v(dout0_23) AT=765.025n

.meas tran vdout0_24ck1520 FIND v(dout0_24) AT=765.025n

.meas tran vdout0_25ck1520 FIND v(dout0_25) AT=765.025n

.meas tran vdout0_26ck1520 FIND v(dout0_26) AT=765.025n

.meas tran vdout0_27ck1520 FIND v(dout0_27) AT=765.025n

.meas tran vdout0_28ck1520 FIND v(dout0_28) AT=765.025n

.meas tran vdout0_29ck1520 FIND v(dout0_29) AT=765.025n

.meas tran vdout0_30ck1520 FIND v(dout0_30) AT=765.025n

.meas tran vdout0_31ck1520 FIND v(dout0_31) AT=765.025n

.meas tran vdout0_0ck1530 FIND v(dout0_0) AT=770.025n

.meas tran vdout0_1ck1530 FIND v(dout0_1) AT=770.025n

.meas tran vdout0_2ck1530 FIND v(dout0_2) AT=770.025n

.meas tran vdout0_3ck1530 FIND v(dout0_3) AT=770.025n

.meas tran vdout0_4ck1530 FIND v(dout0_4) AT=770.025n

.meas tran vdout0_5ck1530 FIND v(dout0_5) AT=770.025n

.meas tran vdout0_6ck1530 FIND v(dout0_6) AT=770.025n

.meas tran vdout0_7ck1530 FIND v(dout0_7) AT=770.025n

.meas tran vdout0_8ck1530 FIND v(dout0_8) AT=770.025n

.meas tran vdout0_9ck1530 FIND v(dout0_9) AT=770.025n

.meas tran vdout0_10ck1530 FIND v(dout0_10) AT=770.025n

.meas tran vdout0_11ck1530 FIND v(dout0_11) AT=770.025n

.meas tran vdout0_12ck1530 FIND v(dout0_12) AT=770.025n

.meas tran vdout0_13ck1530 FIND v(dout0_13) AT=770.025n

.meas tran vdout0_14ck1530 FIND v(dout0_14) AT=770.025n

.meas tran vdout0_15ck1530 FIND v(dout0_15) AT=770.025n

.meas tran vdout0_16ck1530 FIND v(dout0_16) AT=770.025n

.meas tran vdout0_17ck1530 FIND v(dout0_17) AT=770.025n

.meas tran vdout0_18ck1530 FIND v(dout0_18) AT=770.025n

.meas tran vdout0_19ck1530 FIND v(dout0_19) AT=770.025n

.meas tran vdout0_20ck1530 FIND v(dout0_20) AT=770.025n

.meas tran vdout0_21ck1530 FIND v(dout0_21) AT=770.025n

.meas tran vdout0_22ck1530 FIND v(dout0_22) AT=770.025n

.meas tran vdout0_23ck1530 FIND v(dout0_23) AT=770.025n

.meas tran vdout0_24ck1530 FIND v(dout0_24) AT=770.025n

.meas tran vdout0_25ck1530 FIND v(dout0_25) AT=770.025n

.meas tran vdout0_26ck1530 FIND v(dout0_26) AT=770.025n

.meas tran vdout0_27ck1530 FIND v(dout0_27) AT=770.025n

.meas tran vdout0_28ck1530 FIND v(dout0_28) AT=770.025n

.meas tran vdout0_29ck1530 FIND v(dout0_29) AT=770.025n

.meas tran vdout0_30ck1530 FIND v(dout0_30) AT=770.025n

.meas tran vdout0_31ck1530 FIND v(dout0_31) AT=770.025n

.meas tran vdout1_0ck1550 FIND v(dout1_0) AT=780.025n

.meas tran vdout1_1ck1550 FIND v(dout1_1) AT=780.025n

.meas tran vdout1_2ck1550 FIND v(dout1_2) AT=780.025n

.meas tran vdout1_3ck1550 FIND v(dout1_3) AT=780.025n

.meas tran vdout1_4ck1550 FIND v(dout1_4) AT=780.025n

.meas tran vdout1_5ck1550 FIND v(dout1_5) AT=780.025n

.meas tran vdout1_6ck1550 FIND v(dout1_6) AT=780.025n

.meas tran vdout1_7ck1550 FIND v(dout1_7) AT=780.025n

.meas tran vdout1_8ck1550 FIND v(dout1_8) AT=780.025n

.meas tran vdout1_9ck1550 FIND v(dout1_9) AT=780.025n

.meas tran vdout1_10ck1550 FIND v(dout1_10) AT=780.025n

.meas tran vdout1_11ck1550 FIND v(dout1_11) AT=780.025n

.meas tran vdout1_12ck1550 FIND v(dout1_12) AT=780.025n

.meas tran vdout1_13ck1550 FIND v(dout1_13) AT=780.025n

.meas tran vdout1_14ck1550 FIND v(dout1_14) AT=780.025n

.meas tran vdout1_15ck1550 FIND v(dout1_15) AT=780.025n

.meas tran vdout1_16ck1550 FIND v(dout1_16) AT=780.025n

.meas tran vdout1_17ck1550 FIND v(dout1_17) AT=780.025n

.meas tran vdout1_18ck1550 FIND v(dout1_18) AT=780.025n

.meas tran vdout1_19ck1550 FIND v(dout1_19) AT=780.025n

.meas tran vdout1_20ck1550 FIND v(dout1_20) AT=780.025n

.meas tran vdout1_21ck1550 FIND v(dout1_21) AT=780.025n

.meas tran vdout1_22ck1550 FIND v(dout1_22) AT=780.025n

.meas tran vdout1_23ck1550 FIND v(dout1_23) AT=780.025n

.meas tran vdout1_24ck1550 FIND v(dout1_24) AT=780.025n

.meas tran vdout1_25ck1550 FIND v(dout1_25) AT=780.025n

.meas tran vdout1_26ck1550 FIND v(dout1_26) AT=780.025n

.meas tran vdout1_27ck1550 FIND v(dout1_27) AT=780.025n

.meas tran vdout1_28ck1550 FIND v(dout1_28) AT=780.025n

.meas tran vdout1_29ck1550 FIND v(dout1_29) AT=780.025n

.meas tran vdout1_30ck1550 FIND v(dout1_30) AT=780.025n

.meas tran vdout1_31ck1550 FIND v(dout1_31) AT=780.025n

.meas tran vdout1_0ck1570 FIND v(dout1_0) AT=790.025n

.meas tran vdout1_1ck1570 FIND v(dout1_1) AT=790.025n

.meas tran vdout1_2ck1570 FIND v(dout1_2) AT=790.025n

.meas tran vdout1_3ck1570 FIND v(dout1_3) AT=790.025n

.meas tran vdout1_4ck1570 FIND v(dout1_4) AT=790.025n

.meas tran vdout1_5ck1570 FIND v(dout1_5) AT=790.025n

.meas tran vdout1_6ck1570 FIND v(dout1_6) AT=790.025n

.meas tran vdout1_7ck1570 FIND v(dout1_7) AT=790.025n

.meas tran vdout1_8ck1570 FIND v(dout1_8) AT=790.025n

.meas tran vdout1_9ck1570 FIND v(dout1_9) AT=790.025n

.meas tran vdout1_10ck1570 FIND v(dout1_10) AT=790.025n

.meas tran vdout1_11ck1570 FIND v(dout1_11) AT=790.025n

.meas tran vdout1_12ck1570 FIND v(dout1_12) AT=790.025n

.meas tran vdout1_13ck1570 FIND v(dout1_13) AT=790.025n

.meas tran vdout1_14ck1570 FIND v(dout1_14) AT=790.025n

.meas tran vdout1_15ck1570 FIND v(dout1_15) AT=790.025n

.meas tran vdout1_16ck1570 FIND v(dout1_16) AT=790.025n

.meas tran vdout1_17ck1570 FIND v(dout1_17) AT=790.025n

.meas tran vdout1_18ck1570 FIND v(dout1_18) AT=790.025n

.meas tran vdout1_19ck1570 FIND v(dout1_19) AT=790.025n

.meas tran vdout1_20ck1570 FIND v(dout1_20) AT=790.025n

.meas tran vdout1_21ck1570 FIND v(dout1_21) AT=790.025n

.meas tran vdout1_22ck1570 FIND v(dout1_22) AT=790.025n

.meas tran vdout1_23ck1570 FIND v(dout1_23) AT=790.025n

.meas tran vdout1_24ck1570 FIND v(dout1_24) AT=790.025n

.meas tran vdout1_25ck1570 FIND v(dout1_25) AT=790.025n

.meas tran vdout1_26ck1570 FIND v(dout1_26) AT=790.025n

.meas tran vdout1_27ck1570 FIND v(dout1_27) AT=790.025n

.meas tran vdout1_28ck1570 FIND v(dout1_28) AT=790.025n

.meas tran vdout1_29ck1570 FIND v(dout1_29) AT=790.025n

.meas tran vdout1_30ck1570 FIND v(dout1_30) AT=790.025n

.meas tran vdout1_31ck1570 FIND v(dout1_31) AT=790.025n

.meas tran vdout0_0ck1580 FIND v(dout0_0) AT=795.025n

.meas tran vdout0_1ck1580 FIND v(dout0_1) AT=795.025n

.meas tran vdout0_2ck1580 FIND v(dout0_2) AT=795.025n

.meas tran vdout0_3ck1580 FIND v(dout0_3) AT=795.025n

.meas tran vdout0_4ck1580 FIND v(dout0_4) AT=795.025n

.meas tran vdout0_5ck1580 FIND v(dout0_5) AT=795.025n

.meas tran vdout0_6ck1580 FIND v(dout0_6) AT=795.025n

.meas tran vdout0_7ck1580 FIND v(dout0_7) AT=795.025n

.meas tran vdout0_8ck1580 FIND v(dout0_8) AT=795.025n

.meas tran vdout0_9ck1580 FIND v(dout0_9) AT=795.025n

.meas tran vdout0_10ck1580 FIND v(dout0_10) AT=795.025n

.meas tran vdout0_11ck1580 FIND v(dout0_11) AT=795.025n

.meas tran vdout0_12ck1580 FIND v(dout0_12) AT=795.025n

.meas tran vdout0_13ck1580 FIND v(dout0_13) AT=795.025n

.meas tran vdout0_14ck1580 FIND v(dout0_14) AT=795.025n

.meas tran vdout0_15ck1580 FIND v(dout0_15) AT=795.025n

.meas tran vdout0_16ck1580 FIND v(dout0_16) AT=795.025n

.meas tran vdout0_17ck1580 FIND v(dout0_17) AT=795.025n

.meas tran vdout0_18ck1580 FIND v(dout0_18) AT=795.025n

.meas tran vdout0_19ck1580 FIND v(dout0_19) AT=795.025n

.meas tran vdout0_20ck1580 FIND v(dout0_20) AT=795.025n

.meas tran vdout0_21ck1580 FIND v(dout0_21) AT=795.025n

.meas tran vdout0_22ck1580 FIND v(dout0_22) AT=795.025n

.meas tran vdout0_23ck1580 FIND v(dout0_23) AT=795.025n

.meas tran vdout0_24ck1580 FIND v(dout0_24) AT=795.025n

.meas tran vdout0_25ck1580 FIND v(dout0_25) AT=795.025n

.meas tran vdout0_26ck1580 FIND v(dout0_26) AT=795.025n

.meas tran vdout0_27ck1580 FIND v(dout0_27) AT=795.025n

.meas tran vdout0_28ck1580 FIND v(dout0_28) AT=795.025n

.meas tran vdout0_29ck1580 FIND v(dout0_29) AT=795.025n

.meas tran vdout0_30ck1580 FIND v(dout0_30) AT=795.025n

.meas tran vdout0_31ck1580 FIND v(dout0_31) AT=795.025n

.meas tran vdout0_0ck1600 FIND v(dout0_0) AT=805.025n

.meas tran vdout0_1ck1600 FIND v(dout0_1) AT=805.025n

.meas tran vdout0_2ck1600 FIND v(dout0_2) AT=805.025n

.meas tran vdout0_3ck1600 FIND v(dout0_3) AT=805.025n

.meas tran vdout0_4ck1600 FIND v(dout0_4) AT=805.025n

.meas tran vdout0_5ck1600 FIND v(dout0_5) AT=805.025n

.meas tran vdout0_6ck1600 FIND v(dout0_6) AT=805.025n

.meas tran vdout0_7ck1600 FIND v(dout0_7) AT=805.025n

.meas tran vdout0_8ck1600 FIND v(dout0_8) AT=805.025n

.meas tran vdout0_9ck1600 FIND v(dout0_9) AT=805.025n

.meas tran vdout0_10ck1600 FIND v(dout0_10) AT=805.025n

.meas tran vdout0_11ck1600 FIND v(dout0_11) AT=805.025n

.meas tran vdout0_12ck1600 FIND v(dout0_12) AT=805.025n

.meas tran vdout0_13ck1600 FIND v(dout0_13) AT=805.025n

.meas tran vdout0_14ck1600 FIND v(dout0_14) AT=805.025n

.meas tran vdout0_15ck1600 FIND v(dout0_15) AT=805.025n

.meas tran vdout0_16ck1600 FIND v(dout0_16) AT=805.025n

.meas tran vdout0_17ck1600 FIND v(dout0_17) AT=805.025n

.meas tran vdout0_18ck1600 FIND v(dout0_18) AT=805.025n

.meas tran vdout0_19ck1600 FIND v(dout0_19) AT=805.025n

.meas tran vdout0_20ck1600 FIND v(dout0_20) AT=805.025n

.meas tran vdout0_21ck1600 FIND v(dout0_21) AT=805.025n

.meas tran vdout0_22ck1600 FIND v(dout0_22) AT=805.025n

.meas tran vdout0_23ck1600 FIND v(dout0_23) AT=805.025n

.meas tran vdout0_24ck1600 FIND v(dout0_24) AT=805.025n

.meas tran vdout0_25ck1600 FIND v(dout0_25) AT=805.025n

.meas tran vdout0_26ck1600 FIND v(dout0_26) AT=805.025n

.meas tran vdout0_27ck1600 FIND v(dout0_27) AT=805.025n

.meas tran vdout0_28ck1600 FIND v(dout0_28) AT=805.025n

.meas tran vdout0_29ck1600 FIND v(dout0_29) AT=805.025n

.meas tran vdout0_30ck1600 FIND v(dout0_30) AT=805.025n

.meas tran vdout0_31ck1600 FIND v(dout0_31) AT=805.025n

.meas tran vdout1_0ck1600 FIND v(dout1_0) AT=805.025n

.meas tran vdout1_1ck1600 FIND v(dout1_1) AT=805.025n

.meas tran vdout1_2ck1600 FIND v(dout1_2) AT=805.025n

.meas tran vdout1_3ck1600 FIND v(dout1_3) AT=805.025n

.meas tran vdout1_4ck1600 FIND v(dout1_4) AT=805.025n

.meas tran vdout1_5ck1600 FIND v(dout1_5) AT=805.025n

.meas tran vdout1_6ck1600 FIND v(dout1_6) AT=805.025n

.meas tran vdout1_7ck1600 FIND v(dout1_7) AT=805.025n

.meas tran vdout1_8ck1600 FIND v(dout1_8) AT=805.025n

.meas tran vdout1_9ck1600 FIND v(dout1_9) AT=805.025n

.meas tran vdout1_10ck1600 FIND v(dout1_10) AT=805.025n

.meas tran vdout1_11ck1600 FIND v(dout1_11) AT=805.025n

.meas tran vdout1_12ck1600 FIND v(dout1_12) AT=805.025n

.meas tran vdout1_13ck1600 FIND v(dout1_13) AT=805.025n

.meas tran vdout1_14ck1600 FIND v(dout1_14) AT=805.025n

.meas tran vdout1_15ck1600 FIND v(dout1_15) AT=805.025n

.meas tran vdout1_16ck1600 FIND v(dout1_16) AT=805.025n

.meas tran vdout1_17ck1600 FIND v(dout1_17) AT=805.025n

.meas tran vdout1_18ck1600 FIND v(dout1_18) AT=805.025n

.meas tran vdout1_19ck1600 FIND v(dout1_19) AT=805.025n

.meas tran vdout1_20ck1600 FIND v(dout1_20) AT=805.025n

.meas tran vdout1_21ck1600 FIND v(dout1_21) AT=805.025n

.meas tran vdout1_22ck1600 FIND v(dout1_22) AT=805.025n

.meas tran vdout1_23ck1600 FIND v(dout1_23) AT=805.025n

.meas tran vdout1_24ck1600 FIND v(dout1_24) AT=805.025n

.meas tran vdout1_25ck1600 FIND v(dout1_25) AT=805.025n

.meas tran vdout1_26ck1600 FIND v(dout1_26) AT=805.025n

.meas tran vdout1_27ck1600 FIND v(dout1_27) AT=805.025n

.meas tran vdout1_28ck1600 FIND v(dout1_28) AT=805.025n

.meas tran vdout1_29ck1600 FIND v(dout1_29) AT=805.025n

.meas tran vdout1_30ck1600 FIND v(dout1_30) AT=805.025n

.meas tran vdout1_31ck1600 FIND v(dout1_31) AT=805.025n

.meas tran vdout0_0ck1610 FIND v(dout0_0) AT=810.025n

.meas tran vdout0_1ck1610 FIND v(dout0_1) AT=810.025n

.meas tran vdout0_2ck1610 FIND v(dout0_2) AT=810.025n

.meas tran vdout0_3ck1610 FIND v(dout0_3) AT=810.025n

.meas tran vdout0_4ck1610 FIND v(dout0_4) AT=810.025n

.meas tran vdout0_5ck1610 FIND v(dout0_5) AT=810.025n

.meas tran vdout0_6ck1610 FIND v(dout0_6) AT=810.025n

.meas tran vdout0_7ck1610 FIND v(dout0_7) AT=810.025n

.meas tran vdout0_8ck1610 FIND v(dout0_8) AT=810.025n

.meas tran vdout0_9ck1610 FIND v(dout0_9) AT=810.025n

.meas tran vdout0_10ck1610 FIND v(dout0_10) AT=810.025n

.meas tran vdout0_11ck1610 FIND v(dout0_11) AT=810.025n

.meas tran vdout0_12ck1610 FIND v(dout0_12) AT=810.025n

.meas tran vdout0_13ck1610 FIND v(dout0_13) AT=810.025n

.meas tran vdout0_14ck1610 FIND v(dout0_14) AT=810.025n

.meas tran vdout0_15ck1610 FIND v(dout0_15) AT=810.025n

.meas tran vdout0_16ck1610 FIND v(dout0_16) AT=810.025n

.meas tran vdout0_17ck1610 FIND v(dout0_17) AT=810.025n

.meas tran vdout0_18ck1610 FIND v(dout0_18) AT=810.025n

.meas tran vdout0_19ck1610 FIND v(dout0_19) AT=810.025n

.meas tran vdout0_20ck1610 FIND v(dout0_20) AT=810.025n

.meas tran vdout0_21ck1610 FIND v(dout0_21) AT=810.025n

.meas tran vdout0_22ck1610 FIND v(dout0_22) AT=810.025n

.meas tran vdout0_23ck1610 FIND v(dout0_23) AT=810.025n

.meas tran vdout0_24ck1610 FIND v(dout0_24) AT=810.025n

.meas tran vdout0_25ck1610 FIND v(dout0_25) AT=810.025n

.meas tran vdout0_26ck1610 FIND v(dout0_26) AT=810.025n

.meas tran vdout0_27ck1610 FIND v(dout0_27) AT=810.025n

.meas tran vdout0_28ck1610 FIND v(dout0_28) AT=810.025n

.meas tran vdout0_29ck1610 FIND v(dout0_29) AT=810.025n

.meas tran vdout0_30ck1610 FIND v(dout0_30) AT=810.025n

.meas tran vdout0_31ck1610 FIND v(dout0_31) AT=810.025n

.meas tran vdout1_0ck1610 FIND v(dout1_0) AT=810.025n

.meas tran vdout1_1ck1610 FIND v(dout1_1) AT=810.025n

.meas tran vdout1_2ck1610 FIND v(dout1_2) AT=810.025n

.meas tran vdout1_3ck1610 FIND v(dout1_3) AT=810.025n

.meas tran vdout1_4ck1610 FIND v(dout1_4) AT=810.025n

.meas tran vdout1_5ck1610 FIND v(dout1_5) AT=810.025n

.meas tran vdout1_6ck1610 FIND v(dout1_6) AT=810.025n

.meas tran vdout1_7ck1610 FIND v(dout1_7) AT=810.025n

.meas tran vdout1_8ck1610 FIND v(dout1_8) AT=810.025n

.meas tran vdout1_9ck1610 FIND v(dout1_9) AT=810.025n

.meas tran vdout1_10ck1610 FIND v(dout1_10) AT=810.025n

.meas tran vdout1_11ck1610 FIND v(dout1_11) AT=810.025n

.meas tran vdout1_12ck1610 FIND v(dout1_12) AT=810.025n

.meas tran vdout1_13ck1610 FIND v(dout1_13) AT=810.025n

.meas tran vdout1_14ck1610 FIND v(dout1_14) AT=810.025n

.meas tran vdout1_15ck1610 FIND v(dout1_15) AT=810.025n

.meas tran vdout1_16ck1610 FIND v(dout1_16) AT=810.025n

.meas tran vdout1_17ck1610 FIND v(dout1_17) AT=810.025n

.meas tran vdout1_18ck1610 FIND v(dout1_18) AT=810.025n

.meas tran vdout1_19ck1610 FIND v(dout1_19) AT=810.025n

.meas tran vdout1_20ck1610 FIND v(dout1_20) AT=810.025n

.meas tran vdout1_21ck1610 FIND v(dout1_21) AT=810.025n

.meas tran vdout1_22ck1610 FIND v(dout1_22) AT=810.025n

.meas tran vdout1_23ck1610 FIND v(dout1_23) AT=810.025n

.meas tran vdout1_24ck1610 FIND v(dout1_24) AT=810.025n

.meas tran vdout1_25ck1610 FIND v(dout1_25) AT=810.025n

.meas tran vdout1_26ck1610 FIND v(dout1_26) AT=810.025n

.meas tran vdout1_27ck1610 FIND v(dout1_27) AT=810.025n

.meas tran vdout1_28ck1610 FIND v(dout1_28) AT=810.025n

.meas tran vdout1_29ck1610 FIND v(dout1_29) AT=810.025n

.meas tran vdout1_30ck1610 FIND v(dout1_30) AT=810.025n

.meas tran vdout1_31ck1610 FIND v(dout1_31) AT=810.025n

.meas tran vdout0_0ck1650 FIND v(dout0_0) AT=830.025n

.meas tran vdout0_1ck1650 FIND v(dout0_1) AT=830.025n

.meas tran vdout0_2ck1650 FIND v(dout0_2) AT=830.025n

.meas tran vdout0_3ck1650 FIND v(dout0_3) AT=830.025n

.meas tran vdout0_4ck1650 FIND v(dout0_4) AT=830.025n

.meas tran vdout0_5ck1650 FIND v(dout0_5) AT=830.025n

.meas tran vdout0_6ck1650 FIND v(dout0_6) AT=830.025n

.meas tran vdout0_7ck1650 FIND v(dout0_7) AT=830.025n

.meas tran vdout0_8ck1650 FIND v(dout0_8) AT=830.025n

.meas tran vdout0_9ck1650 FIND v(dout0_9) AT=830.025n

.meas tran vdout0_10ck1650 FIND v(dout0_10) AT=830.025n

.meas tran vdout0_11ck1650 FIND v(dout0_11) AT=830.025n

.meas tran vdout0_12ck1650 FIND v(dout0_12) AT=830.025n

.meas tran vdout0_13ck1650 FIND v(dout0_13) AT=830.025n

.meas tran vdout0_14ck1650 FIND v(dout0_14) AT=830.025n

.meas tran vdout0_15ck1650 FIND v(dout0_15) AT=830.025n

.meas tran vdout0_16ck1650 FIND v(dout0_16) AT=830.025n

.meas tran vdout0_17ck1650 FIND v(dout0_17) AT=830.025n

.meas tran vdout0_18ck1650 FIND v(dout0_18) AT=830.025n

.meas tran vdout0_19ck1650 FIND v(dout0_19) AT=830.025n

.meas tran vdout0_20ck1650 FIND v(dout0_20) AT=830.025n

.meas tran vdout0_21ck1650 FIND v(dout0_21) AT=830.025n

.meas tran vdout0_22ck1650 FIND v(dout0_22) AT=830.025n

.meas tran vdout0_23ck1650 FIND v(dout0_23) AT=830.025n

.meas tran vdout0_24ck1650 FIND v(dout0_24) AT=830.025n

.meas tran vdout0_25ck1650 FIND v(dout0_25) AT=830.025n

.meas tran vdout0_26ck1650 FIND v(dout0_26) AT=830.025n

.meas tran vdout0_27ck1650 FIND v(dout0_27) AT=830.025n

.meas tran vdout0_28ck1650 FIND v(dout0_28) AT=830.025n

.meas tran vdout0_29ck1650 FIND v(dout0_29) AT=830.025n

.meas tran vdout0_30ck1650 FIND v(dout0_30) AT=830.025n

.meas tran vdout0_31ck1650 FIND v(dout0_31) AT=830.025n

.meas tran vdout1_0ck1650 FIND v(dout1_0) AT=830.025n

.meas tran vdout1_1ck1650 FIND v(dout1_1) AT=830.025n

.meas tran vdout1_2ck1650 FIND v(dout1_2) AT=830.025n

.meas tran vdout1_3ck1650 FIND v(dout1_3) AT=830.025n

.meas tran vdout1_4ck1650 FIND v(dout1_4) AT=830.025n

.meas tran vdout1_5ck1650 FIND v(dout1_5) AT=830.025n

.meas tran vdout1_6ck1650 FIND v(dout1_6) AT=830.025n

.meas tran vdout1_7ck1650 FIND v(dout1_7) AT=830.025n

.meas tran vdout1_8ck1650 FIND v(dout1_8) AT=830.025n

.meas tran vdout1_9ck1650 FIND v(dout1_9) AT=830.025n

.meas tran vdout1_10ck1650 FIND v(dout1_10) AT=830.025n

.meas tran vdout1_11ck1650 FIND v(dout1_11) AT=830.025n

.meas tran vdout1_12ck1650 FIND v(dout1_12) AT=830.025n

.meas tran vdout1_13ck1650 FIND v(dout1_13) AT=830.025n

.meas tran vdout1_14ck1650 FIND v(dout1_14) AT=830.025n

.meas tran vdout1_15ck1650 FIND v(dout1_15) AT=830.025n

.meas tran vdout1_16ck1650 FIND v(dout1_16) AT=830.025n

.meas tran vdout1_17ck1650 FIND v(dout1_17) AT=830.025n

.meas tran vdout1_18ck1650 FIND v(dout1_18) AT=830.025n

.meas tran vdout1_19ck1650 FIND v(dout1_19) AT=830.025n

.meas tran vdout1_20ck1650 FIND v(dout1_20) AT=830.025n

.meas tran vdout1_21ck1650 FIND v(dout1_21) AT=830.025n

.meas tran vdout1_22ck1650 FIND v(dout1_22) AT=830.025n

.meas tran vdout1_23ck1650 FIND v(dout1_23) AT=830.025n

.meas tran vdout1_24ck1650 FIND v(dout1_24) AT=830.025n

.meas tran vdout1_25ck1650 FIND v(dout1_25) AT=830.025n

.meas tran vdout1_26ck1650 FIND v(dout1_26) AT=830.025n

.meas tran vdout1_27ck1650 FIND v(dout1_27) AT=830.025n

.meas tran vdout1_28ck1650 FIND v(dout1_28) AT=830.025n

.meas tran vdout1_29ck1650 FIND v(dout1_29) AT=830.025n

.meas tran vdout1_30ck1650 FIND v(dout1_30) AT=830.025n

.meas tran vdout1_31ck1650 FIND v(dout1_31) AT=830.025n

.meas tran vdout0_0ck1660 FIND v(dout0_0) AT=835.025n

.meas tran vdout0_1ck1660 FIND v(dout0_1) AT=835.025n

.meas tran vdout0_2ck1660 FIND v(dout0_2) AT=835.025n

.meas tran vdout0_3ck1660 FIND v(dout0_3) AT=835.025n

.meas tran vdout0_4ck1660 FIND v(dout0_4) AT=835.025n

.meas tran vdout0_5ck1660 FIND v(dout0_5) AT=835.025n

.meas tran vdout0_6ck1660 FIND v(dout0_6) AT=835.025n

.meas tran vdout0_7ck1660 FIND v(dout0_7) AT=835.025n

.meas tran vdout0_8ck1660 FIND v(dout0_8) AT=835.025n

.meas tran vdout0_9ck1660 FIND v(dout0_9) AT=835.025n

.meas tran vdout0_10ck1660 FIND v(dout0_10) AT=835.025n

.meas tran vdout0_11ck1660 FIND v(dout0_11) AT=835.025n

.meas tran vdout0_12ck1660 FIND v(dout0_12) AT=835.025n

.meas tran vdout0_13ck1660 FIND v(dout0_13) AT=835.025n

.meas tran vdout0_14ck1660 FIND v(dout0_14) AT=835.025n

.meas tran vdout0_15ck1660 FIND v(dout0_15) AT=835.025n

.meas tran vdout0_16ck1660 FIND v(dout0_16) AT=835.025n

.meas tran vdout0_17ck1660 FIND v(dout0_17) AT=835.025n

.meas tran vdout0_18ck1660 FIND v(dout0_18) AT=835.025n

.meas tran vdout0_19ck1660 FIND v(dout0_19) AT=835.025n

.meas tran vdout0_20ck1660 FIND v(dout0_20) AT=835.025n

.meas tran vdout0_21ck1660 FIND v(dout0_21) AT=835.025n

.meas tran vdout0_22ck1660 FIND v(dout0_22) AT=835.025n

.meas tran vdout0_23ck1660 FIND v(dout0_23) AT=835.025n

.meas tran vdout0_24ck1660 FIND v(dout0_24) AT=835.025n

.meas tran vdout0_25ck1660 FIND v(dout0_25) AT=835.025n

.meas tran vdout0_26ck1660 FIND v(dout0_26) AT=835.025n

.meas tran vdout0_27ck1660 FIND v(dout0_27) AT=835.025n

.meas tran vdout0_28ck1660 FIND v(dout0_28) AT=835.025n

.meas tran vdout0_29ck1660 FIND v(dout0_29) AT=835.025n

.meas tran vdout0_30ck1660 FIND v(dout0_30) AT=835.025n

.meas tran vdout0_31ck1660 FIND v(dout0_31) AT=835.025n

.meas tran vdout1_0ck1660 FIND v(dout1_0) AT=835.025n

.meas tran vdout1_1ck1660 FIND v(dout1_1) AT=835.025n

.meas tran vdout1_2ck1660 FIND v(dout1_2) AT=835.025n

.meas tran vdout1_3ck1660 FIND v(dout1_3) AT=835.025n

.meas tran vdout1_4ck1660 FIND v(dout1_4) AT=835.025n

.meas tran vdout1_5ck1660 FIND v(dout1_5) AT=835.025n

.meas tran vdout1_6ck1660 FIND v(dout1_6) AT=835.025n

.meas tran vdout1_7ck1660 FIND v(dout1_7) AT=835.025n

.meas tran vdout1_8ck1660 FIND v(dout1_8) AT=835.025n

.meas tran vdout1_9ck1660 FIND v(dout1_9) AT=835.025n

.meas tran vdout1_10ck1660 FIND v(dout1_10) AT=835.025n

.meas tran vdout1_11ck1660 FIND v(dout1_11) AT=835.025n

.meas tran vdout1_12ck1660 FIND v(dout1_12) AT=835.025n

.meas tran vdout1_13ck1660 FIND v(dout1_13) AT=835.025n

.meas tran vdout1_14ck1660 FIND v(dout1_14) AT=835.025n

.meas tran vdout1_15ck1660 FIND v(dout1_15) AT=835.025n

.meas tran vdout1_16ck1660 FIND v(dout1_16) AT=835.025n

.meas tran vdout1_17ck1660 FIND v(dout1_17) AT=835.025n

.meas tran vdout1_18ck1660 FIND v(dout1_18) AT=835.025n

.meas tran vdout1_19ck1660 FIND v(dout1_19) AT=835.025n

.meas tran vdout1_20ck1660 FIND v(dout1_20) AT=835.025n

.meas tran vdout1_21ck1660 FIND v(dout1_21) AT=835.025n

.meas tran vdout1_22ck1660 FIND v(dout1_22) AT=835.025n

.meas tran vdout1_23ck1660 FIND v(dout1_23) AT=835.025n

.meas tran vdout1_24ck1660 FIND v(dout1_24) AT=835.025n

.meas tran vdout1_25ck1660 FIND v(dout1_25) AT=835.025n

.meas tran vdout1_26ck1660 FIND v(dout1_26) AT=835.025n

.meas tran vdout1_27ck1660 FIND v(dout1_27) AT=835.025n

.meas tran vdout1_28ck1660 FIND v(dout1_28) AT=835.025n

.meas tran vdout1_29ck1660 FIND v(dout1_29) AT=835.025n

.meas tran vdout1_30ck1660 FIND v(dout1_30) AT=835.025n

.meas tran vdout1_31ck1660 FIND v(dout1_31) AT=835.025n

.meas tran vdout0_0ck1670 FIND v(dout0_0) AT=840.025n

.meas tran vdout0_1ck1670 FIND v(dout0_1) AT=840.025n

.meas tran vdout0_2ck1670 FIND v(dout0_2) AT=840.025n

.meas tran vdout0_3ck1670 FIND v(dout0_3) AT=840.025n

.meas tran vdout0_4ck1670 FIND v(dout0_4) AT=840.025n

.meas tran vdout0_5ck1670 FIND v(dout0_5) AT=840.025n

.meas tran vdout0_6ck1670 FIND v(dout0_6) AT=840.025n

.meas tran vdout0_7ck1670 FIND v(dout0_7) AT=840.025n

.meas tran vdout0_8ck1670 FIND v(dout0_8) AT=840.025n

.meas tran vdout0_9ck1670 FIND v(dout0_9) AT=840.025n

.meas tran vdout0_10ck1670 FIND v(dout0_10) AT=840.025n

.meas tran vdout0_11ck1670 FIND v(dout0_11) AT=840.025n

.meas tran vdout0_12ck1670 FIND v(dout0_12) AT=840.025n

.meas tran vdout0_13ck1670 FIND v(dout0_13) AT=840.025n

.meas tran vdout0_14ck1670 FIND v(dout0_14) AT=840.025n

.meas tran vdout0_15ck1670 FIND v(dout0_15) AT=840.025n

.meas tran vdout0_16ck1670 FIND v(dout0_16) AT=840.025n

.meas tran vdout0_17ck1670 FIND v(dout0_17) AT=840.025n

.meas tran vdout0_18ck1670 FIND v(dout0_18) AT=840.025n

.meas tran vdout0_19ck1670 FIND v(dout0_19) AT=840.025n

.meas tran vdout0_20ck1670 FIND v(dout0_20) AT=840.025n

.meas tran vdout0_21ck1670 FIND v(dout0_21) AT=840.025n

.meas tran vdout0_22ck1670 FIND v(dout0_22) AT=840.025n

.meas tran vdout0_23ck1670 FIND v(dout0_23) AT=840.025n

.meas tran vdout0_24ck1670 FIND v(dout0_24) AT=840.025n

.meas tran vdout0_25ck1670 FIND v(dout0_25) AT=840.025n

.meas tran vdout0_26ck1670 FIND v(dout0_26) AT=840.025n

.meas tran vdout0_27ck1670 FIND v(dout0_27) AT=840.025n

.meas tran vdout0_28ck1670 FIND v(dout0_28) AT=840.025n

.meas tran vdout0_29ck1670 FIND v(dout0_29) AT=840.025n

.meas tran vdout0_30ck1670 FIND v(dout0_30) AT=840.025n

.meas tran vdout0_31ck1670 FIND v(dout0_31) AT=840.025n

.meas tran vdout1_0ck1670 FIND v(dout1_0) AT=840.025n

.meas tran vdout1_1ck1670 FIND v(dout1_1) AT=840.025n

.meas tran vdout1_2ck1670 FIND v(dout1_2) AT=840.025n

.meas tran vdout1_3ck1670 FIND v(dout1_3) AT=840.025n

.meas tran vdout1_4ck1670 FIND v(dout1_4) AT=840.025n

.meas tran vdout1_5ck1670 FIND v(dout1_5) AT=840.025n

.meas tran vdout1_6ck1670 FIND v(dout1_6) AT=840.025n

.meas tran vdout1_7ck1670 FIND v(dout1_7) AT=840.025n

.meas tran vdout1_8ck1670 FIND v(dout1_8) AT=840.025n

.meas tran vdout1_9ck1670 FIND v(dout1_9) AT=840.025n

.meas tran vdout1_10ck1670 FIND v(dout1_10) AT=840.025n

.meas tran vdout1_11ck1670 FIND v(dout1_11) AT=840.025n

.meas tran vdout1_12ck1670 FIND v(dout1_12) AT=840.025n

.meas tran vdout1_13ck1670 FIND v(dout1_13) AT=840.025n

.meas tran vdout1_14ck1670 FIND v(dout1_14) AT=840.025n

.meas tran vdout1_15ck1670 FIND v(dout1_15) AT=840.025n

.meas tran vdout1_16ck1670 FIND v(dout1_16) AT=840.025n

.meas tran vdout1_17ck1670 FIND v(dout1_17) AT=840.025n

.meas tran vdout1_18ck1670 FIND v(dout1_18) AT=840.025n

.meas tran vdout1_19ck1670 FIND v(dout1_19) AT=840.025n

.meas tran vdout1_20ck1670 FIND v(dout1_20) AT=840.025n

.meas tran vdout1_21ck1670 FIND v(dout1_21) AT=840.025n

.meas tran vdout1_22ck1670 FIND v(dout1_22) AT=840.025n

.meas tran vdout1_23ck1670 FIND v(dout1_23) AT=840.025n

.meas tran vdout1_24ck1670 FIND v(dout1_24) AT=840.025n

.meas tran vdout1_25ck1670 FIND v(dout1_25) AT=840.025n

.meas tran vdout1_26ck1670 FIND v(dout1_26) AT=840.025n

.meas tran vdout1_27ck1670 FIND v(dout1_27) AT=840.025n

.meas tran vdout1_28ck1670 FIND v(dout1_28) AT=840.025n

.meas tran vdout1_29ck1670 FIND v(dout1_29) AT=840.025n

.meas tran vdout1_30ck1670 FIND v(dout1_30) AT=840.025n

.meas tran vdout1_31ck1670 FIND v(dout1_31) AT=840.025n

.meas tran vdout0_0ck1680 FIND v(dout0_0) AT=845.025n

.meas tran vdout0_1ck1680 FIND v(dout0_1) AT=845.025n

.meas tran vdout0_2ck1680 FIND v(dout0_2) AT=845.025n

.meas tran vdout0_3ck1680 FIND v(dout0_3) AT=845.025n

.meas tran vdout0_4ck1680 FIND v(dout0_4) AT=845.025n

.meas tran vdout0_5ck1680 FIND v(dout0_5) AT=845.025n

.meas tran vdout0_6ck1680 FIND v(dout0_6) AT=845.025n

.meas tran vdout0_7ck1680 FIND v(dout0_7) AT=845.025n

.meas tran vdout0_8ck1680 FIND v(dout0_8) AT=845.025n

.meas tran vdout0_9ck1680 FIND v(dout0_9) AT=845.025n

.meas tran vdout0_10ck1680 FIND v(dout0_10) AT=845.025n

.meas tran vdout0_11ck1680 FIND v(dout0_11) AT=845.025n

.meas tran vdout0_12ck1680 FIND v(dout0_12) AT=845.025n

.meas tran vdout0_13ck1680 FIND v(dout0_13) AT=845.025n

.meas tran vdout0_14ck1680 FIND v(dout0_14) AT=845.025n

.meas tran vdout0_15ck1680 FIND v(dout0_15) AT=845.025n

.meas tran vdout0_16ck1680 FIND v(dout0_16) AT=845.025n

.meas tran vdout0_17ck1680 FIND v(dout0_17) AT=845.025n

.meas tran vdout0_18ck1680 FIND v(dout0_18) AT=845.025n

.meas tran vdout0_19ck1680 FIND v(dout0_19) AT=845.025n

.meas tran vdout0_20ck1680 FIND v(dout0_20) AT=845.025n

.meas tran vdout0_21ck1680 FIND v(dout0_21) AT=845.025n

.meas tran vdout0_22ck1680 FIND v(dout0_22) AT=845.025n

.meas tran vdout0_23ck1680 FIND v(dout0_23) AT=845.025n

.meas tran vdout0_24ck1680 FIND v(dout0_24) AT=845.025n

.meas tran vdout0_25ck1680 FIND v(dout0_25) AT=845.025n

.meas tran vdout0_26ck1680 FIND v(dout0_26) AT=845.025n

.meas tran vdout0_27ck1680 FIND v(dout0_27) AT=845.025n

.meas tran vdout0_28ck1680 FIND v(dout0_28) AT=845.025n

.meas tran vdout0_29ck1680 FIND v(dout0_29) AT=845.025n

.meas tran vdout0_30ck1680 FIND v(dout0_30) AT=845.025n

.meas tran vdout0_31ck1680 FIND v(dout0_31) AT=845.025n

.meas tran vdout1_0ck1680 FIND v(dout1_0) AT=845.025n

.meas tran vdout1_1ck1680 FIND v(dout1_1) AT=845.025n

.meas tran vdout1_2ck1680 FIND v(dout1_2) AT=845.025n

.meas tran vdout1_3ck1680 FIND v(dout1_3) AT=845.025n

.meas tran vdout1_4ck1680 FIND v(dout1_4) AT=845.025n

.meas tran vdout1_5ck1680 FIND v(dout1_5) AT=845.025n

.meas tran vdout1_6ck1680 FIND v(dout1_6) AT=845.025n

.meas tran vdout1_7ck1680 FIND v(dout1_7) AT=845.025n

.meas tran vdout1_8ck1680 FIND v(dout1_8) AT=845.025n

.meas tran vdout1_9ck1680 FIND v(dout1_9) AT=845.025n

.meas tran vdout1_10ck1680 FIND v(dout1_10) AT=845.025n

.meas tran vdout1_11ck1680 FIND v(dout1_11) AT=845.025n

.meas tran vdout1_12ck1680 FIND v(dout1_12) AT=845.025n

.meas tran vdout1_13ck1680 FIND v(dout1_13) AT=845.025n

.meas tran vdout1_14ck1680 FIND v(dout1_14) AT=845.025n

.meas tran vdout1_15ck1680 FIND v(dout1_15) AT=845.025n

.meas tran vdout1_16ck1680 FIND v(dout1_16) AT=845.025n

.meas tran vdout1_17ck1680 FIND v(dout1_17) AT=845.025n

.meas tran vdout1_18ck1680 FIND v(dout1_18) AT=845.025n

.meas tran vdout1_19ck1680 FIND v(dout1_19) AT=845.025n

.meas tran vdout1_20ck1680 FIND v(dout1_20) AT=845.025n

.meas tran vdout1_21ck1680 FIND v(dout1_21) AT=845.025n

.meas tran vdout1_22ck1680 FIND v(dout1_22) AT=845.025n

.meas tran vdout1_23ck1680 FIND v(dout1_23) AT=845.025n

.meas tran vdout1_24ck1680 FIND v(dout1_24) AT=845.025n

.meas tran vdout1_25ck1680 FIND v(dout1_25) AT=845.025n

.meas tran vdout1_26ck1680 FIND v(dout1_26) AT=845.025n

.meas tran vdout1_27ck1680 FIND v(dout1_27) AT=845.025n

.meas tran vdout1_28ck1680 FIND v(dout1_28) AT=845.025n

.meas tran vdout1_29ck1680 FIND v(dout1_29) AT=845.025n

.meas tran vdout1_30ck1680 FIND v(dout1_30) AT=845.025n

.meas tran vdout1_31ck1680 FIND v(dout1_31) AT=845.025n

.meas tran vdout0_0ck1690 FIND v(dout0_0) AT=850.025n

.meas tran vdout0_1ck1690 FIND v(dout0_1) AT=850.025n

.meas tran vdout0_2ck1690 FIND v(dout0_2) AT=850.025n

.meas tran vdout0_3ck1690 FIND v(dout0_3) AT=850.025n

.meas tran vdout0_4ck1690 FIND v(dout0_4) AT=850.025n

.meas tran vdout0_5ck1690 FIND v(dout0_5) AT=850.025n

.meas tran vdout0_6ck1690 FIND v(dout0_6) AT=850.025n

.meas tran vdout0_7ck1690 FIND v(dout0_7) AT=850.025n

.meas tran vdout0_8ck1690 FIND v(dout0_8) AT=850.025n

.meas tran vdout0_9ck1690 FIND v(dout0_9) AT=850.025n

.meas tran vdout0_10ck1690 FIND v(dout0_10) AT=850.025n

.meas tran vdout0_11ck1690 FIND v(dout0_11) AT=850.025n

.meas tran vdout0_12ck1690 FIND v(dout0_12) AT=850.025n

.meas tran vdout0_13ck1690 FIND v(dout0_13) AT=850.025n

.meas tran vdout0_14ck1690 FIND v(dout0_14) AT=850.025n

.meas tran vdout0_15ck1690 FIND v(dout0_15) AT=850.025n

.meas tran vdout0_16ck1690 FIND v(dout0_16) AT=850.025n

.meas tran vdout0_17ck1690 FIND v(dout0_17) AT=850.025n

.meas tran vdout0_18ck1690 FIND v(dout0_18) AT=850.025n

.meas tran vdout0_19ck1690 FIND v(dout0_19) AT=850.025n

.meas tran vdout0_20ck1690 FIND v(dout0_20) AT=850.025n

.meas tran vdout0_21ck1690 FIND v(dout0_21) AT=850.025n

.meas tran vdout0_22ck1690 FIND v(dout0_22) AT=850.025n

.meas tran vdout0_23ck1690 FIND v(dout0_23) AT=850.025n

.meas tran vdout0_24ck1690 FIND v(dout0_24) AT=850.025n

.meas tran vdout0_25ck1690 FIND v(dout0_25) AT=850.025n

.meas tran vdout0_26ck1690 FIND v(dout0_26) AT=850.025n

.meas tran vdout0_27ck1690 FIND v(dout0_27) AT=850.025n

.meas tran vdout0_28ck1690 FIND v(dout0_28) AT=850.025n

.meas tran vdout0_29ck1690 FIND v(dout0_29) AT=850.025n

.meas tran vdout0_30ck1690 FIND v(dout0_30) AT=850.025n

.meas tran vdout0_31ck1690 FIND v(dout0_31) AT=850.025n

.meas tran vdout1_0ck1690 FIND v(dout1_0) AT=850.025n

.meas tran vdout1_1ck1690 FIND v(dout1_1) AT=850.025n

.meas tran vdout1_2ck1690 FIND v(dout1_2) AT=850.025n

.meas tran vdout1_3ck1690 FIND v(dout1_3) AT=850.025n

.meas tran vdout1_4ck1690 FIND v(dout1_4) AT=850.025n

.meas tran vdout1_5ck1690 FIND v(dout1_5) AT=850.025n

.meas tran vdout1_6ck1690 FIND v(dout1_6) AT=850.025n

.meas tran vdout1_7ck1690 FIND v(dout1_7) AT=850.025n

.meas tran vdout1_8ck1690 FIND v(dout1_8) AT=850.025n

.meas tran vdout1_9ck1690 FIND v(dout1_9) AT=850.025n

.meas tran vdout1_10ck1690 FIND v(dout1_10) AT=850.025n

.meas tran vdout1_11ck1690 FIND v(dout1_11) AT=850.025n

.meas tran vdout1_12ck1690 FIND v(dout1_12) AT=850.025n

.meas tran vdout1_13ck1690 FIND v(dout1_13) AT=850.025n

.meas tran vdout1_14ck1690 FIND v(dout1_14) AT=850.025n

.meas tran vdout1_15ck1690 FIND v(dout1_15) AT=850.025n

.meas tran vdout1_16ck1690 FIND v(dout1_16) AT=850.025n

.meas tran vdout1_17ck1690 FIND v(dout1_17) AT=850.025n

.meas tran vdout1_18ck1690 FIND v(dout1_18) AT=850.025n

.meas tran vdout1_19ck1690 FIND v(dout1_19) AT=850.025n

.meas tran vdout1_20ck1690 FIND v(dout1_20) AT=850.025n

.meas tran vdout1_21ck1690 FIND v(dout1_21) AT=850.025n

.meas tran vdout1_22ck1690 FIND v(dout1_22) AT=850.025n

.meas tran vdout1_23ck1690 FIND v(dout1_23) AT=850.025n

.meas tran vdout1_24ck1690 FIND v(dout1_24) AT=850.025n

.meas tran vdout1_25ck1690 FIND v(dout1_25) AT=850.025n

.meas tran vdout1_26ck1690 FIND v(dout1_26) AT=850.025n

.meas tran vdout1_27ck1690 FIND v(dout1_27) AT=850.025n

.meas tran vdout1_28ck1690 FIND v(dout1_28) AT=850.025n

.meas tran vdout1_29ck1690 FIND v(dout1_29) AT=850.025n

.meas tran vdout1_30ck1690 FIND v(dout1_30) AT=850.025n

.meas tran vdout1_31ck1690 FIND v(dout1_31) AT=850.025n

.meas tran vdout1_0ck1700 FIND v(dout1_0) AT=855.025n

.meas tran vdout1_1ck1700 FIND v(dout1_1) AT=855.025n

.meas tran vdout1_2ck1700 FIND v(dout1_2) AT=855.025n

.meas tran vdout1_3ck1700 FIND v(dout1_3) AT=855.025n

.meas tran vdout1_4ck1700 FIND v(dout1_4) AT=855.025n

.meas tran vdout1_5ck1700 FIND v(dout1_5) AT=855.025n

.meas tran vdout1_6ck1700 FIND v(dout1_6) AT=855.025n

.meas tran vdout1_7ck1700 FIND v(dout1_7) AT=855.025n

.meas tran vdout1_8ck1700 FIND v(dout1_8) AT=855.025n

.meas tran vdout1_9ck1700 FIND v(dout1_9) AT=855.025n

.meas tran vdout1_10ck1700 FIND v(dout1_10) AT=855.025n

.meas tran vdout1_11ck1700 FIND v(dout1_11) AT=855.025n

.meas tran vdout1_12ck1700 FIND v(dout1_12) AT=855.025n

.meas tran vdout1_13ck1700 FIND v(dout1_13) AT=855.025n

.meas tran vdout1_14ck1700 FIND v(dout1_14) AT=855.025n

.meas tran vdout1_15ck1700 FIND v(dout1_15) AT=855.025n

.meas tran vdout1_16ck1700 FIND v(dout1_16) AT=855.025n

.meas tran vdout1_17ck1700 FIND v(dout1_17) AT=855.025n

.meas tran vdout1_18ck1700 FIND v(dout1_18) AT=855.025n

.meas tran vdout1_19ck1700 FIND v(dout1_19) AT=855.025n

.meas tran vdout1_20ck1700 FIND v(dout1_20) AT=855.025n

.meas tran vdout1_21ck1700 FIND v(dout1_21) AT=855.025n

.meas tran vdout1_22ck1700 FIND v(dout1_22) AT=855.025n

.meas tran vdout1_23ck1700 FIND v(dout1_23) AT=855.025n

.meas tran vdout1_24ck1700 FIND v(dout1_24) AT=855.025n

.meas tran vdout1_25ck1700 FIND v(dout1_25) AT=855.025n

.meas tran vdout1_26ck1700 FIND v(dout1_26) AT=855.025n

.meas tran vdout1_27ck1700 FIND v(dout1_27) AT=855.025n

.meas tran vdout1_28ck1700 FIND v(dout1_28) AT=855.025n

.meas tran vdout1_29ck1700 FIND v(dout1_29) AT=855.025n

.meas tran vdout1_30ck1700 FIND v(dout1_30) AT=855.025n

.meas tran vdout1_31ck1700 FIND v(dout1_31) AT=855.025n

.meas tran vdout0_0ck1730 FIND v(dout0_0) AT=870.025n

.meas tran vdout0_1ck1730 FIND v(dout0_1) AT=870.025n

.meas tran vdout0_2ck1730 FIND v(dout0_2) AT=870.025n

.meas tran vdout0_3ck1730 FIND v(dout0_3) AT=870.025n

.meas tran vdout0_4ck1730 FIND v(dout0_4) AT=870.025n

.meas tran vdout0_5ck1730 FIND v(dout0_5) AT=870.025n

.meas tran vdout0_6ck1730 FIND v(dout0_6) AT=870.025n

.meas tran vdout0_7ck1730 FIND v(dout0_7) AT=870.025n

.meas tran vdout0_8ck1730 FIND v(dout0_8) AT=870.025n

.meas tran vdout0_9ck1730 FIND v(dout0_9) AT=870.025n

.meas tran vdout0_10ck1730 FIND v(dout0_10) AT=870.025n

.meas tran vdout0_11ck1730 FIND v(dout0_11) AT=870.025n

.meas tran vdout0_12ck1730 FIND v(dout0_12) AT=870.025n

.meas tran vdout0_13ck1730 FIND v(dout0_13) AT=870.025n

.meas tran vdout0_14ck1730 FIND v(dout0_14) AT=870.025n

.meas tran vdout0_15ck1730 FIND v(dout0_15) AT=870.025n

.meas tran vdout0_16ck1730 FIND v(dout0_16) AT=870.025n

.meas tran vdout0_17ck1730 FIND v(dout0_17) AT=870.025n

.meas tran vdout0_18ck1730 FIND v(dout0_18) AT=870.025n

.meas tran vdout0_19ck1730 FIND v(dout0_19) AT=870.025n

.meas tran vdout0_20ck1730 FIND v(dout0_20) AT=870.025n

.meas tran vdout0_21ck1730 FIND v(dout0_21) AT=870.025n

.meas tran vdout0_22ck1730 FIND v(dout0_22) AT=870.025n

.meas tran vdout0_23ck1730 FIND v(dout0_23) AT=870.025n

.meas tran vdout0_24ck1730 FIND v(dout0_24) AT=870.025n

.meas tran vdout0_25ck1730 FIND v(dout0_25) AT=870.025n

.meas tran vdout0_26ck1730 FIND v(dout0_26) AT=870.025n

.meas tran vdout0_27ck1730 FIND v(dout0_27) AT=870.025n

.meas tran vdout0_28ck1730 FIND v(dout0_28) AT=870.025n

.meas tran vdout0_29ck1730 FIND v(dout0_29) AT=870.025n

.meas tran vdout0_30ck1730 FIND v(dout0_30) AT=870.025n

.meas tran vdout0_31ck1730 FIND v(dout0_31) AT=870.025n

.meas tran vdout1_0ck1730 FIND v(dout1_0) AT=870.025n

.meas tran vdout1_1ck1730 FIND v(dout1_1) AT=870.025n

.meas tran vdout1_2ck1730 FIND v(dout1_2) AT=870.025n

.meas tran vdout1_3ck1730 FIND v(dout1_3) AT=870.025n

.meas tran vdout1_4ck1730 FIND v(dout1_4) AT=870.025n

.meas tran vdout1_5ck1730 FIND v(dout1_5) AT=870.025n

.meas tran vdout1_6ck1730 FIND v(dout1_6) AT=870.025n

.meas tran vdout1_7ck1730 FIND v(dout1_7) AT=870.025n

.meas tran vdout1_8ck1730 FIND v(dout1_8) AT=870.025n

.meas tran vdout1_9ck1730 FIND v(dout1_9) AT=870.025n

.meas tran vdout1_10ck1730 FIND v(dout1_10) AT=870.025n

.meas tran vdout1_11ck1730 FIND v(dout1_11) AT=870.025n

.meas tran vdout1_12ck1730 FIND v(dout1_12) AT=870.025n

.meas tran vdout1_13ck1730 FIND v(dout1_13) AT=870.025n

.meas tran vdout1_14ck1730 FIND v(dout1_14) AT=870.025n

.meas tran vdout1_15ck1730 FIND v(dout1_15) AT=870.025n

.meas tran vdout1_16ck1730 FIND v(dout1_16) AT=870.025n

.meas tran vdout1_17ck1730 FIND v(dout1_17) AT=870.025n

.meas tran vdout1_18ck1730 FIND v(dout1_18) AT=870.025n

.meas tran vdout1_19ck1730 FIND v(dout1_19) AT=870.025n

.meas tran vdout1_20ck1730 FIND v(dout1_20) AT=870.025n

.meas tran vdout1_21ck1730 FIND v(dout1_21) AT=870.025n

.meas tran vdout1_22ck1730 FIND v(dout1_22) AT=870.025n

.meas tran vdout1_23ck1730 FIND v(dout1_23) AT=870.025n

.meas tran vdout1_24ck1730 FIND v(dout1_24) AT=870.025n

.meas tran vdout1_25ck1730 FIND v(dout1_25) AT=870.025n

.meas tran vdout1_26ck1730 FIND v(dout1_26) AT=870.025n

.meas tran vdout1_27ck1730 FIND v(dout1_27) AT=870.025n

.meas tran vdout1_28ck1730 FIND v(dout1_28) AT=870.025n

.meas tran vdout1_29ck1730 FIND v(dout1_29) AT=870.025n

.meas tran vdout1_30ck1730 FIND v(dout1_30) AT=870.025n

.meas tran vdout1_31ck1730 FIND v(dout1_31) AT=870.025n

.meas tran vdout1_0ck1740 FIND v(dout1_0) AT=875.025n

.meas tran vdout1_1ck1740 FIND v(dout1_1) AT=875.025n

.meas tran vdout1_2ck1740 FIND v(dout1_2) AT=875.025n

.meas tran vdout1_3ck1740 FIND v(dout1_3) AT=875.025n

.meas tran vdout1_4ck1740 FIND v(dout1_4) AT=875.025n

.meas tran vdout1_5ck1740 FIND v(dout1_5) AT=875.025n

.meas tran vdout1_6ck1740 FIND v(dout1_6) AT=875.025n

.meas tran vdout1_7ck1740 FIND v(dout1_7) AT=875.025n

.meas tran vdout1_8ck1740 FIND v(dout1_8) AT=875.025n

.meas tran vdout1_9ck1740 FIND v(dout1_9) AT=875.025n

.meas tran vdout1_10ck1740 FIND v(dout1_10) AT=875.025n

.meas tran vdout1_11ck1740 FIND v(dout1_11) AT=875.025n

.meas tran vdout1_12ck1740 FIND v(dout1_12) AT=875.025n

.meas tran vdout1_13ck1740 FIND v(dout1_13) AT=875.025n

.meas tran vdout1_14ck1740 FIND v(dout1_14) AT=875.025n

.meas tran vdout1_15ck1740 FIND v(dout1_15) AT=875.025n

.meas tran vdout1_16ck1740 FIND v(dout1_16) AT=875.025n

.meas tran vdout1_17ck1740 FIND v(dout1_17) AT=875.025n

.meas tran vdout1_18ck1740 FIND v(dout1_18) AT=875.025n

.meas tran vdout1_19ck1740 FIND v(dout1_19) AT=875.025n

.meas tran vdout1_20ck1740 FIND v(dout1_20) AT=875.025n

.meas tran vdout1_21ck1740 FIND v(dout1_21) AT=875.025n

.meas tran vdout1_22ck1740 FIND v(dout1_22) AT=875.025n

.meas tran vdout1_23ck1740 FIND v(dout1_23) AT=875.025n

.meas tran vdout1_24ck1740 FIND v(dout1_24) AT=875.025n

.meas tran vdout1_25ck1740 FIND v(dout1_25) AT=875.025n

.meas tran vdout1_26ck1740 FIND v(dout1_26) AT=875.025n

.meas tran vdout1_27ck1740 FIND v(dout1_27) AT=875.025n

.meas tran vdout1_28ck1740 FIND v(dout1_28) AT=875.025n

.meas tran vdout1_29ck1740 FIND v(dout1_29) AT=875.025n

.meas tran vdout1_30ck1740 FIND v(dout1_30) AT=875.025n

.meas tran vdout1_31ck1740 FIND v(dout1_31) AT=875.025n

.meas tran vdout0_0ck1750 FIND v(dout0_0) AT=880.025n

.meas tran vdout0_1ck1750 FIND v(dout0_1) AT=880.025n

.meas tran vdout0_2ck1750 FIND v(dout0_2) AT=880.025n

.meas tran vdout0_3ck1750 FIND v(dout0_3) AT=880.025n

.meas tran vdout0_4ck1750 FIND v(dout0_4) AT=880.025n

.meas tran vdout0_5ck1750 FIND v(dout0_5) AT=880.025n

.meas tran vdout0_6ck1750 FIND v(dout0_6) AT=880.025n

.meas tran vdout0_7ck1750 FIND v(dout0_7) AT=880.025n

.meas tran vdout0_8ck1750 FIND v(dout0_8) AT=880.025n

.meas tran vdout0_9ck1750 FIND v(dout0_9) AT=880.025n

.meas tran vdout0_10ck1750 FIND v(dout0_10) AT=880.025n

.meas tran vdout0_11ck1750 FIND v(dout0_11) AT=880.025n

.meas tran vdout0_12ck1750 FIND v(dout0_12) AT=880.025n

.meas tran vdout0_13ck1750 FIND v(dout0_13) AT=880.025n

.meas tran vdout0_14ck1750 FIND v(dout0_14) AT=880.025n

.meas tran vdout0_15ck1750 FIND v(dout0_15) AT=880.025n

.meas tran vdout0_16ck1750 FIND v(dout0_16) AT=880.025n

.meas tran vdout0_17ck1750 FIND v(dout0_17) AT=880.025n

.meas tran vdout0_18ck1750 FIND v(dout0_18) AT=880.025n

.meas tran vdout0_19ck1750 FIND v(dout0_19) AT=880.025n

.meas tran vdout0_20ck1750 FIND v(dout0_20) AT=880.025n

.meas tran vdout0_21ck1750 FIND v(dout0_21) AT=880.025n

.meas tran vdout0_22ck1750 FIND v(dout0_22) AT=880.025n

.meas tran vdout0_23ck1750 FIND v(dout0_23) AT=880.025n

.meas tran vdout0_24ck1750 FIND v(dout0_24) AT=880.025n

.meas tran vdout0_25ck1750 FIND v(dout0_25) AT=880.025n

.meas tran vdout0_26ck1750 FIND v(dout0_26) AT=880.025n

.meas tran vdout0_27ck1750 FIND v(dout0_27) AT=880.025n

.meas tran vdout0_28ck1750 FIND v(dout0_28) AT=880.025n

.meas tran vdout0_29ck1750 FIND v(dout0_29) AT=880.025n

.meas tran vdout0_30ck1750 FIND v(dout0_30) AT=880.025n

.meas tran vdout0_31ck1750 FIND v(dout0_31) AT=880.025n

.meas tran vdout1_0ck1750 FIND v(dout1_0) AT=880.025n

.meas tran vdout1_1ck1750 FIND v(dout1_1) AT=880.025n

.meas tran vdout1_2ck1750 FIND v(dout1_2) AT=880.025n

.meas tran vdout1_3ck1750 FIND v(dout1_3) AT=880.025n

.meas tran vdout1_4ck1750 FIND v(dout1_4) AT=880.025n

.meas tran vdout1_5ck1750 FIND v(dout1_5) AT=880.025n

.meas tran vdout1_6ck1750 FIND v(dout1_6) AT=880.025n

.meas tran vdout1_7ck1750 FIND v(dout1_7) AT=880.025n

.meas tran vdout1_8ck1750 FIND v(dout1_8) AT=880.025n

.meas tran vdout1_9ck1750 FIND v(dout1_9) AT=880.025n

.meas tran vdout1_10ck1750 FIND v(dout1_10) AT=880.025n

.meas tran vdout1_11ck1750 FIND v(dout1_11) AT=880.025n

.meas tran vdout1_12ck1750 FIND v(dout1_12) AT=880.025n

.meas tran vdout1_13ck1750 FIND v(dout1_13) AT=880.025n

.meas tran vdout1_14ck1750 FIND v(dout1_14) AT=880.025n

.meas tran vdout1_15ck1750 FIND v(dout1_15) AT=880.025n

.meas tran vdout1_16ck1750 FIND v(dout1_16) AT=880.025n

.meas tran vdout1_17ck1750 FIND v(dout1_17) AT=880.025n

.meas tran vdout1_18ck1750 FIND v(dout1_18) AT=880.025n

.meas tran vdout1_19ck1750 FIND v(dout1_19) AT=880.025n

.meas tran vdout1_20ck1750 FIND v(dout1_20) AT=880.025n

.meas tran vdout1_21ck1750 FIND v(dout1_21) AT=880.025n

.meas tran vdout1_22ck1750 FIND v(dout1_22) AT=880.025n

.meas tran vdout1_23ck1750 FIND v(dout1_23) AT=880.025n

.meas tran vdout1_24ck1750 FIND v(dout1_24) AT=880.025n

.meas tran vdout1_25ck1750 FIND v(dout1_25) AT=880.025n

.meas tran vdout1_26ck1750 FIND v(dout1_26) AT=880.025n

.meas tran vdout1_27ck1750 FIND v(dout1_27) AT=880.025n

.meas tran vdout1_28ck1750 FIND v(dout1_28) AT=880.025n

.meas tran vdout1_29ck1750 FIND v(dout1_29) AT=880.025n

.meas tran vdout1_30ck1750 FIND v(dout1_30) AT=880.025n

.meas tran vdout1_31ck1750 FIND v(dout1_31) AT=880.025n

.meas tran vdout0_0ck1760 FIND v(dout0_0) AT=885.025n

.meas tran vdout0_1ck1760 FIND v(dout0_1) AT=885.025n

.meas tran vdout0_2ck1760 FIND v(dout0_2) AT=885.025n

.meas tran vdout0_3ck1760 FIND v(dout0_3) AT=885.025n

.meas tran vdout0_4ck1760 FIND v(dout0_4) AT=885.025n

.meas tran vdout0_5ck1760 FIND v(dout0_5) AT=885.025n

.meas tran vdout0_6ck1760 FIND v(dout0_6) AT=885.025n

.meas tran vdout0_7ck1760 FIND v(dout0_7) AT=885.025n

.meas tran vdout0_8ck1760 FIND v(dout0_8) AT=885.025n

.meas tran vdout0_9ck1760 FIND v(dout0_9) AT=885.025n

.meas tran vdout0_10ck1760 FIND v(dout0_10) AT=885.025n

.meas tran vdout0_11ck1760 FIND v(dout0_11) AT=885.025n

.meas tran vdout0_12ck1760 FIND v(dout0_12) AT=885.025n

.meas tran vdout0_13ck1760 FIND v(dout0_13) AT=885.025n

.meas tran vdout0_14ck1760 FIND v(dout0_14) AT=885.025n

.meas tran vdout0_15ck1760 FIND v(dout0_15) AT=885.025n

.meas tran vdout0_16ck1760 FIND v(dout0_16) AT=885.025n

.meas tran vdout0_17ck1760 FIND v(dout0_17) AT=885.025n

.meas tran vdout0_18ck1760 FIND v(dout0_18) AT=885.025n

.meas tran vdout0_19ck1760 FIND v(dout0_19) AT=885.025n

.meas tran vdout0_20ck1760 FIND v(dout0_20) AT=885.025n

.meas tran vdout0_21ck1760 FIND v(dout0_21) AT=885.025n

.meas tran vdout0_22ck1760 FIND v(dout0_22) AT=885.025n

.meas tran vdout0_23ck1760 FIND v(dout0_23) AT=885.025n

.meas tran vdout0_24ck1760 FIND v(dout0_24) AT=885.025n

.meas tran vdout0_25ck1760 FIND v(dout0_25) AT=885.025n

.meas tran vdout0_26ck1760 FIND v(dout0_26) AT=885.025n

.meas tran vdout0_27ck1760 FIND v(dout0_27) AT=885.025n

.meas tran vdout0_28ck1760 FIND v(dout0_28) AT=885.025n

.meas tran vdout0_29ck1760 FIND v(dout0_29) AT=885.025n

.meas tran vdout0_30ck1760 FIND v(dout0_30) AT=885.025n

.meas tran vdout0_31ck1760 FIND v(dout0_31) AT=885.025n

.meas tran vdout0_0ck1770 FIND v(dout0_0) AT=890.025n

.meas tran vdout0_1ck1770 FIND v(dout0_1) AT=890.025n

.meas tran vdout0_2ck1770 FIND v(dout0_2) AT=890.025n

.meas tran vdout0_3ck1770 FIND v(dout0_3) AT=890.025n

.meas tran vdout0_4ck1770 FIND v(dout0_4) AT=890.025n

.meas tran vdout0_5ck1770 FIND v(dout0_5) AT=890.025n

.meas tran vdout0_6ck1770 FIND v(dout0_6) AT=890.025n

.meas tran vdout0_7ck1770 FIND v(dout0_7) AT=890.025n

.meas tran vdout0_8ck1770 FIND v(dout0_8) AT=890.025n

.meas tran vdout0_9ck1770 FIND v(dout0_9) AT=890.025n

.meas tran vdout0_10ck1770 FIND v(dout0_10) AT=890.025n

.meas tran vdout0_11ck1770 FIND v(dout0_11) AT=890.025n

.meas tran vdout0_12ck1770 FIND v(dout0_12) AT=890.025n

.meas tran vdout0_13ck1770 FIND v(dout0_13) AT=890.025n

.meas tran vdout0_14ck1770 FIND v(dout0_14) AT=890.025n

.meas tran vdout0_15ck1770 FIND v(dout0_15) AT=890.025n

.meas tran vdout0_16ck1770 FIND v(dout0_16) AT=890.025n

.meas tran vdout0_17ck1770 FIND v(dout0_17) AT=890.025n

.meas tran vdout0_18ck1770 FIND v(dout0_18) AT=890.025n

.meas tran vdout0_19ck1770 FIND v(dout0_19) AT=890.025n

.meas tran vdout0_20ck1770 FIND v(dout0_20) AT=890.025n

.meas tran vdout0_21ck1770 FIND v(dout0_21) AT=890.025n

.meas tran vdout0_22ck1770 FIND v(dout0_22) AT=890.025n

.meas tran vdout0_23ck1770 FIND v(dout0_23) AT=890.025n

.meas tran vdout0_24ck1770 FIND v(dout0_24) AT=890.025n

.meas tran vdout0_25ck1770 FIND v(dout0_25) AT=890.025n

.meas tran vdout0_26ck1770 FIND v(dout0_26) AT=890.025n

.meas tran vdout0_27ck1770 FIND v(dout0_27) AT=890.025n

.meas tran vdout0_28ck1770 FIND v(dout0_28) AT=890.025n

.meas tran vdout0_29ck1770 FIND v(dout0_29) AT=890.025n

.meas tran vdout0_30ck1770 FIND v(dout0_30) AT=890.025n

.meas tran vdout0_31ck1770 FIND v(dout0_31) AT=890.025n

.meas tran vdout1_0ck1770 FIND v(dout1_0) AT=890.025n

.meas tran vdout1_1ck1770 FIND v(dout1_1) AT=890.025n

.meas tran vdout1_2ck1770 FIND v(dout1_2) AT=890.025n

.meas tran vdout1_3ck1770 FIND v(dout1_3) AT=890.025n

.meas tran vdout1_4ck1770 FIND v(dout1_4) AT=890.025n

.meas tran vdout1_5ck1770 FIND v(dout1_5) AT=890.025n

.meas tran vdout1_6ck1770 FIND v(dout1_6) AT=890.025n

.meas tran vdout1_7ck1770 FIND v(dout1_7) AT=890.025n

.meas tran vdout1_8ck1770 FIND v(dout1_8) AT=890.025n

.meas tran vdout1_9ck1770 FIND v(dout1_9) AT=890.025n

.meas tran vdout1_10ck1770 FIND v(dout1_10) AT=890.025n

.meas tran vdout1_11ck1770 FIND v(dout1_11) AT=890.025n

.meas tran vdout1_12ck1770 FIND v(dout1_12) AT=890.025n

.meas tran vdout1_13ck1770 FIND v(dout1_13) AT=890.025n

.meas tran vdout1_14ck1770 FIND v(dout1_14) AT=890.025n

.meas tran vdout1_15ck1770 FIND v(dout1_15) AT=890.025n

.meas tran vdout1_16ck1770 FIND v(dout1_16) AT=890.025n

.meas tran vdout1_17ck1770 FIND v(dout1_17) AT=890.025n

.meas tran vdout1_18ck1770 FIND v(dout1_18) AT=890.025n

.meas tran vdout1_19ck1770 FIND v(dout1_19) AT=890.025n

.meas tran vdout1_20ck1770 FIND v(dout1_20) AT=890.025n

.meas tran vdout1_21ck1770 FIND v(dout1_21) AT=890.025n

.meas tran vdout1_22ck1770 FIND v(dout1_22) AT=890.025n

.meas tran vdout1_23ck1770 FIND v(dout1_23) AT=890.025n

.meas tran vdout1_24ck1770 FIND v(dout1_24) AT=890.025n

.meas tran vdout1_25ck1770 FIND v(dout1_25) AT=890.025n

.meas tran vdout1_26ck1770 FIND v(dout1_26) AT=890.025n

.meas tran vdout1_27ck1770 FIND v(dout1_27) AT=890.025n

.meas tran vdout1_28ck1770 FIND v(dout1_28) AT=890.025n

.meas tran vdout1_29ck1770 FIND v(dout1_29) AT=890.025n

.meas tran vdout1_30ck1770 FIND v(dout1_30) AT=890.025n

.meas tran vdout1_31ck1770 FIND v(dout1_31) AT=890.025n

.meas tran vdout0_0ck1780 FIND v(dout0_0) AT=895.025n

.meas tran vdout0_1ck1780 FIND v(dout0_1) AT=895.025n

.meas tran vdout0_2ck1780 FIND v(dout0_2) AT=895.025n

.meas tran vdout0_3ck1780 FIND v(dout0_3) AT=895.025n

.meas tran vdout0_4ck1780 FIND v(dout0_4) AT=895.025n

.meas tran vdout0_5ck1780 FIND v(dout0_5) AT=895.025n

.meas tran vdout0_6ck1780 FIND v(dout0_6) AT=895.025n

.meas tran vdout0_7ck1780 FIND v(dout0_7) AT=895.025n

.meas tran vdout0_8ck1780 FIND v(dout0_8) AT=895.025n

.meas tran vdout0_9ck1780 FIND v(dout0_9) AT=895.025n

.meas tran vdout0_10ck1780 FIND v(dout0_10) AT=895.025n

.meas tran vdout0_11ck1780 FIND v(dout0_11) AT=895.025n

.meas tran vdout0_12ck1780 FIND v(dout0_12) AT=895.025n

.meas tran vdout0_13ck1780 FIND v(dout0_13) AT=895.025n

.meas tran vdout0_14ck1780 FIND v(dout0_14) AT=895.025n

.meas tran vdout0_15ck1780 FIND v(dout0_15) AT=895.025n

.meas tran vdout0_16ck1780 FIND v(dout0_16) AT=895.025n

.meas tran vdout0_17ck1780 FIND v(dout0_17) AT=895.025n

.meas tran vdout0_18ck1780 FIND v(dout0_18) AT=895.025n

.meas tran vdout0_19ck1780 FIND v(dout0_19) AT=895.025n

.meas tran vdout0_20ck1780 FIND v(dout0_20) AT=895.025n

.meas tran vdout0_21ck1780 FIND v(dout0_21) AT=895.025n

.meas tran vdout0_22ck1780 FIND v(dout0_22) AT=895.025n

.meas tran vdout0_23ck1780 FIND v(dout0_23) AT=895.025n

.meas tran vdout0_24ck1780 FIND v(dout0_24) AT=895.025n

.meas tran vdout0_25ck1780 FIND v(dout0_25) AT=895.025n

.meas tran vdout0_26ck1780 FIND v(dout0_26) AT=895.025n

.meas tran vdout0_27ck1780 FIND v(dout0_27) AT=895.025n

.meas tran vdout0_28ck1780 FIND v(dout0_28) AT=895.025n

.meas tran vdout0_29ck1780 FIND v(dout0_29) AT=895.025n

.meas tran vdout0_30ck1780 FIND v(dout0_30) AT=895.025n

.meas tran vdout0_31ck1780 FIND v(dout0_31) AT=895.025n

.meas tran vdout0_0ck1790 FIND v(dout0_0) AT=900.025n

.meas tran vdout0_1ck1790 FIND v(dout0_1) AT=900.025n

.meas tran vdout0_2ck1790 FIND v(dout0_2) AT=900.025n

.meas tran vdout0_3ck1790 FIND v(dout0_3) AT=900.025n

.meas tran vdout0_4ck1790 FIND v(dout0_4) AT=900.025n

.meas tran vdout0_5ck1790 FIND v(dout0_5) AT=900.025n

.meas tran vdout0_6ck1790 FIND v(dout0_6) AT=900.025n

.meas tran vdout0_7ck1790 FIND v(dout0_7) AT=900.025n

.meas tran vdout0_8ck1790 FIND v(dout0_8) AT=900.025n

.meas tran vdout0_9ck1790 FIND v(dout0_9) AT=900.025n

.meas tran vdout0_10ck1790 FIND v(dout0_10) AT=900.025n

.meas tran vdout0_11ck1790 FIND v(dout0_11) AT=900.025n

.meas tran vdout0_12ck1790 FIND v(dout0_12) AT=900.025n

.meas tran vdout0_13ck1790 FIND v(dout0_13) AT=900.025n

.meas tran vdout0_14ck1790 FIND v(dout0_14) AT=900.025n

.meas tran vdout0_15ck1790 FIND v(dout0_15) AT=900.025n

.meas tran vdout0_16ck1790 FIND v(dout0_16) AT=900.025n

.meas tran vdout0_17ck1790 FIND v(dout0_17) AT=900.025n

.meas tran vdout0_18ck1790 FIND v(dout0_18) AT=900.025n

.meas tran vdout0_19ck1790 FIND v(dout0_19) AT=900.025n

.meas tran vdout0_20ck1790 FIND v(dout0_20) AT=900.025n

.meas tran vdout0_21ck1790 FIND v(dout0_21) AT=900.025n

.meas tran vdout0_22ck1790 FIND v(dout0_22) AT=900.025n

.meas tran vdout0_23ck1790 FIND v(dout0_23) AT=900.025n

.meas tran vdout0_24ck1790 FIND v(dout0_24) AT=900.025n

.meas tran vdout0_25ck1790 FIND v(dout0_25) AT=900.025n

.meas tran vdout0_26ck1790 FIND v(dout0_26) AT=900.025n

.meas tran vdout0_27ck1790 FIND v(dout0_27) AT=900.025n

.meas tran vdout0_28ck1790 FIND v(dout0_28) AT=900.025n

.meas tran vdout0_29ck1790 FIND v(dout0_29) AT=900.025n

.meas tran vdout0_30ck1790 FIND v(dout0_30) AT=900.025n

.meas tran vdout0_31ck1790 FIND v(dout0_31) AT=900.025n

.meas tran vdout1_0ck1800 FIND v(dout1_0) AT=905.025n

.meas tran vdout1_1ck1800 FIND v(dout1_1) AT=905.025n

.meas tran vdout1_2ck1800 FIND v(dout1_2) AT=905.025n

.meas tran vdout1_3ck1800 FIND v(dout1_3) AT=905.025n

.meas tran vdout1_4ck1800 FIND v(dout1_4) AT=905.025n

.meas tran vdout1_5ck1800 FIND v(dout1_5) AT=905.025n

.meas tran vdout1_6ck1800 FIND v(dout1_6) AT=905.025n

.meas tran vdout1_7ck1800 FIND v(dout1_7) AT=905.025n

.meas tran vdout1_8ck1800 FIND v(dout1_8) AT=905.025n

.meas tran vdout1_9ck1800 FIND v(dout1_9) AT=905.025n

.meas tran vdout1_10ck1800 FIND v(dout1_10) AT=905.025n

.meas tran vdout1_11ck1800 FIND v(dout1_11) AT=905.025n

.meas tran vdout1_12ck1800 FIND v(dout1_12) AT=905.025n

.meas tran vdout1_13ck1800 FIND v(dout1_13) AT=905.025n

.meas tran vdout1_14ck1800 FIND v(dout1_14) AT=905.025n

.meas tran vdout1_15ck1800 FIND v(dout1_15) AT=905.025n

.meas tran vdout1_16ck1800 FIND v(dout1_16) AT=905.025n

.meas tran vdout1_17ck1800 FIND v(dout1_17) AT=905.025n

.meas tran vdout1_18ck1800 FIND v(dout1_18) AT=905.025n

.meas tran vdout1_19ck1800 FIND v(dout1_19) AT=905.025n

.meas tran vdout1_20ck1800 FIND v(dout1_20) AT=905.025n

.meas tran vdout1_21ck1800 FIND v(dout1_21) AT=905.025n

.meas tran vdout1_22ck1800 FIND v(dout1_22) AT=905.025n

.meas tran vdout1_23ck1800 FIND v(dout1_23) AT=905.025n

.meas tran vdout1_24ck1800 FIND v(dout1_24) AT=905.025n

.meas tran vdout1_25ck1800 FIND v(dout1_25) AT=905.025n

.meas tran vdout1_26ck1800 FIND v(dout1_26) AT=905.025n

.meas tran vdout1_27ck1800 FIND v(dout1_27) AT=905.025n

.meas tran vdout1_28ck1800 FIND v(dout1_28) AT=905.025n

.meas tran vdout1_29ck1800 FIND v(dout1_29) AT=905.025n

.meas tran vdout1_30ck1800 FIND v(dout1_30) AT=905.025n

.meas tran vdout1_31ck1800 FIND v(dout1_31) AT=905.025n

.meas tran vdout1_0ck1810 FIND v(dout1_0) AT=910.025n

.meas tran vdout1_1ck1810 FIND v(dout1_1) AT=910.025n

.meas tran vdout1_2ck1810 FIND v(dout1_2) AT=910.025n

.meas tran vdout1_3ck1810 FIND v(dout1_3) AT=910.025n

.meas tran vdout1_4ck1810 FIND v(dout1_4) AT=910.025n

.meas tran vdout1_5ck1810 FIND v(dout1_5) AT=910.025n

.meas tran vdout1_6ck1810 FIND v(dout1_6) AT=910.025n

.meas tran vdout1_7ck1810 FIND v(dout1_7) AT=910.025n

.meas tran vdout1_8ck1810 FIND v(dout1_8) AT=910.025n

.meas tran vdout1_9ck1810 FIND v(dout1_9) AT=910.025n

.meas tran vdout1_10ck1810 FIND v(dout1_10) AT=910.025n

.meas tran vdout1_11ck1810 FIND v(dout1_11) AT=910.025n

.meas tran vdout1_12ck1810 FIND v(dout1_12) AT=910.025n

.meas tran vdout1_13ck1810 FIND v(dout1_13) AT=910.025n

.meas tran vdout1_14ck1810 FIND v(dout1_14) AT=910.025n

.meas tran vdout1_15ck1810 FIND v(dout1_15) AT=910.025n

.meas tran vdout1_16ck1810 FIND v(dout1_16) AT=910.025n

.meas tran vdout1_17ck1810 FIND v(dout1_17) AT=910.025n

.meas tran vdout1_18ck1810 FIND v(dout1_18) AT=910.025n

.meas tran vdout1_19ck1810 FIND v(dout1_19) AT=910.025n

.meas tran vdout1_20ck1810 FIND v(dout1_20) AT=910.025n

.meas tran vdout1_21ck1810 FIND v(dout1_21) AT=910.025n

.meas tran vdout1_22ck1810 FIND v(dout1_22) AT=910.025n

.meas tran vdout1_23ck1810 FIND v(dout1_23) AT=910.025n

.meas tran vdout1_24ck1810 FIND v(dout1_24) AT=910.025n

.meas tran vdout1_25ck1810 FIND v(dout1_25) AT=910.025n

.meas tran vdout1_26ck1810 FIND v(dout1_26) AT=910.025n

.meas tran vdout1_27ck1810 FIND v(dout1_27) AT=910.025n

.meas tran vdout1_28ck1810 FIND v(dout1_28) AT=910.025n

.meas tran vdout1_29ck1810 FIND v(dout1_29) AT=910.025n

.meas tran vdout1_30ck1810 FIND v(dout1_30) AT=910.025n

.meas tran vdout1_31ck1810 FIND v(dout1_31) AT=910.025n

.meas tran vdout0_0ck1830 FIND v(dout0_0) AT=920.025n

.meas tran vdout0_1ck1830 FIND v(dout0_1) AT=920.025n

.meas tran vdout0_2ck1830 FIND v(dout0_2) AT=920.025n

.meas tran vdout0_3ck1830 FIND v(dout0_3) AT=920.025n

.meas tran vdout0_4ck1830 FIND v(dout0_4) AT=920.025n

.meas tran vdout0_5ck1830 FIND v(dout0_5) AT=920.025n

.meas tran vdout0_6ck1830 FIND v(dout0_6) AT=920.025n

.meas tran vdout0_7ck1830 FIND v(dout0_7) AT=920.025n

.meas tran vdout0_8ck1830 FIND v(dout0_8) AT=920.025n

.meas tran vdout0_9ck1830 FIND v(dout0_9) AT=920.025n

.meas tran vdout0_10ck1830 FIND v(dout0_10) AT=920.025n

.meas tran vdout0_11ck1830 FIND v(dout0_11) AT=920.025n

.meas tran vdout0_12ck1830 FIND v(dout0_12) AT=920.025n

.meas tran vdout0_13ck1830 FIND v(dout0_13) AT=920.025n

.meas tran vdout0_14ck1830 FIND v(dout0_14) AT=920.025n

.meas tran vdout0_15ck1830 FIND v(dout0_15) AT=920.025n

.meas tran vdout0_16ck1830 FIND v(dout0_16) AT=920.025n

.meas tran vdout0_17ck1830 FIND v(dout0_17) AT=920.025n

.meas tran vdout0_18ck1830 FIND v(dout0_18) AT=920.025n

.meas tran vdout0_19ck1830 FIND v(dout0_19) AT=920.025n

.meas tran vdout0_20ck1830 FIND v(dout0_20) AT=920.025n

.meas tran vdout0_21ck1830 FIND v(dout0_21) AT=920.025n

.meas tran vdout0_22ck1830 FIND v(dout0_22) AT=920.025n

.meas tran vdout0_23ck1830 FIND v(dout0_23) AT=920.025n

.meas tran vdout0_24ck1830 FIND v(dout0_24) AT=920.025n

.meas tran vdout0_25ck1830 FIND v(dout0_25) AT=920.025n

.meas tran vdout0_26ck1830 FIND v(dout0_26) AT=920.025n

.meas tran vdout0_27ck1830 FIND v(dout0_27) AT=920.025n

.meas tran vdout0_28ck1830 FIND v(dout0_28) AT=920.025n

.meas tran vdout0_29ck1830 FIND v(dout0_29) AT=920.025n

.meas tran vdout0_30ck1830 FIND v(dout0_30) AT=920.025n

.meas tran vdout0_31ck1830 FIND v(dout0_31) AT=920.025n

.meas tran vdout1_0ck1830 FIND v(dout1_0) AT=920.025n

.meas tran vdout1_1ck1830 FIND v(dout1_1) AT=920.025n

.meas tran vdout1_2ck1830 FIND v(dout1_2) AT=920.025n

.meas tran vdout1_3ck1830 FIND v(dout1_3) AT=920.025n

.meas tran vdout1_4ck1830 FIND v(dout1_4) AT=920.025n

.meas tran vdout1_5ck1830 FIND v(dout1_5) AT=920.025n

.meas tran vdout1_6ck1830 FIND v(dout1_6) AT=920.025n

.meas tran vdout1_7ck1830 FIND v(dout1_7) AT=920.025n

.meas tran vdout1_8ck1830 FIND v(dout1_8) AT=920.025n

.meas tran vdout1_9ck1830 FIND v(dout1_9) AT=920.025n

.meas tran vdout1_10ck1830 FIND v(dout1_10) AT=920.025n

.meas tran vdout1_11ck1830 FIND v(dout1_11) AT=920.025n

.meas tran vdout1_12ck1830 FIND v(dout1_12) AT=920.025n

.meas tran vdout1_13ck1830 FIND v(dout1_13) AT=920.025n

.meas tran vdout1_14ck1830 FIND v(dout1_14) AT=920.025n

.meas tran vdout1_15ck1830 FIND v(dout1_15) AT=920.025n

.meas tran vdout1_16ck1830 FIND v(dout1_16) AT=920.025n

.meas tran vdout1_17ck1830 FIND v(dout1_17) AT=920.025n

.meas tran vdout1_18ck1830 FIND v(dout1_18) AT=920.025n

.meas tran vdout1_19ck1830 FIND v(dout1_19) AT=920.025n

.meas tran vdout1_20ck1830 FIND v(dout1_20) AT=920.025n

.meas tran vdout1_21ck1830 FIND v(dout1_21) AT=920.025n

.meas tran vdout1_22ck1830 FIND v(dout1_22) AT=920.025n

.meas tran vdout1_23ck1830 FIND v(dout1_23) AT=920.025n

.meas tran vdout1_24ck1830 FIND v(dout1_24) AT=920.025n

.meas tran vdout1_25ck1830 FIND v(dout1_25) AT=920.025n

.meas tran vdout1_26ck1830 FIND v(dout1_26) AT=920.025n

.meas tran vdout1_27ck1830 FIND v(dout1_27) AT=920.025n

.meas tran vdout1_28ck1830 FIND v(dout1_28) AT=920.025n

.meas tran vdout1_29ck1830 FIND v(dout1_29) AT=920.025n

.meas tran vdout1_30ck1830 FIND v(dout1_30) AT=920.025n

.meas tran vdout1_31ck1830 FIND v(dout1_31) AT=920.025n

.meas tran vdout0_0ck1860 FIND v(dout0_0) AT=935.025n

.meas tran vdout0_1ck1860 FIND v(dout0_1) AT=935.025n

.meas tran vdout0_2ck1860 FIND v(dout0_2) AT=935.025n

.meas tran vdout0_3ck1860 FIND v(dout0_3) AT=935.025n

.meas tran vdout0_4ck1860 FIND v(dout0_4) AT=935.025n

.meas tran vdout0_5ck1860 FIND v(dout0_5) AT=935.025n

.meas tran vdout0_6ck1860 FIND v(dout0_6) AT=935.025n

.meas tran vdout0_7ck1860 FIND v(dout0_7) AT=935.025n

.meas tran vdout0_8ck1860 FIND v(dout0_8) AT=935.025n

.meas tran vdout0_9ck1860 FIND v(dout0_9) AT=935.025n

.meas tran vdout0_10ck1860 FIND v(dout0_10) AT=935.025n

.meas tran vdout0_11ck1860 FIND v(dout0_11) AT=935.025n

.meas tran vdout0_12ck1860 FIND v(dout0_12) AT=935.025n

.meas tran vdout0_13ck1860 FIND v(dout0_13) AT=935.025n

.meas tran vdout0_14ck1860 FIND v(dout0_14) AT=935.025n

.meas tran vdout0_15ck1860 FIND v(dout0_15) AT=935.025n

.meas tran vdout0_16ck1860 FIND v(dout0_16) AT=935.025n

.meas tran vdout0_17ck1860 FIND v(dout0_17) AT=935.025n

.meas tran vdout0_18ck1860 FIND v(dout0_18) AT=935.025n

.meas tran vdout0_19ck1860 FIND v(dout0_19) AT=935.025n

.meas tran vdout0_20ck1860 FIND v(dout0_20) AT=935.025n

.meas tran vdout0_21ck1860 FIND v(dout0_21) AT=935.025n

.meas tran vdout0_22ck1860 FIND v(dout0_22) AT=935.025n

.meas tran vdout0_23ck1860 FIND v(dout0_23) AT=935.025n

.meas tran vdout0_24ck1860 FIND v(dout0_24) AT=935.025n

.meas tran vdout0_25ck1860 FIND v(dout0_25) AT=935.025n

.meas tran vdout0_26ck1860 FIND v(dout0_26) AT=935.025n

.meas tran vdout0_27ck1860 FIND v(dout0_27) AT=935.025n

.meas tran vdout0_28ck1860 FIND v(dout0_28) AT=935.025n

.meas tran vdout0_29ck1860 FIND v(dout0_29) AT=935.025n

.meas tran vdout0_30ck1860 FIND v(dout0_30) AT=935.025n

.meas tran vdout0_31ck1860 FIND v(dout0_31) AT=935.025n

.meas tran vdout0_0ck1880 FIND v(dout0_0) AT=945.025n

.meas tran vdout0_1ck1880 FIND v(dout0_1) AT=945.025n

.meas tran vdout0_2ck1880 FIND v(dout0_2) AT=945.025n

.meas tran vdout0_3ck1880 FIND v(dout0_3) AT=945.025n

.meas tran vdout0_4ck1880 FIND v(dout0_4) AT=945.025n

.meas tran vdout0_5ck1880 FIND v(dout0_5) AT=945.025n

.meas tran vdout0_6ck1880 FIND v(dout0_6) AT=945.025n

.meas tran vdout0_7ck1880 FIND v(dout0_7) AT=945.025n

.meas tran vdout0_8ck1880 FIND v(dout0_8) AT=945.025n

.meas tran vdout0_9ck1880 FIND v(dout0_9) AT=945.025n

.meas tran vdout0_10ck1880 FIND v(dout0_10) AT=945.025n

.meas tran vdout0_11ck1880 FIND v(dout0_11) AT=945.025n

.meas tran vdout0_12ck1880 FIND v(dout0_12) AT=945.025n

.meas tran vdout0_13ck1880 FIND v(dout0_13) AT=945.025n

.meas tran vdout0_14ck1880 FIND v(dout0_14) AT=945.025n

.meas tran vdout0_15ck1880 FIND v(dout0_15) AT=945.025n

.meas tran vdout0_16ck1880 FIND v(dout0_16) AT=945.025n

.meas tran vdout0_17ck1880 FIND v(dout0_17) AT=945.025n

.meas tran vdout0_18ck1880 FIND v(dout0_18) AT=945.025n

.meas tran vdout0_19ck1880 FIND v(dout0_19) AT=945.025n

.meas tran vdout0_20ck1880 FIND v(dout0_20) AT=945.025n

.meas tran vdout0_21ck1880 FIND v(dout0_21) AT=945.025n

.meas tran vdout0_22ck1880 FIND v(dout0_22) AT=945.025n

.meas tran vdout0_23ck1880 FIND v(dout0_23) AT=945.025n

.meas tran vdout0_24ck1880 FIND v(dout0_24) AT=945.025n

.meas tran vdout0_25ck1880 FIND v(dout0_25) AT=945.025n

.meas tran vdout0_26ck1880 FIND v(dout0_26) AT=945.025n

.meas tran vdout0_27ck1880 FIND v(dout0_27) AT=945.025n

.meas tran vdout0_28ck1880 FIND v(dout0_28) AT=945.025n

.meas tran vdout0_29ck1880 FIND v(dout0_29) AT=945.025n

.meas tran vdout0_30ck1880 FIND v(dout0_30) AT=945.025n

.meas tran vdout0_31ck1880 FIND v(dout0_31) AT=945.025n

.meas tran vdout1_0ck1880 FIND v(dout1_0) AT=945.025n

.meas tran vdout1_1ck1880 FIND v(dout1_1) AT=945.025n

.meas tran vdout1_2ck1880 FIND v(dout1_2) AT=945.025n

.meas tran vdout1_3ck1880 FIND v(dout1_3) AT=945.025n

.meas tran vdout1_4ck1880 FIND v(dout1_4) AT=945.025n

.meas tran vdout1_5ck1880 FIND v(dout1_5) AT=945.025n

.meas tran vdout1_6ck1880 FIND v(dout1_6) AT=945.025n

.meas tran vdout1_7ck1880 FIND v(dout1_7) AT=945.025n

.meas tran vdout1_8ck1880 FIND v(dout1_8) AT=945.025n

.meas tran vdout1_9ck1880 FIND v(dout1_9) AT=945.025n

.meas tran vdout1_10ck1880 FIND v(dout1_10) AT=945.025n

.meas tran vdout1_11ck1880 FIND v(dout1_11) AT=945.025n

.meas tran vdout1_12ck1880 FIND v(dout1_12) AT=945.025n

.meas tran vdout1_13ck1880 FIND v(dout1_13) AT=945.025n

.meas tran vdout1_14ck1880 FIND v(dout1_14) AT=945.025n

.meas tran vdout1_15ck1880 FIND v(dout1_15) AT=945.025n

.meas tran vdout1_16ck1880 FIND v(dout1_16) AT=945.025n

.meas tran vdout1_17ck1880 FIND v(dout1_17) AT=945.025n

.meas tran vdout1_18ck1880 FIND v(dout1_18) AT=945.025n

.meas tran vdout1_19ck1880 FIND v(dout1_19) AT=945.025n

.meas tran vdout1_20ck1880 FIND v(dout1_20) AT=945.025n

.meas tran vdout1_21ck1880 FIND v(dout1_21) AT=945.025n

.meas tran vdout1_22ck1880 FIND v(dout1_22) AT=945.025n

.meas tran vdout1_23ck1880 FIND v(dout1_23) AT=945.025n

.meas tran vdout1_24ck1880 FIND v(dout1_24) AT=945.025n

.meas tran vdout1_25ck1880 FIND v(dout1_25) AT=945.025n

.meas tran vdout1_26ck1880 FIND v(dout1_26) AT=945.025n

.meas tran vdout1_27ck1880 FIND v(dout1_27) AT=945.025n

.meas tran vdout1_28ck1880 FIND v(dout1_28) AT=945.025n

.meas tran vdout1_29ck1880 FIND v(dout1_29) AT=945.025n

.meas tran vdout1_30ck1880 FIND v(dout1_30) AT=945.025n

.meas tran vdout1_31ck1880 FIND v(dout1_31) AT=945.025n

.meas tran vdout1_0ck1890 FIND v(dout1_0) AT=950.025n

.meas tran vdout1_1ck1890 FIND v(dout1_1) AT=950.025n

.meas tran vdout1_2ck1890 FIND v(dout1_2) AT=950.025n

.meas tran vdout1_3ck1890 FIND v(dout1_3) AT=950.025n

.meas tran vdout1_4ck1890 FIND v(dout1_4) AT=950.025n

.meas tran vdout1_5ck1890 FIND v(dout1_5) AT=950.025n

.meas tran vdout1_6ck1890 FIND v(dout1_6) AT=950.025n

.meas tran vdout1_7ck1890 FIND v(dout1_7) AT=950.025n

.meas tran vdout1_8ck1890 FIND v(dout1_8) AT=950.025n

.meas tran vdout1_9ck1890 FIND v(dout1_9) AT=950.025n

.meas tran vdout1_10ck1890 FIND v(dout1_10) AT=950.025n

.meas tran vdout1_11ck1890 FIND v(dout1_11) AT=950.025n

.meas tran vdout1_12ck1890 FIND v(dout1_12) AT=950.025n

.meas tran vdout1_13ck1890 FIND v(dout1_13) AT=950.025n

.meas tran vdout1_14ck1890 FIND v(dout1_14) AT=950.025n

.meas tran vdout1_15ck1890 FIND v(dout1_15) AT=950.025n

.meas tran vdout1_16ck1890 FIND v(dout1_16) AT=950.025n

.meas tran vdout1_17ck1890 FIND v(dout1_17) AT=950.025n

.meas tran vdout1_18ck1890 FIND v(dout1_18) AT=950.025n

.meas tran vdout1_19ck1890 FIND v(dout1_19) AT=950.025n

.meas tran vdout1_20ck1890 FIND v(dout1_20) AT=950.025n

.meas tran vdout1_21ck1890 FIND v(dout1_21) AT=950.025n

.meas tran vdout1_22ck1890 FIND v(dout1_22) AT=950.025n

.meas tran vdout1_23ck1890 FIND v(dout1_23) AT=950.025n

.meas tran vdout1_24ck1890 FIND v(dout1_24) AT=950.025n

.meas tran vdout1_25ck1890 FIND v(dout1_25) AT=950.025n

.meas tran vdout1_26ck1890 FIND v(dout1_26) AT=950.025n

.meas tran vdout1_27ck1890 FIND v(dout1_27) AT=950.025n

.meas tran vdout1_28ck1890 FIND v(dout1_28) AT=950.025n

.meas tran vdout1_29ck1890 FIND v(dout1_29) AT=950.025n

.meas tran vdout1_30ck1890 FIND v(dout1_30) AT=950.025n

.meas tran vdout1_31ck1890 FIND v(dout1_31) AT=950.025n

.meas tran vdout0_0ck1900 FIND v(dout0_0) AT=955.025n

.meas tran vdout0_1ck1900 FIND v(dout0_1) AT=955.025n

.meas tran vdout0_2ck1900 FIND v(dout0_2) AT=955.025n

.meas tran vdout0_3ck1900 FIND v(dout0_3) AT=955.025n

.meas tran vdout0_4ck1900 FIND v(dout0_4) AT=955.025n

.meas tran vdout0_5ck1900 FIND v(dout0_5) AT=955.025n

.meas tran vdout0_6ck1900 FIND v(dout0_6) AT=955.025n

.meas tran vdout0_7ck1900 FIND v(dout0_7) AT=955.025n

.meas tran vdout0_8ck1900 FIND v(dout0_8) AT=955.025n

.meas tran vdout0_9ck1900 FIND v(dout0_9) AT=955.025n

.meas tran vdout0_10ck1900 FIND v(dout0_10) AT=955.025n

.meas tran vdout0_11ck1900 FIND v(dout0_11) AT=955.025n

.meas tran vdout0_12ck1900 FIND v(dout0_12) AT=955.025n

.meas tran vdout0_13ck1900 FIND v(dout0_13) AT=955.025n

.meas tran vdout0_14ck1900 FIND v(dout0_14) AT=955.025n

.meas tran vdout0_15ck1900 FIND v(dout0_15) AT=955.025n

.meas tran vdout0_16ck1900 FIND v(dout0_16) AT=955.025n

.meas tran vdout0_17ck1900 FIND v(dout0_17) AT=955.025n

.meas tran vdout0_18ck1900 FIND v(dout0_18) AT=955.025n

.meas tran vdout0_19ck1900 FIND v(dout0_19) AT=955.025n

.meas tran vdout0_20ck1900 FIND v(dout0_20) AT=955.025n

.meas tran vdout0_21ck1900 FIND v(dout0_21) AT=955.025n

.meas tran vdout0_22ck1900 FIND v(dout0_22) AT=955.025n

.meas tran vdout0_23ck1900 FIND v(dout0_23) AT=955.025n

.meas tran vdout0_24ck1900 FIND v(dout0_24) AT=955.025n

.meas tran vdout0_25ck1900 FIND v(dout0_25) AT=955.025n

.meas tran vdout0_26ck1900 FIND v(dout0_26) AT=955.025n

.meas tran vdout0_27ck1900 FIND v(dout0_27) AT=955.025n

.meas tran vdout0_28ck1900 FIND v(dout0_28) AT=955.025n

.meas tran vdout0_29ck1900 FIND v(dout0_29) AT=955.025n

.meas tran vdout0_30ck1900 FIND v(dout0_30) AT=955.025n

.meas tran vdout0_31ck1900 FIND v(dout0_31) AT=955.025n

.meas tran vdout0_0ck1930 FIND v(dout0_0) AT=970.025n

.meas tran vdout0_1ck1930 FIND v(dout0_1) AT=970.025n

.meas tran vdout0_2ck1930 FIND v(dout0_2) AT=970.025n

.meas tran vdout0_3ck1930 FIND v(dout0_3) AT=970.025n

.meas tran vdout0_4ck1930 FIND v(dout0_4) AT=970.025n

.meas tran vdout0_5ck1930 FIND v(dout0_5) AT=970.025n

.meas tran vdout0_6ck1930 FIND v(dout0_6) AT=970.025n

.meas tran vdout0_7ck1930 FIND v(dout0_7) AT=970.025n

.meas tran vdout0_8ck1930 FIND v(dout0_8) AT=970.025n

.meas tran vdout0_9ck1930 FIND v(dout0_9) AT=970.025n

.meas tran vdout0_10ck1930 FIND v(dout0_10) AT=970.025n

.meas tran vdout0_11ck1930 FIND v(dout0_11) AT=970.025n

.meas tran vdout0_12ck1930 FIND v(dout0_12) AT=970.025n

.meas tran vdout0_13ck1930 FIND v(dout0_13) AT=970.025n

.meas tran vdout0_14ck1930 FIND v(dout0_14) AT=970.025n

.meas tran vdout0_15ck1930 FIND v(dout0_15) AT=970.025n

.meas tran vdout0_16ck1930 FIND v(dout0_16) AT=970.025n

.meas tran vdout0_17ck1930 FIND v(dout0_17) AT=970.025n

.meas tran vdout0_18ck1930 FIND v(dout0_18) AT=970.025n

.meas tran vdout0_19ck1930 FIND v(dout0_19) AT=970.025n

.meas tran vdout0_20ck1930 FIND v(dout0_20) AT=970.025n

.meas tran vdout0_21ck1930 FIND v(dout0_21) AT=970.025n

.meas tran vdout0_22ck1930 FIND v(dout0_22) AT=970.025n

.meas tran vdout0_23ck1930 FIND v(dout0_23) AT=970.025n

.meas tran vdout0_24ck1930 FIND v(dout0_24) AT=970.025n

.meas tran vdout0_25ck1930 FIND v(dout0_25) AT=970.025n

.meas tran vdout0_26ck1930 FIND v(dout0_26) AT=970.025n

.meas tran vdout0_27ck1930 FIND v(dout0_27) AT=970.025n

.meas tran vdout0_28ck1930 FIND v(dout0_28) AT=970.025n

.meas tran vdout0_29ck1930 FIND v(dout0_29) AT=970.025n

.meas tran vdout0_30ck1930 FIND v(dout0_30) AT=970.025n

.meas tran vdout0_31ck1930 FIND v(dout0_31) AT=970.025n

.meas tran vdout1_0ck1930 FIND v(dout1_0) AT=970.025n

.meas tran vdout1_1ck1930 FIND v(dout1_1) AT=970.025n

.meas tran vdout1_2ck1930 FIND v(dout1_2) AT=970.025n

.meas tran vdout1_3ck1930 FIND v(dout1_3) AT=970.025n

.meas tran vdout1_4ck1930 FIND v(dout1_4) AT=970.025n

.meas tran vdout1_5ck1930 FIND v(dout1_5) AT=970.025n

.meas tran vdout1_6ck1930 FIND v(dout1_6) AT=970.025n

.meas tran vdout1_7ck1930 FIND v(dout1_7) AT=970.025n

.meas tran vdout1_8ck1930 FIND v(dout1_8) AT=970.025n

.meas tran vdout1_9ck1930 FIND v(dout1_9) AT=970.025n

.meas tran vdout1_10ck1930 FIND v(dout1_10) AT=970.025n

.meas tran vdout1_11ck1930 FIND v(dout1_11) AT=970.025n

.meas tran vdout1_12ck1930 FIND v(dout1_12) AT=970.025n

.meas tran vdout1_13ck1930 FIND v(dout1_13) AT=970.025n

.meas tran vdout1_14ck1930 FIND v(dout1_14) AT=970.025n

.meas tran vdout1_15ck1930 FIND v(dout1_15) AT=970.025n

.meas tran vdout1_16ck1930 FIND v(dout1_16) AT=970.025n

.meas tran vdout1_17ck1930 FIND v(dout1_17) AT=970.025n

.meas tran vdout1_18ck1930 FIND v(dout1_18) AT=970.025n

.meas tran vdout1_19ck1930 FIND v(dout1_19) AT=970.025n

.meas tran vdout1_20ck1930 FIND v(dout1_20) AT=970.025n

.meas tran vdout1_21ck1930 FIND v(dout1_21) AT=970.025n

.meas tran vdout1_22ck1930 FIND v(dout1_22) AT=970.025n

.meas tran vdout1_23ck1930 FIND v(dout1_23) AT=970.025n

.meas tran vdout1_24ck1930 FIND v(dout1_24) AT=970.025n

.meas tran vdout1_25ck1930 FIND v(dout1_25) AT=970.025n

.meas tran vdout1_26ck1930 FIND v(dout1_26) AT=970.025n

.meas tran vdout1_27ck1930 FIND v(dout1_27) AT=970.025n

.meas tran vdout1_28ck1930 FIND v(dout1_28) AT=970.025n

.meas tran vdout1_29ck1930 FIND v(dout1_29) AT=970.025n

.meas tran vdout1_30ck1930 FIND v(dout1_30) AT=970.025n

.meas tran vdout1_31ck1930 FIND v(dout1_31) AT=970.025n

.meas tran vdout1_0ck1940 FIND v(dout1_0) AT=975.025n

.meas tran vdout1_1ck1940 FIND v(dout1_1) AT=975.025n

.meas tran vdout1_2ck1940 FIND v(dout1_2) AT=975.025n

.meas tran vdout1_3ck1940 FIND v(dout1_3) AT=975.025n

.meas tran vdout1_4ck1940 FIND v(dout1_4) AT=975.025n

.meas tran vdout1_5ck1940 FIND v(dout1_5) AT=975.025n

.meas tran vdout1_6ck1940 FIND v(dout1_6) AT=975.025n

.meas tran vdout1_7ck1940 FIND v(dout1_7) AT=975.025n

.meas tran vdout1_8ck1940 FIND v(dout1_8) AT=975.025n

.meas tran vdout1_9ck1940 FIND v(dout1_9) AT=975.025n

.meas tran vdout1_10ck1940 FIND v(dout1_10) AT=975.025n

.meas tran vdout1_11ck1940 FIND v(dout1_11) AT=975.025n

.meas tran vdout1_12ck1940 FIND v(dout1_12) AT=975.025n

.meas tran vdout1_13ck1940 FIND v(dout1_13) AT=975.025n

.meas tran vdout1_14ck1940 FIND v(dout1_14) AT=975.025n

.meas tran vdout1_15ck1940 FIND v(dout1_15) AT=975.025n

.meas tran vdout1_16ck1940 FIND v(dout1_16) AT=975.025n

.meas tran vdout1_17ck1940 FIND v(dout1_17) AT=975.025n

.meas tran vdout1_18ck1940 FIND v(dout1_18) AT=975.025n

.meas tran vdout1_19ck1940 FIND v(dout1_19) AT=975.025n

.meas tran vdout1_20ck1940 FIND v(dout1_20) AT=975.025n

.meas tran vdout1_21ck1940 FIND v(dout1_21) AT=975.025n

.meas tran vdout1_22ck1940 FIND v(dout1_22) AT=975.025n

.meas tran vdout1_23ck1940 FIND v(dout1_23) AT=975.025n

.meas tran vdout1_24ck1940 FIND v(dout1_24) AT=975.025n

.meas tran vdout1_25ck1940 FIND v(dout1_25) AT=975.025n

.meas tran vdout1_26ck1940 FIND v(dout1_26) AT=975.025n

.meas tran vdout1_27ck1940 FIND v(dout1_27) AT=975.025n

.meas tran vdout1_28ck1940 FIND v(dout1_28) AT=975.025n

.meas tran vdout1_29ck1940 FIND v(dout1_29) AT=975.025n

.meas tran vdout1_30ck1940 FIND v(dout1_30) AT=975.025n

.meas tran vdout1_31ck1940 FIND v(dout1_31) AT=975.025n

.meas tran vdout0_0ck1950 FIND v(dout0_0) AT=980.025n

.meas tran vdout0_1ck1950 FIND v(dout0_1) AT=980.025n

.meas tran vdout0_2ck1950 FIND v(dout0_2) AT=980.025n

.meas tran vdout0_3ck1950 FIND v(dout0_3) AT=980.025n

.meas tran vdout0_4ck1950 FIND v(dout0_4) AT=980.025n

.meas tran vdout0_5ck1950 FIND v(dout0_5) AT=980.025n

.meas tran vdout0_6ck1950 FIND v(dout0_6) AT=980.025n

.meas tran vdout0_7ck1950 FIND v(dout0_7) AT=980.025n

.meas tran vdout0_8ck1950 FIND v(dout0_8) AT=980.025n

.meas tran vdout0_9ck1950 FIND v(dout0_9) AT=980.025n

.meas tran vdout0_10ck1950 FIND v(dout0_10) AT=980.025n

.meas tran vdout0_11ck1950 FIND v(dout0_11) AT=980.025n

.meas tran vdout0_12ck1950 FIND v(dout0_12) AT=980.025n

.meas tran vdout0_13ck1950 FIND v(dout0_13) AT=980.025n

.meas tran vdout0_14ck1950 FIND v(dout0_14) AT=980.025n

.meas tran vdout0_15ck1950 FIND v(dout0_15) AT=980.025n

.meas tran vdout0_16ck1950 FIND v(dout0_16) AT=980.025n

.meas tran vdout0_17ck1950 FIND v(dout0_17) AT=980.025n

.meas tran vdout0_18ck1950 FIND v(dout0_18) AT=980.025n

.meas tran vdout0_19ck1950 FIND v(dout0_19) AT=980.025n

.meas tran vdout0_20ck1950 FIND v(dout0_20) AT=980.025n

.meas tran vdout0_21ck1950 FIND v(dout0_21) AT=980.025n

.meas tran vdout0_22ck1950 FIND v(dout0_22) AT=980.025n

.meas tran vdout0_23ck1950 FIND v(dout0_23) AT=980.025n

.meas tran vdout0_24ck1950 FIND v(dout0_24) AT=980.025n

.meas tran vdout0_25ck1950 FIND v(dout0_25) AT=980.025n

.meas tran vdout0_26ck1950 FIND v(dout0_26) AT=980.025n

.meas tran vdout0_27ck1950 FIND v(dout0_27) AT=980.025n

.meas tran vdout0_28ck1950 FIND v(dout0_28) AT=980.025n

.meas tran vdout0_29ck1950 FIND v(dout0_29) AT=980.025n

.meas tran vdout0_30ck1950 FIND v(dout0_30) AT=980.025n

.meas tran vdout0_31ck1950 FIND v(dout0_31) AT=980.025n

.meas tran vdout1_0ck1950 FIND v(dout1_0) AT=980.025n

.meas tran vdout1_1ck1950 FIND v(dout1_1) AT=980.025n

.meas tran vdout1_2ck1950 FIND v(dout1_2) AT=980.025n

.meas tran vdout1_3ck1950 FIND v(dout1_3) AT=980.025n

.meas tran vdout1_4ck1950 FIND v(dout1_4) AT=980.025n

.meas tran vdout1_5ck1950 FIND v(dout1_5) AT=980.025n

.meas tran vdout1_6ck1950 FIND v(dout1_6) AT=980.025n

.meas tran vdout1_7ck1950 FIND v(dout1_7) AT=980.025n

.meas tran vdout1_8ck1950 FIND v(dout1_8) AT=980.025n

.meas tran vdout1_9ck1950 FIND v(dout1_9) AT=980.025n

.meas tran vdout1_10ck1950 FIND v(dout1_10) AT=980.025n

.meas tran vdout1_11ck1950 FIND v(dout1_11) AT=980.025n

.meas tran vdout1_12ck1950 FIND v(dout1_12) AT=980.025n

.meas tran vdout1_13ck1950 FIND v(dout1_13) AT=980.025n

.meas tran vdout1_14ck1950 FIND v(dout1_14) AT=980.025n

.meas tran vdout1_15ck1950 FIND v(dout1_15) AT=980.025n

.meas tran vdout1_16ck1950 FIND v(dout1_16) AT=980.025n

.meas tran vdout1_17ck1950 FIND v(dout1_17) AT=980.025n

.meas tran vdout1_18ck1950 FIND v(dout1_18) AT=980.025n

.meas tran vdout1_19ck1950 FIND v(dout1_19) AT=980.025n

.meas tran vdout1_20ck1950 FIND v(dout1_20) AT=980.025n

.meas tran vdout1_21ck1950 FIND v(dout1_21) AT=980.025n

.meas tran vdout1_22ck1950 FIND v(dout1_22) AT=980.025n

.meas tran vdout1_23ck1950 FIND v(dout1_23) AT=980.025n

.meas tran vdout1_24ck1950 FIND v(dout1_24) AT=980.025n

.meas tran vdout1_25ck1950 FIND v(dout1_25) AT=980.025n

.meas tran vdout1_26ck1950 FIND v(dout1_26) AT=980.025n

.meas tran vdout1_27ck1950 FIND v(dout1_27) AT=980.025n

.meas tran vdout1_28ck1950 FIND v(dout1_28) AT=980.025n

.meas tran vdout1_29ck1950 FIND v(dout1_29) AT=980.025n

.meas tran vdout1_30ck1950 FIND v(dout1_30) AT=980.025n

.meas tran vdout1_31ck1950 FIND v(dout1_31) AT=980.025n

.meas tran vdout0_0ck1960 FIND v(dout0_0) AT=985.025n

.meas tran vdout0_1ck1960 FIND v(dout0_1) AT=985.025n

.meas tran vdout0_2ck1960 FIND v(dout0_2) AT=985.025n

.meas tran vdout0_3ck1960 FIND v(dout0_3) AT=985.025n

.meas tran vdout0_4ck1960 FIND v(dout0_4) AT=985.025n

.meas tran vdout0_5ck1960 FIND v(dout0_5) AT=985.025n

.meas tran vdout0_6ck1960 FIND v(dout0_6) AT=985.025n

.meas tran vdout0_7ck1960 FIND v(dout0_7) AT=985.025n

.meas tran vdout0_8ck1960 FIND v(dout0_8) AT=985.025n

.meas tran vdout0_9ck1960 FIND v(dout0_9) AT=985.025n

.meas tran vdout0_10ck1960 FIND v(dout0_10) AT=985.025n

.meas tran vdout0_11ck1960 FIND v(dout0_11) AT=985.025n

.meas tran vdout0_12ck1960 FIND v(dout0_12) AT=985.025n

.meas tran vdout0_13ck1960 FIND v(dout0_13) AT=985.025n

.meas tran vdout0_14ck1960 FIND v(dout0_14) AT=985.025n

.meas tran vdout0_15ck1960 FIND v(dout0_15) AT=985.025n

.meas tran vdout0_16ck1960 FIND v(dout0_16) AT=985.025n

.meas tran vdout0_17ck1960 FIND v(dout0_17) AT=985.025n

.meas tran vdout0_18ck1960 FIND v(dout0_18) AT=985.025n

.meas tran vdout0_19ck1960 FIND v(dout0_19) AT=985.025n

.meas tran vdout0_20ck1960 FIND v(dout0_20) AT=985.025n

.meas tran vdout0_21ck1960 FIND v(dout0_21) AT=985.025n

.meas tran vdout0_22ck1960 FIND v(dout0_22) AT=985.025n

.meas tran vdout0_23ck1960 FIND v(dout0_23) AT=985.025n

.meas tran vdout0_24ck1960 FIND v(dout0_24) AT=985.025n

.meas tran vdout0_25ck1960 FIND v(dout0_25) AT=985.025n

.meas tran vdout0_26ck1960 FIND v(dout0_26) AT=985.025n

.meas tran vdout0_27ck1960 FIND v(dout0_27) AT=985.025n

.meas tran vdout0_28ck1960 FIND v(dout0_28) AT=985.025n

.meas tran vdout0_29ck1960 FIND v(dout0_29) AT=985.025n

.meas tran vdout0_30ck1960 FIND v(dout0_30) AT=985.025n

.meas tran vdout0_31ck1960 FIND v(dout0_31) AT=985.025n

.meas tran vdout1_0ck1960 FIND v(dout1_0) AT=985.025n

.meas tran vdout1_1ck1960 FIND v(dout1_1) AT=985.025n

.meas tran vdout1_2ck1960 FIND v(dout1_2) AT=985.025n

.meas tran vdout1_3ck1960 FIND v(dout1_3) AT=985.025n

.meas tran vdout1_4ck1960 FIND v(dout1_4) AT=985.025n

.meas tran vdout1_5ck1960 FIND v(dout1_5) AT=985.025n

.meas tran vdout1_6ck1960 FIND v(dout1_6) AT=985.025n

.meas tran vdout1_7ck1960 FIND v(dout1_7) AT=985.025n

.meas tran vdout1_8ck1960 FIND v(dout1_8) AT=985.025n

.meas tran vdout1_9ck1960 FIND v(dout1_9) AT=985.025n

.meas tran vdout1_10ck1960 FIND v(dout1_10) AT=985.025n

.meas tran vdout1_11ck1960 FIND v(dout1_11) AT=985.025n

.meas tran vdout1_12ck1960 FIND v(dout1_12) AT=985.025n

.meas tran vdout1_13ck1960 FIND v(dout1_13) AT=985.025n

.meas tran vdout1_14ck1960 FIND v(dout1_14) AT=985.025n

.meas tran vdout1_15ck1960 FIND v(dout1_15) AT=985.025n

.meas tran vdout1_16ck1960 FIND v(dout1_16) AT=985.025n

.meas tran vdout1_17ck1960 FIND v(dout1_17) AT=985.025n

.meas tran vdout1_18ck1960 FIND v(dout1_18) AT=985.025n

.meas tran vdout1_19ck1960 FIND v(dout1_19) AT=985.025n

.meas tran vdout1_20ck1960 FIND v(dout1_20) AT=985.025n

.meas tran vdout1_21ck1960 FIND v(dout1_21) AT=985.025n

.meas tran vdout1_22ck1960 FIND v(dout1_22) AT=985.025n

.meas tran vdout1_23ck1960 FIND v(dout1_23) AT=985.025n

.meas tran vdout1_24ck1960 FIND v(dout1_24) AT=985.025n

.meas tran vdout1_25ck1960 FIND v(dout1_25) AT=985.025n

.meas tran vdout1_26ck1960 FIND v(dout1_26) AT=985.025n

.meas tran vdout1_27ck1960 FIND v(dout1_27) AT=985.025n

.meas tran vdout1_28ck1960 FIND v(dout1_28) AT=985.025n

.meas tran vdout1_29ck1960 FIND v(dout1_29) AT=985.025n

.meas tran vdout1_30ck1960 FIND v(dout1_30) AT=985.025n

.meas tran vdout1_31ck1960 FIND v(dout1_31) AT=985.025n

.meas tran vdout0_0ck1970 FIND v(dout0_0) AT=990.025n

.meas tran vdout0_1ck1970 FIND v(dout0_1) AT=990.025n

.meas tran vdout0_2ck1970 FIND v(dout0_2) AT=990.025n

.meas tran vdout0_3ck1970 FIND v(dout0_3) AT=990.025n

.meas tran vdout0_4ck1970 FIND v(dout0_4) AT=990.025n

.meas tran vdout0_5ck1970 FIND v(dout0_5) AT=990.025n

.meas tran vdout0_6ck1970 FIND v(dout0_6) AT=990.025n

.meas tran vdout0_7ck1970 FIND v(dout0_7) AT=990.025n

.meas tran vdout0_8ck1970 FIND v(dout0_8) AT=990.025n

.meas tran vdout0_9ck1970 FIND v(dout0_9) AT=990.025n

.meas tran vdout0_10ck1970 FIND v(dout0_10) AT=990.025n

.meas tran vdout0_11ck1970 FIND v(dout0_11) AT=990.025n

.meas tran vdout0_12ck1970 FIND v(dout0_12) AT=990.025n

.meas tran vdout0_13ck1970 FIND v(dout0_13) AT=990.025n

.meas tran vdout0_14ck1970 FIND v(dout0_14) AT=990.025n

.meas tran vdout0_15ck1970 FIND v(dout0_15) AT=990.025n

.meas tran vdout0_16ck1970 FIND v(dout0_16) AT=990.025n

.meas tran vdout0_17ck1970 FIND v(dout0_17) AT=990.025n

.meas tran vdout0_18ck1970 FIND v(dout0_18) AT=990.025n

.meas tran vdout0_19ck1970 FIND v(dout0_19) AT=990.025n

.meas tran vdout0_20ck1970 FIND v(dout0_20) AT=990.025n

.meas tran vdout0_21ck1970 FIND v(dout0_21) AT=990.025n

.meas tran vdout0_22ck1970 FIND v(dout0_22) AT=990.025n

.meas tran vdout0_23ck1970 FIND v(dout0_23) AT=990.025n

.meas tran vdout0_24ck1970 FIND v(dout0_24) AT=990.025n

.meas tran vdout0_25ck1970 FIND v(dout0_25) AT=990.025n

.meas tran vdout0_26ck1970 FIND v(dout0_26) AT=990.025n

.meas tran vdout0_27ck1970 FIND v(dout0_27) AT=990.025n

.meas tran vdout0_28ck1970 FIND v(dout0_28) AT=990.025n

.meas tran vdout0_29ck1970 FIND v(dout0_29) AT=990.025n

.meas tran vdout0_30ck1970 FIND v(dout0_30) AT=990.025n

.meas tran vdout0_31ck1970 FIND v(dout0_31) AT=990.025n

.meas tran vdout0_0ck1990 FIND v(dout0_0) AT=1000.025n

.meas tran vdout0_1ck1990 FIND v(dout0_1) AT=1000.025n

.meas tran vdout0_2ck1990 FIND v(dout0_2) AT=1000.025n

.meas tran vdout0_3ck1990 FIND v(dout0_3) AT=1000.025n

.meas tran vdout0_4ck1990 FIND v(dout0_4) AT=1000.025n

.meas tran vdout0_5ck1990 FIND v(dout0_5) AT=1000.025n

.meas tran vdout0_6ck1990 FIND v(dout0_6) AT=1000.025n

.meas tran vdout0_7ck1990 FIND v(dout0_7) AT=1000.025n

.meas tran vdout0_8ck1990 FIND v(dout0_8) AT=1000.025n

.meas tran vdout0_9ck1990 FIND v(dout0_9) AT=1000.025n

.meas tran vdout0_10ck1990 FIND v(dout0_10) AT=1000.025n

.meas tran vdout0_11ck1990 FIND v(dout0_11) AT=1000.025n

.meas tran vdout0_12ck1990 FIND v(dout0_12) AT=1000.025n

.meas tran vdout0_13ck1990 FIND v(dout0_13) AT=1000.025n

.meas tran vdout0_14ck1990 FIND v(dout0_14) AT=1000.025n

.meas tran vdout0_15ck1990 FIND v(dout0_15) AT=1000.025n

.meas tran vdout0_16ck1990 FIND v(dout0_16) AT=1000.025n

.meas tran vdout0_17ck1990 FIND v(dout0_17) AT=1000.025n

.meas tran vdout0_18ck1990 FIND v(dout0_18) AT=1000.025n

.meas tran vdout0_19ck1990 FIND v(dout0_19) AT=1000.025n

.meas tran vdout0_20ck1990 FIND v(dout0_20) AT=1000.025n

.meas tran vdout0_21ck1990 FIND v(dout0_21) AT=1000.025n

.meas tran vdout0_22ck1990 FIND v(dout0_22) AT=1000.025n

.meas tran vdout0_23ck1990 FIND v(dout0_23) AT=1000.025n

.meas tran vdout0_24ck1990 FIND v(dout0_24) AT=1000.025n

.meas tran vdout0_25ck1990 FIND v(dout0_25) AT=1000.025n

.meas tran vdout0_26ck1990 FIND v(dout0_26) AT=1000.025n

.meas tran vdout0_27ck1990 FIND v(dout0_27) AT=1000.025n

.meas tran vdout0_28ck1990 FIND v(dout0_28) AT=1000.025n

.meas tran vdout0_29ck1990 FIND v(dout0_29) AT=1000.025n

.meas tran vdout0_30ck1990 FIND v(dout0_30) AT=1000.025n

.meas tran vdout0_31ck1990 FIND v(dout0_31) AT=1000.025n

.meas tran vdout0_0ck2000 FIND v(dout0_0) AT=1005.025n

.meas tran vdout0_1ck2000 FIND v(dout0_1) AT=1005.025n

.meas tran vdout0_2ck2000 FIND v(dout0_2) AT=1005.025n

.meas tran vdout0_3ck2000 FIND v(dout0_3) AT=1005.025n

.meas tran vdout0_4ck2000 FIND v(dout0_4) AT=1005.025n

.meas tran vdout0_5ck2000 FIND v(dout0_5) AT=1005.025n

.meas tran vdout0_6ck2000 FIND v(dout0_6) AT=1005.025n

.meas tran vdout0_7ck2000 FIND v(dout0_7) AT=1005.025n

.meas tran vdout0_8ck2000 FIND v(dout0_8) AT=1005.025n

.meas tran vdout0_9ck2000 FIND v(dout0_9) AT=1005.025n

.meas tran vdout0_10ck2000 FIND v(dout0_10) AT=1005.025n

.meas tran vdout0_11ck2000 FIND v(dout0_11) AT=1005.025n

.meas tran vdout0_12ck2000 FIND v(dout0_12) AT=1005.025n

.meas tran vdout0_13ck2000 FIND v(dout0_13) AT=1005.025n

.meas tran vdout0_14ck2000 FIND v(dout0_14) AT=1005.025n

.meas tran vdout0_15ck2000 FIND v(dout0_15) AT=1005.025n

.meas tran vdout0_16ck2000 FIND v(dout0_16) AT=1005.025n

.meas tran vdout0_17ck2000 FIND v(dout0_17) AT=1005.025n

.meas tran vdout0_18ck2000 FIND v(dout0_18) AT=1005.025n

.meas tran vdout0_19ck2000 FIND v(dout0_19) AT=1005.025n

.meas tran vdout0_20ck2000 FIND v(dout0_20) AT=1005.025n

.meas tran vdout0_21ck2000 FIND v(dout0_21) AT=1005.025n

.meas tran vdout0_22ck2000 FIND v(dout0_22) AT=1005.025n

.meas tran vdout0_23ck2000 FIND v(dout0_23) AT=1005.025n

.meas tran vdout0_24ck2000 FIND v(dout0_24) AT=1005.025n

.meas tran vdout0_25ck2000 FIND v(dout0_25) AT=1005.025n

.meas tran vdout0_26ck2000 FIND v(dout0_26) AT=1005.025n

.meas tran vdout0_27ck2000 FIND v(dout0_27) AT=1005.025n

.meas tran vdout0_28ck2000 FIND v(dout0_28) AT=1005.025n

.meas tran vdout0_29ck2000 FIND v(dout0_29) AT=1005.025n

.meas tran vdout0_30ck2000 FIND v(dout0_30) AT=1005.025n

.meas tran vdout0_31ck2000 FIND v(dout0_31) AT=1005.025n

.meas tran vdout0_0ck2010 FIND v(dout0_0) AT=1010.025n

.meas tran vdout0_1ck2010 FIND v(dout0_1) AT=1010.025n

.meas tran vdout0_2ck2010 FIND v(dout0_2) AT=1010.025n

.meas tran vdout0_3ck2010 FIND v(dout0_3) AT=1010.025n

.meas tran vdout0_4ck2010 FIND v(dout0_4) AT=1010.025n

.meas tran vdout0_5ck2010 FIND v(dout0_5) AT=1010.025n

.meas tran vdout0_6ck2010 FIND v(dout0_6) AT=1010.025n

.meas tran vdout0_7ck2010 FIND v(dout0_7) AT=1010.025n

.meas tran vdout0_8ck2010 FIND v(dout0_8) AT=1010.025n

.meas tran vdout0_9ck2010 FIND v(dout0_9) AT=1010.025n

.meas tran vdout0_10ck2010 FIND v(dout0_10) AT=1010.025n

.meas tran vdout0_11ck2010 FIND v(dout0_11) AT=1010.025n

.meas tran vdout0_12ck2010 FIND v(dout0_12) AT=1010.025n

.meas tran vdout0_13ck2010 FIND v(dout0_13) AT=1010.025n

.meas tran vdout0_14ck2010 FIND v(dout0_14) AT=1010.025n

.meas tran vdout0_15ck2010 FIND v(dout0_15) AT=1010.025n

.meas tran vdout0_16ck2010 FIND v(dout0_16) AT=1010.025n

.meas tran vdout0_17ck2010 FIND v(dout0_17) AT=1010.025n

.meas tran vdout0_18ck2010 FIND v(dout0_18) AT=1010.025n

.meas tran vdout0_19ck2010 FIND v(dout0_19) AT=1010.025n

.meas tran vdout0_20ck2010 FIND v(dout0_20) AT=1010.025n

.meas tran vdout0_21ck2010 FIND v(dout0_21) AT=1010.025n

.meas tran vdout0_22ck2010 FIND v(dout0_22) AT=1010.025n

.meas tran vdout0_23ck2010 FIND v(dout0_23) AT=1010.025n

.meas tran vdout0_24ck2010 FIND v(dout0_24) AT=1010.025n

.meas tran vdout0_25ck2010 FIND v(dout0_25) AT=1010.025n

.meas tran vdout0_26ck2010 FIND v(dout0_26) AT=1010.025n

.meas tran vdout0_27ck2010 FIND v(dout0_27) AT=1010.025n

.meas tran vdout0_28ck2010 FIND v(dout0_28) AT=1010.025n

.meas tran vdout0_29ck2010 FIND v(dout0_29) AT=1010.025n

.meas tran vdout0_30ck2010 FIND v(dout0_30) AT=1010.025n

.meas tran vdout0_31ck2010 FIND v(dout0_31) AT=1010.025n

.meas tran vdout0_0ck2020 FIND v(dout0_0) AT=1015.025n

.meas tran vdout0_1ck2020 FIND v(dout0_1) AT=1015.025n

.meas tran vdout0_2ck2020 FIND v(dout0_2) AT=1015.025n

.meas tran vdout0_3ck2020 FIND v(dout0_3) AT=1015.025n

.meas tran vdout0_4ck2020 FIND v(dout0_4) AT=1015.025n

.meas tran vdout0_5ck2020 FIND v(dout0_5) AT=1015.025n

.meas tran vdout0_6ck2020 FIND v(dout0_6) AT=1015.025n

.meas tran vdout0_7ck2020 FIND v(dout0_7) AT=1015.025n

.meas tran vdout0_8ck2020 FIND v(dout0_8) AT=1015.025n

.meas tran vdout0_9ck2020 FIND v(dout0_9) AT=1015.025n

.meas tran vdout0_10ck2020 FIND v(dout0_10) AT=1015.025n

.meas tran vdout0_11ck2020 FIND v(dout0_11) AT=1015.025n

.meas tran vdout0_12ck2020 FIND v(dout0_12) AT=1015.025n

.meas tran vdout0_13ck2020 FIND v(dout0_13) AT=1015.025n

.meas tran vdout0_14ck2020 FIND v(dout0_14) AT=1015.025n

.meas tran vdout0_15ck2020 FIND v(dout0_15) AT=1015.025n

.meas tran vdout0_16ck2020 FIND v(dout0_16) AT=1015.025n

.meas tran vdout0_17ck2020 FIND v(dout0_17) AT=1015.025n

.meas tran vdout0_18ck2020 FIND v(dout0_18) AT=1015.025n

.meas tran vdout0_19ck2020 FIND v(dout0_19) AT=1015.025n

.meas tran vdout0_20ck2020 FIND v(dout0_20) AT=1015.025n

.meas tran vdout0_21ck2020 FIND v(dout0_21) AT=1015.025n

.meas tran vdout0_22ck2020 FIND v(dout0_22) AT=1015.025n

.meas tran vdout0_23ck2020 FIND v(dout0_23) AT=1015.025n

.meas tran vdout0_24ck2020 FIND v(dout0_24) AT=1015.025n

.meas tran vdout0_25ck2020 FIND v(dout0_25) AT=1015.025n

.meas tran vdout0_26ck2020 FIND v(dout0_26) AT=1015.025n

.meas tran vdout0_27ck2020 FIND v(dout0_27) AT=1015.025n

.meas tran vdout0_28ck2020 FIND v(dout0_28) AT=1015.025n

.meas tran vdout0_29ck2020 FIND v(dout0_29) AT=1015.025n

.meas tran vdout0_30ck2020 FIND v(dout0_30) AT=1015.025n

.meas tran vdout0_31ck2020 FIND v(dout0_31) AT=1015.025n

.meas tran vdout1_0ck2030 FIND v(dout1_0) AT=1020.025n

.meas tran vdout1_1ck2030 FIND v(dout1_1) AT=1020.025n

.meas tran vdout1_2ck2030 FIND v(dout1_2) AT=1020.025n

.meas tran vdout1_3ck2030 FIND v(dout1_3) AT=1020.025n

.meas tran vdout1_4ck2030 FIND v(dout1_4) AT=1020.025n

.meas tran vdout1_5ck2030 FIND v(dout1_5) AT=1020.025n

.meas tran vdout1_6ck2030 FIND v(dout1_6) AT=1020.025n

.meas tran vdout1_7ck2030 FIND v(dout1_7) AT=1020.025n

.meas tran vdout1_8ck2030 FIND v(dout1_8) AT=1020.025n

.meas tran vdout1_9ck2030 FIND v(dout1_9) AT=1020.025n

.meas tran vdout1_10ck2030 FIND v(dout1_10) AT=1020.025n

.meas tran vdout1_11ck2030 FIND v(dout1_11) AT=1020.025n

.meas tran vdout1_12ck2030 FIND v(dout1_12) AT=1020.025n

.meas tran vdout1_13ck2030 FIND v(dout1_13) AT=1020.025n

.meas tran vdout1_14ck2030 FIND v(dout1_14) AT=1020.025n

.meas tran vdout1_15ck2030 FIND v(dout1_15) AT=1020.025n

.meas tran vdout1_16ck2030 FIND v(dout1_16) AT=1020.025n

.meas tran vdout1_17ck2030 FIND v(dout1_17) AT=1020.025n

.meas tran vdout1_18ck2030 FIND v(dout1_18) AT=1020.025n

.meas tran vdout1_19ck2030 FIND v(dout1_19) AT=1020.025n

.meas tran vdout1_20ck2030 FIND v(dout1_20) AT=1020.025n

.meas tran vdout1_21ck2030 FIND v(dout1_21) AT=1020.025n

.meas tran vdout1_22ck2030 FIND v(dout1_22) AT=1020.025n

.meas tran vdout1_23ck2030 FIND v(dout1_23) AT=1020.025n

.meas tran vdout1_24ck2030 FIND v(dout1_24) AT=1020.025n

.meas tran vdout1_25ck2030 FIND v(dout1_25) AT=1020.025n

.meas tran vdout1_26ck2030 FIND v(dout1_26) AT=1020.025n

.meas tran vdout1_27ck2030 FIND v(dout1_27) AT=1020.025n

.meas tran vdout1_28ck2030 FIND v(dout1_28) AT=1020.025n

.meas tran vdout1_29ck2030 FIND v(dout1_29) AT=1020.025n

.meas tran vdout1_30ck2030 FIND v(dout1_30) AT=1020.025n

.meas tran vdout1_31ck2030 FIND v(dout1_31) AT=1020.025n

.meas tran vdout0_0ck2040 FIND v(dout0_0) AT=1025.025n

.meas tran vdout0_1ck2040 FIND v(dout0_1) AT=1025.025n

.meas tran vdout0_2ck2040 FIND v(dout0_2) AT=1025.025n

.meas tran vdout0_3ck2040 FIND v(dout0_3) AT=1025.025n

.meas tran vdout0_4ck2040 FIND v(dout0_4) AT=1025.025n

.meas tran vdout0_5ck2040 FIND v(dout0_5) AT=1025.025n

.meas tran vdout0_6ck2040 FIND v(dout0_6) AT=1025.025n

.meas tran vdout0_7ck2040 FIND v(dout0_7) AT=1025.025n

.meas tran vdout0_8ck2040 FIND v(dout0_8) AT=1025.025n

.meas tran vdout0_9ck2040 FIND v(dout0_9) AT=1025.025n

.meas tran vdout0_10ck2040 FIND v(dout0_10) AT=1025.025n

.meas tran vdout0_11ck2040 FIND v(dout0_11) AT=1025.025n

.meas tran vdout0_12ck2040 FIND v(dout0_12) AT=1025.025n

.meas tran vdout0_13ck2040 FIND v(dout0_13) AT=1025.025n

.meas tran vdout0_14ck2040 FIND v(dout0_14) AT=1025.025n

.meas tran vdout0_15ck2040 FIND v(dout0_15) AT=1025.025n

.meas tran vdout0_16ck2040 FIND v(dout0_16) AT=1025.025n

.meas tran vdout0_17ck2040 FIND v(dout0_17) AT=1025.025n

.meas tran vdout0_18ck2040 FIND v(dout0_18) AT=1025.025n

.meas tran vdout0_19ck2040 FIND v(dout0_19) AT=1025.025n

.meas tran vdout0_20ck2040 FIND v(dout0_20) AT=1025.025n

.meas tran vdout0_21ck2040 FIND v(dout0_21) AT=1025.025n

.meas tran vdout0_22ck2040 FIND v(dout0_22) AT=1025.025n

.meas tran vdout0_23ck2040 FIND v(dout0_23) AT=1025.025n

.meas tran vdout0_24ck2040 FIND v(dout0_24) AT=1025.025n

.meas tran vdout0_25ck2040 FIND v(dout0_25) AT=1025.025n

.meas tran vdout0_26ck2040 FIND v(dout0_26) AT=1025.025n

.meas tran vdout0_27ck2040 FIND v(dout0_27) AT=1025.025n

.meas tran vdout0_28ck2040 FIND v(dout0_28) AT=1025.025n

.meas tran vdout0_29ck2040 FIND v(dout0_29) AT=1025.025n

.meas tran vdout0_30ck2040 FIND v(dout0_30) AT=1025.025n

.meas tran vdout0_31ck2040 FIND v(dout0_31) AT=1025.025n
